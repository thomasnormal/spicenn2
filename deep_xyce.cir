* N-layer sparse in-circuit trainer (pyramid)
.param Cg=0.0005
.model NSYN NMOS (LEVEL=1 VTO=0.2 KP=50u LAMBDA=0 GAMMA=0 PHI=0.7)
.model NMIR NMOS (LEVEL=1 VTO=0.5 KP=120u LAMBDA=0.02 GAMMA=0 PHI=0.7)
.model PMIR PMOS (LEVEL=1 VTO=-0.5 KP=40u LAMBDA=0.02 GAMMA=0 PHI=0.7)
.model NREL NMOS (LEVEL=1 VTO=0.5 KP=120u LAMBDA=0.02 GAMMA=0 PHI=0.7)
Vvdd vdd 0 3
Vrefh vrefh 0 0.5
Vrefo vrefo 0 0.5
Vg0 vg0 0 0.7
Vvc vcn 0 1.8
Vrefd vrefd 0 1.2
Vboff boff 0 1.9
Vthr vthr 0 0.5
Vcbias vcbias 0 1.0
Vvmid vmid 0 0.5
Vvtb vtb 0 1.4
Vulk vulk 0 0.6
Vbx bx 0 dc 1.7
Va0 a0 0 PWL(0.0000 0.3000 0.1980 0.3000 0.3000 0.4885 0.4980 0.4885 0.6000 0.4856 0.7980 0.4856 0.9000 0.3954 1.0980 0.3954 1.2000 0.3627 1.3980 0.3627 1.5000 0.3323 1.6980 0.3323 1.8000 0.3675 1.9980 0.3675 2.1000 0.5095 2.2980 0.5095 2.4000 0.3615 2.5980 0.3615 2.7000 0.3139 2.8980 0.3139 3.0000 0.5457 3.1980 0.5457 3.3000 0.3702 3.4980 0.3702 3.6000 0.4044 3.7980 0.4044 3.9000 0.4060 4.0980 0.4060 4.2000 0.4588 4.3980 0.4588 4.5000 0.3712 4.6980 0.3712 4.8000 0.3843 4.9980 0.3843 5.1000 0.3918 5.2980 0.3918 5.4000 0.3234 5.5980 0.3234 5.7000 0.4569 5.8980 0.4569 6.0000 0.3840 6.1980 0.3840 6.3000 0.5142 6.4980 0.5142 6.6000 0.4370 6.7980 0.4370 6.9000 0.4637 7.0980 0.4637 7.2000 0.5412 7.3980 0.5412 7.5000 0.5887 7.6980 0.5887 7.8000 0.5985 7.9980 0.5985 8.1000 0.5033 8.2980 0.5033 8.4000 0.5913 8.5980 0.5913 8.7000 0.6190 8.8980 0.6190 9.0000 0.5692 9.1980 0.5692 9.3000 0.5961 9.4980 0.5961 9.6000 0.6150 9.7980 0.6150 9.9000 0.5696 10.0980 0.5696 10.2000 0.6065 10.3980 0.6065 10.5000 0.6194 10.6980 0.6194 10.8000 0.5673 10.9980 0.5673 11.1000 0.6056 11.2980 0.6056 11.4000 0.5477 11.5980 0.5477 11.7000 0.5860 11.8980 0.5860 12.0000 0.5723 12.1980 0.5723 12.3000 0.6247 12.4980 0.6247 12.6000 0.5668 12.7980 0.5668 12.9000 0.5998 13.0980 0.5998 13.2000 0.5790 13.3980 0.5790 13.5000 0.6068 13.6980 0.6068 13.8000 0.5960 13.9980 0.5960 14.1000 0.6236 14.2980 0.6236 14.4000 0.5892 14.5980 0.5892 14.7000 0.6006 14.8980 0.6006 15.0000 0.5595 15.1980 0.5595 15.3000 0.5968 15.4980 0.5968 15.6000 0.5883 15.7980 0.5883 15.9000 0.6004 16.0980 0.6004 16.2000 0.5933 16.3980 0.5933 16.5000 0.5768 16.6980 0.5768 16.8000 0.6007 16.9980 0.6007 17.1000 0.6082 17.2980 0.6082 17.4000 0.5745 17.5980 0.5745 17.7000 0.5786 17.8980 0.5786 18.0000 0.5559 18.1980 0.5559 18.3000 0.6088 18.4980 0.6088 18.6000 0.5452 18.7980 0.5452 18.9000 0.5821 19.0980 0.5821 19.2000 0.5732 19.3980 0.5732 19.5000 0.6057 19.6980 0.6057 19.8000 0.5458 19.9980 0.5458 20.1000 0.6020 20.2980 0.6020 20.4000 0.5708 20.5980 0.5708 20.7000 0.5164 20.8980 0.5164 21.0000 0.5718 21.1980 0.5718 21.3000 0.5754 21.4980 0.5754 21.6000 0.3000 21.7980 0.3000 21.9000 0.4885 22.0980 0.4885 22.2000 0.4856 22.3980 0.4856 22.5000 0.3954 22.6980 0.3954 22.8000 0.3627 22.9980 0.3627 23.1000 0.3323 23.2980 0.3323 23.4000 0.3675 23.5980 0.3675 23.7000 0.5095 23.8980 0.5095 24.0000 0.3615 24.1980 0.3615 24.3000 0.3139 24.4980 0.3139 24.6000 0.5457 24.7980 0.5457 24.9000 0.3702 25.0980 0.3702 25.2000 0.4044 25.3980 0.4044 25.5000 0.4060 25.6980 0.4060 25.8000 0.4588 25.9980 0.4588 26.1000 0.3712 26.2980 0.3712 26.4000 0.3843 26.5980 0.3843 26.7000 0.3918 26.8980 0.3918 27.0000 0.3234 27.1980 0.3234 27.3000 0.4569 27.4980 0.4569 27.6000 0.3840 27.7980 0.3840 27.9000 0.5142 28.0980 0.5142 28.2000 0.4370 28.3980 0.4370 28.5000 0.4637 28.6980 0.4637 28.8000 0.5412 28.9980 0.5412 29.1000 0.5887 29.2980 0.5887 29.4000 0.5985 29.5980 0.5985 29.7000 0.5033 29.8980 0.5033 30.0000 0.5913 30.1980 0.5913 30.3000 0.6190 30.4980 0.6190 30.6000 0.5692 30.7980 0.5692 30.9000 0.5961 31.0980 0.5961 31.2000 0.6150 31.3980 0.6150 31.5000 0.5696 31.6980 0.5696 31.8000 0.6065 31.9980 0.6065 32.1000 0.6194 32.2980 0.6194 32.4000 0.5673 32.5980 0.5673 32.7000 0.6056 32.8980 0.6056 33.0000 0.5477 33.1980 0.5477 33.3000 0.5860 33.4980 0.5860 33.6000 0.5723 33.7980 0.5723 33.9000 0.6247 34.0980 0.6247 34.2000 0.5668 34.3980 0.5668 34.5000 0.5998 34.6980 0.5998 34.8000 0.5790 34.9980 0.5790 35.1000 0.6068 35.2980 0.6068 35.4000 0.5960 35.5980 0.5960 35.7000 0.6236 35.8980 0.6236 36.0000 0.5892 36.1980 0.5892 36.3000 0.6006 36.4980 0.6006 36.6000 0.5595 36.7980 0.5595 36.9000 0.5968 37.0980 0.5968 37.2000 0.5883 37.3980 0.5883 37.5000 0.6004 37.6980 0.6004 37.8000 0.5933 37.9980 0.5933 38.1000 0.5768 38.2980 0.5768 38.4000 0.6007 38.5980 0.6007 38.7000 0.6082 38.8980 0.6082 39.0000 0.5745 39.1980 0.5745 39.3000 0.5786 39.4980 0.5786 39.6000 0.5559 39.7980 0.5559 39.9000 0.6088 40.0980 0.6088 40.2000 0.5452 40.3980 0.5452 40.5000 0.5821 40.6980 0.5821 40.8000 0.5732 40.9980 0.5732 41.1000 0.6057 41.2980 0.6057 41.4000 0.5458 41.5980 0.5458 41.7000 0.6020 41.8980 0.6020 42.0000 0.5708 42.1980 0.5708 42.3000 0.5164 42.4980 0.5164 42.6000 0.5718 42.7980 0.5718 42.9000 0.5754 43.0980 0.5754 43.2000 0.3000 43.3980 0.3000 43.5000 0.4885 43.6980 0.4885 43.8000 0.4856 43.9980 0.4856 44.1000 0.3954 44.2980 0.3954 44.4000 0.3627 44.5980 0.3627 44.7000 0.3323 44.8980 0.3323 45.0000 0.3675 45.1980 0.3675 45.3000 0.5095 45.4980 0.5095 45.6000 0.3615 45.7980 0.3615 45.9000 0.3139 46.0980 0.3139 46.2000 0.5457 46.3980 0.5457 46.5000 0.3702 46.6980 0.3702 46.8000 0.4044 46.9980 0.4044 47.1000 0.4060 47.2980 0.4060 47.4000 0.4588 47.5980 0.4588 47.7000 0.3712 47.8980 0.3712 48.0000 0.3843 48.1980 0.3843 48.3000 0.3918 48.4980 0.3918 48.6000 0.3234 48.7980 0.3234 48.9000 0.4569 49.0980 0.4569 49.2000 0.3840 49.3980 0.3840 49.5000 0.5142 49.6980 0.5142 49.8000 0.4370 49.9980 0.4370 50.1000 0.4637 50.2980 0.4637 50.4000 0.5412 50.5980 0.5412 50.7000 0.5887 50.8980 0.5887 51.0000 0.5985 51.1980 0.5985 51.3000 0.5033 51.4980 0.5033 51.6000 0.5913 51.7980 0.5913 51.9000 0.6190 52.0980 0.6190 52.2000 0.5692 52.3980 0.5692 52.5000 0.5961 52.6980 0.5961 52.8000 0.6150 52.9980 0.6150 53.1000 0.5696 53.2980 0.5696 53.4000 0.6065 53.5980 0.6065 53.7000 0.6194 53.8980 0.6194 54.0000 0.5673 54.1980 0.5673 54.3000 0.6056 54.4980 0.6056 54.6000 0.5477 54.7980 0.5477 54.9000 0.5860 55.0980 0.5860 55.2000 0.5723 55.3980 0.5723 55.5000 0.6247 55.6980 0.6247 55.8000 0.5668 55.9980 0.5668 56.1000 0.5998 56.2980 0.5998 56.4000 0.5790 56.5980 0.5790 56.7000 0.6068 56.8980 0.6068 57.0000 0.5960 57.1980 0.5960 57.3000 0.6236 57.4980 0.6236 57.6000 0.5892 57.7980 0.5892 57.9000 0.6006 58.0980 0.6006 58.2000 0.5595 58.3980 0.5595 58.5000 0.5968 58.6980 0.5968 58.8000 0.5883 58.9980 0.5883 59.1000 0.6004 59.2980 0.6004 59.4000 0.5933 59.5980 0.5933 59.7000 0.5768 59.8980 0.5768 60.0000 0.6007 60.1980 0.6007 60.3000 0.6082 60.4980 0.6082 60.6000 0.5745 60.7980 0.5745 60.9000 0.5786 61.0980 0.5786 61.2000 0.5559 61.3980 0.5559 61.5000 0.6088 61.6980 0.6088 61.8000 0.5452 61.9980 0.5452 62.1000 0.5821 62.2980 0.5821 62.4000 0.5732 62.5980 0.5732 62.7000 0.6057 62.8980 0.6057 63.0000 0.5458 63.1980 0.5458 63.3000 0.6020 63.4980 0.6020 63.6000 0.5708 63.7980 0.5708 63.9000 0.5164 64.0980 0.5164 64.2000 0.5718 64.3980 0.5718 64.5000 0.5754 64.6980 0.5754 64.8000 0.3000 64.9980 0.3000 65.1000 0.4885 65.2980 0.4885 65.4000 0.4856 65.5980 0.4856 65.7000 0.3954 65.8980 0.3954 66.0000 0.3627 66.1980 0.3627 66.3000 0.3323 66.4980 0.3323 66.6000 0.3675 66.7980 0.3675 66.9000 0.5095 67.0980 0.5095 67.2000 0.3615 67.3980 0.3615 67.5000 0.3139 67.6980 0.3139 67.8000 0.5457 67.9980 0.5457 68.1000 0.3702 68.2980 0.3702 68.4000 0.4044 68.5980 0.4044 68.7000 0.4060 68.8980 0.4060 69.0000 0.4588 69.1980 0.4588 69.3000 0.3712 69.4980 0.3712 69.6000 0.3843 69.7980 0.3843 69.9000 0.3918 70.0980 0.3918 70.2000 0.3234 70.3980 0.3234 70.5000 0.4569 70.6980 0.4569 70.8000 0.3840 70.9980 0.3840 71.1000 0.5142 71.2980 0.5142 71.4000 0.4370 71.5980 0.4370 71.7000 0.4637 71.8980 0.4637 72.0000 0.5412 72.1980 0.5412 72.3000 0.5887 72.4980 0.5887 72.6000 0.5985 72.7980 0.5985 72.9000 0.5033 73.0980 0.5033 73.2000 0.5913 73.3980 0.5913 73.5000 0.6190 73.6980 0.6190 73.8000 0.5692 73.9980 0.5692 74.1000 0.5961 74.2980 0.5961 74.4000 0.6150 74.5980 0.6150 74.7000 0.5696 74.8980 0.5696 75.0000 0.6065 75.1980 0.6065 75.3000 0.6194 75.4980 0.6194 75.6000 0.5673 75.7980 0.5673 75.9000 0.6056 76.0980 0.6056 76.2000 0.5477 76.3980 0.5477 76.5000 0.5860 76.6980 0.5860 76.8000 0.5723 76.9980 0.5723 77.1000 0.6247 77.2980 0.6247 77.4000 0.5668 77.5980 0.5668 77.7000 0.5998 77.8980 0.5998 78.0000 0.5790 78.1980 0.5790 78.3000 0.6068 78.4980 0.6068 78.6000 0.5960 78.7980 0.5960 78.9000 0.6236 79.0980 0.6236 79.2000 0.5892 79.3980 0.5892 79.5000 0.6006 79.6980 0.6006 79.8000 0.5595 79.9980 0.5595 80.1000 0.5968 80.2980 0.5968 80.4000 0.5883 80.5980 0.5883 80.7000 0.6004 80.8980 0.6004 81.0000 0.5933 81.1980 0.5933 81.3000 0.5768 81.4980 0.5768 81.6000 0.6007 81.7980 0.6007 81.9000 0.6082 82.0980 0.6082 82.2000 0.5745 82.3980 0.5745 82.5000 0.5786 82.6980 0.5786 82.8000 0.5559 82.9980 0.5559 83.1000 0.6088 83.2980 0.6088 83.4000 0.5452 83.5980 0.5452 83.7000 0.5821 83.8980 0.5821 84.0000 0.5732 84.1980 0.5732 84.3000 0.6057 84.4980 0.6057 84.6000 0.5458 84.7980 0.5458 84.9000 0.6020 85.0980 0.6020 85.2000 0.5708 85.3980 0.5708 85.5000 0.5164 85.6980 0.5164 85.8000 0.5718 85.9980 0.5718 86.1000 0.5754 86.2980 0.5754 86.4000 0.3000 86.5980 0.3000 86.7000 0.4885 86.8980 0.4885 87.0000 0.4856 87.1980 0.4856 87.3000 0.3954 87.4980 0.3954 87.6000 0.3627 87.7980 0.3627 87.9000 0.3323 88.0980 0.3323 88.2000 0.3675 88.3980 0.3675 88.5000 0.5095 88.6980 0.5095 88.8000 0.3615 88.9980 0.3615 89.1000 0.3139 89.2980 0.3139 89.4000 0.5457 89.5980 0.5457 89.7000 0.3702 89.8980 0.3702 90.0000 0.4044 90.1980 0.4044 90.3000 0.4060 90.4980 0.4060 90.6000 0.4588 90.7980 0.4588 90.9000 0.3712 91.0980 0.3712 91.2000 0.3843 91.3980 0.3843 91.5000 0.3918 91.6980 0.3918 91.8000 0.3234 91.9980 0.3234 92.1000 0.4569 92.2980 0.4569 92.4000 0.3840 92.5980 0.3840 92.7000 0.5142 92.8980 0.5142 93.0000 0.4370 93.1980 0.4370 93.3000 0.4637 93.4980 0.4637 93.6000 0.5412 93.7980 0.5412 93.9000 0.5887 94.0980 0.5887 94.2000 0.5985 94.3980 0.5985 94.5000 0.5033 94.6980 0.5033 94.8000 0.5913 94.9980 0.5913 95.1000 0.6190 95.2980 0.6190 95.4000 0.5692 95.5980 0.5692 95.7000 0.5961 95.8980 0.5961 96.0000 0.6150 96.1980 0.6150 96.3000 0.5696 96.4980 0.5696 96.6000 0.6065 96.7980 0.6065 96.9000 0.6194 97.0980 0.6194 97.2000 0.5673 97.3980 0.5673 97.5000 0.6056 97.6980 0.6056 97.8000 0.5477 97.9980 0.5477 98.1000 0.5860 98.2980 0.5860 98.4000 0.5723 98.5980 0.5723 98.7000 0.6247 98.8980 0.6247 99.0000 0.5668 99.1980 0.5668 99.3000 0.5998 99.4980 0.5998 99.6000 0.5790 99.7980 0.5790 99.9000 0.6068 100.0980 0.6068 100.2000 0.5960 100.3980 0.5960 100.5000 0.6236 100.6980 0.6236 100.8000 0.5892 100.9980 0.5892 101.1000 0.6006 101.2980 0.6006 101.4000 0.5595 101.5980 0.5595 101.7000 0.5968 101.8980 0.5968 102.0000 0.5883 102.1980 0.5883 102.3000 0.6004 102.4980 0.6004 102.6000 0.5933 102.7980 0.5933 102.9000 0.5768 103.0980 0.5768 103.2000 0.6007 103.3980 0.6007 103.5000 0.6082 103.6980 0.6082 103.8000 0.5745 103.9980 0.5745 104.1000 0.5786 104.2980 0.5786 104.4000 0.5559 104.5980 0.5559 104.7000 0.6088 104.8980 0.6088 105.0000 0.5452 105.1980 0.5452 105.3000 0.5821 105.4980 0.5821 105.6000 0.5732 105.7980 0.5732 105.9000 0.6057 106.0980 0.6057 106.2000 0.5458 106.3980 0.5458 106.5000 0.6020 106.6980 0.6020 106.8000 0.5708 106.9980 0.5708 107.1000 0.5164 107.2980 0.5164 107.4000 0.5718 107.5980 0.5718 107.7000 0.5754 107.8980 0.5754 108.0000 0.3000 108.1980 0.3000 108.3000 0.4885 108.4980 0.4885 108.6000 0.4856 108.7980 0.4856 108.9000 0.3954 109.0980 0.3954 109.2000 0.3627 109.3980 0.3627 109.5000 0.3323 109.6980 0.3323 109.8000 0.3675 109.9980 0.3675 110.1000 0.5095 110.2980 0.5095 110.4000 0.3615 110.5980 0.3615 110.7000 0.3139 110.8980 0.3139 111.0000 0.5457 111.1980 0.5457 111.3000 0.3702 111.4980 0.3702 111.6000 0.4044 111.7980 0.4044 111.9000 0.4060 112.0980 0.4060 112.2000 0.4588 112.3980 0.4588 112.5000 0.3712 112.6980 0.3712 112.8000 0.3843 112.9980 0.3843 113.1000 0.3918 113.2980 0.3918 113.4000 0.3234 113.5980 0.3234 113.7000 0.4569 113.8980 0.4569 114.0000 0.3840 114.1980 0.3840 114.3000 0.5142 114.4980 0.5142 114.6000 0.4370 114.7980 0.4370 114.9000 0.4637 115.0980 0.4637 115.2000 0.5412 115.3980 0.5412 115.5000 0.5887 115.6980 0.5887 115.8000 0.5985 115.9980 0.5985 116.1000 0.5033 116.2980 0.5033 116.4000 0.5913 116.5980 0.5913 116.7000 0.6190 116.8980 0.6190 117.0000 0.5692 117.1980 0.5692 117.3000 0.5961 117.4980 0.5961 117.6000 0.6150 117.7980 0.6150 117.9000 0.5696 118.0980 0.5696 118.2000 0.6065 118.3980 0.6065 118.5000 0.6194 118.6980 0.6194 118.8000 0.5673 118.9980 0.5673 119.1000 0.6056 119.2980 0.6056 119.4000 0.5477 119.5980 0.5477 119.7000 0.5860 119.8980 0.5860 120.0000 0.5723 120.1980 0.5723 120.3000 0.6247 120.4980 0.6247 120.6000 0.5668 120.7980 0.5668 120.9000 0.5998 121.0980 0.5998 121.2000 0.5790 121.3980 0.5790 121.5000 0.6068 121.6980 0.6068 121.8000 0.5960 121.9980 0.5960 122.1000 0.6236 122.2980 0.6236 122.4000 0.5892 122.5980 0.5892 122.7000 0.6006 122.8980 0.6006 123.0000 0.5595 123.1980 0.5595 123.3000 0.5968 123.4980 0.5968 123.6000 0.5883 123.7980 0.5883 123.9000 0.6004 124.0980 0.6004 124.2000 0.5933 124.3980 0.5933 124.5000 0.5768 124.6980 0.5768 124.8000 0.6007 124.9980 0.6007 125.1000 0.6082 125.2980 0.6082 125.4000 0.5745 125.5980 0.5745 125.7000 0.5786 125.8980 0.5786 126.0000 0.5559 126.1980 0.5559 126.3000 0.6088 126.4980 0.6088 126.6000 0.5452 126.7980 0.5452 126.9000 0.5821 127.0980 0.5821 127.2000 0.5732 127.3980 0.5732 127.5000 0.6057 127.6980 0.6057 127.8000 0.5458 127.9980 0.5458 128.1000 0.6020 128.2980 0.6020 128.4000 0.5708 128.5980 0.5708 128.7000 0.5164 128.8980 0.5164 129.0000 0.5718 129.1980 0.5718 129.3000 0.5754 129.4980 0.5754 129.6000 0.3000 129.7980 0.3000 129.9000 0.4885 130.0980 0.4885 130.2000 0.4856 130.3980 0.4856 130.5000 0.3954 130.6980 0.3954 130.8000 0.3627 130.9980 0.3627 131.1000 0.3323 131.2980 0.3323 131.4000 0.3675 131.5980 0.3675 131.7000 0.5095 131.8980 0.5095 132.0000 0.3615 132.1980 0.3615 132.3000 0.3139 132.4980 0.3139 132.6000 0.5457 132.7980 0.5457 132.9000 0.3702 133.0980 0.3702 133.2000 0.4044 133.3980 0.4044 133.5000 0.4060 133.6980 0.4060 133.8000 0.4588 133.9980 0.4588 134.1000 0.3712 134.2980 0.3712 134.4000 0.3843 134.5980 0.3843 134.7000 0.3918 134.8980 0.3918 135.0000 0.3234 135.1980 0.3234 135.3000 0.4569 135.4980 0.4569 135.6000 0.3840 135.7980 0.3840 135.9000 0.5142 136.0980 0.5142 136.2000 0.4370 136.3980 0.4370 136.5000 0.4637 136.6980 0.4637 136.8000 0.5412 136.9980 0.5412 137.1000 0.5887 137.2980 0.5887 137.4000 0.5985 137.5980 0.5985 137.7000 0.5033 137.8980 0.5033 138.0000 0.5913 138.1980 0.5913 138.3000 0.6190 138.4980 0.6190 138.6000 0.5692 138.7980 0.5692 138.9000 0.5961 139.0980 0.5961 139.2000 0.6150 139.3980 0.6150 139.5000 0.5696 139.6980 0.5696 139.8000 0.6065 139.9980 0.6065 140.1000 0.6194 140.2980 0.6194 140.4000 0.5673 140.5980 0.5673 140.7000 0.6056 140.8980 0.6056 141.0000 0.5477 141.1980 0.5477 141.3000 0.5860 141.4980 0.5860 141.6000 0.5723 141.7980 0.5723 141.9000 0.6247 142.0980 0.6247 142.2000 0.5668 142.3980 0.5668 142.5000 0.5998 142.6980 0.5998 142.8000 0.5790 142.9980 0.5790 143.1000 0.6068 143.2980 0.6068 143.4000 0.5960 143.5980 0.5960 143.7000 0.6236 143.8980 0.6236 144.0000 0.5892 144.1980 0.5892 144.3000 0.6006 144.4980 0.6006 144.6000 0.5595 144.7980 0.5595 144.9000 0.5968 145.0980 0.5968 145.2000 0.5883 145.3980 0.5883 145.5000 0.6004 145.6980 0.6004 145.8000 0.5933 145.9980 0.5933 146.1000 0.5768 146.2980 0.5768 146.4000 0.6007 146.5980 0.6007 146.7000 0.6082 146.8980 0.6082 147.0000 0.5745 147.1980 0.5745 147.3000 0.5786 147.4980 0.5786 147.6000 0.5559 147.7980 0.5559 147.9000 0.6088 148.0980 0.6088 148.2000 0.5452 148.3980 0.5452 148.5000 0.5821 148.6980 0.5821 148.8000 0.5732 148.9980 0.5732 149.1000 0.6057 149.2980 0.6057 149.4000 0.5458 149.5980 0.5458 149.7000 0.6020 149.8980 0.6020 150.0000 0.5708 150.1980 0.5708 150.3000 0.5164 150.4980 0.5164 150.6000 0.5718 150.7980 0.5718 150.9000 0.5754 151.0980 0.5754 151.2000 0.3000 151.3980 0.3000 151.5000 0.4885 151.6980 0.4885 151.8000 0.4856 151.9980 0.4856 152.1000 0.3954 152.2980 0.3954 152.4000 0.3627 152.5980 0.3627 152.7000 0.3323 152.8980 0.3323 153.0000 0.3675 153.1980 0.3675 153.3000 0.5095 153.4980 0.5095 153.6000 0.3615 153.7980 0.3615 153.9000 0.3139 154.0980 0.3139 154.2000 0.5457 154.3980 0.5457 154.5000 0.3702 154.6980 0.3702 154.8000 0.4044 154.9980 0.4044 155.1000 0.4060 155.2980 0.4060 155.4000 0.4588 155.5980 0.4588 155.7000 0.3712 155.8980 0.3712 156.0000 0.3843 156.1980 0.3843 156.3000 0.3918 156.4980 0.3918 156.6000 0.3234 156.7980 0.3234 156.9000 0.4569 157.0980 0.4569 157.2000 0.3840 157.3980 0.3840 157.5000 0.5142 157.6980 0.5142 157.8000 0.4370 157.9980 0.4370 158.1000 0.4637 158.2980 0.4637 158.4000 0.5412 158.5980 0.5412 158.7000 0.5887 158.8980 0.5887 159.0000 0.5985 159.1980 0.5985 159.3000 0.5033 159.4980 0.5033 159.6000 0.5913 159.7980 0.5913 159.9000 0.6190 160.0980 0.6190 160.2000 0.5692 160.3980 0.5692 160.5000 0.5961 160.6980 0.5961 160.8000 0.6150 160.9980 0.6150 161.1000 0.5696 161.2980 0.5696 161.4000 0.6065 161.5980 0.6065 161.7000 0.6194 161.8980 0.6194 162.0000 0.5673 162.1980 0.5673 162.3000 0.6056 162.4980 0.6056 162.6000 0.5477 162.7980 0.5477 162.9000 0.5860 163.0980 0.5860 163.2000 0.5723 163.3980 0.5723 163.5000 0.6247 163.6980 0.6247 163.8000 0.5668 163.9980 0.5668 164.1000 0.5998 164.2980 0.5998 164.4000 0.5790 164.5980 0.5790 164.7000 0.6068 164.8980 0.6068 165.0000 0.5960 165.1980 0.5960 165.3000 0.6236 165.4980 0.6236 165.6000 0.5892 165.7980 0.5892 165.9000 0.6006 166.0980 0.6006 166.2000 0.5595 166.3980 0.5595 166.5000 0.5968 166.6980 0.5968 166.8000 0.5883 166.9980 0.5883 167.1000 0.6004 167.2980 0.6004 167.4000 0.5933 167.5980 0.5933 167.7000 0.5768 167.8980 0.5768 168.0000 0.6007 168.1980 0.6007 168.3000 0.6082 168.4980 0.6082 168.6000 0.5745 168.7980 0.5745 168.9000 0.5786 169.0980 0.5786 169.2000 0.5559 169.3980 0.5559 169.5000 0.6088 169.6980 0.6088 169.8000 0.5452 169.9980 0.5452 170.1000 0.5821 170.2980 0.5821 170.4000 0.5732 170.5980 0.5732 170.7000 0.6057 170.8980 0.6057 171.0000 0.5458 171.1980 0.5458 171.3000 0.6020 171.4980 0.6020 171.6000 0.5708 171.7980 0.5708 171.9000 0.5164 172.0980 0.5164 172.2000 0.5718 172.3980 0.5718 172.5000 0.5754 172.6980 0.5754 172.8000 0.3000 172.9980 0.3000 173.1000 0.4885 173.2980 0.4885 173.4000 0.4856 173.5980 0.4856 173.7000 0.3954 173.8980 0.3954 174.0000 0.3627 174.1980 0.3627 174.3000 0.3323 174.4980 0.3323 174.6000 0.3675 174.7980 0.3675 174.9000 0.5095 175.0980 0.5095 175.2000 0.3615 175.3980 0.3615 175.5000 0.3139 175.6980 0.3139 175.8000 0.5457 175.9980 0.5457 176.1000 0.3702 176.2980 0.3702 176.4000 0.4044 176.5980 0.4044 176.7000 0.4060 176.8980 0.4060 177.0000 0.4588 177.1980 0.4588 177.3000 0.3712 177.4980 0.3712 177.6000 0.3843 177.7980 0.3843 177.9000 0.3918 178.0980 0.3918 178.2000 0.3234 178.3980 0.3234 178.5000 0.4569 178.6980 0.4569 178.8000 0.3840 178.9980 0.3840 179.1000 0.5142 179.2980 0.5142 179.4000 0.4370 179.5980 0.4370 179.7000 0.4637 179.8980 0.4637 180.0000 0.5412 180.1980 0.5412 180.3000 0.5887 180.4980 0.5887 180.6000 0.5985 180.7980 0.5985 180.9000 0.5033 181.0980 0.5033 181.2000 0.5913 181.3980 0.5913 181.5000 0.6190 181.6980 0.6190 181.8000 0.5692 181.9980 0.5692 182.1000 0.5961 182.2980 0.5961 182.4000 0.6150 182.5980 0.6150 182.7000 0.5696 182.8980 0.5696 183.0000 0.6065 183.1980 0.6065 183.3000 0.6194 183.4980 0.6194 183.6000 0.5673 183.7980 0.5673 183.9000 0.6056 184.0980 0.6056 184.2000 0.5477 184.3980 0.5477 184.5000 0.5860 184.6980 0.5860 184.8000 0.5723 184.9980 0.5723 185.1000 0.6247 185.2980 0.6247 185.4000 0.5668 185.5980 0.5668 185.7000 0.5998 185.8980 0.5998 186.0000 0.5790 186.1980 0.5790 186.3000 0.6068 186.4980 0.6068 186.6000 0.5960 186.7980 0.5960 186.9000 0.6236 187.0980 0.6236 187.2000 0.5892 187.3980 0.5892 187.5000 0.6006 187.6980 0.6006 187.8000 0.5595 187.9980 0.5595 188.1000 0.5968 188.2980 0.5968 188.4000 0.5883 188.5980 0.5883 188.7000 0.6004 188.8980 0.6004 189.0000 0.5933 189.1980 0.5933 189.3000 0.5768 189.4980 0.5768 189.6000 0.6007 189.7980 0.6007 189.9000 0.6082 190.0980 0.6082 190.2000 0.5745 190.3980 0.5745 190.5000 0.5786 190.6980 0.5786 190.8000 0.5559 190.9980 0.5559 191.1000 0.6088 191.2980 0.6088 191.4000 0.5452 191.5980 0.5452 191.7000 0.5821 191.8980 0.5821 192.0000 0.5732 192.1980 0.5732 192.3000 0.6057 192.4980 0.6057 192.6000 0.5458 192.7980 0.5458 192.9000 0.6020 193.0980 0.6020 193.2000 0.5708 193.3980 0.5708 193.5000 0.5164 193.6980 0.5164 193.8000 0.5718 193.9980 0.5718 194.1000 0.5754 194.2980 0.5754 194.4000 0.3000 194.5980 0.3000 194.7000 0.4885 194.8980 0.4885 195.0000 0.4856 195.1980 0.4856 195.3000 0.3954 195.4980 0.3954 195.6000 0.3627 195.7980 0.3627 195.9000 0.3323 196.0980 0.3323 196.2000 0.3675 196.3980 0.3675 196.5000 0.5095 196.6980 0.5095 196.8000 0.3615 196.9980 0.3615 197.1000 0.3139 197.2980 0.3139 197.4000 0.5457 197.5980 0.5457 197.7000 0.3702 197.8980 0.3702 198.0000 0.4044 198.1980 0.4044 198.3000 0.4060 198.4980 0.4060 198.6000 0.4588 198.7980 0.4588 198.9000 0.3712 199.0980 0.3712 199.2000 0.3843 199.3980 0.3843 199.5000 0.3918 199.6980 0.3918 199.8000 0.3234 199.9980 0.3234 200.1000 0.4569 200.2980 0.4569 200.4000 0.3840 200.5980 0.3840 200.7000 0.5142 200.8980 0.5142 201.0000 0.4370 201.1980 0.4370 201.3000 0.4637 201.4980 0.4637 201.6000 0.5412 201.7980 0.5412 201.9000 0.5887 202.0980 0.5887 202.2000 0.5985 202.3980 0.5985 202.5000 0.5033 202.6980 0.5033 202.8000 0.5913 202.9980 0.5913 203.1000 0.6190 203.2980 0.6190 203.4000 0.5692 203.5980 0.5692 203.7000 0.5961 203.8980 0.5961 204.0000 0.6150 204.1980 0.6150 204.3000 0.5696 204.4980 0.5696 204.6000 0.6065 204.7980 0.6065 204.9000 0.6194 205.0980 0.6194 205.2000 0.5673 205.3980 0.5673 205.5000 0.6056 205.6980 0.6056 205.8000 0.5477 205.9980 0.5477 206.1000 0.5860 206.2980 0.5860 206.4000 0.5723 206.5980 0.5723 206.7000 0.6247 206.8980 0.6247 207.0000 0.5668 207.1980 0.5668 207.3000 0.5998 207.4980 0.5998 207.6000 0.5790 207.7980 0.5790 207.9000 0.6068 208.0980 0.6068 208.2000 0.5960 208.3980 0.5960 208.5000 0.6236 208.6980 0.6236 208.8000 0.5892 208.9980 0.5892 209.1000 0.6006 209.2980 0.6006 209.4000 0.5595 209.5980 0.5595 209.7000 0.5968 209.8980 0.5968 210.0000 0.5883 210.1980 0.5883 210.3000 0.6004 210.4980 0.6004 210.6000 0.5933 210.7980 0.5933 210.9000 0.5768 211.0980 0.5768 211.2000 0.6007 211.3980 0.6007 211.5000 0.6082 211.6980 0.6082 211.8000 0.5745 211.9980 0.5745 212.1000 0.5786 212.2980 0.5786 212.4000 0.5559 212.5980 0.5559 212.7000 0.6088 212.8980 0.6088 213.0000 0.5452 213.1980 0.5452 213.3000 0.5821 213.4980 0.5821 213.6000 0.5732 213.7980 0.5732 213.9000 0.6057 214.0980 0.6057 214.2000 0.5458 214.3980 0.5458 214.5000 0.6020 214.6980 0.6020 214.8000 0.5708 214.9980 0.5708 215.1000 0.5164 215.2980 0.5164 215.4000 0.5718 215.5980 0.5718 215.7000 0.5754 215.8980 0.5754 216.0000 0.3000 216.1980 0.3000 216.3000 0.4885 216.4980 0.4885 216.6000 0.4856 216.7980 0.4856 216.9000 0.3954 217.0980 0.3954 217.2000 0.3627 217.3980 0.3627 217.5000 0.3323 217.6980 0.3323 217.8000 0.3675 217.9980 0.3675 218.1000 0.5095 218.2980 0.5095 218.4000 0.3615 218.5980 0.3615 218.7000 0.3139 218.8980 0.3139 219.0000 0.5457 219.1980 0.5457 219.3000 0.3702 219.4980 0.3702 219.6000 0.4044 219.7980 0.4044 219.9000 0.4060 220.0980 0.4060 220.2000 0.4588 220.3980 0.4588 220.5000 0.3712 220.6980 0.3712 220.8000 0.3843 220.9980 0.3843 221.1000 0.3918 221.2980 0.3918 221.4000 0.3234 221.5980 0.3234 221.7000 0.4569 221.8980 0.4569 222.0000 0.3840 222.1980 0.3840 222.3000 0.5142 222.4980 0.5142 222.6000 0.4370 222.7980 0.4370 222.9000 0.4637 223.0980 0.4637 223.2000 0.5412 223.3980 0.5412 223.5000 0.5887 223.6980 0.5887 223.8000 0.5985 223.9980 0.5985 224.1000 0.5033 224.2980 0.5033 224.4000 0.5913 224.5980 0.5913 224.7000 0.6190 224.8980 0.6190 225.0000 0.5692 225.1980 0.5692 225.3000 0.5961 225.4980 0.5961 225.6000 0.6150 225.7980 0.6150 225.9000 0.5696 226.0980 0.5696 226.2000 0.6065 226.3980 0.6065 226.5000 0.6194 226.6980 0.6194 226.8000 0.5673 226.9980 0.5673 227.1000 0.6056 227.2980 0.6056 227.4000 0.5477 227.5980 0.5477 227.7000 0.5860 227.8980 0.5860 228.0000 0.5723 228.1980 0.5723 228.3000 0.6247 228.4980 0.6247 228.6000 0.5668 228.7980 0.5668 228.9000 0.5998 229.0980 0.5998 229.2000 0.5790 229.3980 0.5790 229.5000 0.6068 229.6980 0.6068 229.8000 0.5960 229.9980 0.5960 230.1000 0.6236 230.2980 0.6236 230.4000 0.5892 230.5980 0.5892 230.7000 0.6006 230.8980 0.6006 231.0000 0.5595 231.1980 0.5595 231.3000 0.5968 231.4980 0.5968 231.6000 0.5883 231.7980 0.5883 231.9000 0.6004 232.0980 0.6004 232.2000 0.5933 232.3980 0.5933 232.5000 0.5768 232.6980 0.5768 232.8000 0.6007 232.9980 0.6007 233.1000 0.6082 233.2980 0.6082 233.4000 0.5745 233.5980 0.5745 233.7000 0.5786 233.8980 0.5786 234.0000 0.5559 234.1980 0.5559 234.3000 0.6088 234.4980 0.6088 234.6000 0.5452 234.7980 0.5452 234.9000 0.5821 235.0980 0.5821 235.2000 0.5732 235.3980 0.5732 235.5000 0.6057 235.6980 0.6057 235.8000 0.5458 235.9980 0.5458 236.1000 0.6020 236.2980 0.6020 236.4000 0.5708 236.5980 0.5708 236.7000 0.5164 236.8980 0.5164 237.0000 0.5718 237.1980 0.5718 237.3000 0.5754 237.4980 0.5754 237.6000 0.3000 237.7980 0.3000 237.9000 0.4885 238.0980 0.4885 238.2000 0.4856 238.3980 0.4856 238.5000 0.3954 238.6980 0.3954 238.8000 0.3627 238.9980 0.3627 239.1000 0.3323 239.2980 0.3323 239.4000 0.3675 239.5980 0.3675 239.7000 0.5095 239.8980 0.5095 240.0000 0.3615 240.1980 0.3615 240.3000 0.3139 240.4980 0.3139 240.6000 0.5457 240.7980 0.5457 240.9000 0.3702 241.0980 0.3702 241.2000 0.4044 241.3980 0.4044 241.5000 0.4060 241.6980 0.4060 241.8000 0.4588 241.9980 0.4588 242.1000 0.3712 242.2980 0.3712 242.4000 0.3843 242.5980 0.3843 242.7000 0.3918 242.8980 0.3918 243.0000 0.3234 243.1980 0.3234 243.3000 0.4569 243.4980 0.4569 243.6000 0.3840 243.7980 0.3840 243.9000 0.5142 244.0980 0.5142 244.2000 0.4370 244.3980 0.4370 244.5000 0.4637 244.6980 0.4637 244.8000 0.5412 244.9980 0.5412 245.1000 0.5887 245.2980 0.5887 245.4000 0.5985 245.5980 0.5985 245.7000 0.5033 245.8980 0.5033 246.0000 0.5913 246.1980 0.5913 246.3000 0.6190 246.4980 0.6190 246.6000 0.5692 246.7980 0.5692 246.9000 0.5961 247.0980 0.5961 247.2000 0.6150 247.3980 0.6150 247.5000 0.5696 247.6980 0.5696 247.8000 0.6065 247.9980 0.6065 248.1000 0.6194 248.2980 0.6194 248.4000 0.5673 248.5980 0.5673 248.7000 0.6056 248.8980 0.6056 249.0000 0.5477 249.1980 0.5477 249.3000 0.5860 249.4980 0.5860 249.6000 0.5723 249.7980 0.5723 249.9000 0.6247 250.0980 0.6247 250.2000 0.5668 250.3980 0.5668 250.5000 0.5998 250.6980 0.5998 250.8000 0.5790 250.9980 0.5790 251.1000 0.6068 251.2980 0.6068 251.4000 0.5960 251.5980 0.5960 251.7000 0.6236 251.8980 0.6236 252.0000 0.5892 252.1980 0.5892 252.3000 0.6006 252.4980 0.6006 252.6000 0.5595 252.7980 0.5595 252.9000 0.5968 253.0980 0.5968 253.2000 0.5883 253.3980 0.5883 253.5000 0.6004 253.6980 0.6004 253.8000 0.5933 253.9980 0.5933 254.1000 0.5768 254.2980 0.5768 254.4000 0.6007 254.5980 0.6007 254.7000 0.6082 254.8980 0.6082 255.0000 0.5745 255.1980 0.5745 255.3000 0.5786 255.4980 0.5786 255.6000 0.5559 255.7980 0.5559 255.9000 0.6088 256.0980 0.6088 256.2000 0.5452 256.3980 0.5452 256.5000 0.5821 256.6980 0.5821 256.8000 0.5732 256.9980 0.5732 257.1000 0.6057 257.2980 0.6057 257.4000 0.5458 257.5980 0.5458 257.7000 0.6020 257.8980 0.6020 258.0000 0.5708 258.1980 0.5708 258.3000 0.5164 258.4980 0.5164 258.6000 0.5718 258.7980 0.5718 258.9000 0.5754 259.0980 0.5754 259.2000 0.3000 259.3980 0.3000 259.5000 0.4885 259.6980 0.4885 259.8000 0.4856 259.9980 0.4856 260.1000 0.3954 260.2980 0.3954 260.4000 0.3627 260.5980 0.3627 260.7000 0.3323 260.8980 0.3323 261.0000 0.3675 261.1980 0.3675 261.3000 0.5095 261.4980 0.5095 261.6000 0.3615 261.7980 0.3615 261.9000 0.3139 262.0980 0.3139 262.2000 0.5457 262.3980 0.5457 262.5000 0.3702 262.6980 0.3702 262.8000 0.4044 262.9980 0.4044 263.1000 0.4060 263.2980 0.4060 263.4000 0.4588 263.5980 0.4588 263.7000 0.3712 263.8980 0.3712 264.0000 0.3843 264.1980 0.3843 264.3000 0.3918 264.4980 0.3918 264.6000 0.3234 264.7980 0.3234 264.9000 0.4569 265.0980 0.4569 265.2000 0.3840 265.3980 0.3840 265.5000 0.5142 265.6980 0.5142 265.8000 0.4370 265.9980 0.4370 266.1000 0.4637 266.2980 0.4637 266.4000 0.5412 266.5980 0.5412 266.7000 0.5887 266.8980 0.5887 267.0000 0.5985 267.1980 0.5985 267.3000 0.5033 267.4980 0.5033 267.6000 0.5913 267.7980 0.5913 267.9000 0.6190 268.0980 0.6190 268.2000 0.5692 268.3980 0.5692 268.5000 0.5961 268.6980 0.5961 268.8000 0.6150 268.9980 0.6150 269.1000 0.5696 269.2980 0.5696 269.4000 0.6065 269.5980 0.6065 269.7000 0.6194 269.8980 0.6194 270.0000 0.5673 270.1980 0.5673 270.3000 0.6056 270.4980 0.6056 270.6000 0.5477 270.7980 0.5477 270.9000 0.5860 271.0980 0.5860 271.2000 0.5723 271.3980 0.5723 271.5000 0.6247 271.6980 0.6247 271.8000 0.5668 271.9980 0.5668 272.1000 0.5998 272.2980 0.5998 272.4000 0.5790 272.5980 0.5790 272.7000 0.6068 272.8980 0.6068 273.0000 0.5960 273.1980 0.5960 273.3000 0.6236 273.4980 0.6236 273.6000 0.5892 273.7980 0.5892 273.9000 0.6006 274.0980 0.6006 274.2000 0.5595 274.3980 0.5595 274.5000 0.5968 274.6980 0.5968 274.8000 0.5883 274.9980 0.5883 275.1000 0.6004 275.2980 0.6004 275.4000 0.5933 275.5980 0.5933 275.7000 0.5768 275.8980 0.5768 276.0000 0.6007 276.1980 0.6007 276.3000 0.6082 276.4980 0.6082 276.6000 0.5745 276.7980 0.5745 276.9000 0.5786 277.0980 0.5786 277.2000 0.5559 277.3980 0.5559 277.5000 0.6088 277.6980 0.6088 277.8000 0.5452 277.9980 0.5452 278.1000 0.5821 278.2980 0.5821 278.4000 0.5732 278.5980 0.5732 278.7000 0.6057 278.8980 0.6057 279.0000 0.5458 279.1980 0.5458 279.3000 0.6020 279.4980 0.6020 279.6000 0.5708 279.7980 0.5708 279.9000 0.5164 280.0980 0.5164 280.2000 0.5718 280.3980 0.5718 280.5000 0.5754 280.6980 0.5754 280.8000 0.3000 280.9980 0.3000 281.1000 0.4885 281.2980 0.4885 281.4000 0.4856 281.5980 0.4856 281.7000 0.3954 281.8980 0.3954 282.0000 0.3627 282.1980 0.3627 282.3000 0.3323 282.4980 0.3323 282.6000 0.3675 282.7980 0.3675 282.9000 0.5095 283.0980 0.5095 283.2000 0.3615 283.3980 0.3615 283.5000 0.3139 283.6980 0.3139 283.8000 0.5457 283.9980 0.5457 284.1000 0.3702 284.2980 0.3702 284.4000 0.4044 284.5980 0.4044 284.7000 0.4060 284.8980 0.4060 285.0000 0.4588 285.1980 0.4588 285.3000 0.3712 285.4980 0.3712 285.6000 0.3843 285.7980 0.3843 285.9000 0.3918 286.0980 0.3918 286.2000 0.3234 286.3980 0.3234 286.5000 0.4569 286.6980 0.4569 286.8000 0.3840 286.9980 0.3840 287.1000 0.5142 287.2980 0.5142 287.4000 0.4370 287.5980 0.4370 287.7000 0.4637 287.8980 0.4637 288.0000 0.5412 288.1980 0.5412 288.3000 0.5887 288.4980 0.5887 288.6000 0.5985 288.7980 0.5985 288.9000 0.5033 289.0980 0.5033 289.2000 0.5913 289.3980 0.5913 289.5000 0.6190 289.6980 0.6190 289.8000 0.5692 289.9980 0.5692 290.1000 0.5961 290.2980 0.5961 290.4000 0.6150 290.5980 0.6150 290.7000 0.5696 290.8980 0.5696 291.0000 0.6065 291.1980 0.6065 291.3000 0.6194 291.4980 0.6194 291.6000 0.5673 291.7980 0.5673 291.9000 0.6056 292.0980 0.6056 292.2000 0.5477 292.3980 0.5477 292.5000 0.5860 292.6980 0.5860 292.8000 0.5723 292.9980 0.5723 293.1000 0.6247 293.2980 0.6247 293.4000 0.5668 293.5980 0.5668 293.7000 0.5998 293.8980 0.5998 294.0000 0.5790 294.1980 0.5790 294.3000 0.6068 294.4980 0.6068 294.6000 0.5960 294.7980 0.5960 294.9000 0.6236 295.0980 0.6236 295.2000 0.5892 295.3980 0.5892 295.5000 0.6006 295.6980 0.6006 295.8000 0.5595 295.9980 0.5595 296.1000 0.5968 296.2980 0.5968 296.4000 0.5883 296.5980 0.5883 296.7000 0.6004 296.8980 0.6004 297.0000 0.5933 297.1980 0.5933 297.3000 0.5768 297.4980 0.5768 297.6000 0.6007 297.7980 0.6007 297.9000 0.6082 298.0980 0.6082 298.2000 0.5745 298.3980 0.5745 298.5000 0.5786 298.6980 0.5786 298.8000 0.5559 298.9980 0.5559 299.1000 0.6088 299.2980 0.6088 299.4000 0.5452 299.5980 0.5452 299.7000 0.5821 299.8980 0.5821 300.0000 0.5732 300.1980 0.5732 300.3000 0.6057 300.4980 0.6057 300.6000 0.5458 300.7980 0.5458 300.9000 0.6020 301.0980 0.6020 301.2000 0.5708 301.3980 0.5708 301.5000 0.5164 301.6980 0.5164 301.8000 0.5718 301.9980 0.5718 302.1000 0.5754 302.2980 0.5754 302.4000 0.3000 302.5980 0.3000 302.7000 0.4885 302.8980 0.4885 303.0000 0.4856 303.1980 0.4856 303.3000 0.3954 303.4980 0.3954 303.6000 0.3627 303.7980 0.3627 303.9000 0.3323 304.0980 0.3323 304.2000 0.3675 304.3980 0.3675 304.5000 0.5095 304.6980 0.5095 304.8000 0.3615 304.9980 0.3615 305.1000 0.3139 305.2980 0.3139 305.4000 0.5457 305.5980 0.5457 305.7000 0.3702 305.8980 0.3702 306.0000 0.4044 306.1980 0.4044 306.3000 0.4060 306.4980 0.4060 306.6000 0.4588 306.7980 0.4588 306.9000 0.3712 307.0980 0.3712 307.2000 0.3843 307.3980 0.3843 307.5000 0.3918 307.6980 0.3918 307.8000 0.3234 307.9980 0.3234 308.1000 0.4569 308.2980 0.4569 308.4000 0.3840 308.5980 0.3840 308.7000 0.5142 308.8980 0.5142 309.0000 0.4370 309.1980 0.4370 309.3000 0.4637 309.4980 0.4637 309.6000 0.5412 309.7980 0.5412 309.9000 0.5887 310.0980 0.5887 310.2000 0.5985 310.3980 0.5985 310.5000 0.5033 310.6980 0.5033 310.8000 0.5913 310.9980 0.5913 311.1000 0.6190 311.2980 0.6190 311.4000 0.5692 311.5980 0.5692 311.7000 0.5961 311.8980 0.5961 312.0000 0.6150 312.1980 0.6150 312.3000 0.5696 312.4980 0.5696 312.6000 0.6065 312.7980 0.6065 312.9000 0.6194 313.0980 0.6194 313.2000 0.5673 313.3980 0.5673 313.5000 0.6056 313.6980 0.6056 313.8000 0.5477 313.9980 0.5477 314.1000 0.5860 314.2980 0.5860 314.4000 0.5723 314.5980 0.5723 314.7000 0.6247 314.8980 0.6247 315.0000 0.5668 315.1980 0.5668 315.3000 0.5998 315.4980 0.5998 315.6000 0.5790 315.7980 0.5790 315.9000 0.6068 316.0980 0.6068 316.2000 0.5960 316.3980 0.5960 316.5000 0.6236 316.6980 0.6236 316.8000 0.5892 316.9980 0.5892 317.1000 0.6006 317.2980 0.6006 317.4000 0.5595 317.5980 0.5595 317.7000 0.5968 317.8980 0.5968 318.0000 0.5883 318.1980 0.5883 318.3000 0.6004 318.4980 0.6004 318.6000 0.5933 318.7980 0.5933 318.9000 0.5768 319.0980 0.5768 319.2000 0.6007 319.3980 0.6007 319.5000 0.6082 319.6980 0.6082 319.8000 0.5745 319.9980 0.5745 320.1000 0.5786 320.2980 0.5786 320.4000 0.5559 320.5980 0.5559 320.7000 0.6088 320.8980 0.6088 321.0000 0.5452 321.1980 0.5452 321.3000 0.5821 321.4980 0.5821 321.6000 0.5732 321.7980 0.5732 321.9000 0.6057 322.0980 0.6057 322.2000 0.5458 322.3980 0.5458 322.5000 0.6020 322.6980 0.6020 322.8000 0.5708 322.9980 0.5708 323.1000 0.5164 323.2980 0.5164 323.4000 0.5718 323.5980 0.5718 323.7000 0.5754 323.8980 0.5754 324.0000 0.3000 324.1980 0.3000 324.3000 0.4885 324.4980 0.4885 324.6000 0.4856 324.7980 0.4856 324.9000 0.3954 325.0980 0.3954 325.2000 0.3627 325.3980 0.3627 325.5000 0.3323 325.6980 0.3323 325.8000 0.3675 325.9980 0.3675 326.1000 0.5095 326.2980 0.5095 326.4000 0.3615 326.5980 0.3615 326.7000 0.3139 326.8980 0.3139 327.0000 0.5457 327.1980 0.5457 327.3000 0.3702 327.4980 0.3702 327.6000 0.4044 327.7980 0.4044 327.9000 0.4060 328.0980 0.4060 328.2000 0.4588 328.3980 0.4588 328.5000 0.3712 328.6980 0.3712 328.8000 0.3843 328.9980 0.3843 329.1000 0.3918 329.2980 0.3918 329.4000 0.3234 329.5980 0.3234 329.7000 0.4569 329.8980 0.4569 330.0000 0.3840 330.1980 0.3840 330.3000 0.5142 330.4980 0.5142 330.6000 0.4370 330.7980 0.4370 330.9000 0.4637 331.0980 0.4637 331.2000 0.5412 331.3980 0.5412 331.5000 0.5887 331.6980 0.5887 331.8000 0.5985 331.9980 0.5985 332.1000 0.5033 332.2980 0.5033 332.4000 0.5913 332.5980 0.5913 332.7000 0.6190 332.8980 0.6190 333.0000 0.5692 333.1980 0.5692 333.3000 0.5961 333.4980 0.5961 333.6000 0.6150 333.7980 0.6150 333.9000 0.5696 334.0980 0.5696 334.2000 0.6065 334.3980 0.6065 334.5000 0.6194 334.6980 0.6194 334.8000 0.5673 334.9980 0.5673 335.1000 0.6056 335.2980 0.6056 335.4000 0.5477 335.5980 0.5477 335.7000 0.5860 335.8980 0.5860 336.0000 0.5723 336.1980 0.5723 336.3000 0.6247 336.4980 0.6247 336.6000 0.5668 336.7980 0.5668 336.9000 0.5998 337.0980 0.5998 337.2000 0.5790 337.3980 0.5790 337.5000 0.6068 337.6980 0.6068 337.8000 0.5960 337.9980 0.5960 338.1000 0.6236 338.2980 0.6236 338.4000 0.5892 338.5980 0.5892 338.7000 0.6006 338.8980 0.6006 339.0000 0.5595 339.1980 0.5595 339.3000 0.5968 339.4980 0.5968 339.6000 0.5883 339.7980 0.5883 339.9000 0.6004 340.0980 0.6004 340.2000 0.5933 340.3980 0.5933 340.5000 0.5768 340.6980 0.5768 340.8000 0.6007 340.9980 0.6007 341.1000 0.6082 341.2980 0.6082 341.4000 0.5745 341.5980 0.5745 341.7000 0.5786 341.8980 0.5786 342.0000 0.5559 342.1980 0.5559 342.3000 0.6088 342.4980 0.6088 342.6000 0.5452 342.7980 0.5452 342.9000 0.5821 343.0980 0.5821 343.2000 0.5732 343.3980 0.5732 343.5000 0.6057 343.6980 0.6057 343.8000 0.5458 343.9980 0.5458 344.1000 0.6020 344.2980 0.6020 344.4000 0.5708 344.5980 0.5708 344.7000 0.5164 344.8980 0.5164 345.0000 0.5718 345.1980 0.5718 345.3000 0.5754 345.4980 0.5754 345.6000 0.3000 345.7980 0.3000 345.9000 0.4885 346.0980 0.4885 346.2000 0.4856 346.3980 0.4856 346.5000 0.3954 346.6980 0.3954 346.8000 0.3627 346.9980 0.3627 347.1000 0.3323 347.2980 0.3323 347.4000 0.3675 347.5980 0.3675 347.7000 0.5095 347.8980 0.5095 348.0000 0.3615 348.1980 0.3615 348.3000 0.3139 348.4980 0.3139 348.6000 0.5457 348.7980 0.5457 348.9000 0.3702 349.0980 0.3702 349.2000 0.4044 349.3980 0.4044 349.5000 0.4060 349.6980 0.4060 349.8000 0.4588 349.9980 0.4588 350.1000 0.3712 350.2980 0.3712 350.4000 0.3843 350.5980 0.3843 350.7000 0.3918 350.8980 0.3918 351.0000 0.3234 351.1980 0.3234 351.3000 0.4569 351.4980 0.4569 351.6000 0.3840 351.7980 0.3840 351.9000 0.5142 352.0980 0.5142 352.2000 0.4370 352.3980 0.4370 352.5000 0.4637 352.6980 0.4637 352.8000 0.5412 352.9980 0.5412 353.1000 0.5887 353.2980 0.5887 353.4000 0.5985 353.5980 0.5985 353.7000 0.5033 353.8980 0.5033 354.0000 0.5913 354.1980 0.5913 354.3000 0.6190 354.4980 0.6190 354.6000 0.5692 354.7980 0.5692 354.9000 0.5961 355.0980 0.5961 355.2000 0.6150 355.3980 0.6150 355.5000 0.5696 355.6980 0.5696 355.8000 0.6065 355.9980 0.6065 356.1000 0.6194 356.2980 0.6194 356.4000 0.5673 356.5980 0.5673 356.7000 0.6056 356.8980 0.6056 357.0000 0.5477 357.1980 0.5477 357.3000 0.5860 357.4980 0.5860 357.6000 0.5723 357.7980 0.5723 357.9000 0.6247 358.0980 0.6247 358.2000 0.5668 358.3980 0.5668 358.5000 0.5998 358.6980 0.5998 358.8000 0.5790 358.9980 0.5790 359.1000 0.6068 359.2980 0.6068 359.4000 0.5960 359.5980 0.5960 359.7000 0.6236 359.8980 0.6236 360.0000 0.5892 360.1980 0.5892 360.3000 0.6006 360.4980 0.6006 360.6000 0.5595 360.7980 0.5595 360.9000 0.5968 361.0980 0.5968 361.2000 0.5883 361.3980 0.5883 361.5000 0.6004 361.6980 0.6004 361.8000 0.5933 361.9980 0.5933 362.1000 0.5768 362.2980 0.5768 362.4000 0.6007 362.5980 0.6007 362.7000 0.6082 362.8980 0.6082 363.0000 0.5745 363.1980 0.5745 363.3000 0.5786 363.4980 0.5786 363.6000 0.5559 363.7980 0.5559 363.9000 0.6088 364.0980 0.6088 364.2000 0.5452 364.3980 0.5452 364.5000 0.5821 364.6980 0.5821 364.8000 0.5732 364.9980 0.5732 365.1000 0.6057 365.2980 0.6057 365.4000 0.5458 365.5980 0.5458 365.7000 0.6020 365.8980 0.6020 366.0000 0.5708 366.1980 0.5708 366.3000 0.5164 366.4980 0.5164 366.6000 0.5718 366.7980 0.5718 366.9000 0.5754 367.0980 0.5754 367.2000 0.3000 367.3980 0.3000 367.5000 0.4885 367.6980 0.4885 367.8000 0.4856 367.9980 0.4856 368.1000 0.3954 368.2980 0.3954 368.4000 0.3627 368.5980 0.3627 368.7000 0.3323 368.8980 0.3323 369.0000 0.3675 369.1980 0.3675 369.3000 0.5095 369.4980 0.5095 369.6000 0.3615 369.7980 0.3615 369.9000 0.3139 370.0980 0.3139 370.2000 0.5457 370.3980 0.5457 370.5000 0.3702 370.6980 0.3702 370.8000 0.4044 370.9980 0.4044 371.1000 0.4060 371.2980 0.4060 371.4000 0.4588 371.5980 0.4588 371.7000 0.3712 371.8980 0.3712 372.0000 0.3843 372.1980 0.3843 372.3000 0.3918 372.4980 0.3918 372.6000 0.3234 372.7980 0.3234 372.9000 0.4569 373.0980 0.4569 373.2000 0.3840 373.3980 0.3840 373.5000 0.5142 373.6980 0.5142 373.8000 0.4370 373.9980 0.4370 374.1000 0.4637 374.2980 0.4637 374.4000 0.5412 374.5980 0.5412 374.7000 0.5887 374.8980 0.5887 375.0000 0.5985 375.1980 0.5985 375.3000 0.5033 375.4980 0.5033 375.6000 0.5913 375.7980 0.5913 375.9000 0.6190 376.0980 0.6190 376.2000 0.5692 376.3980 0.5692 376.5000 0.5961 376.6980 0.5961 376.8000 0.6150 376.9980 0.6150 377.1000 0.5696 377.2980 0.5696 377.4000 0.6065 377.5980 0.6065 377.7000 0.6194 377.8980 0.6194 378.0000 0.5673 378.1980 0.5673 378.3000 0.6056 378.4980 0.6056 378.6000 0.5477 378.7980 0.5477 378.9000 0.5860 379.0980 0.5860 379.2000 0.5723 379.3980 0.5723 379.5000 0.6247 379.6980 0.6247 379.8000 0.5668 379.9980 0.5668 380.1000 0.5998 380.2980 0.5998 380.4000 0.5790 380.5980 0.5790 380.7000 0.6068 380.8980 0.6068 381.0000 0.5960 381.1980 0.5960 381.3000 0.6236 381.4980 0.6236 381.6000 0.5892 381.7980 0.5892 381.9000 0.6006 382.0980 0.6006 382.2000 0.5595 382.3980 0.5595 382.5000 0.5968 382.6980 0.5968 382.8000 0.5883 382.9980 0.5883 383.1000 0.6004 383.2980 0.6004 383.4000 0.5933 383.5980 0.5933 383.7000 0.5768 383.8980 0.5768 384.0000 0.6007 384.1980 0.6007 384.3000 0.6082 384.4980 0.6082 384.6000 0.5745 384.7980 0.5745 384.9000 0.5786 385.0980 0.5786 385.2000 0.5559 385.3980 0.5559 385.5000 0.6088 385.6980 0.6088 385.8000 0.5452 385.9980 0.5452 386.1000 0.5821 386.2980 0.5821 386.4000 0.5732 386.5980 0.5732 386.7000 0.6057 386.8980 0.6057 387.0000 0.5458 387.1980 0.5458 387.3000 0.6020 387.4980 0.6020 387.6000 0.5708 387.7980 0.5708 387.9000 0.5164 388.0980 0.5164 388.2000 0.5718 388.3980 0.5718 388.5000 0.5754 388.6980 0.5754 388.8000 0.3000 388.9980 0.3000 389.1000 0.4885 389.2980 0.4885 389.4000 0.4856 389.5980 0.4856 389.7000 0.3954 389.8980 0.3954 390.0000 0.3627 390.1980 0.3627 390.3000 0.3323 390.4980 0.3323 390.6000 0.3675 390.7980 0.3675 390.9000 0.5095 391.0980 0.5095 391.2000 0.3615 391.3980 0.3615 391.5000 0.3139 391.6980 0.3139 391.8000 0.5457 391.9980 0.5457 392.1000 0.3702 392.2980 0.3702 392.4000 0.4044 392.5980 0.4044 392.7000 0.4060 392.8980 0.4060 393.0000 0.4588 393.1980 0.4588 393.3000 0.3712 393.4980 0.3712 393.6000 0.3843 393.7980 0.3843 393.9000 0.3918 394.0980 0.3918 394.2000 0.3234 394.3980 0.3234 394.5000 0.4569 394.6980 0.4569 394.8000 0.3840 394.9980 0.3840 395.1000 0.5142 395.2980 0.5142 395.4000 0.4370 395.5980 0.4370 395.7000 0.4637 395.8980 0.4637 396.0000 0.5412 396.1980 0.5412 396.3000 0.5887 396.4980 0.5887 396.6000 0.5985 396.7980 0.5985 396.9000 0.5033 397.0980 0.5033 397.2000 0.5913 397.3980 0.5913 397.5000 0.6190 397.6980 0.6190 397.8000 0.5692 397.9980 0.5692 398.1000 0.5961 398.2980 0.5961 398.4000 0.6150 398.5980 0.6150 398.7000 0.5696 398.8980 0.5696 399.0000 0.6065 399.1980 0.6065 399.3000 0.6194 399.4980 0.6194 399.6000 0.5673 399.7980 0.5673 399.9000 0.6056 400.0980 0.6056 400.2000 0.5477 400.3980 0.5477 400.5000 0.5860 400.6980 0.5860 400.8000 0.5723 400.9980 0.5723 401.1000 0.6247 401.2980 0.6247 401.4000 0.5668 401.5980 0.5668 401.7000 0.5998 401.8980 0.5998 402.0000 0.5790 402.1980 0.5790 402.3000 0.6068 402.4980 0.6068 402.6000 0.5960 402.7980 0.5960 402.9000 0.6236 403.0980 0.6236 403.2000 0.5892 403.3980 0.5892 403.5000 0.6006 403.6980 0.6006 403.8000 0.5595 403.9980 0.5595 404.1000 0.5968 404.2980 0.5968 404.4000 0.5883 404.5980 0.5883 404.7000 0.6004 404.8980 0.6004 405.0000 0.5933 405.1980 0.5933 405.3000 0.5768 405.4980 0.5768 405.6000 0.6007 405.7980 0.6007 405.9000 0.6082 406.0980 0.6082 406.2000 0.5745 406.3980 0.5745 406.5000 0.5786 406.6980 0.5786 406.8000 0.5559 406.9980 0.5559 407.1000 0.6088 407.2980 0.6088 407.4000 0.5452 407.5980 0.5452 407.7000 0.5821 407.8980 0.5821 408.0000 0.5732 408.1980 0.5732 408.3000 0.6057 408.4980 0.6057 408.6000 0.5458 408.7980 0.5458 408.9000 0.6020 409.0980 0.6020 409.2000 0.5708 409.3980 0.5708 409.5000 0.5164 409.6980 0.5164 409.8000 0.5718 409.9980 0.5718 410.1000 0.5754 410.2980 0.5754 410.4000 0.3000 410.5980 0.3000 410.7000 0.4885 410.8980 0.4885 411.0000 0.4856 411.1980 0.4856 411.3000 0.3954 411.4980 0.3954 411.6000 0.3627 411.7980 0.3627 411.9000 0.3323 412.0980 0.3323 412.2000 0.3675 412.3980 0.3675 412.5000 0.5095 412.6980 0.5095 412.8000 0.3615 412.9980 0.3615 413.1000 0.3139 413.2980 0.3139 413.4000 0.5457 413.5980 0.5457 413.7000 0.3702 413.8980 0.3702 414.0000 0.4044 414.1980 0.4044 414.3000 0.4060 414.4980 0.4060 414.6000 0.4588 414.7980 0.4588 414.9000 0.3712 415.0980 0.3712 415.2000 0.3843 415.3980 0.3843 415.5000 0.3918 415.6980 0.3918 415.8000 0.3234 415.9980 0.3234 416.1000 0.4569 416.2980 0.4569 416.4000 0.3840 416.5980 0.3840 416.7000 0.5142 416.8980 0.5142 417.0000 0.4370 417.1980 0.4370 417.3000 0.4637 417.4980 0.4637 417.6000 0.5412 417.7980 0.5412 417.9000 0.5887 418.0980 0.5887 418.2000 0.5985 418.3980 0.5985 418.5000 0.5033 418.6980 0.5033 418.8000 0.5913 418.9980 0.5913 419.1000 0.6190 419.2980 0.6190 419.4000 0.5692 419.5980 0.5692 419.7000 0.5961 419.8980 0.5961 420.0000 0.6150 420.1980 0.6150 420.3000 0.5696 420.4980 0.5696 420.6000 0.6065 420.7980 0.6065 420.9000 0.6194 421.0980 0.6194 421.2000 0.5673 421.3980 0.5673 421.5000 0.6056 421.6980 0.6056 421.8000 0.5477 421.9980 0.5477 422.1000 0.5860 422.2980 0.5860 422.4000 0.5723 422.5980 0.5723 422.7000 0.6247 422.8980 0.6247 423.0000 0.5668 423.1980 0.5668 423.3000 0.5998 423.4980 0.5998 423.6000 0.5790 423.7980 0.5790 423.9000 0.6068 424.0980 0.6068 424.2000 0.5960 424.3980 0.5960 424.5000 0.6236 424.6980 0.6236 424.8000 0.5892 424.9980 0.5892 425.1000 0.6006 425.2980 0.6006 425.4000 0.5595 425.5980 0.5595 425.7000 0.5968 425.8980 0.5968 426.0000 0.5883 426.1980 0.5883 426.3000 0.6004 426.4980 0.6004 426.6000 0.5933 426.7980 0.5933 426.9000 0.5768 427.0980 0.5768 427.2000 0.6007 427.3980 0.6007 427.5000 0.6082 427.6980 0.6082 427.8000 0.5745 427.9980 0.5745 428.1000 0.5786 428.2980 0.5786 428.4000 0.5559 428.5980 0.5559 428.7000 0.6088 428.8980 0.6088 429.0000 0.5452 429.1980 0.5452 429.3000 0.5821 429.4980 0.5821 429.6000 0.5732 429.7980 0.5732 429.9000 0.6057 430.0980 0.6057 430.2000 0.5458 430.3980 0.5458 430.5000 0.6020 430.6980 0.6020 430.8000 0.5708 430.9980 0.5708 431.1000 0.5164 431.2980 0.5164 431.4000 0.5718 431.5980 0.5718 431.7000 0.5754 431.8980 0.5754 432.0000 0.3000 432.1980 0.3000 432.3000 0.4885 432.4980 0.4885 432.6000 0.4856 432.7980 0.4856 432.9000 0.3954 433.0980 0.3954 433.2000 0.3627 433.3980 0.3627 433.5000 0.3323 433.6980 0.3323 433.8000 0.3675 433.9980 0.3675 434.1000 0.5095 434.2980 0.5095 434.4000 0.3615 434.5980 0.3615 434.7000 0.3139 434.8980 0.3139 435.0000 0.5457 435.1980 0.5457 435.3000 0.3702 435.4980 0.3702 435.6000 0.4044 435.7980 0.4044 435.9000 0.4060 436.0980 0.4060 436.2000 0.4588 436.3980 0.4588 436.5000 0.3712 436.6980 0.3712 436.8000 0.3843 436.9980 0.3843 437.1000 0.3918 437.2980 0.3918 437.4000 0.3234 437.5980 0.3234 437.7000 0.4569 437.8980 0.4569 438.0000 0.3840 438.1980 0.3840 438.3000 0.5142 438.4980 0.5142 438.6000 0.4370 438.7980 0.4370 438.9000 0.4637 439.0980 0.4637 439.2000 0.5412 439.3980 0.5412 439.5000 0.5887 439.6980 0.5887 439.8000 0.5985 439.9980 0.5985 440.1000 0.5033 440.2980 0.5033 440.4000 0.5913 440.5980 0.5913 440.7000 0.6190 440.8980 0.6190 441.0000 0.5692 441.1980 0.5692 441.3000 0.5961 441.4980 0.5961 441.6000 0.6150 441.7980 0.6150 441.9000 0.5696 442.0980 0.5696 442.2000 0.6065 442.3980 0.6065 442.5000 0.6194 442.6980 0.6194 442.8000 0.5673 442.9980 0.5673 443.1000 0.6056 443.2980 0.6056 443.4000 0.5477 443.5980 0.5477 443.7000 0.5860 443.8980 0.5860 444.0000 0.5723 444.1980 0.5723 444.3000 0.6247 444.4980 0.6247 444.6000 0.5668 444.7980 0.5668 444.9000 0.5998 445.0980 0.5998 445.2000 0.5790 445.3980 0.5790 445.5000 0.6068 445.6980 0.6068 445.8000 0.5960 445.9980 0.5960 446.1000 0.6236 446.2980 0.6236 446.4000 0.5892 446.5980 0.5892 446.7000 0.6006 446.8980 0.6006 447.0000 0.5595 447.1980 0.5595 447.3000 0.5968 447.4980 0.5968 447.6000 0.5883 447.7980 0.5883 447.9000 0.6004 448.0980 0.6004 448.2000 0.5933 448.3980 0.5933 448.5000 0.5768 448.6980 0.5768 448.8000 0.6007 448.9980 0.6007 449.1000 0.6082 449.2980 0.6082 449.4000 0.5745 449.5980 0.5745 449.7000 0.5786 449.8980 0.5786 450.0000 0.5559 450.1980 0.5559 450.3000 0.6088 450.4980 0.6088 450.6000 0.5452 450.7980 0.5452 450.9000 0.5821 451.0980 0.5821 451.2000 0.5732 451.3980 0.5732 451.5000 0.6057 451.6980 0.6057 451.8000 0.5458 451.9980 0.5458 452.1000 0.6020 452.2980 0.6020 452.4000 0.5708 452.5980 0.5708 452.7000 0.5164 452.8980 0.5164 453.0000 0.5718 453.1980 0.5718 453.3000 0.5754 453.4980 0.5754 453.6000 0.3000 453.7980 0.3000 453.9000 0.4885 454.0980 0.4885 454.2000 0.4856 454.3980 0.4856 454.5000 0.3954 454.6980 0.3954 454.8000 0.3627 454.9980 0.3627 455.1000 0.3323 455.2980 0.3323 455.4000 0.3675 455.5980 0.3675 455.7000 0.5095 455.8980 0.5095 456.0000 0.3615 456.1980 0.3615 456.3000 0.3139 456.4980 0.3139 456.6000 0.5457 456.7980 0.5457 456.9000 0.3702 457.0980 0.3702 457.2000 0.4044 457.3980 0.4044 457.5000 0.4060 457.6980 0.4060 457.8000 0.4588 457.9980 0.4588 458.1000 0.3712 458.2980 0.3712 458.4000 0.3843 458.5980 0.3843 458.7000 0.3918 458.8980 0.3918 459.0000 0.3234 459.1980 0.3234 459.3000 0.4569 459.4980 0.4569 459.6000 0.3840 459.7980 0.3840 459.9000 0.5142 460.0980 0.5142 460.2000 0.4370 460.3980 0.4370 460.5000 0.4637 460.6980 0.4637 460.8000 0.5412 460.9980 0.5412 461.1000 0.5887 461.2980 0.5887 461.4000 0.5985 461.5980 0.5985 461.7000 0.5033 461.8980 0.5033 462.0000 0.5913 462.1980 0.5913 462.3000 0.6190 462.4980 0.6190 462.6000 0.5692 462.7980 0.5692 462.9000 0.5961 463.0980 0.5961 463.2000 0.6150 463.3980 0.6150 463.5000 0.5696 463.6980 0.5696 463.8000 0.6065 463.9980 0.6065 464.1000 0.6194 464.2980 0.6194 464.4000 0.5673 464.5980 0.5673 464.7000 0.6056 464.8980 0.6056 465.0000 0.5477 465.1980 0.5477 465.3000 0.5860 465.4980 0.5860 465.6000 0.5723 465.7980 0.5723 465.9000 0.6247 466.0980 0.6247 466.2000 0.5668 466.3980 0.5668 466.5000 0.5998 466.6980 0.5998 466.8000 0.5790 466.9980 0.5790 467.1000 0.6068 467.2980 0.6068 467.4000 0.5960 467.5980 0.5960 467.7000 0.6236 467.8980 0.6236 468.0000 0.5892 468.1980 0.5892 468.3000 0.6006 468.4980 0.6006 468.6000 0.5595 468.7980 0.5595 468.9000 0.5968 469.0980 0.5968 469.2000 0.5883 469.3980 0.5883 469.5000 0.6004 469.6980 0.6004 469.8000 0.5933 469.9980 0.5933 470.1000 0.5768 470.2980 0.5768 470.4000 0.6007 470.5980 0.6007 470.7000 0.6082 470.8980 0.6082 471.0000 0.5745 471.1980 0.5745 471.3000 0.5786 471.4980 0.5786 471.6000 0.5559 471.7980 0.5559 471.9000 0.6088 472.0980 0.6088 472.2000 0.5452 472.3980 0.5452 472.5000 0.5821 472.6980 0.5821 472.8000 0.5732 472.9980 0.5732 473.1000 0.6057 473.2980 0.6057 473.4000 0.5458 473.5980 0.5458 473.7000 0.6020 473.8980 0.6020 474.0000 0.5708 474.1980 0.5708 474.3000 0.5164 474.4980 0.5164 474.6000 0.5718 474.7980 0.5718 474.9000 0.5754 475.0980 0.5754 475.2000 0.3000 475.3980 0.3000 475.5000 0.4885 475.6980 0.4885 475.8000 0.4856 475.9980 0.4856 476.1000 0.3954 476.2980 0.3954 476.4000 0.3627 476.5980 0.3627 476.7000 0.3323 476.8980 0.3323 477.0000 0.3675 477.1980 0.3675 477.3000 0.5095 477.4980 0.5095 477.6000 0.3615 477.7980 0.3615 477.9000 0.3139 478.0980 0.3139 478.2000 0.5457 478.3980 0.5457 478.5000 0.3702 478.6980 0.3702 478.8000 0.4044 478.9980 0.4044 479.1000 0.4060 479.2980 0.4060 479.4000 0.4588 479.5980 0.4588 479.7000 0.3712 479.8980 0.3712 480.0000 0.3843 480.1980 0.3843 480.3000 0.3918 480.4980 0.3918 480.6000 0.3234 480.7980 0.3234 480.9000 0.4569 481.0980 0.4569 481.2000 0.3840 481.3980 0.3840 481.5000 0.5142 481.6980 0.5142 481.8000 0.4370 481.9980 0.4370 482.1000 0.4637 482.2980 0.4637 482.4000 0.5412 482.5980 0.5412 482.7000 0.5887 482.8980 0.5887 483.0000 0.5985 483.1980 0.5985 483.3000 0.5033 483.4980 0.5033 483.6000 0.5913 483.7980 0.5913 483.9000 0.6190 484.0980 0.6190 484.2000 0.5692 484.3980 0.5692 484.5000 0.5961 484.6980 0.5961 484.8000 0.6150 484.9980 0.6150 485.1000 0.5696 485.2980 0.5696 485.4000 0.6065 485.5980 0.6065 485.7000 0.6194 485.8980 0.6194 486.0000 0.5673 486.1980 0.5673 486.3000 0.6056 486.4980 0.6056 486.6000 0.5477 486.7980 0.5477 486.9000 0.5860 487.0980 0.5860 487.2000 0.5723 487.3980 0.5723 487.5000 0.6247 487.6980 0.6247 487.8000 0.5668 487.9980 0.5668 488.1000 0.5998 488.2980 0.5998 488.4000 0.5790 488.5980 0.5790 488.7000 0.6068 488.8980 0.6068 489.0000 0.5960 489.1980 0.5960 489.3000 0.6236 489.4980 0.6236 489.6000 0.5892 489.7980 0.5892 489.9000 0.6006 490.0980 0.6006 490.2000 0.5595 490.3980 0.5595 490.5000 0.5968 490.6980 0.5968 490.8000 0.5883 490.9980 0.5883 491.1000 0.6004 491.2980 0.6004 491.4000 0.5933 491.5980 0.5933 491.7000 0.5768 491.8980 0.5768 492.0000 0.6007 492.1980 0.6007 492.3000 0.6082 492.4980 0.6082 492.6000 0.5745 492.7980 0.5745 492.9000 0.5786 493.0980 0.5786 493.2000 0.5559 493.3980 0.5559 493.5000 0.6088 493.6980 0.6088 493.8000 0.5452 493.9980 0.5452 494.1000 0.5821 494.2980 0.5821 494.4000 0.5732 494.5980 0.5732 494.7000 0.6057 494.8980 0.6057 495.0000 0.5458 495.1980 0.5458 495.3000 0.6020 495.4980 0.6020 495.6000 0.5708 495.7980 0.5708 495.9000 0.5164 496.0980 0.5164 496.2000 0.5718 496.3980 0.5718 496.5000 0.5754 496.6980 0.5754 496.8000 0.3000 496.9980 0.3000 497.1000 0.4885 497.2980 0.4885 497.4000 0.4856 497.5980 0.4856 497.7000 0.3954 497.8980 0.3954 498.0000 0.3627 498.1980 0.3627 498.3000 0.3323 498.4980 0.3323 498.6000 0.3675 498.7980 0.3675 498.9000 0.5095 499.0980 0.5095 499.2000 0.3615 499.3980 0.3615 499.5000 0.3139 499.6980 0.3139 499.8000 0.5457 499.9980 0.5457 500.1000 0.3702 500.2980 0.3702 500.4000 0.4044 500.5980 0.4044 500.7000 0.4060 500.8980 0.4060 501.0000 0.4588 501.1980 0.4588 501.3000 0.3712 501.4980 0.3712 501.6000 0.3843 501.7980 0.3843 501.9000 0.3918 502.0980 0.3918 502.2000 0.3234 502.3980 0.3234 502.5000 0.4569 502.6980 0.4569 502.8000 0.3840 502.9980 0.3840 503.1000 0.5142 503.2980 0.5142 503.4000 0.4370 503.5980 0.4370 503.7000 0.4637 503.8980 0.4637 504.0000 0.5412 504.1980 0.5412 504.3000 0.5887 504.4980 0.5887 504.6000 0.5985 504.7980 0.5985 504.9000 0.5033 505.0980 0.5033 505.2000 0.5913 505.3980 0.5913 505.5000 0.6190 505.6980 0.6190 505.8000 0.5692 505.9980 0.5692 506.1000 0.5961 506.2980 0.5961 506.4000 0.6150 506.5980 0.6150 506.7000 0.5696 506.8980 0.5696 507.0000 0.6065 507.1980 0.6065 507.3000 0.6194 507.4980 0.6194 507.6000 0.5673 507.7980 0.5673 507.9000 0.6056 508.0980 0.6056 508.2000 0.5477 508.3980 0.5477 508.5000 0.5860 508.6980 0.5860 508.8000 0.5723 508.9980 0.5723 509.1000 0.6247 509.2980 0.6247 509.4000 0.5668 509.5980 0.5668 509.7000 0.5998 509.8980 0.5998 510.0000 0.5790 510.1980 0.5790 510.3000 0.6068 510.4980 0.6068 510.6000 0.5960 510.7980 0.5960 510.9000 0.6236 511.0980 0.6236 511.2000 0.5892 511.3980 0.5892 511.5000 0.6006 511.6980 0.6006 511.8000 0.5595 511.9980 0.5595 512.1000 0.5968 512.2980 0.5968 512.4000 0.5883 512.5980 0.5883 512.7000 0.6004 512.8980 0.6004 513.0000 0.5933 513.1980 0.5933 513.3000 0.5768 513.4980 0.5768 513.6000 0.6007 513.7980 0.6007 513.9000 0.6082 514.0980 0.6082 514.2000 0.5745 514.3980 0.5745 514.5000 0.5786 514.6980 0.5786 514.8000 0.5559 514.9980 0.5559 515.1000 0.6088 515.2980 0.6088 515.4000 0.5452 515.5980 0.5452 515.7000 0.5821 515.8980 0.5821 516.0000 0.5732 516.1980 0.5732 516.3000 0.6057 516.4980 0.6057 516.6000 0.5458 516.7980 0.5458 516.9000 0.6020 517.0980 0.6020 517.2000 0.5708 517.3980 0.5708 517.5000 0.5164 517.6980 0.5164 517.8000 0.5718 517.9980 0.5718 518.1000 0.5754 518.2980 0.5754 518.4000 0.3000 518.5980 0.3000 518.7000 0.4885 518.8980 0.4885 519.0000 0.4856 519.1980 0.4856 519.3000 0.3954 519.4980 0.3954 519.6000 0.3627 519.7980 0.3627 519.9000 0.3323 520.0980 0.3323 520.2000 0.3675 520.3980 0.3675 520.5000 0.5095 520.6980 0.5095 520.8000 0.3615 520.9980 0.3615 521.1000 0.3139 521.2980 0.3139 521.4000 0.5457 521.5980 0.5457 521.7000 0.3702 521.8980 0.3702 522.0000 0.4044 522.1980 0.4044 522.3000 0.4060 522.4980 0.4060 522.6000 0.4588 522.7980 0.4588 522.9000 0.3712 523.0980 0.3712 523.2000 0.3843 523.3980 0.3843 523.5000 0.3918 523.6980 0.3918 523.8000 0.3234 523.9980 0.3234 524.1000 0.4569 524.2980 0.4569 524.4000 0.3840 524.5980 0.3840 524.7000 0.5142 524.8980 0.5142 525.0000 0.4370 525.1980 0.4370 525.3000 0.4637 525.4980 0.4637 525.6000 0.5412 525.7980 0.5412 525.9000 0.5887 526.0980 0.5887 526.2000 0.5985 526.3980 0.5985 526.5000 0.5033 526.6980 0.5033 526.8000 0.5913 526.9980 0.5913 527.1000 0.6190 527.2980 0.6190 527.4000 0.5692 527.5980 0.5692 527.7000 0.5961 527.8980 0.5961 528.0000 0.6150 528.1980 0.6150 528.3000 0.5696 528.4980 0.5696 528.6000 0.6065 528.7980 0.6065 528.9000 0.6194 529.0980 0.6194 529.2000 0.5673 529.3980 0.5673 529.5000 0.6056 529.6980 0.6056 529.8000 0.5477 529.9980 0.5477 530.1000 0.5860 530.2980 0.5860 530.4000 0.5723 530.5980 0.5723 530.7000 0.6247 530.8980 0.6247 531.0000 0.5668 531.1980 0.5668 531.3000 0.5998 531.4980 0.5998 531.6000 0.5790 531.7980 0.5790 531.9000 0.6068 532.0980 0.6068 532.2000 0.5960 532.3980 0.5960 532.5000 0.6236 532.6980 0.6236 532.8000 0.5892 532.9980 0.5892 533.1000 0.6006 533.2980 0.6006 533.4000 0.5595 533.5980 0.5595 533.7000 0.5968 533.8980 0.5968 534.0000 0.5883 534.1980 0.5883 534.3000 0.6004 534.4980 0.6004 534.6000 0.5933 534.7980 0.5933 534.9000 0.5768 535.0980 0.5768 535.2000 0.6007 535.3980 0.6007 535.5000 0.6082 535.6980 0.6082 535.8000 0.5745 535.9980 0.5745 536.1000 0.5786 536.2980 0.5786 536.4000 0.5559 536.5980 0.5559 536.7000 0.6088 536.8980 0.6088 537.0000 0.5452 537.1980 0.5452 537.3000 0.5821 537.4980 0.5821 537.6000 0.5732 537.7980 0.5732 537.9000 0.6057 538.0980 0.6057 538.2000 0.5458 538.3980 0.5458 538.5000 0.6020 538.6980 0.6020 538.8000 0.5708 538.9980 0.5708 539.1000 0.5164 539.2980 0.5164 539.4000 0.5718 539.5980 0.5718 539.7000 0.5754 539.8980 0.5754 540.0000 0.3000 540.1980 0.3000 540.3000 0.4885 540.4980 0.4885 540.6000 0.4856 540.7980 0.4856 540.9000 0.3954 541.0980 0.3954 541.2000 0.3627 541.3980 0.3627 541.5000 0.3323 541.6980 0.3323 541.8000 0.3675 541.9980 0.3675 542.1000 0.5095 542.2980 0.5095 542.4000 0.3615 542.5980 0.3615 542.7000 0.3139 542.8980 0.3139 543.0000 0.5457 543.1980 0.5457 543.3000 0.3702 543.4980 0.3702 543.6000 0.4044 543.7980 0.4044 543.9000 0.4060 544.0980 0.4060 544.2000 0.4588 544.3980 0.4588 544.5000 0.3712 544.6980 0.3712 544.8000 0.3843 544.9980 0.3843 545.1000 0.3918 545.2980 0.3918 545.4000 0.3234 545.5980 0.3234 545.7000 0.4569 545.8980 0.4569 546.0000 0.3840 546.1980 0.3840 546.3000 0.5142 546.4980 0.5142 546.6000 0.4370 546.7980 0.4370 546.9000 0.4637 547.0980 0.4637 547.2000 0.5412 547.3980 0.5412 547.5000 0.5887 547.6980 0.5887 547.8000 0.5985 547.9980 0.5985 548.1000 0.5033 548.2980 0.5033 548.4000 0.5913 548.5980 0.5913 548.7000 0.6190 548.8980 0.6190 549.0000 0.5692 549.1980 0.5692 549.3000 0.5961 549.4980 0.5961 549.6000 0.6150 549.7980 0.6150 549.9000 0.5696 550.0980 0.5696 550.2000 0.6065 550.3980 0.6065 550.5000 0.6194 550.6980 0.6194 550.8000 0.5673 550.9980 0.5673 551.1000 0.6056 551.2980 0.6056 551.4000 0.5477 551.5980 0.5477 551.7000 0.5860 551.8980 0.5860 552.0000 0.5723 552.1980 0.5723 552.3000 0.6247 552.4980 0.6247 552.6000 0.5668 552.7980 0.5668 552.9000 0.5998 553.0980 0.5998 553.2000 0.5790 553.3980 0.5790 553.5000 0.6068 553.6980 0.6068 553.8000 0.5960 553.9980 0.5960 554.1000 0.6236 554.2980 0.6236 554.4000 0.5892 554.5980 0.5892 554.7000 0.6006 554.8980 0.6006 555.0000 0.5595 555.1980 0.5595 555.3000 0.5968 555.4980 0.5968 555.6000 0.5883 555.7980 0.5883 555.9000 0.6004 556.0980 0.6004 556.2000 0.5933 556.3980 0.5933 556.5000 0.5768 556.6980 0.5768 556.8000 0.6007 556.9980 0.6007 557.1000 0.6082 557.2980 0.6082 557.4000 0.5745 557.5980 0.5745 557.7000 0.5786 557.8980 0.5786 558.0000 0.5559 558.1980 0.5559 558.3000 0.6088 558.4980 0.6088 558.6000 0.5452 558.7980 0.5452 558.9000 0.5821 559.0980 0.5821 559.2000 0.5732 559.3980 0.5732 559.5000 0.6057 559.6980 0.6057 559.8000 0.5458 559.9980 0.5458 560.1000 0.6020 560.2980 0.6020 560.4000 0.5708 560.5980 0.5708 560.7000 0.5164 560.8980 0.5164 561.0000 0.5718 561.1980 0.5718 561.3000 0.5754 561.4980 0.5754 561.6000 0.3000 561.7980 0.3000 561.9000 0.4885 562.0980 0.4885 562.2000 0.4856 562.3980 0.4856 562.5000 0.3954 562.6980 0.3954 562.8000 0.3627 562.9980 0.3627 563.1000 0.3323 563.2980 0.3323 563.4000 0.3675 563.5980 0.3675 563.7000 0.5095 563.8980 0.5095 564.0000 0.3615 564.1980 0.3615 564.3000 0.3139 564.4980 0.3139 564.6000 0.5457 564.7980 0.5457 564.9000 0.3702 565.0980 0.3702 565.2000 0.4044 565.3980 0.4044 565.5000 0.4060 565.6980 0.4060 565.8000 0.4588 565.9980 0.4588 566.1000 0.3712 566.2980 0.3712 566.4000 0.3843 566.5980 0.3843 566.7000 0.3918 566.8980 0.3918 567.0000 0.3234 567.1980 0.3234 567.3000 0.4569 567.4980 0.4569 567.6000 0.3840 567.7980 0.3840 567.9000 0.5142 568.0980 0.5142 568.2000 0.4370 568.3980 0.4370 568.5000 0.4637 568.6980 0.4637 568.8000 0.5412 568.9980 0.5412 569.1000 0.5887 569.2980 0.5887 569.4000 0.5985 569.5980 0.5985 569.7000 0.5033 569.8980 0.5033 570.0000 0.5913 570.1980 0.5913 570.3000 0.6190 570.4980 0.6190 570.6000 0.5692 570.7980 0.5692 570.9000 0.5961 571.0980 0.5961 571.2000 0.6150 571.3980 0.6150 571.5000 0.5696 571.6980 0.5696 571.8000 0.6065 571.9980 0.6065 572.1000 0.6194 572.2980 0.6194 572.4000 0.5673 572.5980 0.5673 572.7000 0.6056 572.8980 0.6056 573.0000 0.5477 573.1980 0.5477 573.3000 0.5860 573.4980 0.5860 573.6000 0.5723 573.7980 0.5723 573.9000 0.6247 574.0980 0.6247 574.2000 0.5668 574.3980 0.5668 574.5000 0.5998 574.6980 0.5998 574.8000 0.5790 574.9980 0.5790 575.1000 0.6068 575.2980 0.6068 575.4000 0.5960 575.5980 0.5960 575.7000 0.6236 575.8980 0.6236 576.0000 0.5892 576.1980 0.5892 576.3000 0.6006 576.4980 0.6006 576.6000 0.5595 576.7980 0.5595 576.9000 0.5968 577.0980 0.5968 577.2000 0.5883 577.3980 0.5883 577.5000 0.6004 577.6980 0.6004 577.8000 0.5933 577.9980 0.5933 578.1000 0.5768 578.2980 0.5768 578.4000 0.6007 578.5980 0.6007 578.7000 0.6082 578.8980 0.6082 579.0000 0.5745 579.1980 0.5745 579.3000 0.5786 579.4980 0.5786 579.6000 0.5559 579.7980 0.5559 579.9000 0.6088 580.0980 0.6088 580.2000 0.5452 580.3980 0.5452 580.5000 0.5821 580.6980 0.5821 580.8000 0.5732 580.9980 0.5732 581.1000 0.6057 581.2980 0.6057 581.4000 0.5458 581.5980 0.5458 581.7000 0.6020 581.8980 0.6020 582.0000 0.5708 582.1980 0.5708 582.3000 0.5164 582.4980 0.5164 582.6000 0.5718 582.7980 0.5718 582.9000 0.5754 583.0980 0.5754 583.2000 0.3000 583.3980 0.3000 583.5000 0.4885 583.6980 0.4885 583.8000 0.4856 583.9980 0.4856 584.1000 0.3954 584.2980 0.3954 584.4000 0.3627 584.5980 0.3627 584.7000 0.3323 584.8980 0.3323 585.0000 0.3675 585.1980 0.3675 585.3000 0.5095 585.4980 0.5095 585.6000 0.3615 585.7980 0.3615 585.9000 0.3139 586.0980 0.3139 586.2000 0.5457 586.3980 0.5457 586.5000 0.3702 586.6980 0.3702 586.8000 0.4044 586.9980 0.4044 587.1000 0.4060 587.2980 0.4060 587.4000 0.4588 587.5980 0.4588 587.7000 0.3712 587.8980 0.3712 588.0000 0.3843 588.1980 0.3843 588.3000 0.3918 588.4980 0.3918 588.6000 0.3234 588.7980 0.3234 588.9000 0.4569 589.0980 0.4569 589.2000 0.3840 589.3980 0.3840 589.5000 0.5142 589.6980 0.5142 589.8000 0.4370 589.9980 0.4370 590.1000 0.4637 590.2980 0.4637 590.4000 0.5412 590.5980 0.5412 590.7000 0.5887 590.8980 0.5887 591.0000 0.5985 591.1980 0.5985 591.3000 0.5033 591.4980 0.5033 591.6000 0.5913 591.7980 0.5913 591.9000 0.6190 592.0980 0.6190 592.2000 0.5692 592.3980 0.5692 592.5000 0.5961 592.6980 0.5961 592.8000 0.6150 592.9980 0.6150 593.1000 0.5696 593.2980 0.5696 593.4000 0.6065 593.5980 0.6065 593.7000 0.6194 593.8980 0.6194 594.0000 0.5673 594.1980 0.5673 594.3000 0.6056 594.4980 0.6056 594.6000 0.5477 594.7980 0.5477 594.9000 0.5860 595.0980 0.5860 595.2000 0.5723 595.3980 0.5723 595.5000 0.6247 595.6980 0.6247 595.8000 0.5668 595.9980 0.5668 596.1000 0.5998 596.2980 0.5998 596.4000 0.5790 596.5980 0.5790 596.7000 0.6068 596.8980 0.6068 597.0000 0.5960 597.1980 0.5960 597.3000 0.6236 597.4980 0.6236 597.6000 0.5892 597.7980 0.5892 597.9000 0.6006 598.0980 0.6006 598.2000 0.5595 598.3980 0.5595 598.5000 0.5968 598.6980 0.5968 598.8000 0.5883 598.9980 0.5883 599.1000 0.6004 599.2980 0.6004 599.4000 0.5933 599.5980 0.5933 599.7000 0.5768 599.8980 0.5768 600.0000 0.5768)
Va1 a1 0 PWL(0.0000 0.6885 0.1980 0.6885 0.3000 0.6888 0.4980 0.6888 0.6000 0.4856 0.7980 0.4856 0.9000 0.6350 1.0980 0.6350 1.2000 0.3627 1.3980 0.3627 1.5000 0.6583 1.6980 0.6583 1.8000 0.3915 1.9980 0.3915 2.1000 0.5095 2.2980 0.5095 2.4000 0.7708 2.5980 0.7708 2.7000 0.4973 2.8980 0.4973 3.0000 0.6048 3.1980 0.6048 3.3000 0.3886 3.4980 0.3886 3.6000 0.4078 3.7980 0.4078 3.9000 0.5004 4.0980 0.5004 4.2000 0.5907 4.3980 0.5907 4.5000 0.3939 4.6980 0.3939 4.8000 0.6037 4.9980 0.6037 5.1000 0.8411 5.2980 0.8411 5.4000 0.3459 5.5980 0.3459 5.7000 0.4569 5.8980 0.4569 6.0000 0.6672 6.1980 0.6672 6.3000 0.6636 6.4980 0.6636 6.6000 0.5998 6.7980 0.5998 6.9000 1.0003 7.0980 1.0003 7.2000 0.5670 7.3980 0.5670 7.5000 1.0167 7.6980 1.0167 7.8000 0.5985 7.9980 0.5985 8.1000 0.5143 8.2980 0.5143 8.4000 0.5913 8.5980 0.5913 8.7000 0.6190 8.8980 0.6190 9.0000 0.5692 9.1980 0.5692 9.3000 0.5961 9.4980 0.5961 9.6000 0.6150 9.7980 0.6150 9.9000 0.5696 10.0980 0.5696 10.2000 0.6065 10.3980 0.6065 10.5000 0.6194 10.6980 0.6194 10.8000 0.6475 10.9980 0.6475 11.1000 0.6056 11.2980 0.6056 11.4000 0.8301 11.5980 0.8301 11.7000 0.5860 11.8980 0.5860 12.0000 0.6538 12.1980 0.6538 12.3000 0.6247 12.4980 0.6247 12.6000 0.5668 12.7980 0.5668 12.9000 0.5998 13.0980 0.5998 13.2000 1.0691 13.3980 1.0691 13.5000 0.6068 13.6980 0.6068 13.8000 0.7579 13.9980 0.7579 14.1000 0.6236 14.2980 0.6236 14.4000 0.6693 14.5980 0.6693 14.7000 0.6006 14.8980 0.6006 15.0000 0.7447 15.1980 0.7447 15.3000 0.5968 15.4980 0.5968 15.6000 0.5883 15.7980 0.5883 15.9000 0.6004 16.0980 0.6004 16.2000 0.5933 16.3980 0.5933 16.5000 0.5768 16.6980 0.5768 16.8000 0.6007 16.9980 0.6007 17.1000 0.6082 17.2980 0.6082 17.4000 0.6937 17.5980 0.6937 17.7000 0.6144 17.8980 0.6144 18.0000 0.5609 18.1980 0.5609 18.3000 0.7432 18.4980 0.7432 18.6000 0.5452 18.7980 0.5452 18.9000 0.5821 19.0980 0.5821 19.2000 0.5732 19.3980 0.5732 19.5000 0.6057 19.6980 0.6057 19.8000 0.5458 19.9980 0.5458 20.1000 0.6020 20.2980 0.6020 20.4000 0.5708 20.5980 0.5708 20.7000 0.5164 20.8980 0.5164 21.0000 0.6817 21.1980 0.6817 21.3000 0.5754 21.4980 0.5754 21.6000 0.6885 21.7980 0.6885 21.9000 0.6888 22.0980 0.6888 22.2000 0.4856 22.3980 0.4856 22.5000 0.6350 22.6980 0.6350 22.8000 0.3627 22.9980 0.3627 23.1000 0.6583 23.2980 0.6583 23.4000 0.3915 23.5980 0.3915 23.7000 0.5095 23.8980 0.5095 24.0000 0.7708 24.1980 0.7708 24.3000 0.4973 24.4980 0.4973 24.6000 0.6048 24.7980 0.6048 24.9000 0.3886 25.0980 0.3886 25.2000 0.4078 25.3980 0.4078 25.5000 0.5004 25.6980 0.5004 25.8000 0.5907 25.9980 0.5907 26.1000 0.3939 26.2980 0.3939 26.4000 0.6037 26.5980 0.6037 26.7000 0.8411 26.8980 0.8411 27.0000 0.3459 27.1980 0.3459 27.3000 0.4569 27.4980 0.4569 27.6000 0.6672 27.7980 0.6672 27.9000 0.6636 28.0980 0.6636 28.2000 0.5998 28.3980 0.5998 28.5000 1.0003 28.6980 1.0003 28.8000 0.5670 28.9980 0.5670 29.1000 1.0167 29.2980 1.0167 29.4000 0.5985 29.5980 0.5985 29.7000 0.5143 29.8980 0.5143 30.0000 0.5913 30.1980 0.5913 30.3000 0.6190 30.4980 0.6190 30.6000 0.5692 30.7980 0.5692 30.9000 0.5961 31.0980 0.5961 31.2000 0.6150 31.3980 0.6150 31.5000 0.5696 31.6980 0.5696 31.8000 0.6065 31.9980 0.6065 32.1000 0.6194 32.2980 0.6194 32.4000 0.6475 32.5980 0.6475 32.7000 0.6056 32.8980 0.6056 33.0000 0.8301 33.1980 0.8301 33.3000 0.5860 33.4980 0.5860 33.6000 0.6538 33.7980 0.6538 33.9000 0.6247 34.0980 0.6247 34.2000 0.5668 34.3980 0.5668 34.5000 0.5998 34.6980 0.5998 34.8000 1.0691 34.9980 1.0691 35.1000 0.6068 35.2980 0.6068 35.4000 0.7579 35.5980 0.7579 35.7000 0.6236 35.8980 0.6236 36.0000 0.6693 36.1980 0.6693 36.3000 0.6006 36.4980 0.6006 36.6000 0.7447 36.7980 0.7447 36.9000 0.5968 37.0980 0.5968 37.2000 0.5883 37.3980 0.5883 37.5000 0.6004 37.6980 0.6004 37.8000 0.5933 37.9980 0.5933 38.1000 0.5768 38.2980 0.5768 38.4000 0.6007 38.5980 0.6007 38.7000 0.6082 38.8980 0.6082 39.0000 0.6937 39.1980 0.6937 39.3000 0.6144 39.4980 0.6144 39.6000 0.5609 39.7980 0.5609 39.9000 0.7432 40.0980 0.7432 40.2000 0.5452 40.3980 0.5452 40.5000 0.5821 40.6980 0.5821 40.8000 0.5732 40.9980 0.5732 41.1000 0.6057 41.2980 0.6057 41.4000 0.5458 41.5980 0.5458 41.7000 0.6020 41.8980 0.6020 42.0000 0.5708 42.1980 0.5708 42.3000 0.5164 42.4980 0.5164 42.6000 0.6817 42.7980 0.6817 42.9000 0.5754 43.0980 0.5754 43.2000 0.6885 43.3980 0.6885 43.5000 0.6888 43.6980 0.6888 43.8000 0.4856 43.9980 0.4856 44.1000 0.6350 44.2980 0.6350 44.4000 0.3627 44.5980 0.3627 44.7000 0.6583 44.8980 0.6583 45.0000 0.3915 45.1980 0.3915 45.3000 0.5095 45.4980 0.5095 45.6000 0.7708 45.7980 0.7708 45.9000 0.4973 46.0980 0.4973 46.2000 0.6048 46.3980 0.6048 46.5000 0.3886 46.6980 0.3886 46.8000 0.4078 46.9980 0.4078 47.1000 0.5004 47.2980 0.5004 47.4000 0.5907 47.5980 0.5907 47.7000 0.3939 47.8980 0.3939 48.0000 0.6037 48.1980 0.6037 48.3000 0.8411 48.4980 0.8411 48.6000 0.3459 48.7980 0.3459 48.9000 0.4569 49.0980 0.4569 49.2000 0.6672 49.3980 0.6672 49.5000 0.6636 49.6980 0.6636 49.8000 0.5998 49.9980 0.5998 50.1000 1.0003 50.2980 1.0003 50.4000 0.5670 50.5980 0.5670 50.7000 1.0167 50.8980 1.0167 51.0000 0.5985 51.1980 0.5985 51.3000 0.5143 51.4980 0.5143 51.6000 0.5913 51.7980 0.5913 51.9000 0.6190 52.0980 0.6190 52.2000 0.5692 52.3980 0.5692 52.5000 0.5961 52.6980 0.5961 52.8000 0.6150 52.9980 0.6150 53.1000 0.5696 53.2980 0.5696 53.4000 0.6065 53.5980 0.6065 53.7000 0.6194 53.8980 0.6194 54.0000 0.6475 54.1980 0.6475 54.3000 0.6056 54.4980 0.6056 54.6000 0.8301 54.7980 0.8301 54.9000 0.5860 55.0980 0.5860 55.2000 0.6538 55.3980 0.6538 55.5000 0.6247 55.6980 0.6247 55.8000 0.5668 55.9980 0.5668 56.1000 0.5998 56.2980 0.5998 56.4000 1.0691 56.5980 1.0691 56.7000 0.6068 56.8980 0.6068 57.0000 0.7579 57.1980 0.7579 57.3000 0.6236 57.4980 0.6236 57.6000 0.6693 57.7980 0.6693 57.9000 0.6006 58.0980 0.6006 58.2000 0.7447 58.3980 0.7447 58.5000 0.5968 58.6980 0.5968 58.8000 0.5883 58.9980 0.5883 59.1000 0.6004 59.2980 0.6004 59.4000 0.5933 59.5980 0.5933 59.7000 0.5768 59.8980 0.5768 60.0000 0.6007 60.1980 0.6007 60.3000 0.6082 60.4980 0.6082 60.6000 0.6937 60.7980 0.6937 60.9000 0.6144 61.0980 0.6144 61.2000 0.5609 61.3980 0.5609 61.5000 0.7432 61.6980 0.7432 61.8000 0.5452 61.9980 0.5452 62.1000 0.5821 62.2980 0.5821 62.4000 0.5732 62.5980 0.5732 62.7000 0.6057 62.8980 0.6057 63.0000 0.5458 63.1980 0.5458 63.3000 0.6020 63.4980 0.6020 63.6000 0.5708 63.7980 0.5708 63.9000 0.5164 64.0980 0.5164 64.2000 0.6817 64.3980 0.6817 64.5000 0.5754 64.6980 0.5754 64.8000 0.6885 64.9980 0.6885 65.1000 0.6888 65.2980 0.6888 65.4000 0.4856 65.5980 0.4856 65.7000 0.6350 65.8980 0.6350 66.0000 0.3627 66.1980 0.3627 66.3000 0.6583 66.4980 0.6583 66.6000 0.3915 66.7980 0.3915 66.9000 0.5095 67.0980 0.5095 67.2000 0.7708 67.3980 0.7708 67.5000 0.4973 67.6980 0.4973 67.8000 0.6048 67.9980 0.6048 68.1000 0.3886 68.2980 0.3886 68.4000 0.4078 68.5980 0.4078 68.7000 0.5004 68.8980 0.5004 69.0000 0.5907 69.1980 0.5907 69.3000 0.3939 69.4980 0.3939 69.6000 0.6037 69.7980 0.6037 69.9000 0.8411 70.0980 0.8411 70.2000 0.3459 70.3980 0.3459 70.5000 0.4569 70.6980 0.4569 70.8000 0.6672 70.9980 0.6672 71.1000 0.6636 71.2980 0.6636 71.4000 0.5998 71.5980 0.5998 71.7000 1.0003 71.8980 1.0003 72.0000 0.5670 72.1980 0.5670 72.3000 1.0167 72.4980 1.0167 72.6000 0.5985 72.7980 0.5985 72.9000 0.5143 73.0980 0.5143 73.2000 0.5913 73.3980 0.5913 73.5000 0.6190 73.6980 0.6190 73.8000 0.5692 73.9980 0.5692 74.1000 0.5961 74.2980 0.5961 74.4000 0.6150 74.5980 0.6150 74.7000 0.5696 74.8980 0.5696 75.0000 0.6065 75.1980 0.6065 75.3000 0.6194 75.4980 0.6194 75.6000 0.6475 75.7980 0.6475 75.9000 0.6056 76.0980 0.6056 76.2000 0.8301 76.3980 0.8301 76.5000 0.5860 76.6980 0.5860 76.8000 0.6538 76.9980 0.6538 77.1000 0.6247 77.2980 0.6247 77.4000 0.5668 77.5980 0.5668 77.7000 0.5998 77.8980 0.5998 78.0000 1.0691 78.1980 1.0691 78.3000 0.6068 78.4980 0.6068 78.6000 0.7579 78.7980 0.7579 78.9000 0.6236 79.0980 0.6236 79.2000 0.6693 79.3980 0.6693 79.5000 0.6006 79.6980 0.6006 79.8000 0.7447 79.9980 0.7447 80.1000 0.5968 80.2980 0.5968 80.4000 0.5883 80.5980 0.5883 80.7000 0.6004 80.8980 0.6004 81.0000 0.5933 81.1980 0.5933 81.3000 0.5768 81.4980 0.5768 81.6000 0.6007 81.7980 0.6007 81.9000 0.6082 82.0980 0.6082 82.2000 0.6937 82.3980 0.6937 82.5000 0.6144 82.6980 0.6144 82.8000 0.5609 82.9980 0.5609 83.1000 0.7432 83.2980 0.7432 83.4000 0.5452 83.5980 0.5452 83.7000 0.5821 83.8980 0.5821 84.0000 0.5732 84.1980 0.5732 84.3000 0.6057 84.4980 0.6057 84.6000 0.5458 84.7980 0.5458 84.9000 0.6020 85.0980 0.6020 85.2000 0.5708 85.3980 0.5708 85.5000 0.5164 85.6980 0.5164 85.8000 0.6817 85.9980 0.6817 86.1000 0.5754 86.2980 0.5754 86.4000 0.6885 86.5980 0.6885 86.7000 0.6888 86.8980 0.6888 87.0000 0.4856 87.1980 0.4856 87.3000 0.6350 87.4980 0.6350 87.6000 0.3627 87.7980 0.3627 87.9000 0.6583 88.0980 0.6583 88.2000 0.3915 88.3980 0.3915 88.5000 0.5095 88.6980 0.5095 88.8000 0.7708 88.9980 0.7708 89.1000 0.4973 89.2980 0.4973 89.4000 0.6048 89.5980 0.6048 89.7000 0.3886 89.8980 0.3886 90.0000 0.4078 90.1980 0.4078 90.3000 0.5004 90.4980 0.5004 90.6000 0.5907 90.7980 0.5907 90.9000 0.3939 91.0980 0.3939 91.2000 0.6037 91.3980 0.6037 91.5000 0.8411 91.6980 0.8411 91.8000 0.3459 91.9980 0.3459 92.1000 0.4569 92.2980 0.4569 92.4000 0.6672 92.5980 0.6672 92.7000 0.6636 92.8980 0.6636 93.0000 0.5998 93.1980 0.5998 93.3000 1.0003 93.4980 1.0003 93.6000 0.5670 93.7980 0.5670 93.9000 1.0167 94.0980 1.0167 94.2000 0.5985 94.3980 0.5985 94.5000 0.5143 94.6980 0.5143 94.8000 0.5913 94.9980 0.5913 95.1000 0.6190 95.2980 0.6190 95.4000 0.5692 95.5980 0.5692 95.7000 0.5961 95.8980 0.5961 96.0000 0.6150 96.1980 0.6150 96.3000 0.5696 96.4980 0.5696 96.6000 0.6065 96.7980 0.6065 96.9000 0.6194 97.0980 0.6194 97.2000 0.6475 97.3980 0.6475 97.5000 0.6056 97.6980 0.6056 97.8000 0.8301 97.9980 0.8301 98.1000 0.5860 98.2980 0.5860 98.4000 0.6538 98.5980 0.6538 98.7000 0.6247 98.8980 0.6247 99.0000 0.5668 99.1980 0.5668 99.3000 0.5998 99.4980 0.5998 99.6000 1.0691 99.7980 1.0691 99.9000 0.6068 100.0980 0.6068 100.2000 0.7579 100.3980 0.7579 100.5000 0.6236 100.6980 0.6236 100.8000 0.6693 100.9980 0.6693 101.1000 0.6006 101.2980 0.6006 101.4000 0.7447 101.5980 0.7447 101.7000 0.5968 101.8980 0.5968 102.0000 0.5883 102.1980 0.5883 102.3000 0.6004 102.4980 0.6004 102.6000 0.5933 102.7980 0.5933 102.9000 0.5768 103.0980 0.5768 103.2000 0.6007 103.3980 0.6007 103.5000 0.6082 103.6980 0.6082 103.8000 0.6937 103.9980 0.6937 104.1000 0.6144 104.2980 0.6144 104.4000 0.5609 104.5980 0.5609 104.7000 0.7432 104.8980 0.7432 105.0000 0.5452 105.1980 0.5452 105.3000 0.5821 105.4980 0.5821 105.6000 0.5732 105.7980 0.5732 105.9000 0.6057 106.0980 0.6057 106.2000 0.5458 106.3980 0.5458 106.5000 0.6020 106.6980 0.6020 106.8000 0.5708 106.9980 0.5708 107.1000 0.5164 107.2980 0.5164 107.4000 0.6817 107.5980 0.6817 107.7000 0.5754 107.8980 0.5754 108.0000 0.6885 108.1980 0.6885 108.3000 0.6888 108.4980 0.6888 108.6000 0.4856 108.7980 0.4856 108.9000 0.6350 109.0980 0.6350 109.2000 0.3627 109.3980 0.3627 109.5000 0.6583 109.6980 0.6583 109.8000 0.3915 109.9980 0.3915 110.1000 0.5095 110.2980 0.5095 110.4000 0.7708 110.5980 0.7708 110.7000 0.4973 110.8980 0.4973 111.0000 0.6048 111.1980 0.6048 111.3000 0.3886 111.4980 0.3886 111.6000 0.4078 111.7980 0.4078 111.9000 0.5004 112.0980 0.5004 112.2000 0.5907 112.3980 0.5907 112.5000 0.3939 112.6980 0.3939 112.8000 0.6037 112.9980 0.6037 113.1000 0.8411 113.2980 0.8411 113.4000 0.3459 113.5980 0.3459 113.7000 0.4569 113.8980 0.4569 114.0000 0.6672 114.1980 0.6672 114.3000 0.6636 114.4980 0.6636 114.6000 0.5998 114.7980 0.5998 114.9000 1.0003 115.0980 1.0003 115.2000 0.5670 115.3980 0.5670 115.5000 1.0167 115.6980 1.0167 115.8000 0.5985 115.9980 0.5985 116.1000 0.5143 116.2980 0.5143 116.4000 0.5913 116.5980 0.5913 116.7000 0.6190 116.8980 0.6190 117.0000 0.5692 117.1980 0.5692 117.3000 0.5961 117.4980 0.5961 117.6000 0.6150 117.7980 0.6150 117.9000 0.5696 118.0980 0.5696 118.2000 0.6065 118.3980 0.6065 118.5000 0.6194 118.6980 0.6194 118.8000 0.6475 118.9980 0.6475 119.1000 0.6056 119.2980 0.6056 119.4000 0.8301 119.5980 0.8301 119.7000 0.5860 119.8980 0.5860 120.0000 0.6538 120.1980 0.6538 120.3000 0.6247 120.4980 0.6247 120.6000 0.5668 120.7980 0.5668 120.9000 0.5998 121.0980 0.5998 121.2000 1.0691 121.3980 1.0691 121.5000 0.6068 121.6980 0.6068 121.8000 0.7579 121.9980 0.7579 122.1000 0.6236 122.2980 0.6236 122.4000 0.6693 122.5980 0.6693 122.7000 0.6006 122.8980 0.6006 123.0000 0.7447 123.1980 0.7447 123.3000 0.5968 123.4980 0.5968 123.6000 0.5883 123.7980 0.5883 123.9000 0.6004 124.0980 0.6004 124.2000 0.5933 124.3980 0.5933 124.5000 0.5768 124.6980 0.5768 124.8000 0.6007 124.9980 0.6007 125.1000 0.6082 125.2980 0.6082 125.4000 0.6937 125.5980 0.6937 125.7000 0.6144 125.8980 0.6144 126.0000 0.5609 126.1980 0.5609 126.3000 0.7432 126.4980 0.7432 126.6000 0.5452 126.7980 0.5452 126.9000 0.5821 127.0980 0.5821 127.2000 0.5732 127.3980 0.5732 127.5000 0.6057 127.6980 0.6057 127.8000 0.5458 127.9980 0.5458 128.1000 0.6020 128.2980 0.6020 128.4000 0.5708 128.5980 0.5708 128.7000 0.5164 128.8980 0.5164 129.0000 0.6817 129.1980 0.6817 129.3000 0.5754 129.4980 0.5754 129.6000 0.6885 129.7980 0.6885 129.9000 0.6888 130.0980 0.6888 130.2000 0.4856 130.3980 0.4856 130.5000 0.6350 130.6980 0.6350 130.8000 0.3627 130.9980 0.3627 131.1000 0.6583 131.2980 0.6583 131.4000 0.3915 131.5980 0.3915 131.7000 0.5095 131.8980 0.5095 132.0000 0.7708 132.1980 0.7708 132.3000 0.4973 132.4980 0.4973 132.6000 0.6048 132.7980 0.6048 132.9000 0.3886 133.0980 0.3886 133.2000 0.4078 133.3980 0.4078 133.5000 0.5004 133.6980 0.5004 133.8000 0.5907 133.9980 0.5907 134.1000 0.3939 134.2980 0.3939 134.4000 0.6037 134.5980 0.6037 134.7000 0.8411 134.8980 0.8411 135.0000 0.3459 135.1980 0.3459 135.3000 0.4569 135.4980 0.4569 135.6000 0.6672 135.7980 0.6672 135.9000 0.6636 136.0980 0.6636 136.2000 0.5998 136.3980 0.5998 136.5000 1.0003 136.6980 1.0003 136.8000 0.5670 136.9980 0.5670 137.1000 1.0167 137.2980 1.0167 137.4000 0.5985 137.5980 0.5985 137.7000 0.5143 137.8980 0.5143 138.0000 0.5913 138.1980 0.5913 138.3000 0.6190 138.4980 0.6190 138.6000 0.5692 138.7980 0.5692 138.9000 0.5961 139.0980 0.5961 139.2000 0.6150 139.3980 0.6150 139.5000 0.5696 139.6980 0.5696 139.8000 0.6065 139.9980 0.6065 140.1000 0.6194 140.2980 0.6194 140.4000 0.6475 140.5980 0.6475 140.7000 0.6056 140.8980 0.6056 141.0000 0.8301 141.1980 0.8301 141.3000 0.5860 141.4980 0.5860 141.6000 0.6538 141.7980 0.6538 141.9000 0.6247 142.0980 0.6247 142.2000 0.5668 142.3980 0.5668 142.5000 0.5998 142.6980 0.5998 142.8000 1.0691 142.9980 1.0691 143.1000 0.6068 143.2980 0.6068 143.4000 0.7579 143.5980 0.7579 143.7000 0.6236 143.8980 0.6236 144.0000 0.6693 144.1980 0.6693 144.3000 0.6006 144.4980 0.6006 144.6000 0.7447 144.7980 0.7447 144.9000 0.5968 145.0980 0.5968 145.2000 0.5883 145.3980 0.5883 145.5000 0.6004 145.6980 0.6004 145.8000 0.5933 145.9980 0.5933 146.1000 0.5768 146.2980 0.5768 146.4000 0.6007 146.5980 0.6007 146.7000 0.6082 146.8980 0.6082 147.0000 0.6937 147.1980 0.6937 147.3000 0.6144 147.4980 0.6144 147.6000 0.5609 147.7980 0.5609 147.9000 0.7432 148.0980 0.7432 148.2000 0.5452 148.3980 0.5452 148.5000 0.5821 148.6980 0.5821 148.8000 0.5732 148.9980 0.5732 149.1000 0.6057 149.2980 0.6057 149.4000 0.5458 149.5980 0.5458 149.7000 0.6020 149.8980 0.6020 150.0000 0.5708 150.1980 0.5708 150.3000 0.5164 150.4980 0.5164 150.6000 0.6817 150.7980 0.6817 150.9000 0.5754 151.0980 0.5754 151.2000 0.6885 151.3980 0.6885 151.5000 0.6888 151.6980 0.6888 151.8000 0.4856 151.9980 0.4856 152.1000 0.6350 152.2980 0.6350 152.4000 0.3627 152.5980 0.3627 152.7000 0.6583 152.8980 0.6583 153.0000 0.3915 153.1980 0.3915 153.3000 0.5095 153.4980 0.5095 153.6000 0.7708 153.7980 0.7708 153.9000 0.4973 154.0980 0.4973 154.2000 0.6048 154.3980 0.6048 154.5000 0.3886 154.6980 0.3886 154.8000 0.4078 154.9980 0.4078 155.1000 0.5004 155.2980 0.5004 155.4000 0.5907 155.5980 0.5907 155.7000 0.3939 155.8980 0.3939 156.0000 0.6037 156.1980 0.6037 156.3000 0.8411 156.4980 0.8411 156.6000 0.3459 156.7980 0.3459 156.9000 0.4569 157.0980 0.4569 157.2000 0.6672 157.3980 0.6672 157.5000 0.6636 157.6980 0.6636 157.8000 0.5998 157.9980 0.5998 158.1000 1.0003 158.2980 1.0003 158.4000 0.5670 158.5980 0.5670 158.7000 1.0167 158.8980 1.0167 159.0000 0.5985 159.1980 0.5985 159.3000 0.5143 159.4980 0.5143 159.6000 0.5913 159.7980 0.5913 159.9000 0.6190 160.0980 0.6190 160.2000 0.5692 160.3980 0.5692 160.5000 0.5961 160.6980 0.5961 160.8000 0.6150 160.9980 0.6150 161.1000 0.5696 161.2980 0.5696 161.4000 0.6065 161.5980 0.6065 161.7000 0.6194 161.8980 0.6194 162.0000 0.6475 162.1980 0.6475 162.3000 0.6056 162.4980 0.6056 162.6000 0.8301 162.7980 0.8301 162.9000 0.5860 163.0980 0.5860 163.2000 0.6538 163.3980 0.6538 163.5000 0.6247 163.6980 0.6247 163.8000 0.5668 163.9980 0.5668 164.1000 0.5998 164.2980 0.5998 164.4000 1.0691 164.5980 1.0691 164.7000 0.6068 164.8980 0.6068 165.0000 0.7579 165.1980 0.7579 165.3000 0.6236 165.4980 0.6236 165.6000 0.6693 165.7980 0.6693 165.9000 0.6006 166.0980 0.6006 166.2000 0.7447 166.3980 0.7447 166.5000 0.5968 166.6980 0.5968 166.8000 0.5883 166.9980 0.5883 167.1000 0.6004 167.2980 0.6004 167.4000 0.5933 167.5980 0.5933 167.7000 0.5768 167.8980 0.5768 168.0000 0.6007 168.1980 0.6007 168.3000 0.6082 168.4980 0.6082 168.6000 0.6937 168.7980 0.6937 168.9000 0.6144 169.0980 0.6144 169.2000 0.5609 169.3980 0.5609 169.5000 0.7432 169.6980 0.7432 169.8000 0.5452 169.9980 0.5452 170.1000 0.5821 170.2980 0.5821 170.4000 0.5732 170.5980 0.5732 170.7000 0.6057 170.8980 0.6057 171.0000 0.5458 171.1980 0.5458 171.3000 0.6020 171.4980 0.6020 171.6000 0.5708 171.7980 0.5708 171.9000 0.5164 172.0980 0.5164 172.2000 0.6817 172.3980 0.6817 172.5000 0.5754 172.6980 0.5754 172.8000 0.6885 172.9980 0.6885 173.1000 0.6888 173.2980 0.6888 173.4000 0.4856 173.5980 0.4856 173.7000 0.6350 173.8980 0.6350 174.0000 0.3627 174.1980 0.3627 174.3000 0.6583 174.4980 0.6583 174.6000 0.3915 174.7980 0.3915 174.9000 0.5095 175.0980 0.5095 175.2000 0.7708 175.3980 0.7708 175.5000 0.4973 175.6980 0.4973 175.8000 0.6048 175.9980 0.6048 176.1000 0.3886 176.2980 0.3886 176.4000 0.4078 176.5980 0.4078 176.7000 0.5004 176.8980 0.5004 177.0000 0.5907 177.1980 0.5907 177.3000 0.3939 177.4980 0.3939 177.6000 0.6037 177.7980 0.6037 177.9000 0.8411 178.0980 0.8411 178.2000 0.3459 178.3980 0.3459 178.5000 0.4569 178.6980 0.4569 178.8000 0.6672 178.9980 0.6672 179.1000 0.6636 179.2980 0.6636 179.4000 0.5998 179.5980 0.5998 179.7000 1.0003 179.8980 1.0003 180.0000 0.5670 180.1980 0.5670 180.3000 1.0167 180.4980 1.0167 180.6000 0.5985 180.7980 0.5985 180.9000 0.5143 181.0980 0.5143 181.2000 0.5913 181.3980 0.5913 181.5000 0.6190 181.6980 0.6190 181.8000 0.5692 181.9980 0.5692 182.1000 0.5961 182.2980 0.5961 182.4000 0.6150 182.5980 0.6150 182.7000 0.5696 182.8980 0.5696 183.0000 0.6065 183.1980 0.6065 183.3000 0.6194 183.4980 0.6194 183.6000 0.6475 183.7980 0.6475 183.9000 0.6056 184.0980 0.6056 184.2000 0.8301 184.3980 0.8301 184.5000 0.5860 184.6980 0.5860 184.8000 0.6538 184.9980 0.6538 185.1000 0.6247 185.2980 0.6247 185.4000 0.5668 185.5980 0.5668 185.7000 0.5998 185.8980 0.5998 186.0000 1.0691 186.1980 1.0691 186.3000 0.6068 186.4980 0.6068 186.6000 0.7579 186.7980 0.7579 186.9000 0.6236 187.0980 0.6236 187.2000 0.6693 187.3980 0.6693 187.5000 0.6006 187.6980 0.6006 187.8000 0.7447 187.9980 0.7447 188.1000 0.5968 188.2980 0.5968 188.4000 0.5883 188.5980 0.5883 188.7000 0.6004 188.8980 0.6004 189.0000 0.5933 189.1980 0.5933 189.3000 0.5768 189.4980 0.5768 189.6000 0.6007 189.7980 0.6007 189.9000 0.6082 190.0980 0.6082 190.2000 0.6937 190.3980 0.6937 190.5000 0.6144 190.6980 0.6144 190.8000 0.5609 190.9980 0.5609 191.1000 0.7432 191.2980 0.7432 191.4000 0.5452 191.5980 0.5452 191.7000 0.5821 191.8980 0.5821 192.0000 0.5732 192.1980 0.5732 192.3000 0.6057 192.4980 0.6057 192.6000 0.5458 192.7980 0.5458 192.9000 0.6020 193.0980 0.6020 193.2000 0.5708 193.3980 0.5708 193.5000 0.5164 193.6980 0.5164 193.8000 0.6817 193.9980 0.6817 194.1000 0.5754 194.2980 0.5754 194.4000 0.6885 194.5980 0.6885 194.7000 0.6888 194.8980 0.6888 195.0000 0.4856 195.1980 0.4856 195.3000 0.6350 195.4980 0.6350 195.6000 0.3627 195.7980 0.3627 195.9000 0.6583 196.0980 0.6583 196.2000 0.3915 196.3980 0.3915 196.5000 0.5095 196.6980 0.5095 196.8000 0.7708 196.9980 0.7708 197.1000 0.4973 197.2980 0.4973 197.4000 0.6048 197.5980 0.6048 197.7000 0.3886 197.8980 0.3886 198.0000 0.4078 198.1980 0.4078 198.3000 0.5004 198.4980 0.5004 198.6000 0.5907 198.7980 0.5907 198.9000 0.3939 199.0980 0.3939 199.2000 0.6037 199.3980 0.6037 199.5000 0.8411 199.6980 0.8411 199.8000 0.3459 199.9980 0.3459 200.1000 0.4569 200.2980 0.4569 200.4000 0.6672 200.5980 0.6672 200.7000 0.6636 200.8980 0.6636 201.0000 0.5998 201.1980 0.5998 201.3000 1.0003 201.4980 1.0003 201.6000 0.5670 201.7980 0.5670 201.9000 1.0167 202.0980 1.0167 202.2000 0.5985 202.3980 0.5985 202.5000 0.5143 202.6980 0.5143 202.8000 0.5913 202.9980 0.5913 203.1000 0.6190 203.2980 0.6190 203.4000 0.5692 203.5980 0.5692 203.7000 0.5961 203.8980 0.5961 204.0000 0.6150 204.1980 0.6150 204.3000 0.5696 204.4980 0.5696 204.6000 0.6065 204.7980 0.6065 204.9000 0.6194 205.0980 0.6194 205.2000 0.6475 205.3980 0.6475 205.5000 0.6056 205.6980 0.6056 205.8000 0.8301 205.9980 0.8301 206.1000 0.5860 206.2980 0.5860 206.4000 0.6538 206.5980 0.6538 206.7000 0.6247 206.8980 0.6247 207.0000 0.5668 207.1980 0.5668 207.3000 0.5998 207.4980 0.5998 207.6000 1.0691 207.7980 1.0691 207.9000 0.6068 208.0980 0.6068 208.2000 0.7579 208.3980 0.7579 208.5000 0.6236 208.6980 0.6236 208.8000 0.6693 208.9980 0.6693 209.1000 0.6006 209.2980 0.6006 209.4000 0.7447 209.5980 0.7447 209.7000 0.5968 209.8980 0.5968 210.0000 0.5883 210.1980 0.5883 210.3000 0.6004 210.4980 0.6004 210.6000 0.5933 210.7980 0.5933 210.9000 0.5768 211.0980 0.5768 211.2000 0.6007 211.3980 0.6007 211.5000 0.6082 211.6980 0.6082 211.8000 0.6937 211.9980 0.6937 212.1000 0.6144 212.2980 0.6144 212.4000 0.5609 212.5980 0.5609 212.7000 0.7432 212.8980 0.7432 213.0000 0.5452 213.1980 0.5452 213.3000 0.5821 213.4980 0.5821 213.6000 0.5732 213.7980 0.5732 213.9000 0.6057 214.0980 0.6057 214.2000 0.5458 214.3980 0.5458 214.5000 0.6020 214.6980 0.6020 214.8000 0.5708 214.9980 0.5708 215.1000 0.5164 215.2980 0.5164 215.4000 0.6817 215.5980 0.6817 215.7000 0.5754 215.8980 0.5754 216.0000 0.6885 216.1980 0.6885 216.3000 0.6888 216.4980 0.6888 216.6000 0.4856 216.7980 0.4856 216.9000 0.6350 217.0980 0.6350 217.2000 0.3627 217.3980 0.3627 217.5000 0.6583 217.6980 0.6583 217.8000 0.3915 217.9980 0.3915 218.1000 0.5095 218.2980 0.5095 218.4000 0.7708 218.5980 0.7708 218.7000 0.4973 218.8980 0.4973 219.0000 0.6048 219.1980 0.6048 219.3000 0.3886 219.4980 0.3886 219.6000 0.4078 219.7980 0.4078 219.9000 0.5004 220.0980 0.5004 220.2000 0.5907 220.3980 0.5907 220.5000 0.3939 220.6980 0.3939 220.8000 0.6037 220.9980 0.6037 221.1000 0.8411 221.2980 0.8411 221.4000 0.3459 221.5980 0.3459 221.7000 0.4569 221.8980 0.4569 222.0000 0.6672 222.1980 0.6672 222.3000 0.6636 222.4980 0.6636 222.6000 0.5998 222.7980 0.5998 222.9000 1.0003 223.0980 1.0003 223.2000 0.5670 223.3980 0.5670 223.5000 1.0167 223.6980 1.0167 223.8000 0.5985 223.9980 0.5985 224.1000 0.5143 224.2980 0.5143 224.4000 0.5913 224.5980 0.5913 224.7000 0.6190 224.8980 0.6190 225.0000 0.5692 225.1980 0.5692 225.3000 0.5961 225.4980 0.5961 225.6000 0.6150 225.7980 0.6150 225.9000 0.5696 226.0980 0.5696 226.2000 0.6065 226.3980 0.6065 226.5000 0.6194 226.6980 0.6194 226.8000 0.6475 226.9980 0.6475 227.1000 0.6056 227.2980 0.6056 227.4000 0.8301 227.5980 0.8301 227.7000 0.5860 227.8980 0.5860 228.0000 0.6538 228.1980 0.6538 228.3000 0.6247 228.4980 0.6247 228.6000 0.5668 228.7980 0.5668 228.9000 0.5998 229.0980 0.5998 229.2000 1.0691 229.3980 1.0691 229.5000 0.6068 229.6980 0.6068 229.8000 0.7579 229.9980 0.7579 230.1000 0.6236 230.2980 0.6236 230.4000 0.6693 230.5980 0.6693 230.7000 0.6006 230.8980 0.6006 231.0000 0.7447 231.1980 0.7447 231.3000 0.5968 231.4980 0.5968 231.6000 0.5883 231.7980 0.5883 231.9000 0.6004 232.0980 0.6004 232.2000 0.5933 232.3980 0.5933 232.5000 0.5768 232.6980 0.5768 232.8000 0.6007 232.9980 0.6007 233.1000 0.6082 233.2980 0.6082 233.4000 0.6937 233.5980 0.6937 233.7000 0.6144 233.8980 0.6144 234.0000 0.5609 234.1980 0.5609 234.3000 0.7432 234.4980 0.7432 234.6000 0.5452 234.7980 0.5452 234.9000 0.5821 235.0980 0.5821 235.2000 0.5732 235.3980 0.5732 235.5000 0.6057 235.6980 0.6057 235.8000 0.5458 235.9980 0.5458 236.1000 0.6020 236.2980 0.6020 236.4000 0.5708 236.5980 0.5708 236.7000 0.5164 236.8980 0.5164 237.0000 0.6817 237.1980 0.6817 237.3000 0.5754 237.4980 0.5754 237.6000 0.6885 237.7980 0.6885 237.9000 0.6888 238.0980 0.6888 238.2000 0.4856 238.3980 0.4856 238.5000 0.6350 238.6980 0.6350 238.8000 0.3627 238.9980 0.3627 239.1000 0.6583 239.2980 0.6583 239.4000 0.3915 239.5980 0.3915 239.7000 0.5095 239.8980 0.5095 240.0000 0.7708 240.1980 0.7708 240.3000 0.4973 240.4980 0.4973 240.6000 0.6048 240.7980 0.6048 240.9000 0.3886 241.0980 0.3886 241.2000 0.4078 241.3980 0.4078 241.5000 0.5004 241.6980 0.5004 241.8000 0.5907 241.9980 0.5907 242.1000 0.3939 242.2980 0.3939 242.4000 0.6037 242.5980 0.6037 242.7000 0.8411 242.8980 0.8411 243.0000 0.3459 243.1980 0.3459 243.3000 0.4569 243.4980 0.4569 243.6000 0.6672 243.7980 0.6672 243.9000 0.6636 244.0980 0.6636 244.2000 0.5998 244.3980 0.5998 244.5000 1.0003 244.6980 1.0003 244.8000 0.5670 244.9980 0.5670 245.1000 1.0167 245.2980 1.0167 245.4000 0.5985 245.5980 0.5985 245.7000 0.5143 245.8980 0.5143 246.0000 0.5913 246.1980 0.5913 246.3000 0.6190 246.4980 0.6190 246.6000 0.5692 246.7980 0.5692 246.9000 0.5961 247.0980 0.5961 247.2000 0.6150 247.3980 0.6150 247.5000 0.5696 247.6980 0.5696 247.8000 0.6065 247.9980 0.6065 248.1000 0.6194 248.2980 0.6194 248.4000 0.6475 248.5980 0.6475 248.7000 0.6056 248.8980 0.6056 249.0000 0.8301 249.1980 0.8301 249.3000 0.5860 249.4980 0.5860 249.6000 0.6538 249.7980 0.6538 249.9000 0.6247 250.0980 0.6247 250.2000 0.5668 250.3980 0.5668 250.5000 0.5998 250.6980 0.5998 250.8000 1.0691 250.9980 1.0691 251.1000 0.6068 251.2980 0.6068 251.4000 0.7579 251.5980 0.7579 251.7000 0.6236 251.8980 0.6236 252.0000 0.6693 252.1980 0.6693 252.3000 0.6006 252.4980 0.6006 252.6000 0.7447 252.7980 0.7447 252.9000 0.5968 253.0980 0.5968 253.2000 0.5883 253.3980 0.5883 253.5000 0.6004 253.6980 0.6004 253.8000 0.5933 253.9980 0.5933 254.1000 0.5768 254.2980 0.5768 254.4000 0.6007 254.5980 0.6007 254.7000 0.6082 254.8980 0.6082 255.0000 0.6937 255.1980 0.6937 255.3000 0.6144 255.4980 0.6144 255.6000 0.5609 255.7980 0.5609 255.9000 0.7432 256.0980 0.7432 256.2000 0.5452 256.3980 0.5452 256.5000 0.5821 256.6980 0.5821 256.8000 0.5732 256.9980 0.5732 257.1000 0.6057 257.2980 0.6057 257.4000 0.5458 257.5980 0.5458 257.7000 0.6020 257.8980 0.6020 258.0000 0.5708 258.1980 0.5708 258.3000 0.5164 258.4980 0.5164 258.6000 0.6817 258.7980 0.6817 258.9000 0.5754 259.0980 0.5754 259.2000 0.6885 259.3980 0.6885 259.5000 0.6888 259.6980 0.6888 259.8000 0.4856 259.9980 0.4856 260.1000 0.6350 260.2980 0.6350 260.4000 0.3627 260.5980 0.3627 260.7000 0.6583 260.8980 0.6583 261.0000 0.3915 261.1980 0.3915 261.3000 0.5095 261.4980 0.5095 261.6000 0.7708 261.7980 0.7708 261.9000 0.4973 262.0980 0.4973 262.2000 0.6048 262.3980 0.6048 262.5000 0.3886 262.6980 0.3886 262.8000 0.4078 262.9980 0.4078 263.1000 0.5004 263.2980 0.5004 263.4000 0.5907 263.5980 0.5907 263.7000 0.3939 263.8980 0.3939 264.0000 0.6037 264.1980 0.6037 264.3000 0.8411 264.4980 0.8411 264.6000 0.3459 264.7980 0.3459 264.9000 0.4569 265.0980 0.4569 265.2000 0.6672 265.3980 0.6672 265.5000 0.6636 265.6980 0.6636 265.8000 0.5998 265.9980 0.5998 266.1000 1.0003 266.2980 1.0003 266.4000 0.5670 266.5980 0.5670 266.7000 1.0167 266.8980 1.0167 267.0000 0.5985 267.1980 0.5985 267.3000 0.5143 267.4980 0.5143 267.6000 0.5913 267.7980 0.5913 267.9000 0.6190 268.0980 0.6190 268.2000 0.5692 268.3980 0.5692 268.5000 0.5961 268.6980 0.5961 268.8000 0.6150 268.9980 0.6150 269.1000 0.5696 269.2980 0.5696 269.4000 0.6065 269.5980 0.6065 269.7000 0.6194 269.8980 0.6194 270.0000 0.6475 270.1980 0.6475 270.3000 0.6056 270.4980 0.6056 270.6000 0.8301 270.7980 0.8301 270.9000 0.5860 271.0980 0.5860 271.2000 0.6538 271.3980 0.6538 271.5000 0.6247 271.6980 0.6247 271.8000 0.5668 271.9980 0.5668 272.1000 0.5998 272.2980 0.5998 272.4000 1.0691 272.5980 1.0691 272.7000 0.6068 272.8980 0.6068 273.0000 0.7579 273.1980 0.7579 273.3000 0.6236 273.4980 0.6236 273.6000 0.6693 273.7980 0.6693 273.9000 0.6006 274.0980 0.6006 274.2000 0.7447 274.3980 0.7447 274.5000 0.5968 274.6980 0.5968 274.8000 0.5883 274.9980 0.5883 275.1000 0.6004 275.2980 0.6004 275.4000 0.5933 275.5980 0.5933 275.7000 0.5768 275.8980 0.5768 276.0000 0.6007 276.1980 0.6007 276.3000 0.6082 276.4980 0.6082 276.6000 0.6937 276.7980 0.6937 276.9000 0.6144 277.0980 0.6144 277.2000 0.5609 277.3980 0.5609 277.5000 0.7432 277.6980 0.7432 277.8000 0.5452 277.9980 0.5452 278.1000 0.5821 278.2980 0.5821 278.4000 0.5732 278.5980 0.5732 278.7000 0.6057 278.8980 0.6057 279.0000 0.5458 279.1980 0.5458 279.3000 0.6020 279.4980 0.6020 279.6000 0.5708 279.7980 0.5708 279.9000 0.5164 280.0980 0.5164 280.2000 0.6817 280.3980 0.6817 280.5000 0.5754 280.6980 0.5754 280.8000 0.6885 280.9980 0.6885 281.1000 0.6888 281.2980 0.6888 281.4000 0.4856 281.5980 0.4856 281.7000 0.6350 281.8980 0.6350 282.0000 0.3627 282.1980 0.3627 282.3000 0.6583 282.4980 0.6583 282.6000 0.3915 282.7980 0.3915 282.9000 0.5095 283.0980 0.5095 283.2000 0.7708 283.3980 0.7708 283.5000 0.4973 283.6980 0.4973 283.8000 0.6048 283.9980 0.6048 284.1000 0.3886 284.2980 0.3886 284.4000 0.4078 284.5980 0.4078 284.7000 0.5004 284.8980 0.5004 285.0000 0.5907 285.1980 0.5907 285.3000 0.3939 285.4980 0.3939 285.6000 0.6037 285.7980 0.6037 285.9000 0.8411 286.0980 0.8411 286.2000 0.3459 286.3980 0.3459 286.5000 0.4569 286.6980 0.4569 286.8000 0.6672 286.9980 0.6672 287.1000 0.6636 287.2980 0.6636 287.4000 0.5998 287.5980 0.5998 287.7000 1.0003 287.8980 1.0003 288.0000 0.5670 288.1980 0.5670 288.3000 1.0167 288.4980 1.0167 288.6000 0.5985 288.7980 0.5985 288.9000 0.5143 289.0980 0.5143 289.2000 0.5913 289.3980 0.5913 289.5000 0.6190 289.6980 0.6190 289.8000 0.5692 289.9980 0.5692 290.1000 0.5961 290.2980 0.5961 290.4000 0.6150 290.5980 0.6150 290.7000 0.5696 290.8980 0.5696 291.0000 0.6065 291.1980 0.6065 291.3000 0.6194 291.4980 0.6194 291.6000 0.6475 291.7980 0.6475 291.9000 0.6056 292.0980 0.6056 292.2000 0.8301 292.3980 0.8301 292.5000 0.5860 292.6980 0.5860 292.8000 0.6538 292.9980 0.6538 293.1000 0.6247 293.2980 0.6247 293.4000 0.5668 293.5980 0.5668 293.7000 0.5998 293.8980 0.5998 294.0000 1.0691 294.1980 1.0691 294.3000 0.6068 294.4980 0.6068 294.6000 0.7579 294.7980 0.7579 294.9000 0.6236 295.0980 0.6236 295.2000 0.6693 295.3980 0.6693 295.5000 0.6006 295.6980 0.6006 295.8000 0.7447 295.9980 0.7447 296.1000 0.5968 296.2980 0.5968 296.4000 0.5883 296.5980 0.5883 296.7000 0.6004 296.8980 0.6004 297.0000 0.5933 297.1980 0.5933 297.3000 0.5768 297.4980 0.5768 297.6000 0.6007 297.7980 0.6007 297.9000 0.6082 298.0980 0.6082 298.2000 0.6937 298.3980 0.6937 298.5000 0.6144 298.6980 0.6144 298.8000 0.5609 298.9980 0.5609 299.1000 0.7432 299.2980 0.7432 299.4000 0.5452 299.5980 0.5452 299.7000 0.5821 299.8980 0.5821 300.0000 0.5732 300.1980 0.5732 300.3000 0.6057 300.4980 0.6057 300.6000 0.5458 300.7980 0.5458 300.9000 0.6020 301.0980 0.6020 301.2000 0.5708 301.3980 0.5708 301.5000 0.5164 301.6980 0.5164 301.8000 0.6817 301.9980 0.6817 302.1000 0.5754 302.2980 0.5754 302.4000 0.6885 302.5980 0.6885 302.7000 0.6888 302.8980 0.6888 303.0000 0.4856 303.1980 0.4856 303.3000 0.6350 303.4980 0.6350 303.6000 0.3627 303.7980 0.3627 303.9000 0.6583 304.0980 0.6583 304.2000 0.3915 304.3980 0.3915 304.5000 0.5095 304.6980 0.5095 304.8000 0.7708 304.9980 0.7708 305.1000 0.4973 305.2980 0.4973 305.4000 0.6048 305.5980 0.6048 305.7000 0.3886 305.8980 0.3886 306.0000 0.4078 306.1980 0.4078 306.3000 0.5004 306.4980 0.5004 306.6000 0.5907 306.7980 0.5907 306.9000 0.3939 307.0980 0.3939 307.2000 0.6037 307.3980 0.6037 307.5000 0.8411 307.6980 0.8411 307.8000 0.3459 307.9980 0.3459 308.1000 0.4569 308.2980 0.4569 308.4000 0.6672 308.5980 0.6672 308.7000 0.6636 308.8980 0.6636 309.0000 0.5998 309.1980 0.5998 309.3000 1.0003 309.4980 1.0003 309.6000 0.5670 309.7980 0.5670 309.9000 1.0167 310.0980 1.0167 310.2000 0.5985 310.3980 0.5985 310.5000 0.5143 310.6980 0.5143 310.8000 0.5913 310.9980 0.5913 311.1000 0.6190 311.2980 0.6190 311.4000 0.5692 311.5980 0.5692 311.7000 0.5961 311.8980 0.5961 312.0000 0.6150 312.1980 0.6150 312.3000 0.5696 312.4980 0.5696 312.6000 0.6065 312.7980 0.6065 312.9000 0.6194 313.0980 0.6194 313.2000 0.6475 313.3980 0.6475 313.5000 0.6056 313.6980 0.6056 313.8000 0.8301 313.9980 0.8301 314.1000 0.5860 314.2980 0.5860 314.4000 0.6538 314.5980 0.6538 314.7000 0.6247 314.8980 0.6247 315.0000 0.5668 315.1980 0.5668 315.3000 0.5998 315.4980 0.5998 315.6000 1.0691 315.7980 1.0691 315.9000 0.6068 316.0980 0.6068 316.2000 0.7579 316.3980 0.7579 316.5000 0.6236 316.6980 0.6236 316.8000 0.6693 316.9980 0.6693 317.1000 0.6006 317.2980 0.6006 317.4000 0.7447 317.5980 0.7447 317.7000 0.5968 317.8980 0.5968 318.0000 0.5883 318.1980 0.5883 318.3000 0.6004 318.4980 0.6004 318.6000 0.5933 318.7980 0.5933 318.9000 0.5768 319.0980 0.5768 319.2000 0.6007 319.3980 0.6007 319.5000 0.6082 319.6980 0.6082 319.8000 0.6937 319.9980 0.6937 320.1000 0.6144 320.2980 0.6144 320.4000 0.5609 320.5980 0.5609 320.7000 0.7432 320.8980 0.7432 321.0000 0.5452 321.1980 0.5452 321.3000 0.5821 321.4980 0.5821 321.6000 0.5732 321.7980 0.5732 321.9000 0.6057 322.0980 0.6057 322.2000 0.5458 322.3980 0.5458 322.5000 0.6020 322.6980 0.6020 322.8000 0.5708 322.9980 0.5708 323.1000 0.5164 323.2980 0.5164 323.4000 0.6817 323.5980 0.6817 323.7000 0.5754 323.8980 0.5754 324.0000 0.6885 324.1980 0.6885 324.3000 0.6888 324.4980 0.6888 324.6000 0.4856 324.7980 0.4856 324.9000 0.6350 325.0980 0.6350 325.2000 0.3627 325.3980 0.3627 325.5000 0.6583 325.6980 0.6583 325.8000 0.3915 325.9980 0.3915 326.1000 0.5095 326.2980 0.5095 326.4000 0.7708 326.5980 0.7708 326.7000 0.4973 326.8980 0.4973 327.0000 0.6048 327.1980 0.6048 327.3000 0.3886 327.4980 0.3886 327.6000 0.4078 327.7980 0.4078 327.9000 0.5004 328.0980 0.5004 328.2000 0.5907 328.3980 0.5907 328.5000 0.3939 328.6980 0.3939 328.8000 0.6037 328.9980 0.6037 329.1000 0.8411 329.2980 0.8411 329.4000 0.3459 329.5980 0.3459 329.7000 0.4569 329.8980 0.4569 330.0000 0.6672 330.1980 0.6672 330.3000 0.6636 330.4980 0.6636 330.6000 0.5998 330.7980 0.5998 330.9000 1.0003 331.0980 1.0003 331.2000 0.5670 331.3980 0.5670 331.5000 1.0167 331.6980 1.0167 331.8000 0.5985 331.9980 0.5985 332.1000 0.5143 332.2980 0.5143 332.4000 0.5913 332.5980 0.5913 332.7000 0.6190 332.8980 0.6190 333.0000 0.5692 333.1980 0.5692 333.3000 0.5961 333.4980 0.5961 333.6000 0.6150 333.7980 0.6150 333.9000 0.5696 334.0980 0.5696 334.2000 0.6065 334.3980 0.6065 334.5000 0.6194 334.6980 0.6194 334.8000 0.6475 334.9980 0.6475 335.1000 0.6056 335.2980 0.6056 335.4000 0.8301 335.5980 0.8301 335.7000 0.5860 335.8980 0.5860 336.0000 0.6538 336.1980 0.6538 336.3000 0.6247 336.4980 0.6247 336.6000 0.5668 336.7980 0.5668 336.9000 0.5998 337.0980 0.5998 337.2000 1.0691 337.3980 1.0691 337.5000 0.6068 337.6980 0.6068 337.8000 0.7579 337.9980 0.7579 338.1000 0.6236 338.2980 0.6236 338.4000 0.6693 338.5980 0.6693 338.7000 0.6006 338.8980 0.6006 339.0000 0.7447 339.1980 0.7447 339.3000 0.5968 339.4980 0.5968 339.6000 0.5883 339.7980 0.5883 339.9000 0.6004 340.0980 0.6004 340.2000 0.5933 340.3980 0.5933 340.5000 0.5768 340.6980 0.5768 340.8000 0.6007 340.9980 0.6007 341.1000 0.6082 341.2980 0.6082 341.4000 0.6937 341.5980 0.6937 341.7000 0.6144 341.8980 0.6144 342.0000 0.5609 342.1980 0.5609 342.3000 0.7432 342.4980 0.7432 342.6000 0.5452 342.7980 0.5452 342.9000 0.5821 343.0980 0.5821 343.2000 0.5732 343.3980 0.5732 343.5000 0.6057 343.6980 0.6057 343.8000 0.5458 343.9980 0.5458 344.1000 0.6020 344.2980 0.6020 344.4000 0.5708 344.5980 0.5708 344.7000 0.5164 344.8980 0.5164 345.0000 0.6817 345.1980 0.6817 345.3000 0.5754 345.4980 0.5754 345.6000 0.6885 345.7980 0.6885 345.9000 0.6888 346.0980 0.6888 346.2000 0.4856 346.3980 0.4856 346.5000 0.6350 346.6980 0.6350 346.8000 0.3627 346.9980 0.3627 347.1000 0.6583 347.2980 0.6583 347.4000 0.3915 347.5980 0.3915 347.7000 0.5095 347.8980 0.5095 348.0000 0.7708 348.1980 0.7708 348.3000 0.4973 348.4980 0.4973 348.6000 0.6048 348.7980 0.6048 348.9000 0.3886 349.0980 0.3886 349.2000 0.4078 349.3980 0.4078 349.5000 0.5004 349.6980 0.5004 349.8000 0.5907 349.9980 0.5907 350.1000 0.3939 350.2980 0.3939 350.4000 0.6037 350.5980 0.6037 350.7000 0.8411 350.8980 0.8411 351.0000 0.3459 351.1980 0.3459 351.3000 0.4569 351.4980 0.4569 351.6000 0.6672 351.7980 0.6672 351.9000 0.6636 352.0980 0.6636 352.2000 0.5998 352.3980 0.5998 352.5000 1.0003 352.6980 1.0003 352.8000 0.5670 352.9980 0.5670 353.1000 1.0167 353.2980 1.0167 353.4000 0.5985 353.5980 0.5985 353.7000 0.5143 353.8980 0.5143 354.0000 0.5913 354.1980 0.5913 354.3000 0.6190 354.4980 0.6190 354.6000 0.5692 354.7980 0.5692 354.9000 0.5961 355.0980 0.5961 355.2000 0.6150 355.3980 0.6150 355.5000 0.5696 355.6980 0.5696 355.8000 0.6065 355.9980 0.6065 356.1000 0.6194 356.2980 0.6194 356.4000 0.6475 356.5980 0.6475 356.7000 0.6056 356.8980 0.6056 357.0000 0.8301 357.1980 0.8301 357.3000 0.5860 357.4980 0.5860 357.6000 0.6538 357.7980 0.6538 357.9000 0.6247 358.0980 0.6247 358.2000 0.5668 358.3980 0.5668 358.5000 0.5998 358.6980 0.5998 358.8000 1.0691 358.9980 1.0691 359.1000 0.6068 359.2980 0.6068 359.4000 0.7579 359.5980 0.7579 359.7000 0.6236 359.8980 0.6236 360.0000 0.6693 360.1980 0.6693 360.3000 0.6006 360.4980 0.6006 360.6000 0.7447 360.7980 0.7447 360.9000 0.5968 361.0980 0.5968 361.2000 0.5883 361.3980 0.5883 361.5000 0.6004 361.6980 0.6004 361.8000 0.5933 361.9980 0.5933 362.1000 0.5768 362.2980 0.5768 362.4000 0.6007 362.5980 0.6007 362.7000 0.6082 362.8980 0.6082 363.0000 0.6937 363.1980 0.6937 363.3000 0.6144 363.4980 0.6144 363.6000 0.5609 363.7980 0.5609 363.9000 0.7432 364.0980 0.7432 364.2000 0.5452 364.3980 0.5452 364.5000 0.5821 364.6980 0.5821 364.8000 0.5732 364.9980 0.5732 365.1000 0.6057 365.2980 0.6057 365.4000 0.5458 365.5980 0.5458 365.7000 0.6020 365.8980 0.6020 366.0000 0.5708 366.1980 0.5708 366.3000 0.5164 366.4980 0.5164 366.6000 0.6817 366.7980 0.6817 366.9000 0.5754 367.0980 0.5754 367.2000 0.6885 367.3980 0.6885 367.5000 0.6888 367.6980 0.6888 367.8000 0.4856 367.9980 0.4856 368.1000 0.6350 368.2980 0.6350 368.4000 0.3627 368.5980 0.3627 368.7000 0.6583 368.8980 0.6583 369.0000 0.3915 369.1980 0.3915 369.3000 0.5095 369.4980 0.5095 369.6000 0.7708 369.7980 0.7708 369.9000 0.4973 370.0980 0.4973 370.2000 0.6048 370.3980 0.6048 370.5000 0.3886 370.6980 0.3886 370.8000 0.4078 370.9980 0.4078 371.1000 0.5004 371.2980 0.5004 371.4000 0.5907 371.5980 0.5907 371.7000 0.3939 371.8980 0.3939 372.0000 0.6037 372.1980 0.6037 372.3000 0.8411 372.4980 0.8411 372.6000 0.3459 372.7980 0.3459 372.9000 0.4569 373.0980 0.4569 373.2000 0.6672 373.3980 0.6672 373.5000 0.6636 373.6980 0.6636 373.8000 0.5998 373.9980 0.5998 374.1000 1.0003 374.2980 1.0003 374.4000 0.5670 374.5980 0.5670 374.7000 1.0167 374.8980 1.0167 375.0000 0.5985 375.1980 0.5985 375.3000 0.5143 375.4980 0.5143 375.6000 0.5913 375.7980 0.5913 375.9000 0.6190 376.0980 0.6190 376.2000 0.5692 376.3980 0.5692 376.5000 0.5961 376.6980 0.5961 376.8000 0.6150 376.9980 0.6150 377.1000 0.5696 377.2980 0.5696 377.4000 0.6065 377.5980 0.6065 377.7000 0.6194 377.8980 0.6194 378.0000 0.6475 378.1980 0.6475 378.3000 0.6056 378.4980 0.6056 378.6000 0.8301 378.7980 0.8301 378.9000 0.5860 379.0980 0.5860 379.2000 0.6538 379.3980 0.6538 379.5000 0.6247 379.6980 0.6247 379.8000 0.5668 379.9980 0.5668 380.1000 0.5998 380.2980 0.5998 380.4000 1.0691 380.5980 1.0691 380.7000 0.6068 380.8980 0.6068 381.0000 0.7579 381.1980 0.7579 381.3000 0.6236 381.4980 0.6236 381.6000 0.6693 381.7980 0.6693 381.9000 0.6006 382.0980 0.6006 382.2000 0.7447 382.3980 0.7447 382.5000 0.5968 382.6980 0.5968 382.8000 0.5883 382.9980 0.5883 383.1000 0.6004 383.2980 0.6004 383.4000 0.5933 383.5980 0.5933 383.7000 0.5768 383.8980 0.5768 384.0000 0.6007 384.1980 0.6007 384.3000 0.6082 384.4980 0.6082 384.6000 0.6937 384.7980 0.6937 384.9000 0.6144 385.0980 0.6144 385.2000 0.5609 385.3980 0.5609 385.5000 0.7432 385.6980 0.7432 385.8000 0.5452 385.9980 0.5452 386.1000 0.5821 386.2980 0.5821 386.4000 0.5732 386.5980 0.5732 386.7000 0.6057 386.8980 0.6057 387.0000 0.5458 387.1980 0.5458 387.3000 0.6020 387.4980 0.6020 387.6000 0.5708 387.7980 0.5708 387.9000 0.5164 388.0980 0.5164 388.2000 0.6817 388.3980 0.6817 388.5000 0.5754 388.6980 0.5754 388.8000 0.6885 388.9980 0.6885 389.1000 0.6888 389.2980 0.6888 389.4000 0.4856 389.5980 0.4856 389.7000 0.6350 389.8980 0.6350 390.0000 0.3627 390.1980 0.3627 390.3000 0.6583 390.4980 0.6583 390.6000 0.3915 390.7980 0.3915 390.9000 0.5095 391.0980 0.5095 391.2000 0.7708 391.3980 0.7708 391.5000 0.4973 391.6980 0.4973 391.8000 0.6048 391.9980 0.6048 392.1000 0.3886 392.2980 0.3886 392.4000 0.4078 392.5980 0.4078 392.7000 0.5004 392.8980 0.5004 393.0000 0.5907 393.1980 0.5907 393.3000 0.3939 393.4980 0.3939 393.6000 0.6037 393.7980 0.6037 393.9000 0.8411 394.0980 0.8411 394.2000 0.3459 394.3980 0.3459 394.5000 0.4569 394.6980 0.4569 394.8000 0.6672 394.9980 0.6672 395.1000 0.6636 395.2980 0.6636 395.4000 0.5998 395.5980 0.5998 395.7000 1.0003 395.8980 1.0003 396.0000 0.5670 396.1980 0.5670 396.3000 1.0167 396.4980 1.0167 396.6000 0.5985 396.7980 0.5985 396.9000 0.5143 397.0980 0.5143 397.2000 0.5913 397.3980 0.5913 397.5000 0.6190 397.6980 0.6190 397.8000 0.5692 397.9980 0.5692 398.1000 0.5961 398.2980 0.5961 398.4000 0.6150 398.5980 0.6150 398.7000 0.5696 398.8980 0.5696 399.0000 0.6065 399.1980 0.6065 399.3000 0.6194 399.4980 0.6194 399.6000 0.6475 399.7980 0.6475 399.9000 0.6056 400.0980 0.6056 400.2000 0.8301 400.3980 0.8301 400.5000 0.5860 400.6980 0.5860 400.8000 0.6538 400.9980 0.6538 401.1000 0.6247 401.2980 0.6247 401.4000 0.5668 401.5980 0.5668 401.7000 0.5998 401.8980 0.5998 402.0000 1.0691 402.1980 1.0691 402.3000 0.6068 402.4980 0.6068 402.6000 0.7579 402.7980 0.7579 402.9000 0.6236 403.0980 0.6236 403.2000 0.6693 403.3980 0.6693 403.5000 0.6006 403.6980 0.6006 403.8000 0.7447 403.9980 0.7447 404.1000 0.5968 404.2980 0.5968 404.4000 0.5883 404.5980 0.5883 404.7000 0.6004 404.8980 0.6004 405.0000 0.5933 405.1980 0.5933 405.3000 0.5768 405.4980 0.5768 405.6000 0.6007 405.7980 0.6007 405.9000 0.6082 406.0980 0.6082 406.2000 0.6937 406.3980 0.6937 406.5000 0.6144 406.6980 0.6144 406.8000 0.5609 406.9980 0.5609 407.1000 0.7432 407.2980 0.7432 407.4000 0.5452 407.5980 0.5452 407.7000 0.5821 407.8980 0.5821 408.0000 0.5732 408.1980 0.5732 408.3000 0.6057 408.4980 0.6057 408.6000 0.5458 408.7980 0.5458 408.9000 0.6020 409.0980 0.6020 409.2000 0.5708 409.3980 0.5708 409.5000 0.5164 409.6980 0.5164 409.8000 0.6817 409.9980 0.6817 410.1000 0.5754 410.2980 0.5754 410.4000 0.6885 410.5980 0.6885 410.7000 0.6888 410.8980 0.6888 411.0000 0.4856 411.1980 0.4856 411.3000 0.6350 411.4980 0.6350 411.6000 0.3627 411.7980 0.3627 411.9000 0.6583 412.0980 0.6583 412.2000 0.3915 412.3980 0.3915 412.5000 0.5095 412.6980 0.5095 412.8000 0.7708 412.9980 0.7708 413.1000 0.4973 413.2980 0.4973 413.4000 0.6048 413.5980 0.6048 413.7000 0.3886 413.8980 0.3886 414.0000 0.4078 414.1980 0.4078 414.3000 0.5004 414.4980 0.5004 414.6000 0.5907 414.7980 0.5907 414.9000 0.3939 415.0980 0.3939 415.2000 0.6037 415.3980 0.6037 415.5000 0.8411 415.6980 0.8411 415.8000 0.3459 415.9980 0.3459 416.1000 0.4569 416.2980 0.4569 416.4000 0.6672 416.5980 0.6672 416.7000 0.6636 416.8980 0.6636 417.0000 0.5998 417.1980 0.5998 417.3000 1.0003 417.4980 1.0003 417.6000 0.5670 417.7980 0.5670 417.9000 1.0167 418.0980 1.0167 418.2000 0.5985 418.3980 0.5985 418.5000 0.5143 418.6980 0.5143 418.8000 0.5913 418.9980 0.5913 419.1000 0.6190 419.2980 0.6190 419.4000 0.5692 419.5980 0.5692 419.7000 0.5961 419.8980 0.5961 420.0000 0.6150 420.1980 0.6150 420.3000 0.5696 420.4980 0.5696 420.6000 0.6065 420.7980 0.6065 420.9000 0.6194 421.0980 0.6194 421.2000 0.6475 421.3980 0.6475 421.5000 0.6056 421.6980 0.6056 421.8000 0.8301 421.9980 0.8301 422.1000 0.5860 422.2980 0.5860 422.4000 0.6538 422.5980 0.6538 422.7000 0.6247 422.8980 0.6247 423.0000 0.5668 423.1980 0.5668 423.3000 0.5998 423.4980 0.5998 423.6000 1.0691 423.7980 1.0691 423.9000 0.6068 424.0980 0.6068 424.2000 0.7579 424.3980 0.7579 424.5000 0.6236 424.6980 0.6236 424.8000 0.6693 424.9980 0.6693 425.1000 0.6006 425.2980 0.6006 425.4000 0.7447 425.5980 0.7447 425.7000 0.5968 425.8980 0.5968 426.0000 0.5883 426.1980 0.5883 426.3000 0.6004 426.4980 0.6004 426.6000 0.5933 426.7980 0.5933 426.9000 0.5768 427.0980 0.5768 427.2000 0.6007 427.3980 0.6007 427.5000 0.6082 427.6980 0.6082 427.8000 0.6937 427.9980 0.6937 428.1000 0.6144 428.2980 0.6144 428.4000 0.5609 428.5980 0.5609 428.7000 0.7432 428.8980 0.7432 429.0000 0.5452 429.1980 0.5452 429.3000 0.5821 429.4980 0.5821 429.6000 0.5732 429.7980 0.5732 429.9000 0.6057 430.0980 0.6057 430.2000 0.5458 430.3980 0.5458 430.5000 0.6020 430.6980 0.6020 430.8000 0.5708 430.9980 0.5708 431.1000 0.5164 431.2980 0.5164 431.4000 0.6817 431.5980 0.6817 431.7000 0.5754 431.8980 0.5754 432.0000 0.6885 432.1980 0.6885 432.3000 0.6888 432.4980 0.6888 432.6000 0.4856 432.7980 0.4856 432.9000 0.6350 433.0980 0.6350 433.2000 0.3627 433.3980 0.3627 433.5000 0.6583 433.6980 0.6583 433.8000 0.3915 433.9980 0.3915 434.1000 0.5095 434.2980 0.5095 434.4000 0.7708 434.5980 0.7708 434.7000 0.4973 434.8980 0.4973 435.0000 0.6048 435.1980 0.6048 435.3000 0.3886 435.4980 0.3886 435.6000 0.4078 435.7980 0.4078 435.9000 0.5004 436.0980 0.5004 436.2000 0.5907 436.3980 0.5907 436.5000 0.3939 436.6980 0.3939 436.8000 0.6037 436.9980 0.6037 437.1000 0.8411 437.2980 0.8411 437.4000 0.3459 437.5980 0.3459 437.7000 0.4569 437.8980 0.4569 438.0000 0.6672 438.1980 0.6672 438.3000 0.6636 438.4980 0.6636 438.6000 0.5998 438.7980 0.5998 438.9000 1.0003 439.0980 1.0003 439.2000 0.5670 439.3980 0.5670 439.5000 1.0167 439.6980 1.0167 439.8000 0.5985 439.9980 0.5985 440.1000 0.5143 440.2980 0.5143 440.4000 0.5913 440.5980 0.5913 440.7000 0.6190 440.8980 0.6190 441.0000 0.5692 441.1980 0.5692 441.3000 0.5961 441.4980 0.5961 441.6000 0.6150 441.7980 0.6150 441.9000 0.5696 442.0980 0.5696 442.2000 0.6065 442.3980 0.6065 442.5000 0.6194 442.6980 0.6194 442.8000 0.6475 442.9980 0.6475 443.1000 0.6056 443.2980 0.6056 443.4000 0.8301 443.5980 0.8301 443.7000 0.5860 443.8980 0.5860 444.0000 0.6538 444.1980 0.6538 444.3000 0.6247 444.4980 0.6247 444.6000 0.5668 444.7980 0.5668 444.9000 0.5998 445.0980 0.5998 445.2000 1.0691 445.3980 1.0691 445.5000 0.6068 445.6980 0.6068 445.8000 0.7579 445.9980 0.7579 446.1000 0.6236 446.2980 0.6236 446.4000 0.6693 446.5980 0.6693 446.7000 0.6006 446.8980 0.6006 447.0000 0.7447 447.1980 0.7447 447.3000 0.5968 447.4980 0.5968 447.6000 0.5883 447.7980 0.5883 447.9000 0.6004 448.0980 0.6004 448.2000 0.5933 448.3980 0.5933 448.5000 0.5768 448.6980 0.5768 448.8000 0.6007 448.9980 0.6007 449.1000 0.6082 449.2980 0.6082 449.4000 0.6937 449.5980 0.6937 449.7000 0.6144 449.8980 0.6144 450.0000 0.5609 450.1980 0.5609 450.3000 0.7432 450.4980 0.7432 450.6000 0.5452 450.7980 0.5452 450.9000 0.5821 451.0980 0.5821 451.2000 0.5732 451.3980 0.5732 451.5000 0.6057 451.6980 0.6057 451.8000 0.5458 451.9980 0.5458 452.1000 0.6020 452.2980 0.6020 452.4000 0.5708 452.5980 0.5708 452.7000 0.5164 452.8980 0.5164 453.0000 0.6817 453.1980 0.6817 453.3000 0.5754 453.4980 0.5754 453.6000 0.6885 453.7980 0.6885 453.9000 0.6888 454.0980 0.6888 454.2000 0.4856 454.3980 0.4856 454.5000 0.6350 454.6980 0.6350 454.8000 0.3627 454.9980 0.3627 455.1000 0.6583 455.2980 0.6583 455.4000 0.3915 455.5980 0.3915 455.7000 0.5095 455.8980 0.5095 456.0000 0.7708 456.1980 0.7708 456.3000 0.4973 456.4980 0.4973 456.6000 0.6048 456.7980 0.6048 456.9000 0.3886 457.0980 0.3886 457.2000 0.4078 457.3980 0.4078 457.5000 0.5004 457.6980 0.5004 457.8000 0.5907 457.9980 0.5907 458.1000 0.3939 458.2980 0.3939 458.4000 0.6037 458.5980 0.6037 458.7000 0.8411 458.8980 0.8411 459.0000 0.3459 459.1980 0.3459 459.3000 0.4569 459.4980 0.4569 459.6000 0.6672 459.7980 0.6672 459.9000 0.6636 460.0980 0.6636 460.2000 0.5998 460.3980 0.5998 460.5000 1.0003 460.6980 1.0003 460.8000 0.5670 460.9980 0.5670 461.1000 1.0167 461.2980 1.0167 461.4000 0.5985 461.5980 0.5985 461.7000 0.5143 461.8980 0.5143 462.0000 0.5913 462.1980 0.5913 462.3000 0.6190 462.4980 0.6190 462.6000 0.5692 462.7980 0.5692 462.9000 0.5961 463.0980 0.5961 463.2000 0.6150 463.3980 0.6150 463.5000 0.5696 463.6980 0.5696 463.8000 0.6065 463.9980 0.6065 464.1000 0.6194 464.2980 0.6194 464.4000 0.6475 464.5980 0.6475 464.7000 0.6056 464.8980 0.6056 465.0000 0.8301 465.1980 0.8301 465.3000 0.5860 465.4980 0.5860 465.6000 0.6538 465.7980 0.6538 465.9000 0.6247 466.0980 0.6247 466.2000 0.5668 466.3980 0.5668 466.5000 0.5998 466.6980 0.5998 466.8000 1.0691 466.9980 1.0691 467.1000 0.6068 467.2980 0.6068 467.4000 0.7579 467.5980 0.7579 467.7000 0.6236 467.8980 0.6236 468.0000 0.6693 468.1980 0.6693 468.3000 0.6006 468.4980 0.6006 468.6000 0.7447 468.7980 0.7447 468.9000 0.5968 469.0980 0.5968 469.2000 0.5883 469.3980 0.5883 469.5000 0.6004 469.6980 0.6004 469.8000 0.5933 469.9980 0.5933 470.1000 0.5768 470.2980 0.5768 470.4000 0.6007 470.5980 0.6007 470.7000 0.6082 470.8980 0.6082 471.0000 0.6937 471.1980 0.6937 471.3000 0.6144 471.4980 0.6144 471.6000 0.5609 471.7980 0.5609 471.9000 0.7432 472.0980 0.7432 472.2000 0.5452 472.3980 0.5452 472.5000 0.5821 472.6980 0.5821 472.8000 0.5732 472.9980 0.5732 473.1000 0.6057 473.2980 0.6057 473.4000 0.5458 473.5980 0.5458 473.7000 0.6020 473.8980 0.6020 474.0000 0.5708 474.1980 0.5708 474.3000 0.5164 474.4980 0.5164 474.6000 0.6817 474.7980 0.6817 474.9000 0.5754 475.0980 0.5754 475.2000 0.6885 475.3980 0.6885 475.5000 0.6888 475.6980 0.6888 475.8000 0.4856 475.9980 0.4856 476.1000 0.6350 476.2980 0.6350 476.4000 0.3627 476.5980 0.3627 476.7000 0.6583 476.8980 0.6583 477.0000 0.3915 477.1980 0.3915 477.3000 0.5095 477.4980 0.5095 477.6000 0.7708 477.7980 0.7708 477.9000 0.4973 478.0980 0.4973 478.2000 0.6048 478.3980 0.6048 478.5000 0.3886 478.6980 0.3886 478.8000 0.4078 478.9980 0.4078 479.1000 0.5004 479.2980 0.5004 479.4000 0.5907 479.5980 0.5907 479.7000 0.3939 479.8980 0.3939 480.0000 0.6037 480.1980 0.6037 480.3000 0.8411 480.4980 0.8411 480.6000 0.3459 480.7980 0.3459 480.9000 0.4569 481.0980 0.4569 481.2000 0.6672 481.3980 0.6672 481.5000 0.6636 481.6980 0.6636 481.8000 0.5998 481.9980 0.5998 482.1000 1.0003 482.2980 1.0003 482.4000 0.5670 482.5980 0.5670 482.7000 1.0167 482.8980 1.0167 483.0000 0.5985 483.1980 0.5985 483.3000 0.5143 483.4980 0.5143 483.6000 0.5913 483.7980 0.5913 483.9000 0.6190 484.0980 0.6190 484.2000 0.5692 484.3980 0.5692 484.5000 0.5961 484.6980 0.5961 484.8000 0.6150 484.9980 0.6150 485.1000 0.5696 485.2980 0.5696 485.4000 0.6065 485.5980 0.6065 485.7000 0.6194 485.8980 0.6194 486.0000 0.6475 486.1980 0.6475 486.3000 0.6056 486.4980 0.6056 486.6000 0.8301 486.7980 0.8301 486.9000 0.5860 487.0980 0.5860 487.2000 0.6538 487.3980 0.6538 487.5000 0.6247 487.6980 0.6247 487.8000 0.5668 487.9980 0.5668 488.1000 0.5998 488.2980 0.5998 488.4000 1.0691 488.5980 1.0691 488.7000 0.6068 488.8980 0.6068 489.0000 0.7579 489.1980 0.7579 489.3000 0.6236 489.4980 0.6236 489.6000 0.6693 489.7980 0.6693 489.9000 0.6006 490.0980 0.6006 490.2000 0.7447 490.3980 0.7447 490.5000 0.5968 490.6980 0.5968 490.8000 0.5883 490.9980 0.5883 491.1000 0.6004 491.2980 0.6004 491.4000 0.5933 491.5980 0.5933 491.7000 0.5768 491.8980 0.5768 492.0000 0.6007 492.1980 0.6007 492.3000 0.6082 492.4980 0.6082 492.6000 0.6937 492.7980 0.6937 492.9000 0.6144 493.0980 0.6144 493.2000 0.5609 493.3980 0.5609 493.5000 0.7432 493.6980 0.7432 493.8000 0.5452 493.9980 0.5452 494.1000 0.5821 494.2980 0.5821 494.4000 0.5732 494.5980 0.5732 494.7000 0.6057 494.8980 0.6057 495.0000 0.5458 495.1980 0.5458 495.3000 0.6020 495.4980 0.6020 495.6000 0.5708 495.7980 0.5708 495.9000 0.5164 496.0980 0.5164 496.2000 0.6817 496.3980 0.6817 496.5000 0.5754 496.6980 0.5754 496.8000 0.6885 496.9980 0.6885 497.1000 0.6888 497.2980 0.6888 497.4000 0.4856 497.5980 0.4856 497.7000 0.6350 497.8980 0.6350 498.0000 0.3627 498.1980 0.3627 498.3000 0.6583 498.4980 0.6583 498.6000 0.3915 498.7980 0.3915 498.9000 0.5095 499.0980 0.5095 499.2000 0.7708 499.3980 0.7708 499.5000 0.4973 499.6980 0.4973 499.8000 0.6048 499.9980 0.6048 500.1000 0.3886 500.2980 0.3886 500.4000 0.4078 500.5980 0.4078 500.7000 0.5004 500.8980 0.5004 501.0000 0.5907 501.1980 0.5907 501.3000 0.3939 501.4980 0.3939 501.6000 0.6037 501.7980 0.6037 501.9000 0.8411 502.0980 0.8411 502.2000 0.3459 502.3980 0.3459 502.5000 0.4569 502.6980 0.4569 502.8000 0.6672 502.9980 0.6672 503.1000 0.6636 503.2980 0.6636 503.4000 0.5998 503.5980 0.5998 503.7000 1.0003 503.8980 1.0003 504.0000 0.5670 504.1980 0.5670 504.3000 1.0167 504.4980 1.0167 504.6000 0.5985 504.7980 0.5985 504.9000 0.5143 505.0980 0.5143 505.2000 0.5913 505.3980 0.5913 505.5000 0.6190 505.6980 0.6190 505.8000 0.5692 505.9980 0.5692 506.1000 0.5961 506.2980 0.5961 506.4000 0.6150 506.5980 0.6150 506.7000 0.5696 506.8980 0.5696 507.0000 0.6065 507.1980 0.6065 507.3000 0.6194 507.4980 0.6194 507.6000 0.6475 507.7980 0.6475 507.9000 0.6056 508.0980 0.6056 508.2000 0.8301 508.3980 0.8301 508.5000 0.5860 508.6980 0.5860 508.8000 0.6538 508.9980 0.6538 509.1000 0.6247 509.2980 0.6247 509.4000 0.5668 509.5980 0.5668 509.7000 0.5998 509.8980 0.5998 510.0000 1.0691 510.1980 1.0691 510.3000 0.6068 510.4980 0.6068 510.6000 0.7579 510.7980 0.7579 510.9000 0.6236 511.0980 0.6236 511.2000 0.6693 511.3980 0.6693 511.5000 0.6006 511.6980 0.6006 511.8000 0.7447 511.9980 0.7447 512.1000 0.5968 512.2980 0.5968 512.4000 0.5883 512.5980 0.5883 512.7000 0.6004 512.8980 0.6004 513.0000 0.5933 513.1980 0.5933 513.3000 0.5768 513.4980 0.5768 513.6000 0.6007 513.7980 0.6007 513.9000 0.6082 514.0980 0.6082 514.2000 0.6937 514.3980 0.6937 514.5000 0.6144 514.6980 0.6144 514.8000 0.5609 514.9980 0.5609 515.1000 0.7432 515.2980 0.7432 515.4000 0.5452 515.5980 0.5452 515.7000 0.5821 515.8980 0.5821 516.0000 0.5732 516.1980 0.5732 516.3000 0.6057 516.4980 0.6057 516.6000 0.5458 516.7980 0.5458 516.9000 0.6020 517.0980 0.6020 517.2000 0.5708 517.3980 0.5708 517.5000 0.5164 517.6980 0.5164 517.8000 0.6817 517.9980 0.6817 518.1000 0.5754 518.2980 0.5754 518.4000 0.6885 518.5980 0.6885 518.7000 0.6888 518.8980 0.6888 519.0000 0.4856 519.1980 0.4856 519.3000 0.6350 519.4980 0.6350 519.6000 0.3627 519.7980 0.3627 519.9000 0.6583 520.0980 0.6583 520.2000 0.3915 520.3980 0.3915 520.5000 0.5095 520.6980 0.5095 520.8000 0.7708 520.9980 0.7708 521.1000 0.4973 521.2980 0.4973 521.4000 0.6048 521.5980 0.6048 521.7000 0.3886 521.8980 0.3886 522.0000 0.4078 522.1980 0.4078 522.3000 0.5004 522.4980 0.5004 522.6000 0.5907 522.7980 0.5907 522.9000 0.3939 523.0980 0.3939 523.2000 0.6037 523.3980 0.6037 523.5000 0.8411 523.6980 0.8411 523.8000 0.3459 523.9980 0.3459 524.1000 0.4569 524.2980 0.4569 524.4000 0.6672 524.5980 0.6672 524.7000 0.6636 524.8980 0.6636 525.0000 0.5998 525.1980 0.5998 525.3000 1.0003 525.4980 1.0003 525.6000 0.5670 525.7980 0.5670 525.9000 1.0167 526.0980 1.0167 526.2000 0.5985 526.3980 0.5985 526.5000 0.5143 526.6980 0.5143 526.8000 0.5913 526.9980 0.5913 527.1000 0.6190 527.2980 0.6190 527.4000 0.5692 527.5980 0.5692 527.7000 0.5961 527.8980 0.5961 528.0000 0.6150 528.1980 0.6150 528.3000 0.5696 528.4980 0.5696 528.6000 0.6065 528.7980 0.6065 528.9000 0.6194 529.0980 0.6194 529.2000 0.6475 529.3980 0.6475 529.5000 0.6056 529.6980 0.6056 529.8000 0.8301 529.9980 0.8301 530.1000 0.5860 530.2980 0.5860 530.4000 0.6538 530.5980 0.6538 530.7000 0.6247 530.8980 0.6247 531.0000 0.5668 531.1980 0.5668 531.3000 0.5998 531.4980 0.5998 531.6000 1.0691 531.7980 1.0691 531.9000 0.6068 532.0980 0.6068 532.2000 0.7579 532.3980 0.7579 532.5000 0.6236 532.6980 0.6236 532.8000 0.6693 532.9980 0.6693 533.1000 0.6006 533.2980 0.6006 533.4000 0.7447 533.5980 0.7447 533.7000 0.5968 533.8980 0.5968 534.0000 0.5883 534.1980 0.5883 534.3000 0.6004 534.4980 0.6004 534.6000 0.5933 534.7980 0.5933 534.9000 0.5768 535.0980 0.5768 535.2000 0.6007 535.3980 0.6007 535.5000 0.6082 535.6980 0.6082 535.8000 0.6937 535.9980 0.6937 536.1000 0.6144 536.2980 0.6144 536.4000 0.5609 536.5980 0.5609 536.7000 0.7432 536.8980 0.7432 537.0000 0.5452 537.1980 0.5452 537.3000 0.5821 537.4980 0.5821 537.6000 0.5732 537.7980 0.5732 537.9000 0.6057 538.0980 0.6057 538.2000 0.5458 538.3980 0.5458 538.5000 0.6020 538.6980 0.6020 538.8000 0.5708 538.9980 0.5708 539.1000 0.5164 539.2980 0.5164 539.4000 0.6817 539.5980 0.6817 539.7000 0.5754 539.8980 0.5754 540.0000 0.6885 540.1980 0.6885 540.3000 0.6888 540.4980 0.6888 540.6000 0.4856 540.7980 0.4856 540.9000 0.6350 541.0980 0.6350 541.2000 0.3627 541.3980 0.3627 541.5000 0.6583 541.6980 0.6583 541.8000 0.3915 541.9980 0.3915 542.1000 0.5095 542.2980 0.5095 542.4000 0.7708 542.5980 0.7708 542.7000 0.4973 542.8980 0.4973 543.0000 0.6048 543.1980 0.6048 543.3000 0.3886 543.4980 0.3886 543.6000 0.4078 543.7980 0.4078 543.9000 0.5004 544.0980 0.5004 544.2000 0.5907 544.3980 0.5907 544.5000 0.3939 544.6980 0.3939 544.8000 0.6037 544.9980 0.6037 545.1000 0.8411 545.2980 0.8411 545.4000 0.3459 545.5980 0.3459 545.7000 0.4569 545.8980 0.4569 546.0000 0.6672 546.1980 0.6672 546.3000 0.6636 546.4980 0.6636 546.6000 0.5998 546.7980 0.5998 546.9000 1.0003 547.0980 1.0003 547.2000 0.5670 547.3980 0.5670 547.5000 1.0167 547.6980 1.0167 547.8000 0.5985 547.9980 0.5985 548.1000 0.5143 548.2980 0.5143 548.4000 0.5913 548.5980 0.5913 548.7000 0.6190 548.8980 0.6190 549.0000 0.5692 549.1980 0.5692 549.3000 0.5961 549.4980 0.5961 549.6000 0.6150 549.7980 0.6150 549.9000 0.5696 550.0980 0.5696 550.2000 0.6065 550.3980 0.6065 550.5000 0.6194 550.6980 0.6194 550.8000 0.6475 550.9980 0.6475 551.1000 0.6056 551.2980 0.6056 551.4000 0.8301 551.5980 0.8301 551.7000 0.5860 551.8980 0.5860 552.0000 0.6538 552.1980 0.6538 552.3000 0.6247 552.4980 0.6247 552.6000 0.5668 552.7980 0.5668 552.9000 0.5998 553.0980 0.5998 553.2000 1.0691 553.3980 1.0691 553.5000 0.6068 553.6980 0.6068 553.8000 0.7579 553.9980 0.7579 554.1000 0.6236 554.2980 0.6236 554.4000 0.6693 554.5980 0.6693 554.7000 0.6006 554.8980 0.6006 555.0000 0.7447 555.1980 0.7447 555.3000 0.5968 555.4980 0.5968 555.6000 0.5883 555.7980 0.5883 555.9000 0.6004 556.0980 0.6004 556.2000 0.5933 556.3980 0.5933 556.5000 0.5768 556.6980 0.5768 556.8000 0.6007 556.9980 0.6007 557.1000 0.6082 557.2980 0.6082 557.4000 0.6937 557.5980 0.6937 557.7000 0.6144 557.8980 0.6144 558.0000 0.5609 558.1980 0.5609 558.3000 0.7432 558.4980 0.7432 558.6000 0.5452 558.7980 0.5452 558.9000 0.5821 559.0980 0.5821 559.2000 0.5732 559.3980 0.5732 559.5000 0.6057 559.6980 0.6057 559.8000 0.5458 559.9980 0.5458 560.1000 0.6020 560.2980 0.6020 560.4000 0.5708 560.5980 0.5708 560.7000 0.5164 560.8980 0.5164 561.0000 0.6817 561.1980 0.6817 561.3000 0.5754 561.4980 0.5754 561.6000 0.6885 561.7980 0.6885 561.9000 0.6888 562.0980 0.6888 562.2000 0.4856 562.3980 0.4856 562.5000 0.6350 562.6980 0.6350 562.8000 0.3627 562.9980 0.3627 563.1000 0.6583 563.2980 0.6583 563.4000 0.3915 563.5980 0.3915 563.7000 0.5095 563.8980 0.5095 564.0000 0.7708 564.1980 0.7708 564.3000 0.4973 564.4980 0.4973 564.6000 0.6048 564.7980 0.6048 564.9000 0.3886 565.0980 0.3886 565.2000 0.4078 565.3980 0.4078 565.5000 0.5004 565.6980 0.5004 565.8000 0.5907 565.9980 0.5907 566.1000 0.3939 566.2980 0.3939 566.4000 0.6037 566.5980 0.6037 566.7000 0.8411 566.8980 0.8411 567.0000 0.3459 567.1980 0.3459 567.3000 0.4569 567.4980 0.4569 567.6000 0.6672 567.7980 0.6672 567.9000 0.6636 568.0980 0.6636 568.2000 0.5998 568.3980 0.5998 568.5000 1.0003 568.6980 1.0003 568.8000 0.5670 568.9980 0.5670 569.1000 1.0167 569.2980 1.0167 569.4000 0.5985 569.5980 0.5985 569.7000 0.5143 569.8980 0.5143 570.0000 0.5913 570.1980 0.5913 570.3000 0.6190 570.4980 0.6190 570.6000 0.5692 570.7980 0.5692 570.9000 0.5961 571.0980 0.5961 571.2000 0.6150 571.3980 0.6150 571.5000 0.5696 571.6980 0.5696 571.8000 0.6065 571.9980 0.6065 572.1000 0.6194 572.2980 0.6194 572.4000 0.6475 572.5980 0.6475 572.7000 0.6056 572.8980 0.6056 573.0000 0.8301 573.1980 0.8301 573.3000 0.5860 573.4980 0.5860 573.6000 0.6538 573.7980 0.6538 573.9000 0.6247 574.0980 0.6247 574.2000 0.5668 574.3980 0.5668 574.5000 0.5998 574.6980 0.5998 574.8000 1.0691 574.9980 1.0691 575.1000 0.6068 575.2980 0.6068 575.4000 0.7579 575.5980 0.7579 575.7000 0.6236 575.8980 0.6236 576.0000 0.6693 576.1980 0.6693 576.3000 0.6006 576.4980 0.6006 576.6000 0.7447 576.7980 0.7447 576.9000 0.5968 577.0980 0.5968 577.2000 0.5883 577.3980 0.5883 577.5000 0.6004 577.6980 0.6004 577.8000 0.5933 577.9980 0.5933 578.1000 0.5768 578.2980 0.5768 578.4000 0.6007 578.5980 0.6007 578.7000 0.6082 578.8980 0.6082 579.0000 0.6937 579.1980 0.6937 579.3000 0.6144 579.4980 0.6144 579.6000 0.5609 579.7980 0.5609 579.9000 0.7432 580.0980 0.7432 580.2000 0.5452 580.3980 0.5452 580.5000 0.5821 580.6980 0.5821 580.8000 0.5732 580.9980 0.5732 581.1000 0.6057 581.2980 0.6057 581.4000 0.5458 581.5980 0.5458 581.7000 0.6020 581.8980 0.6020 582.0000 0.5708 582.1980 0.5708 582.3000 0.5164 582.4980 0.5164 582.6000 0.6817 582.7980 0.6817 582.9000 0.5754 583.0980 0.5754 583.2000 0.6885 583.3980 0.6885 583.5000 0.6888 583.6980 0.6888 583.8000 0.4856 583.9980 0.4856 584.1000 0.6350 584.2980 0.6350 584.4000 0.3627 584.5980 0.3627 584.7000 0.6583 584.8980 0.6583 585.0000 0.3915 585.1980 0.3915 585.3000 0.5095 585.4980 0.5095 585.6000 0.7708 585.7980 0.7708 585.9000 0.4973 586.0980 0.4973 586.2000 0.6048 586.3980 0.6048 586.5000 0.3886 586.6980 0.3886 586.8000 0.4078 586.9980 0.4078 587.1000 0.5004 587.2980 0.5004 587.4000 0.5907 587.5980 0.5907 587.7000 0.3939 587.8980 0.3939 588.0000 0.6037 588.1980 0.6037 588.3000 0.8411 588.4980 0.8411 588.6000 0.3459 588.7980 0.3459 588.9000 0.4569 589.0980 0.4569 589.2000 0.6672 589.3980 0.6672 589.5000 0.6636 589.6980 0.6636 589.8000 0.5998 589.9980 0.5998 590.1000 1.0003 590.2980 1.0003 590.4000 0.5670 590.5980 0.5670 590.7000 1.0167 590.8980 1.0167 591.0000 0.5985 591.1980 0.5985 591.3000 0.5143 591.4980 0.5143 591.6000 0.5913 591.7980 0.5913 591.9000 0.6190 592.0980 0.6190 592.2000 0.5692 592.3980 0.5692 592.5000 0.5961 592.6980 0.5961 592.8000 0.6150 592.9980 0.6150 593.1000 0.5696 593.2980 0.5696 593.4000 0.6065 593.5980 0.6065 593.7000 0.6194 593.8980 0.6194 594.0000 0.6475 594.1980 0.6475 594.3000 0.6056 594.4980 0.6056 594.6000 0.8301 594.7980 0.8301 594.9000 0.5860 595.0980 0.5860 595.2000 0.6538 595.3980 0.6538 595.5000 0.6247 595.6980 0.6247 595.8000 0.5668 595.9980 0.5668 596.1000 0.5998 596.2980 0.5998 596.4000 1.0691 596.5980 1.0691 596.7000 0.6068 596.8980 0.6068 597.0000 0.7579 597.1980 0.7579 597.3000 0.6236 597.4980 0.6236 597.6000 0.6693 597.7980 0.6693 597.9000 0.6006 598.0980 0.6006 598.2000 0.7447 598.3980 0.7447 598.5000 0.5968 598.6980 0.5968 598.8000 0.5883 598.9980 0.5883 599.1000 0.6004 599.2980 0.6004 599.4000 0.5933 599.5980 0.5933 599.7000 0.5768 599.8980 0.5768 600.0000 0.5768)
Va2 a2 0 PWL(0.0000 0.9401 0.1980 0.9401 0.3000 0.7668 0.4980 0.7668 0.6000 0.5838 0.7980 0.5838 0.9000 0.7326 1.0980 0.7326 1.2000 0.8951 1.3980 0.8951 1.5000 1.0223 1.6980 1.0223 1.8000 0.9722 1.9980 0.9722 2.1000 0.5095 2.2980 0.5095 2.4000 0.6608 2.5980 0.6608 2.7000 0.8046 2.8980 0.8046 3.0000 1.0954 3.1980 1.0954 3.3000 0.8831 3.4980 0.8831 3.6000 0.9960 3.7980 0.9960 3.9000 0.9835 4.0980 0.9835 4.2000 0.9471 4.3980 0.9471 4.5000 1.0374 4.6980 1.0374 4.8000 1.3489 4.9980 1.3489 5.1000 0.9163 5.2980 0.9163 5.4000 0.9688 5.5980 0.9688 5.7000 0.8247 5.8980 0.8247 6.0000 1.0204 6.1980 1.0204 6.3000 0.6670 6.4980 0.6670 6.6000 0.7327 6.7980 0.7327 6.9000 0.8027 7.0980 0.8027 7.2000 1.0307 7.3980 1.0307 7.5000 0.7115 7.6980 0.7115 7.8000 0.7664 7.9980 0.7664 8.1000 1.0944 8.2980 1.0944 8.4000 1.1378 8.5980 1.1378 8.7000 0.9829 8.8980 0.9829 9.0000 1.0336 9.1980 1.0336 9.3000 1.0903 9.4980 1.0903 9.6000 0.9204 9.7980 0.9204 9.9000 1.1430 10.0980 1.1430 10.2000 0.8651 10.3980 0.8651 10.5000 0.8453 10.6980 0.8453 10.8000 0.9064 10.9980 0.9064 11.1000 1.1466 11.2980 1.1466 11.4000 0.6079 11.5980 0.6079 11.7000 1.0068 11.8980 1.0068 12.0000 0.7961 12.1980 0.7961 12.3000 1.0684 12.4980 1.0684 12.6000 1.0703 12.7980 1.0703 12.9000 1.0515 13.0980 1.0515 13.2000 0.6093 13.3980 0.6093 13.5000 1.0267 13.6980 1.0267 13.8000 0.7863 13.9980 0.7863 14.1000 1.0404 14.2980 1.0404 14.4000 0.6547 14.5980 0.6547 14.7000 0.6006 14.8980 0.6006 15.0000 0.6548 15.1980 0.6548 15.3000 0.5968 15.4980 0.5968 15.6000 0.5883 15.7980 0.5883 15.9000 0.6004 16.0980 0.6004 16.2000 0.5933 16.3980 0.5933 16.5000 0.5768 16.6980 0.5768 16.8000 0.6007 16.9980 0.6007 17.1000 0.6082 17.2980 0.6082 17.4000 0.7191 17.5980 0.7191 17.7000 0.7002 17.8980 0.7002 18.0000 0.7282 18.1980 0.7282 18.3000 0.7377 18.4980 0.7377 18.6000 0.5452 18.7980 0.5452 18.9000 0.5821 19.0980 0.5821 19.2000 0.5732 19.3980 0.5732 19.5000 0.6057 19.6980 0.6057 19.8000 0.7154 19.9980 0.7154 20.1000 0.6020 20.2980 0.6020 20.4000 0.5708 20.5980 0.5708 20.7000 0.5164 20.8980 0.5164 21.0000 0.5878 21.1980 0.5878 21.3000 0.5754 21.4980 0.5754 21.6000 0.9401 21.7980 0.9401 21.9000 0.7668 22.0980 0.7668 22.2000 0.5838 22.3980 0.5838 22.5000 0.7326 22.6980 0.7326 22.8000 0.8951 22.9980 0.8951 23.1000 1.0223 23.2980 1.0223 23.4000 0.9722 23.5980 0.9722 23.7000 0.5095 23.8980 0.5095 24.0000 0.6608 24.1980 0.6608 24.3000 0.8046 24.4980 0.8046 24.6000 1.0954 24.7980 1.0954 24.9000 0.8831 25.0980 0.8831 25.2000 0.9960 25.3980 0.9960 25.5000 0.9835 25.6980 0.9835 25.8000 0.9471 25.9980 0.9471 26.1000 1.0374 26.2980 1.0374 26.4000 1.3489 26.5980 1.3489 26.7000 0.9163 26.8980 0.9163 27.0000 0.9688 27.1980 0.9688 27.3000 0.8247 27.4980 0.8247 27.6000 1.0204 27.7980 1.0204 27.9000 0.6670 28.0980 0.6670 28.2000 0.7327 28.3980 0.7327 28.5000 0.8027 28.6980 0.8027 28.8000 1.0307 28.9980 1.0307 29.1000 0.7115 29.2980 0.7115 29.4000 0.7664 29.5980 0.7664 29.7000 1.0944 29.8980 1.0944 30.0000 1.1378 30.1980 1.1378 30.3000 0.9829 30.4980 0.9829 30.6000 1.0336 30.7980 1.0336 30.9000 1.0903 31.0980 1.0903 31.2000 0.9204 31.3980 0.9204 31.5000 1.1430 31.6980 1.1430 31.8000 0.8651 31.9980 0.8651 32.1000 0.8453 32.2980 0.8453 32.4000 0.9064 32.5980 0.9064 32.7000 1.1466 32.8980 1.1466 33.0000 0.6079 33.1980 0.6079 33.3000 1.0068 33.4980 1.0068 33.6000 0.7961 33.7980 0.7961 33.9000 1.0684 34.0980 1.0684 34.2000 1.0703 34.3980 1.0703 34.5000 1.0515 34.6980 1.0515 34.8000 0.6093 34.9980 0.6093 35.1000 1.0267 35.2980 1.0267 35.4000 0.7863 35.5980 0.7863 35.7000 1.0404 35.8980 1.0404 36.0000 0.6547 36.1980 0.6547 36.3000 0.6006 36.4980 0.6006 36.6000 0.6548 36.7980 0.6548 36.9000 0.5968 37.0980 0.5968 37.2000 0.5883 37.3980 0.5883 37.5000 0.6004 37.6980 0.6004 37.8000 0.5933 37.9980 0.5933 38.1000 0.5768 38.2980 0.5768 38.4000 0.6007 38.5980 0.6007 38.7000 0.6082 38.8980 0.6082 39.0000 0.7191 39.1980 0.7191 39.3000 0.7002 39.4980 0.7002 39.6000 0.7282 39.7980 0.7282 39.9000 0.7377 40.0980 0.7377 40.2000 0.5452 40.3980 0.5452 40.5000 0.5821 40.6980 0.5821 40.8000 0.5732 40.9980 0.5732 41.1000 0.6057 41.2980 0.6057 41.4000 0.7154 41.5980 0.7154 41.7000 0.6020 41.8980 0.6020 42.0000 0.5708 42.1980 0.5708 42.3000 0.5164 42.4980 0.5164 42.6000 0.5878 42.7980 0.5878 42.9000 0.5754 43.0980 0.5754 43.2000 0.9401 43.3980 0.9401 43.5000 0.7668 43.6980 0.7668 43.8000 0.5838 43.9980 0.5838 44.1000 0.7326 44.2980 0.7326 44.4000 0.8951 44.5980 0.8951 44.7000 1.0223 44.8980 1.0223 45.0000 0.9722 45.1980 0.9722 45.3000 0.5095 45.4980 0.5095 45.6000 0.6608 45.7980 0.6608 45.9000 0.8046 46.0980 0.8046 46.2000 1.0954 46.3980 1.0954 46.5000 0.8831 46.6980 0.8831 46.8000 0.9960 46.9980 0.9960 47.1000 0.9835 47.2980 0.9835 47.4000 0.9471 47.5980 0.9471 47.7000 1.0374 47.8980 1.0374 48.0000 1.3489 48.1980 1.3489 48.3000 0.9163 48.4980 0.9163 48.6000 0.9688 48.7980 0.9688 48.9000 0.8247 49.0980 0.8247 49.2000 1.0204 49.3980 1.0204 49.5000 0.6670 49.6980 0.6670 49.8000 0.7327 49.9980 0.7327 50.1000 0.8027 50.2980 0.8027 50.4000 1.0307 50.5980 1.0307 50.7000 0.7115 50.8980 0.7115 51.0000 0.7664 51.1980 0.7664 51.3000 1.0944 51.4980 1.0944 51.6000 1.1378 51.7980 1.1378 51.9000 0.9829 52.0980 0.9829 52.2000 1.0336 52.3980 1.0336 52.5000 1.0903 52.6980 1.0903 52.8000 0.9204 52.9980 0.9204 53.1000 1.1430 53.2980 1.1430 53.4000 0.8651 53.5980 0.8651 53.7000 0.8453 53.8980 0.8453 54.0000 0.9064 54.1980 0.9064 54.3000 1.1466 54.4980 1.1466 54.6000 0.6079 54.7980 0.6079 54.9000 1.0068 55.0980 1.0068 55.2000 0.7961 55.3980 0.7961 55.5000 1.0684 55.6980 1.0684 55.8000 1.0703 55.9980 1.0703 56.1000 1.0515 56.2980 1.0515 56.4000 0.6093 56.5980 0.6093 56.7000 1.0267 56.8980 1.0267 57.0000 0.7863 57.1980 0.7863 57.3000 1.0404 57.4980 1.0404 57.6000 0.6547 57.7980 0.6547 57.9000 0.6006 58.0980 0.6006 58.2000 0.6548 58.3980 0.6548 58.5000 0.5968 58.6980 0.5968 58.8000 0.5883 58.9980 0.5883 59.1000 0.6004 59.2980 0.6004 59.4000 0.5933 59.5980 0.5933 59.7000 0.5768 59.8980 0.5768 60.0000 0.6007 60.1980 0.6007 60.3000 0.6082 60.4980 0.6082 60.6000 0.7191 60.7980 0.7191 60.9000 0.7002 61.0980 0.7002 61.2000 0.7282 61.3980 0.7282 61.5000 0.7377 61.6980 0.7377 61.8000 0.5452 61.9980 0.5452 62.1000 0.5821 62.2980 0.5821 62.4000 0.5732 62.5980 0.5732 62.7000 0.6057 62.8980 0.6057 63.0000 0.7154 63.1980 0.7154 63.3000 0.6020 63.4980 0.6020 63.6000 0.5708 63.7980 0.5708 63.9000 0.5164 64.0980 0.5164 64.2000 0.5878 64.3980 0.5878 64.5000 0.5754 64.6980 0.5754 64.8000 0.9401 64.9980 0.9401 65.1000 0.7668 65.2980 0.7668 65.4000 0.5838 65.5980 0.5838 65.7000 0.7326 65.8980 0.7326 66.0000 0.8951 66.1980 0.8951 66.3000 1.0223 66.4980 1.0223 66.6000 0.9722 66.7980 0.9722 66.9000 0.5095 67.0980 0.5095 67.2000 0.6608 67.3980 0.6608 67.5000 0.8046 67.6980 0.8046 67.8000 1.0954 67.9980 1.0954 68.1000 0.8831 68.2980 0.8831 68.4000 0.9960 68.5980 0.9960 68.7000 0.9835 68.8980 0.9835 69.0000 0.9471 69.1980 0.9471 69.3000 1.0374 69.4980 1.0374 69.6000 1.3489 69.7980 1.3489 69.9000 0.9163 70.0980 0.9163 70.2000 0.9688 70.3980 0.9688 70.5000 0.8247 70.6980 0.8247 70.8000 1.0204 70.9980 1.0204 71.1000 0.6670 71.2980 0.6670 71.4000 0.7327 71.5980 0.7327 71.7000 0.8027 71.8980 0.8027 72.0000 1.0307 72.1980 1.0307 72.3000 0.7115 72.4980 0.7115 72.6000 0.7664 72.7980 0.7664 72.9000 1.0944 73.0980 1.0944 73.2000 1.1378 73.3980 1.1378 73.5000 0.9829 73.6980 0.9829 73.8000 1.0336 73.9980 1.0336 74.1000 1.0903 74.2980 1.0903 74.4000 0.9204 74.5980 0.9204 74.7000 1.1430 74.8980 1.1430 75.0000 0.8651 75.1980 0.8651 75.3000 0.8453 75.4980 0.8453 75.6000 0.9064 75.7980 0.9064 75.9000 1.1466 76.0980 1.1466 76.2000 0.6079 76.3980 0.6079 76.5000 1.0068 76.6980 1.0068 76.8000 0.7961 76.9980 0.7961 77.1000 1.0684 77.2980 1.0684 77.4000 1.0703 77.5980 1.0703 77.7000 1.0515 77.8980 1.0515 78.0000 0.6093 78.1980 0.6093 78.3000 1.0267 78.4980 1.0267 78.6000 0.7863 78.7980 0.7863 78.9000 1.0404 79.0980 1.0404 79.2000 0.6547 79.3980 0.6547 79.5000 0.6006 79.6980 0.6006 79.8000 0.6548 79.9980 0.6548 80.1000 0.5968 80.2980 0.5968 80.4000 0.5883 80.5980 0.5883 80.7000 0.6004 80.8980 0.6004 81.0000 0.5933 81.1980 0.5933 81.3000 0.5768 81.4980 0.5768 81.6000 0.6007 81.7980 0.6007 81.9000 0.6082 82.0980 0.6082 82.2000 0.7191 82.3980 0.7191 82.5000 0.7002 82.6980 0.7002 82.8000 0.7282 82.9980 0.7282 83.1000 0.7377 83.2980 0.7377 83.4000 0.5452 83.5980 0.5452 83.7000 0.5821 83.8980 0.5821 84.0000 0.5732 84.1980 0.5732 84.3000 0.6057 84.4980 0.6057 84.6000 0.7154 84.7980 0.7154 84.9000 0.6020 85.0980 0.6020 85.2000 0.5708 85.3980 0.5708 85.5000 0.5164 85.6980 0.5164 85.8000 0.5878 85.9980 0.5878 86.1000 0.5754 86.2980 0.5754 86.4000 0.9401 86.5980 0.9401 86.7000 0.7668 86.8980 0.7668 87.0000 0.5838 87.1980 0.5838 87.3000 0.7326 87.4980 0.7326 87.6000 0.8951 87.7980 0.8951 87.9000 1.0223 88.0980 1.0223 88.2000 0.9722 88.3980 0.9722 88.5000 0.5095 88.6980 0.5095 88.8000 0.6608 88.9980 0.6608 89.1000 0.8046 89.2980 0.8046 89.4000 1.0954 89.5980 1.0954 89.7000 0.8831 89.8980 0.8831 90.0000 0.9960 90.1980 0.9960 90.3000 0.9835 90.4980 0.9835 90.6000 0.9471 90.7980 0.9471 90.9000 1.0374 91.0980 1.0374 91.2000 1.3489 91.3980 1.3489 91.5000 0.9163 91.6980 0.9163 91.8000 0.9688 91.9980 0.9688 92.1000 0.8247 92.2980 0.8247 92.4000 1.0204 92.5980 1.0204 92.7000 0.6670 92.8980 0.6670 93.0000 0.7327 93.1980 0.7327 93.3000 0.8027 93.4980 0.8027 93.6000 1.0307 93.7980 1.0307 93.9000 0.7115 94.0980 0.7115 94.2000 0.7664 94.3980 0.7664 94.5000 1.0944 94.6980 1.0944 94.8000 1.1378 94.9980 1.1378 95.1000 0.9829 95.2980 0.9829 95.4000 1.0336 95.5980 1.0336 95.7000 1.0903 95.8980 1.0903 96.0000 0.9204 96.1980 0.9204 96.3000 1.1430 96.4980 1.1430 96.6000 0.8651 96.7980 0.8651 96.9000 0.8453 97.0980 0.8453 97.2000 0.9064 97.3980 0.9064 97.5000 1.1466 97.6980 1.1466 97.8000 0.6079 97.9980 0.6079 98.1000 1.0068 98.2980 1.0068 98.4000 0.7961 98.5980 0.7961 98.7000 1.0684 98.8980 1.0684 99.0000 1.0703 99.1980 1.0703 99.3000 1.0515 99.4980 1.0515 99.6000 0.6093 99.7980 0.6093 99.9000 1.0267 100.0980 1.0267 100.2000 0.7863 100.3980 0.7863 100.5000 1.0404 100.6980 1.0404 100.8000 0.6547 100.9980 0.6547 101.1000 0.6006 101.2980 0.6006 101.4000 0.6548 101.5980 0.6548 101.7000 0.5968 101.8980 0.5968 102.0000 0.5883 102.1980 0.5883 102.3000 0.6004 102.4980 0.6004 102.6000 0.5933 102.7980 0.5933 102.9000 0.5768 103.0980 0.5768 103.2000 0.6007 103.3980 0.6007 103.5000 0.6082 103.6980 0.6082 103.8000 0.7191 103.9980 0.7191 104.1000 0.7002 104.2980 0.7002 104.4000 0.7282 104.5980 0.7282 104.7000 0.7377 104.8980 0.7377 105.0000 0.5452 105.1980 0.5452 105.3000 0.5821 105.4980 0.5821 105.6000 0.5732 105.7980 0.5732 105.9000 0.6057 106.0980 0.6057 106.2000 0.7154 106.3980 0.7154 106.5000 0.6020 106.6980 0.6020 106.8000 0.5708 106.9980 0.5708 107.1000 0.5164 107.2980 0.5164 107.4000 0.5878 107.5980 0.5878 107.7000 0.5754 107.8980 0.5754 108.0000 0.9401 108.1980 0.9401 108.3000 0.7668 108.4980 0.7668 108.6000 0.5838 108.7980 0.5838 108.9000 0.7326 109.0980 0.7326 109.2000 0.8951 109.3980 0.8951 109.5000 1.0223 109.6980 1.0223 109.8000 0.9722 109.9980 0.9722 110.1000 0.5095 110.2980 0.5095 110.4000 0.6608 110.5980 0.6608 110.7000 0.8046 110.8980 0.8046 111.0000 1.0954 111.1980 1.0954 111.3000 0.8831 111.4980 0.8831 111.6000 0.9960 111.7980 0.9960 111.9000 0.9835 112.0980 0.9835 112.2000 0.9471 112.3980 0.9471 112.5000 1.0374 112.6980 1.0374 112.8000 1.3489 112.9980 1.3489 113.1000 0.9163 113.2980 0.9163 113.4000 0.9688 113.5980 0.9688 113.7000 0.8247 113.8980 0.8247 114.0000 1.0204 114.1980 1.0204 114.3000 0.6670 114.4980 0.6670 114.6000 0.7327 114.7980 0.7327 114.9000 0.8027 115.0980 0.8027 115.2000 1.0307 115.3980 1.0307 115.5000 0.7115 115.6980 0.7115 115.8000 0.7664 115.9980 0.7664 116.1000 1.0944 116.2980 1.0944 116.4000 1.1378 116.5980 1.1378 116.7000 0.9829 116.8980 0.9829 117.0000 1.0336 117.1980 1.0336 117.3000 1.0903 117.4980 1.0903 117.6000 0.9204 117.7980 0.9204 117.9000 1.1430 118.0980 1.1430 118.2000 0.8651 118.3980 0.8651 118.5000 0.8453 118.6980 0.8453 118.8000 0.9064 118.9980 0.9064 119.1000 1.1466 119.2980 1.1466 119.4000 0.6079 119.5980 0.6079 119.7000 1.0068 119.8980 1.0068 120.0000 0.7961 120.1980 0.7961 120.3000 1.0684 120.4980 1.0684 120.6000 1.0703 120.7980 1.0703 120.9000 1.0515 121.0980 1.0515 121.2000 0.6093 121.3980 0.6093 121.5000 1.0267 121.6980 1.0267 121.8000 0.7863 121.9980 0.7863 122.1000 1.0404 122.2980 1.0404 122.4000 0.6547 122.5980 0.6547 122.7000 0.6006 122.8980 0.6006 123.0000 0.6548 123.1980 0.6548 123.3000 0.5968 123.4980 0.5968 123.6000 0.5883 123.7980 0.5883 123.9000 0.6004 124.0980 0.6004 124.2000 0.5933 124.3980 0.5933 124.5000 0.5768 124.6980 0.5768 124.8000 0.6007 124.9980 0.6007 125.1000 0.6082 125.2980 0.6082 125.4000 0.7191 125.5980 0.7191 125.7000 0.7002 125.8980 0.7002 126.0000 0.7282 126.1980 0.7282 126.3000 0.7377 126.4980 0.7377 126.6000 0.5452 126.7980 0.5452 126.9000 0.5821 127.0980 0.5821 127.2000 0.5732 127.3980 0.5732 127.5000 0.6057 127.6980 0.6057 127.8000 0.7154 127.9980 0.7154 128.1000 0.6020 128.2980 0.6020 128.4000 0.5708 128.5980 0.5708 128.7000 0.5164 128.8980 0.5164 129.0000 0.5878 129.1980 0.5878 129.3000 0.5754 129.4980 0.5754 129.6000 0.9401 129.7980 0.9401 129.9000 0.7668 130.0980 0.7668 130.2000 0.5838 130.3980 0.5838 130.5000 0.7326 130.6980 0.7326 130.8000 0.8951 130.9980 0.8951 131.1000 1.0223 131.2980 1.0223 131.4000 0.9722 131.5980 0.9722 131.7000 0.5095 131.8980 0.5095 132.0000 0.6608 132.1980 0.6608 132.3000 0.8046 132.4980 0.8046 132.6000 1.0954 132.7980 1.0954 132.9000 0.8831 133.0980 0.8831 133.2000 0.9960 133.3980 0.9960 133.5000 0.9835 133.6980 0.9835 133.8000 0.9471 133.9980 0.9471 134.1000 1.0374 134.2980 1.0374 134.4000 1.3489 134.5980 1.3489 134.7000 0.9163 134.8980 0.9163 135.0000 0.9688 135.1980 0.9688 135.3000 0.8247 135.4980 0.8247 135.6000 1.0204 135.7980 1.0204 135.9000 0.6670 136.0980 0.6670 136.2000 0.7327 136.3980 0.7327 136.5000 0.8027 136.6980 0.8027 136.8000 1.0307 136.9980 1.0307 137.1000 0.7115 137.2980 0.7115 137.4000 0.7664 137.5980 0.7664 137.7000 1.0944 137.8980 1.0944 138.0000 1.1378 138.1980 1.1378 138.3000 0.9829 138.4980 0.9829 138.6000 1.0336 138.7980 1.0336 138.9000 1.0903 139.0980 1.0903 139.2000 0.9204 139.3980 0.9204 139.5000 1.1430 139.6980 1.1430 139.8000 0.8651 139.9980 0.8651 140.1000 0.8453 140.2980 0.8453 140.4000 0.9064 140.5980 0.9064 140.7000 1.1466 140.8980 1.1466 141.0000 0.6079 141.1980 0.6079 141.3000 1.0068 141.4980 1.0068 141.6000 0.7961 141.7980 0.7961 141.9000 1.0684 142.0980 1.0684 142.2000 1.0703 142.3980 1.0703 142.5000 1.0515 142.6980 1.0515 142.8000 0.6093 142.9980 0.6093 143.1000 1.0267 143.2980 1.0267 143.4000 0.7863 143.5980 0.7863 143.7000 1.0404 143.8980 1.0404 144.0000 0.6547 144.1980 0.6547 144.3000 0.6006 144.4980 0.6006 144.6000 0.6548 144.7980 0.6548 144.9000 0.5968 145.0980 0.5968 145.2000 0.5883 145.3980 0.5883 145.5000 0.6004 145.6980 0.6004 145.8000 0.5933 145.9980 0.5933 146.1000 0.5768 146.2980 0.5768 146.4000 0.6007 146.5980 0.6007 146.7000 0.6082 146.8980 0.6082 147.0000 0.7191 147.1980 0.7191 147.3000 0.7002 147.4980 0.7002 147.6000 0.7282 147.7980 0.7282 147.9000 0.7377 148.0980 0.7377 148.2000 0.5452 148.3980 0.5452 148.5000 0.5821 148.6980 0.5821 148.8000 0.5732 148.9980 0.5732 149.1000 0.6057 149.2980 0.6057 149.4000 0.7154 149.5980 0.7154 149.7000 0.6020 149.8980 0.6020 150.0000 0.5708 150.1980 0.5708 150.3000 0.5164 150.4980 0.5164 150.6000 0.5878 150.7980 0.5878 150.9000 0.5754 151.0980 0.5754 151.2000 0.9401 151.3980 0.9401 151.5000 0.7668 151.6980 0.7668 151.8000 0.5838 151.9980 0.5838 152.1000 0.7326 152.2980 0.7326 152.4000 0.8951 152.5980 0.8951 152.7000 1.0223 152.8980 1.0223 153.0000 0.9722 153.1980 0.9722 153.3000 0.5095 153.4980 0.5095 153.6000 0.6608 153.7980 0.6608 153.9000 0.8046 154.0980 0.8046 154.2000 1.0954 154.3980 1.0954 154.5000 0.8831 154.6980 0.8831 154.8000 0.9960 154.9980 0.9960 155.1000 0.9835 155.2980 0.9835 155.4000 0.9471 155.5980 0.9471 155.7000 1.0374 155.8980 1.0374 156.0000 1.3489 156.1980 1.3489 156.3000 0.9163 156.4980 0.9163 156.6000 0.9688 156.7980 0.9688 156.9000 0.8247 157.0980 0.8247 157.2000 1.0204 157.3980 1.0204 157.5000 0.6670 157.6980 0.6670 157.8000 0.7327 157.9980 0.7327 158.1000 0.8027 158.2980 0.8027 158.4000 1.0307 158.5980 1.0307 158.7000 0.7115 158.8980 0.7115 159.0000 0.7664 159.1980 0.7664 159.3000 1.0944 159.4980 1.0944 159.6000 1.1378 159.7980 1.1378 159.9000 0.9829 160.0980 0.9829 160.2000 1.0336 160.3980 1.0336 160.5000 1.0903 160.6980 1.0903 160.8000 0.9204 160.9980 0.9204 161.1000 1.1430 161.2980 1.1430 161.4000 0.8651 161.5980 0.8651 161.7000 0.8453 161.8980 0.8453 162.0000 0.9064 162.1980 0.9064 162.3000 1.1466 162.4980 1.1466 162.6000 0.6079 162.7980 0.6079 162.9000 1.0068 163.0980 1.0068 163.2000 0.7961 163.3980 0.7961 163.5000 1.0684 163.6980 1.0684 163.8000 1.0703 163.9980 1.0703 164.1000 1.0515 164.2980 1.0515 164.4000 0.6093 164.5980 0.6093 164.7000 1.0267 164.8980 1.0267 165.0000 0.7863 165.1980 0.7863 165.3000 1.0404 165.4980 1.0404 165.6000 0.6547 165.7980 0.6547 165.9000 0.6006 166.0980 0.6006 166.2000 0.6548 166.3980 0.6548 166.5000 0.5968 166.6980 0.5968 166.8000 0.5883 166.9980 0.5883 167.1000 0.6004 167.2980 0.6004 167.4000 0.5933 167.5980 0.5933 167.7000 0.5768 167.8980 0.5768 168.0000 0.6007 168.1980 0.6007 168.3000 0.6082 168.4980 0.6082 168.6000 0.7191 168.7980 0.7191 168.9000 0.7002 169.0980 0.7002 169.2000 0.7282 169.3980 0.7282 169.5000 0.7377 169.6980 0.7377 169.8000 0.5452 169.9980 0.5452 170.1000 0.5821 170.2980 0.5821 170.4000 0.5732 170.5980 0.5732 170.7000 0.6057 170.8980 0.6057 171.0000 0.7154 171.1980 0.7154 171.3000 0.6020 171.4980 0.6020 171.6000 0.5708 171.7980 0.5708 171.9000 0.5164 172.0980 0.5164 172.2000 0.5878 172.3980 0.5878 172.5000 0.5754 172.6980 0.5754 172.8000 0.9401 172.9980 0.9401 173.1000 0.7668 173.2980 0.7668 173.4000 0.5838 173.5980 0.5838 173.7000 0.7326 173.8980 0.7326 174.0000 0.8951 174.1980 0.8951 174.3000 1.0223 174.4980 1.0223 174.6000 0.9722 174.7980 0.9722 174.9000 0.5095 175.0980 0.5095 175.2000 0.6608 175.3980 0.6608 175.5000 0.8046 175.6980 0.8046 175.8000 1.0954 175.9980 1.0954 176.1000 0.8831 176.2980 0.8831 176.4000 0.9960 176.5980 0.9960 176.7000 0.9835 176.8980 0.9835 177.0000 0.9471 177.1980 0.9471 177.3000 1.0374 177.4980 1.0374 177.6000 1.3489 177.7980 1.3489 177.9000 0.9163 178.0980 0.9163 178.2000 0.9688 178.3980 0.9688 178.5000 0.8247 178.6980 0.8247 178.8000 1.0204 178.9980 1.0204 179.1000 0.6670 179.2980 0.6670 179.4000 0.7327 179.5980 0.7327 179.7000 0.8027 179.8980 0.8027 180.0000 1.0307 180.1980 1.0307 180.3000 0.7115 180.4980 0.7115 180.6000 0.7664 180.7980 0.7664 180.9000 1.0944 181.0980 1.0944 181.2000 1.1378 181.3980 1.1378 181.5000 0.9829 181.6980 0.9829 181.8000 1.0336 181.9980 1.0336 182.1000 1.0903 182.2980 1.0903 182.4000 0.9204 182.5980 0.9204 182.7000 1.1430 182.8980 1.1430 183.0000 0.8651 183.1980 0.8651 183.3000 0.8453 183.4980 0.8453 183.6000 0.9064 183.7980 0.9064 183.9000 1.1466 184.0980 1.1466 184.2000 0.6079 184.3980 0.6079 184.5000 1.0068 184.6980 1.0068 184.8000 0.7961 184.9980 0.7961 185.1000 1.0684 185.2980 1.0684 185.4000 1.0703 185.5980 1.0703 185.7000 1.0515 185.8980 1.0515 186.0000 0.6093 186.1980 0.6093 186.3000 1.0267 186.4980 1.0267 186.6000 0.7863 186.7980 0.7863 186.9000 1.0404 187.0980 1.0404 187.2000 0.6547 187.3980 0.6547 187.5000 0.6006 187.6980 0.6006 187.8000 0.6548 187.9980 0.6548 188.1000 0.5968 188.2980 0.5968 188.4000 0.5883 188.5980 0.5883 188.7000 0.6004 188.8980 0.6004 189.0000 0.5933 189.1980 0.5933 189.3000 0.5768 189.4980 0.5768 189.6000 0.6007 189.7980 0.6007 189.9000 0.6082 190.0980 0.6082 190.2000 0.7191 190.3980 0.7191 190.5000 0.7002 190.6980 0.7002 190.8000 0.7282 190.9980 0.7282 191.1000 0.7377 191.2980 0.7377 191.4000 0.5452 191.5980 0.5452 191.7000 0.5821 191.8980 0.5821 192.0000 0.5732 192.1980 0.5732 192.3000 0.6057 192.4980 0.6057 192.6000 0.7154 192.7980 0.7154 192.9000 0.6020 193.0980 0.6020 193.2000 0.5708 193.3980 0.5708 193.5000 0.5164 193.6980 0.5164 193.8000 0.5878 193.9980 0.5878 194.1000 0.5754 194.2980 0.5754 194.4000 0.9401 194.5980 0.9401 194.7000 0.7668 194.8980 0.7668 195.0000 0.5838 195.1980 0.5838 195.3000 0.7326 195.4980 0.7326 195.6000 0.8951 195.7980 0.8951 195.9000 1.0223 196.0980 1.0223 196.2000 0.9722 196.3980 0.9722 196.5000 0.5095 196.6980 0.5095 196.8000 0.6608 196.9980 0.6608 197.1000 0.8046 197.2980 0.8046 197.4000 1.0954 197.5980 1.0954 197.7000 0.8831 197.8980 0.8831 198.0000 0.9960 198.1980 0.9960 198.3000 0.9835 198.4980 0.9835 198.6000 0.9471 198.7980 0.9471 198.9000 1.0374 199.0980 1.0374 199.2000 1.3489 199.3980 1.3489 199.5000 0.9163 199.6980 0.9163 199.8000 0.9688 199.9980 0.9688 200.1000 0.8247 200.2980 0.8247 200.4000 1.0204 200.5980 1.0204 200.7000 0.6670 200.8980 0.6670 201.0000 0.7327 201.1980 0.7327 201.3000 0.8027 201.4980 0.8027 201.6000 1.0307 201.7980 1.0307 201.9000 0.7115 202.0980 0.7115 202.2000 0.7664 202.3980 0.7664 202.5000 1.0944 202.6980 1.0944 202.8000 1.1378 202.9980 1.1378 203.1000 0.9829 203.2980 0.9829 203.4000 1.0336 203.5980 1.0336 203.7000 1.0903 203.8980 1.0903 204.0000 0.9204 204.1980 0.9204 204.3000 1.1430 204.4980 1.1430 204.6000 0.8651 204.7980 0.8651 204.9000 0.8453 205.0980 0.8453 205.2000 0.9064 205.3980 0.9064 205.5000 1.1466 205.6980 1.1466 205.8000 0.6079 205.9980 0.6079 206.1000 1.0068 206.2980 1.0068 206.4000 0.7961 206.5980 0.7961 206.7000 1.0684 206.8980 1.0684 207.0000 1.0703 207.1980 1.0703 207.3000 1.0515 207.4980 1.0515 207.6000 0.6093 207.7980 0.6093 207.9000 1.0267 208.0980 1.0267 208.2000 0.7863 208.3980 0.7863 208.5000 1.0404 208.6980 1.0404 208.8000 0.6547 208.9980 0.6547 209.1000 0.6006 209.2980 0.6006 209.4000 0.6548 209.5980 0.6548 209.7000 0.5968 209.8980 0.5968 210.0000 0.5883 210.1980 0.5883 210.3000 0.6004 210.4980 0.6004 210.6000 0.5933 210.7980 0.5933 210.9000 0.5768 211.0980 0.5768 211.2000 0.6007 211.3980 0.6007 211.5000 0.6082 211.6980 0.6082 211.8000 0.7191 211.9980 0.7191 212.1000 0.7002 212.2980 0.7002 212.4000 0.7282 212.5980 0.7282 212.7000 0.7377 212.8980 0.7377 213.0000 0.5452 213.1980 0.5452 213.3000 0.5821 213.4980 0.5821 213.6000 0.5732 213.7980 0.5732 213.9000 0.6057 214.0980 0.6057 214.2000 0.7154 214.3980 0.7154 214.5000 0.6020 214.6980 0.6020 214.8000 0.5708 214.9980 0.5708 215.1000 0.5164 215.2980 0.5164 215.4000 0.5878 215.5980 0.5878 215.7000 0.5754 215.8980 0.5754 216.0000 0.9401 216.1980 0.9401 216.3000 0.7668 216.4980 0.7668 216.6000 0.5838 216.7980 0.5838 216.9000 0.7326 217.0980 0.7326 217.2000 0.8951 217.3980 0.8951 217.5000 1.0223 217.6980 1.0223 217.8000 0.9722 217.9980 0.9722 218.1000 0.5095 218.2980 0.5095 218.4000 0.6608 218.5980 0.6608 218.7000 0.8046 218.8980 0.8046 219.0000 1.0954 219.1980 1.0954 219.3000 0.8831 219.4980 0.8831 219.6000 0.9960 219.7980 0.9960 219.9000 0.9835 220.0980 0.9835 220.2000 0.9471 220.3980 0.9471 220.5000 1.0374 220.6980 1.0374 220.8000 1.3489 220.9980 1.3489 221.1000 0.9163 221.2980 0.9163 221.4000 0.9688 221.5980 0.9688 221.7000 0.8247 221.8980 0.8247 222.0000 1.0204 222.1980 1.0204 222.3000 0.6670 222.4980 0.6670 222.6000 0.7327 222.7980 0.7327 222.9000 0.8027 223.0980 0.8027 223.2000 1.0307 223.3980 1.0307 223.5000 0.7115 223.6980 0.7115 223.8000 0.7664 223.9980 0.7664 224.1000 1.0944 224.2980 1.0944 224.4000 1.1378 224.5980 1.1378 224.7000 0.9829 224.8980 0.9829 225.0000 1.0336 225.1980 1.0336 225.3000 1.0903 225.4980 1.0903 225.6000 0.9204 225.7980 0.9204 225.9000 1.1430 226.0980 1.1430 226.2000 0.8651 226.3980 0.8651 226.5000 0.8453 226.6980 0.8453 226.8000 0.9064 226.9980 0.9064 227.1000 1.1466 227.2980 1.1466 227.4000 0.6079 227.5980 0.6079 227.7000 1.0068 227.8980 1.0068 228.0000 0.7961 228.1980 0.7961 228.3000 1.0684 228.4980 1.0684 228.6000 1.0703 228.7980 1.0703 228.9000 1.0515 229.0980 1.0515 229.2000 0.6093 229.3980 0.6093 229.5000 1.0267 229.6980 1.0267 229.8000 0.7863 229.9980 0.7863 230.1000 1.0404 230.2980 1.0404 230.4000 0.6547 230.5980 0.6547 230.7000 0.6006 230.8980 0.6006 231.0000 0.6548 231.1980 0.6548 231.3000 0.5968 231.4980 0.5968 231.6000 0.5883 231.7980 0.5883 231.9000 0.6004 232.0980 0.6004 232.2000 0.5933 232.3980 0.5933 232.5000 0.5768 232.6980 0.5768 232.8000 0.6007 232.9980 0.6007 233.1000 0.6082 233.2980 0.6082 233.4000 0.7191 233.5980 0.7191 233.7000 0.7002 233.8980 0.7002 234.0000 0.7282 234.1980 0.7282 234.3000 0.7377 234.4980 0.7377 234.6000 0.5452 234.7980 0.5452 234.9000 0.5821 235.0980 0.5821 235.2000 0.5732 235.3980 0.5732 235.5000 0.6057 235.6980 0.6057 235.8000 0.7154 235.9980 0.7154 236.1000 0.6020 236.2980 0.6020 236.4000 0.5708 236.5980 0.5708 236.7000 0.5164 236.8980 0.5164 237.0000 0.5878 237.1980 0.5878 237.3000 0.5754 237.4980 0.5754 237.6000 0.9401 237.7980 0.9401 237.9000 0.7668 238.0980 0.7668 238.2000 0.5838 238.3980 0.5838 238.5000 0.7326 238.6980 0.7326 238.8000 0.8951 238.9980 0.8951 239.1000 1.0223 239.2980 1.0223 239.4000 0.9722 239.5980 0.9722 239.7000 0.5095 239.8980 0.5095 240.0000 0.6608 240.1980 0.6608 240.3000 0.8046 240.4980 0.8046 240.6000 1.0954 240.7980 1.0954 240.9000 0.8831 241.0980 0.8831 241.2000 0.9960 241.3980 0.9960 241.5000 0.9835 241.6980 0.9835 241.8000 0.9471 241.9980 0.9471 242.1000 1.0374 242.2980 1.0374 242.4000 1.3489 242.5980 1.3489 242.7000 0.9163 242.8980 0.9163 243.0000 0.9688 243.1980 0.9688 243.3000 0.8247 243.4980 0.8247 243.6000 1.0204 243.7980 1.0204 243.9000 0.6670 244.0980 0.6670 244.2000 0.7327 244.3980 0.7327 244.5000 0.8027 244.6980 0.8027 244.8000 1.0307 244.9980 1.0307 245.1000 0.7115 245.2980 0.7115 245.4000 0.7664 245.5980 0.7664 245.7000 1.0944 245.8980 1.0944 246.0000 1.1378 246.1980 1.1378 246.3000 0.9829 246.4980 0.9829 246.6000 1.0336 246.7980 1.0336 246.9000 1.0903 247.0980 1.0903 247.2000 0.9204 247.3980 0.9204 247.5000 1.1430 247.6980 1.1430 247.8000 0.8651 247.9980 0.8651 248.1000 0.8453 248.2980 0.8453 248.4000 0.9064 248.5980 0.9064 248.7000 1.1466 248.8980 1.1466 249.0000 0.6079 249.1980 0.6079 249.3000 1.0068 249.4980 1.0068 249.6000 0.7961 249.7980 0.7961 249.9000 1.0684 250.0980 1.0684 250.2000 1.0703 250.3980 1.0703 250.5000 1.0515 250.6980 1.0515 250.8000 0.6093 250.9980 0.6093 251.1000 1.0267 251.2980 1.0267 251.4000 0.7863 251.5980 0.7863 251.7000 1.0404 251.8980 1.0404 252.0000 0.6547 252.1980 0.6547 252.3000 0.6006 252.4980 0.6006 252.6000 0.6548 252.7980 0.6548 252.9000 0.5968 253.0980 0.5968 253.2000 0.5883 253.3980 0.5883 253.5000 0.6004 253.6980 0.6004 253.8000 0.5933 253.9980 0.5933 254.1000 0.5768 254.2980 0.5768 254.4000 0.6007 254.5980 0.6007 254.7000 0.6082 254.8980 0.6082 255.0000 0.7191 255.1980 0.7191 255.3000 0.7002 255.4980 0.7002 255.6000 0.7282 255.7980 0.7282 255.9000 0.7377 256.0980 0.7377 256.2000 0.5452 256.3980 0.5452 256.5000 0.5821 256.6980 0.5821 256.8000 0.5732 256.9980 0.5732 257.1000 0.6057 257.2980 0.6057 257.4000 0.7154 257.5980 0.7154 257.7000 0.6020 257.8980 0.6020 258.0000 0.5708 258.1980 0.5708 258.3000 0.5164 258.4980 0.5164 258.6000 0.5878 258.7980 0.5878 258.9000 0.5754 259.0980 0.5754 259.2000 0.9401 259.3980 0.9401 259.5000 0.7668 259.6980 0.7668 259.8000 0.5838 259.9980 0.5838 260.1000 0.7326 260.2980 0.7326 260.4000 0.8951 260.5980 0.8951 260.7000 1.0223 260.8980 1.0223 261.0000 0.9722 261.1980 0.9722 261.3000 0.5095 261.4980 0.5095 261.6000 0.6608 261.7980 0.6608 261.9000 0.8046 262.0980 0.8046 262.2000 1.0954 262.3980 1.0954 262.5000 0.8831 262.6980 0.8831 262.8000 0.9960 262.9980 0.9960 263.1000 0.9835 263.2980 0.9835 263.4000 0.9471 263.5980 0.9471 263.7000 1.0374 263.8980 1.0374 264.0000 1.3489 264.1980 1.3489 264.3000 0.9163 264.4980 0.9163 264.6000 0.9688 264.7980 0.9688 264.9000 0.8247 265.0980 0.8247 265.2000 1.0204 265.3980 1.0204 265.5000 0.6670 265.6980 0.6670 265.8000 0.7327 265.9980 0.7327 266.1000 0.8027 266.2980 0.8027 266.4000 1.0307 266.5980 1.0307 266.7000 0.7115 266.8980 0.7115 267.0000 0.7664 267.1980 0.7664 267.3000 1.0944 267.4980 1.0944 267.6000 1.1378 267.7980 1.1378 267.9000 0.9829 268.0980 0.9829 268.2000 1.0336 268.3980 1.0336 268.5000 1.0903 268.6980 1.0903 268.8000 0.9204 268.9980 0.9204 269.1000 1.1430 269.2980 1.1430 269.4000 0.8651 269.5980 0.8651 269.7000 0.8453 269.8980 0.8453 270.0000 0.9064 270.1980 0.9064 270.3000 1.1466 270.4980 1.1466 270.6000 0.6079 270.7980 0.6079 270.9000 1.0068 271.0980 1.0068 271.2000 0.7961 271.3980 0.7961 271.5000 1.0684 271.6980 1.0684 271.8000 1.0703 271.9980 1.0703 272.1000 1.0515 272.2980 1.0515 272.4000 0.6093 272.5980 0.6093 272.7000 1.0267 272.8980 1.0267 273.0000 0.7863 273.1980 0.7863 273.3000 1.0404 273.4980 1.0404 273.6000 0.6547 273.7980 0.6547 273.9000 0.6006 274.0980 0.6006 274.2000 0.6548 274.3980 0.6548 274.5000 0.5968 274.6980 0.5968 274.8000 0.5883 274.9980 0.5883 275.1000 0.6004 275.2980 0.6004 275.4000 0.5933 275.5980 0.5933 275.7000 0.5768 275.8980 0.5768 276.0000 0.6007 276.1980 0.6007 276.3000 0.6082 276.4980 0.6082 276.6000 0.7191 276.7980 0.7191 276.9000 0.7002 277.0980 0.7002 277.2000 0.7282 277.3980 0.7282 277.5000 0.7377 277.6980 0.7377 277.8000 0.5452 277.9980 0.5452 278.1000 0.5821 278.2980 0.5821 278.4000 0.5732 278.5980 0.5732 278.7000 0.6057 278.8980 0.6057 279.0000 0.7154 279.1980 0.7154 279.3000 0.6020 279.4980 0.6020 279.6000 0.5708 279.7980 0.5708 279.9000 0.5164 280.0980 0.5164 280.2000 0.5878 280.3980 0.5878 280.5000 0.5754 280.6980 0.5754 280.8000 0.9401 280.9980 0.9401 281.1000 0.7668 281.2980 0.7668 281.4000 0.5838 281.5980 0.5838 281.7000 0.7326 281.8980 0.7326 282.0000 0.8951 282.1980 0.8951 282.3000 1.0223 282.4980 1.0223 282.6000 0.9722 282.7980 0.9722 282.9000 0.5095 283.0980 0.5095 283.2000 0.6608 283.3980 0.6608 283.5000 0.8046 283.6980 0.8046 283.8000 1.0954 283.9980 1.0954 284.1000 0.8831 284.2980 0.8831 284.4000 0.9960 284.5980 0.9960 284.7000 0.9835 284.8980 0.9835 285.0000 0.9471 285.1980 0.9471 285.3000 1.0374 285.4980 1.0374 285.6000 1.3489 285.7980 1.3489 285.9000 0.9163 286.0980 0.9163 286.2000 0.9688 286.3980 0.9688 286.5000 0.8247 286.6980 0.8247 286.8000 1.0204 286.9980 1.0204 287.1000 0.6670 287.2980 0.6670 287.4000 0.7327 287.5980 0.7327 287.7000 0.8027 287.8980 0.8027 288.0000 1.0307 288.1980 1.0307 288.3000 0.7115 288.4980 0.7115 288.6000 0.7664 288.7980 0.7664 288.9000 1.0944 289.0980 1.0944 289.2000 1.1378 289.3980 1.1378 289.5000 0.9829 289.6980 0.9829 289.8000 1.0336 289.9980 1.0336 290.1000 1.0903 290.2980 1.0903 290.4000 0.9204 290.5980 0.9204 290.7000 1.1430 290.8980 1.1430 291.0000 0.8651 291.1980 0.8651 291.3000 0.8453 291.4980 0.8453 291.6000 0.9064 291.7980 0.9064 291.9000 1.1466 292.0980 1.1466 292.2000 0.6079 292.3980 0.6079 292.5000 1.0068 292.6980 1.0068 292.8000 0.7961 292.9980 0.7961 293.1000 1.0684 293.2980 1.0684 293.4000 1.0703 293.5980 1.0703 293.7000 1.0515 293.8980 1.0515 294.0000 0.6093 294.1980 0.6093 294.3000 1.0267 294.4980 1.0267 294.6000 0.7863 294.7980 0.7863 294.9000 1.0404 295.0980 1.0404 295.2000 0.6547 295.3980 0.6547 295.5000 0.6006 295.6980 0.6006 295.8000 0.6548 295.9980 0.6548 296.1000 0.5968 296.2980 0.5968 296.4000 0.5883 296.5980 0.5883 296.7000 0.6004 296.8980 0.6004 297.0000 0.5933 297.1980 0.5933 297.3000 0.5768 297.4980 0.5768 297.6000 0.6007 297.7980 0.6007 297.9000 0.6082 298.0980 0.6082 298.2000 0.7191 298.3980 0.7191 298.5000 0.7002 298.6980 0.7002 298.8000 0.7282 298.9980 0.7282 299.1000 0.7377 299.2980 0.7377 299.4000 0.5452 299.5980 0.5452 299.7000 0.5821 299.8980 0.5821 300.0000 0.5732 300.1980 0.5732 300.3000 0.6057 300.4980 0.6057 300.6000 0.7154 300.7980 0.7154 300.9000 0.6020 301.0980 0.6020 301.2000 0.5708 301.3980 0.5708 301.5000 0.5164 301.6980 0.5164 301.8000 0.5878 301.9980 0.5878 302.1000 0.5754 302.2980 0.5754 302.4000 0.9401 302.5980 0.9401 302.7000 0.7668 302.8980 0.7668 303.0000 0.5838 303.1980 0.5838 303.3000 0.7326 303.4980 0.7326 303.6000 0.8951 303.7980 0.8951 303.9000 1.0223 304.0980 1.0223 304.2000 0.9722 304.3980 0.9722 304.5000 0.5095 304.6980 0.5095 304.8000 0.6608 304.9980 0.6608 305.1000 0.8046 305.2980 0.8046 305.4000 1.0954 305.5980 1.0954 305.7000 0.8831 305.8980 0.8831 306.0000 0.9960 306.1980 0.9960 306.3000 0.9835 306.4980 0.9835 306.6000 0.9471 306.7980 0.9471 306.9000 1.0374 307.0980 1.0374 307.2000 1.3489 307.3980 1.3489 307.5000 0.9163 307.6980 0.9163 307.8000 0.9688 307.9980 0.9688 308.1000 0.8247 308.2980 0.8247 308.4000 1.0204 308.5980 1.0204 308.7000 0.6670 308.8980 0.6670 309.0000 0.7327 309.1980 0.7327 309.3000 0.8027 309.4980 0.8027 309.6000 1.0307 309.7980 1.0307 309.9000 0.7115 310.0980 0.7115 310.2000 0.7664 310.3980 0.7664 310.5000 1.0944 310.6980 1.0944 310.8000 1.1378 310.9980 1.1378 311.1000 0.9829 311.2980 0.9829 311.4000 1.0336 311.5980 1.0336 311.7000 1.0903 311.8980 1.0903 312.0000 0.9204 312.1980 0.9204 312.3000 1.1430 312.4980 1.1430 312.6000 0.8651 312.7980 0.8651 312.9000 0.8453 313.0980 0.8453 313.2000 0.9064 313.3980 0.9064 313.5000 1.1466 313.6980 1.1466 313.8000 0.6079 313.9980 0.6079 314.1000 1.0068 314.2980 1.0068 314.4000 0.7961 314.5980 0.7961 314.7000 1.0684 314.8980 1.0684 315.0000 1.0703 315.1980 1.0703 315.3000 1.0515 315.4980 1.0515 315.6000 0.6093 315.7980 0.6093 315.9000 1.0267 316.0980 1.0267 316.2000 0.7863 316.3980 0.7863 316.5000 1.0404 316.6980 1.0404 316.8000 0.6547 316.9980 0.6547 317.1000 0.6006 317.2980 0.6006 317.4000 0.6548 317.5980 0.6548 317.7000 0.5968 317.8980 0.5968 318.0000 0.5883 318.1980 0.5883 318.3000 0.6004 318.4980 0.6004 318.6000 0.5933 318.7980 0.5933 318.9000 0.5768 319.0980 0.5768 319.2000 0.6007 319.3980 0.6007 319.5000 0.6082 319.6980 0.6082 319.8000 0.7191 319.9980 0.7191 320.1000 0.7002 320.2980 0.7002 320.4000 0.7282 320.5980 0.7282 320.7000 0.7377 320.8980 0.7377 321.0000 0.5452 321.1980 0.5452 321.3000 0.5821 321.4980 0.5821 321.6000 0.5732 321.7980 0.5732 321.9000 0.6057 322.0980 0.6057 322.2000 0.7154 322.3980 0.7154 322.5000 0.6020 322.6980 0.6020 322.8000 0.5708 322.9980 0.5708 323.1000 0.5164 323.2980 0.5164 323.4000 0.5878 323.5980 0.5878 323.7000 0.5754 323.8980 0.5754 324.0000 0.9401 324.1980 0.9401 324.3000 0.7668 324.4980 0.7668 324.6000 0.5838 324.7980 0.5838 324.9000 0.7326 325.0980 0.7326 325.2000 0.8951 325.3980 0.8951 325.5000 1.0223 325.6980 1.0223 325.8000 0.9722 325.9980 0.9722 326.1000 0.5095 326.2980 0.5095 326.4000 0.6608 326.5980 0.6608 326.7000 0.8046 326.8980 0.8046 327.0000 1.0954 327.1980 1.0954 327.3000 0.8831 327.4980 0.8831 327.6000 0.9960 327.7980 0.9960 327.9000 0.9835 328.0980 0.9835 328.2000 0.9471 328.3980 0.9471 328.5000 1.0374 328.6980 1.0374 328.8000 1.3489 328.9980 1.3489 329.1000 0.9163 329.2980 0.9163 329.4000 0.9688 329.5980 0.9688 329.7000 0.8247 329.8980 0.8247 330.0000 1.0204 330.1980 1.0204 330.3000 0.6670 330.4980 0.6670 330.6000 0.7327 330.7980 0.7327 330.9000 0.8027 331.0980 0.8027 331.2000 1.0307 331.3980 1.0307 331.5000 0.7115 331.6980 0.7115 331.8000 0.7664 331.9980 0.7664 332.1000 1.0944 332.2980 1.0944 332.4000 1.1378 332.5980 1.1378 332.7000 0.9829 332.8980 0.9829 333.0000 1.0336 333.1980 1.0336 333.3000 1.0903 333.4980 1.0903 333.6000 0.9204 333.7980 0.9204 333.9000 1.1430 334.0980 1.1430 334.2000 0.8651 334.3980 0.8651 334.5000 0.8453 334.6980 0.8453 334.8000 0.9064 334.9980 0.9064 335.1000 1.1466 335.2980 1.1466 335.4000 0.6079 335.5980 0.6079 335.7000 1.0068 335.8980 1.0068 336.0000 0.7961 336.1980 0.7961 336.3000 1.0684 336.4980 1.0684 336.6000 1.0703 336.7980 1.0703 336.9000 1.0515 337.0980 1.0515 337.2000 0.6093 337.3980 0.6093 337.5000 1.0267 337.6980 1.0267 337.8000 0.7863 337.9980 0.7863 338.1000 1.0404 338.2980 1.0404 338.4000 0.6547 338.5980 0.6547 338.7000 0.6006 338.8980 0.6006 339.0000 0.6548 339.1980 0.6548 339.3000 0.5968 339.4980 0.5968 339.6000 0.5883 339.7980 0.5883 339.9000 0.6004 340.0980 0.6004 340.2000 0.5933 340.3980 0.5933 340.5000 0.5768 340.6980 0.5768 340.8000 0.6007 340.9980 0.6007 341.1000 0.6082 341.2980 0.6082 341.4000 0.7191 341.5980 0.7191 341.7000 0.7002 341.8980 0.7002 342.0000 0.7282 342.1980 0.7282 342.3000 0.7377 342.4980 0.7377 342.6000 0.5452 342.7980 0.5452 342.9000 0.5821 343.0980 0.5821 343.2000 0.5732 343.3980 0.5732 343.5000 0.6057 343.6980 0.6057 343.8000 0.7154 343.9980 0.7154 344.1000 0.6020 344.2980 0.6020 344.4000 0.5708 344.5980 0.5708 344.7000 0.5164 344.8980 0.5164 345.0000 0.5878 345.1980 0.5878 345.3000 0.5754 345.4980 0.5754 345.6000 0.9401 345.7980 0.9401 345.9000 0.7668 346.0980 0.7668 346.2000 0.5838 346.3980 0.5838 346.5000 0.7326 346.6980 0.7326 346.8000 0.8951 346.9980 0.8951 347.1000 1.0223 347.2980 1.0223 347.4000 0.9722 347.5980 0.9722 347.7000 0.5095 347.8980 0.5095 348.0000 0.6608 348.1980 0.6608 348.3000 0.8046 348.4980 0.8046 348.6000 1.0954 348.7980 1.0954 348.9000 0.8831 349.0980 0.8831 349.2000 0.9960 349.3980 0.9960 349.5000 0.9835 349.6980 0.9835 349.8000 0.9471 349.9980 0.9471 350.1000 1.0374 350.2980 1.0374 350.4000 1.3489 350.5980 1.3489 350.7000 0.9163 350.8980 0.9163 351.0000 0.9688 351.1980 0.9688 351.3000 0.8247 351.4980 0.8247 351.6000 1.0204 351.7980 1.0204 351.9000 0.6670 352.0980 0.6670 352.2000 0.7327 352.3980 0.7327 352.5000 0.8027 352.6980 0.8027 352.8000 1.0307 352.9980 1.0307 353.1000 0.7115 353.2980 0.7115 353.4000 0.7664 353.5980 0.7664 353.7000 1.0944 353.8980 1.0944 354.0000 1.1378 354.1980 1.1378 354.3000 0.9829 354.4980 0.9829 354.6000 1.0336 354.7980 1.0336 354.9000 1.0903 355.0980 1.0903 355.2000 0.9204 355.3980 0.9204 355.5000 1.1430 355.6980 1.1430 355.8000 0.8651 355.9980 0.8651 356.1000 0.8453 356.2980 0.8453 356.4000 0.9064 356.5980 0.9064 356.7000 1.1466 356.8980 1.1466 357.0000 0.6079 357.1980 0.6079 357.3000 1.0068 357.4980 1.0068 357.6000 0.7961 357.7980 0.7961 357.9000 1.0684 358.0980 1.0684 358.2000 1.0703 358.3980 1.0703 358.5000 1.0515 358.6980 1.0515 358.8000 0.6093 358.9980 0.6093 359.1000 1.0267 359.2980 1.0267 359.4000 0.7863 359.5980 0.7863 359.7000 1.0404 359.8980 1.0404 360.0000 0.6547 360.1980 0.6547 360.3000 0.6006 360.4980 0.6006 360.6000 0.6548 360.7980 0.6548 360.9000 0.5968 361.0980 0.5968 361.2000 0.5883 361.3980 0.5883 361.5000 0.6004 361.6980 0.6004 361.8000 0.5933 361.9980 0.5933 362.1000 0.5768 362.2980 0.5768 362.4000 0.6007 362.5980 0.6007 362.7000 0.6082 362.8980 0.6082 363.0000 0.7191 363.1980 0.7191 363.3000 0.7002 363.4980 0.7002 363.6000 0.7282 363.7980 0.7282 363.9000 0.7377 364.0980 0.7377 364.2000 0.5452 364.3980 0.5452 364.5000 0.5821 364.6980 0.5821 364.8000 0.5732 364.9980 0.5732 365.1000 0.6057 365.2980 0.6057 365.4000 0.7154 365.5980 0.7154 365.7000 0.6020 365.8980 0.6020 366.0000 0.5708 366.1980 0.5708 366.3000 0.5164 366.4980 0.5164 366.6000 0.5878 366.7980 0.5878 366.9000 0.5754 367.0980 0.5754 367.2000 0.9401 367.3980 0.9401 367.5000 0.7668 367.6980 0.7668 367.8000 0.5838 367.9980 0.5838 368.1000 0.7326 368.2980 0.7326 368.4000 0.8951 368.5980 0.8951 368.7000 1.0223 368.8980 1.0223 369.0000 0.9722 369.1980 0.9722 369.3000 0.5095 369.4980 0.5095 369.6000 0.6608 369.7980 0.6608 369.9000 0.8046 370.0980 0.8046 370.2000 1.0954 370.3980 1.0954 370.5000 0.8831 370.6980 0.8831 370.8000 0.9960 370.9980 0.9960 371.1000 0.9835 371.2980 0.9835 371.4000 0.9471 371.5980 0.9471 371.7000 1.0374 371.8980 1.0374 372.0000 1.3489 372.1980 1.3489 372.3000 0.9163 372.4980 0.9163 372.6000 0.9688 372.7980 0.9688 372.9000 0.8247 373.0980 0.8247 373.2000 1.0204 373.3980 1.0204 373.5000 0.6670 373.6980 0.6670 373.8000 0.7327 373.9980 0.7327 374.1000 0.8027 374.2980 0.8027 374.4000 1.0307 374.5980 1.0307 374.7000 0.7115 374.8980 0.7115 375.0000 0.7664 375.1980 0.7664 375.3000 1.0944 375.4980 1.0944 375.6000 1.1378 375.7980 1.1378 375.9000 0.9829 376.0980 0.9829 376.2000 1.0336 376.3980 1.0336 376.5000 1.0903 376.6980 1.0903 376.8000 0.9204 376.9980 0.9204 377.1000 1.1430 377.2980 1.1430 377.4000 0.8651 377.5980 0.8651 377.7000 0.8453 377.8980 0.8453 378.0000 0.9064 378.1980 0.9064 378.3000 1.1466 378.4980 1.1466 378.6000 0.6079 378.7980 0.6079 378.9000 1.0068 379.0980 1.0068 379.2000 0.7961 379.3980 0.7961 379.5000 1.0684 379.6980 1.0684 379.8000 1.0703 379.9980 1.0703 380.1000 1.0515 380.2980 1.0515 380.4000 0.6093 380.5980 0.6093 380.7000 1.0267 380.8980 1.0267 381.0000 0.7863 381.1980 0.7863 381.3000 1.0404 381.4980 1.0404 381.6000 0.6547 381.7980 0.6547 381.9000 0.6006 382.0980 0.6006 382.2000 0.6548 382.3980 0.6548 382.5000 0.5968 382.6980 0.5968 382.8000 0.5883 382.9980 0.5883 383.1000 0.6004 383.2980 0.6004 383.4000 0.5933 383.5980 0.5933 383.7000 0.5768 383.8980 0.5768 384.0000 0.6007 384.1980 0.6007 384.3000 0.6082 384.4980 0.6082 384.6000 0.7191 384.7980 0.7191 384.9000 0.7002 385.0980 0.7002 385.2000 0.7282 385.3980 0.7282 385.5000 0.7377 385.6980 0.7377 385.8000 0.5452 385.9980 0.5452 386.1000 0.5821 386.2980 0.5821 386.4000 0.5732 386.5980 0.5732 386.7000 0.6057 386.8980 0.6057 387.0000 0.7154 387.1980 0.7154 387.3000 0.6020 387.4980 0.6020 387.6000 0.5708 387.7980 0.5708 387.9000 0.5164 388.0980 0.5164 388.2000 0.5878 388.3980 0.5878 388.5000 0.5754 388.6980 0.5754 388.8000 0.9401 388.9980 0.9401 389.1000 0.7668 389.2980 0.7668 389.4000 0.5838 389.5980 0.5838 389.7000 0.7326 389.8980 0.7326 390.0000 0.8951 390.1980 0.8951 390.3000 1.0223 390.4980 1.0223 390.6000 0.9722 390.7980 0.9722 390.9000 0.5095 391.0980 0.5095 391.2000 0.6608 391.3980 0.6608 391.5000 0.8046 391.6980 0.8046 391.8000 1.0954 391.9980 1.0954 392.1000 0.8831 392.2980 0.8831 392.4000 0.9960 392.5980 0.9960 392.7000 0.9835 392.8980 0.9835 393.0000 0.9471 393.1980 0.9471 393.3000 1.0374 393.4980 1.0374 393.6000 1.3489 393.7980 1.3489 393.9000 0.9163 394.0980 0.9163 394.2000 0.9688 394.3980 0.9688 394.5000 0.8247 394.6980 0.8247 394.8000 1.0204 394.9980 1.0204 395.1000 0.6670 395.2980 0.6670 395.4000 0.7327 395.5980 0.7327 395.7000 0.8027 395.8980 0.8027 396.0000 1.0307 396.1980 1.0307 396.3000 0.7115 396.4980 0.7115 396.6000 0.7664 396.7980 0.7664 396.9000 1.0944 397.0980 1.0944 397.2000 1.1378 397.3980 1.1378 397.5000 0.9829 397.6980 0.9829 397.8000 1.0336 397.9980 1.0336 398.1000 1.0903 398.2980 1.0903 398.4000 0.9204 398.5980 0.9204 398.7000 1.1430 398.8980 1.1430 399.0000 0.8651 399.1980 0.8651 399.3000 0.8453 399.4980 0.8453 399.6000 0.9064 399.7980 0.9064 399.9000 1.1466 400.0980 1.1466 400.2000 0.6079 400.3980 0.6079 400.5000 1.0068 400.6980 1.0068 400.8000 0.7961 400.9980 0.7961 401.1000 1.0684 401.2980 1.0684 401.4000 1.0703 401.5980 1.0703 401.7000 1.0515 401.8980 1.0515 402.0000 0.6093 402.1980 0.6093 402.3000 1.0267 402.4980 1.0267 402.6000 0.7863 402.7980 0.7863 402.9000 1.0404 403.0980 1.0404 403.2000 0.6547 403.3980 0.6547 403.5000 0.6006 403.6980 0.6006 403.8000 0.6548 403.9980 0.6548 404.1000 0.5968 404.2980 0.5968 404.4000 0.5883 404.5980 0.5883 404.7000 0.6004 404.8980 0.6004 405.0000 0.5933 405.1980 0.5933 405.3000 0.5768 405.4980 0.5768 405.6000 0.6007 405.7980 0.6007 405.9000 0.6082 406.0980 0.6082 406.2000 0.7191 406.3980 0.7191 406.5000 0.7002 406.6980 0.7002 406.8000 0.7282 406.9980 0.7282 407.1000 0.7377 407.2980 0.7377 407.4000 0.5452 407.5980 0.5452 407.7000 0.5821 407.8980 0.5821 408.0000 0.5732 408.1980 0.5732 408.3000 0.6057 408.4980 0.6057 408.6000 0.7154 408.7980 0.7154 408.9000 0.6020 409.0980 0.6020 409.2000 0.5708 409.3980 0.5708 409.5000 0.5164 409.6980 0.5164 409.8000 0.5878 409.9980 0.5878 410.1000 0.5754 410.2980 0.5754 410.4000 0.9401 410.5980 0.9401 410.7000 0.7668 410.8980 0.7668 411.0000 0.5838 411.1980 0.5838 411.3000 0.7326 411.4980 0.7326 411.6000 0.8951 411.7980 0.8951 411.9000 1.0223 412.0980 1.0223 412.2000 0.9722 412.3980 0.9722 412.5000 0.5095 412.6980 0.5095 412.8000 0.6608 412.9980 0.6608 413.1000 0.8046 413.2980 0.8046 413.4000 1.0954 413.5980 1.0954 413.7000 0.8831 413.8980 0.8831 414.0000 0.9960 414.1980 0.9960 414.3000 0.9835 414.4980 0.9835 414.6000 0.9471 414.7980 0.9471 414.9000 1.0374 415.0980 1.0374 415.2000 1.3489 415.3980 1.3489 415.5000 0.9163 415.6980 0.9163 415.8000 0.9688 415.9980 0.9688 416.1000 0.8247 416.2980 0.8247 416.4000 1.0204 416.5980 1.0204 416.7000 0.6670 416.8980 0.6670 417.0000 0.7327 417.1980 0.7327 417.3000 0.8027 417.4980 0.8027 417.6000 1.0307 417.7980 1.0307 417.9000 0.7115 418.0980 0.7115 418.2000 0.7664 418.3980 0.7664 418.5000 1.0944 418.6980 1.0944 418.8000 1.1378 418.9980 1.1378 419.1000 0.9829 419.2980 0.9829 419.4000 1.0336 419.5980 1.0336 419.7000 1.0903 419.8980 1.0903 420.0000 0.9204 420.1980 0.9204 420.3000 1.1430 420.4980 1.1430 420.6000 0.8651 420.7980 0.8651 420.9000 0.8453 421.0980 0.8453 421.2000 0.9064 421.3980 0.9064 421.5000 1.1466 421.6980 1.1466 421.8000 0.6079 421.9980 0.6079 422.1000 1.0068 422.2980 1.0068 422.4000 0.7961 422.5980 0.7961 422.7000 1.0684 422.8980 1.0684 423.0000 1.0703 423.1980 1.0703 423.3000 1.0515 423.4980 1.0515 423.6000 0.6093 423.7980 0.6093 423.9000 1.0267 424.0980 1.0267 424.2000 0.7863 424.3980 0.7863 424.5000 1.0404 424.6980 1.0404 424.8000 0.6547 424.9980 0.6547 425.1000 0.6006 425.2980 0.6006 425.4000 0.6548 425.5980 0.6548 425.7000 0.5968 425.8980 0.5968 426.0000 0.5883 426.1980 0.5883 426.3000 0.6004 426.4980 0.6004 426.6000 0.5933 426.7980 0.5933 426.9000 0.5768 427.0980 0.5768 427.2000 0.6007 427.3980 0.6007 427.5000 0.6082 427.6980 0.6082 427.8000 0.7191 427.9980 0.7191 428.1000 0.7002 428.2980 0.7002 428.4000 0.7282 428.5980 0.7282 428.7000 0.7377 428.8980 0.7377 429.0000 0.5452 429.1980 0.5452 429.3000 0.5821 429.4980 0.5821 429.6000 0.5732 429.7980 0.5732 429.9000 0.6057 430.0980 0.6057 430.2000 0.7154 430.3980 0.7154 430.5000 0.6020 430.6980 0.6020 430.8000 0.5708 430.9980 0.5708 431.1000 0.5164 431.2980 0.5164 431.4000 0.5878 431.5980 0.5878 431.7000 0.5754 431.8980 0.5754 432.0000 0.9401 432.1980 0.9401 432.3000 0.7668 432.4980 0.7668 432.6000 0.5838 432.7980 0.5838 432.9000 0.7326 433.0980 0.7326 433.2000 0.8951 433.3980 0.8951 433.5000 1.0223 433.6980 1.0223 433.8000 0.9722 433.9980 0.9722 434.1000 0.5095 434.2980 0.5095 434.4000 0.6608 434.5980 0.6608 434.7000 0.8046 434.8980 0.8046 435.0000 1.0954 435.1980 1.0954 435.3000 0.8831 435.4980 0.8831 435.6000 0.9960 435.7980 0.9960 435.9000 0.9835 436.0980 0.9835 436.2000 0.9471 436.3980 0.9471 436.5000 1.0374 436.6980 1.0374 436.8000 1.3489 436.9980 1.3489 437.1000 0.9163 437.2980 0.9163 437.4000 0.9688 437.5980 0.9688 437.7000 0.8247 437.8980 0.8247 438.0000 1.0204 438.1980 1.0204 438.3000 0.6670 438.4980 0.6670 438.6000 0.7327 438.7980 0.7327 438.9000 0.8027 439.0980 0.8027 439.2000 1.0307 439.3980 1.0307 439.5000 0.7115 439.6980 0.7115 439.8000 0.7664 439.9980 0.7664 440.1000 1.0944 440.2980 1.0944 440.4000 1.1378 440.5980 1.1378 440.7000 0.9829 440.8980 0.9829 441.0000 1.0336 441.1980 1.0336 441.3000 1.0903 441.4980 1.0903 441.6000 0.9204 441.7980 0.9204 441.9000 1.1430 442.0980 1.1430 442.2000 0.8651 442.3980 0.8651 442.5000 0.8453 442.6980 0.8453 442.8000 0.9064 442.9980 0.9064 443.1000 1.1466 443.2980 1.1466 443.4000 0.6079 443.5980 0.6079 443.7000 1.0068 443.8980 1.0068 444.0000 0.7961 444.1980 0.7961 444.3000 1.0684 444.4980 1.0684 444.6000 1.0703 444.7980 1.0703 444.9000 1.0515 445.0980 1.0515 445.2000 0.6093 445.3980 0.6093 445.5000 1.0267 445.6980 1.0267 445.8000 0.7863 445.9980 0.7863 446.1000 1.0404 446.2980 1.0404 446.4000 0.6547 446.5980 0.6547 446.7000 0.6006 446.8980 0.6006 447.0000 0.6548 447.1980 0.6548 447.3000 0.5968 447.4980 0.5968 447.6000 0.5883 447.7980 0.5883 447.9000 0.6004 448.0980 0.6004 448.2000 0.5933 448.3980 0.5933 448.5000 0.5768 448.6980 0.5768 448.8000 0.6007 448.9980 0.6007 449.1000 0.6082 449.2980 0.6082 449.4000 0.7191 449.5980 0.7191 449.7000 0.7002 449.8980 0.7002 450.0000 0.7282 450.1980 0.7282 450.3000 0.7377 450.4980 0.7377 450.6000 0.5452 450.7980 0.5452 450.9000 0.5821 451.0980 0.5821 451.2000 0.5732 451.3980 0.5732 451.5000 0.6057 451.6980 0.6057 451.8000 0.7154 451.9980 0.7154 452.1000 0.6020 452.2980 0.6020 452.4000 0.5708 452.5980 0.5708 452.7000 0.5164 452.8980 0.5164 453.0000 0.5878 453.1980 0.5878 453.3000 0.5754 453.4980 0.5754 453.6000 0.9401 453.7980 0.9401 453.9000 0.7668 454.0980 0.7668 454.2000 0.5838 454.3980 0.5838 454.5000 0.7326 454.6980 0.7326 454.8000 0.8951 454.9980 0.8951 455.1000 1.0223 455.2980 1.0223 455.4000 0.9722 455.5980 0.9722 455.7000 0.5095 455.8980 0.5095 456.0000 0.6608 456.1980 0.6608 456.3000 0.8046 456.4980 0.8046 456.6000 1.0954 456.7980 1.0954 456.9000 0.8831 457.0980 0.8831 457.2000 0.9960 457.3980 0.9960 457.5000 0.9835 457.6980 0.9835 457.8000 0.9471 457.9980 0.9471 458.1000 1.0374 458.2980 1.0374 458.4000 1.3489 458.5980 1.3489 458.7000 0.9163 458.8980 0.9163 459.0000 0.9688 459.1980 0.9688 459.3000 0.8247 459.4980 0.8247 459.6000 1.0204 459.7980 1.0204 459.9000 0.6670 460.0980 0.6670 460.2000 0.7327 460.3980 0.7327 460.5000 0.8027 460.6980 0.8027 460.8000 1.0307 460.9980 1.0307 461.1000 0.7115 461.2980 0.7115 461.4000 0.7664 461.5980 0.7664 461.7000 1.0944 461.8980 1.0944 462.0000 1.1378 462.1980 1.1378 462.3000 0.9829 462.4980 0.9829 462.6000 1.0336 462.7980 1.0336 462.9000 1.0903 463.0980 1.0903 463.2000 0.9204 463.3980 0.9204 463.5000 1.1430 463.6980 1.1430 463.8000 0.8651 463.9980 0.8651 464.1000 0.8453 464.2980 0.8453 464.4000 0.9064 464.5980 0.9064 464.7000 1.1466 464.8980 1.1466 465.0000 0.6079 465.1980 0.6079 465.3000 1.0068 465.4980 1.0068 465.6000 0.7961 465.7980 0.7961 465.9000 1.0684 466.0980 1.0684 466.2000 1.0703 466.3980 1.0703 466.5000 1.0515 466.6980 1.0515 466.8000 0.6093 466.9980 0.6093 467.1000 1.0267 467.2980 1.0267 467.4000 0.7863 467.5980 0.7863 467.7000 1.0404 467.8980 1.0404 468.0000 0.6547 468.1980 0.6547 468.3000 0.6006 468.4980 0.6006 468.6000 0.6548 468.7980 0.6548 468.9000 0.5968 469.0980 0.5968 469.2000 0.5883 469.3980 0.5883 469.5000 0.6004 469.6980 0.6004 469.8000 0.5933 469.9980 0.5933 470.1000 0.5768 470.2980 0.5768 470.4000 0.6007 470.5980 0.6007 470.7000 0.6082 470.8980 0.6082 471.0000 0.7191 471.1980 0.7191 471.3000 0.7002 471.4980 0.7002 471.6000 0.7282 471.7980 0.7282 471.9000 0.7377 472.0980 0.7377 472.2000 0.5452 472.3980 0.5452 472.5000 0.5821 472.6980 0.5821 472.8000 0.5732 472.9980 0.5732 473.1000 0.6057 473.2980 0.6057 473.4000 0.7154 473.5980 0.7154 473.7000 0.6020 473.8980 0.6020 474.0000 0.5708 474.1980 0.5708 474.3000 0.5164 474.4980 0.5164 474.6000 0.5878 474.7980 0.5878 474.9000 0.5754 475.0980 0.5754 475.2000 0.9401 475.3980 0.9401 475.5000 0.7668 475.6980 0.7668 475.8000 0.5838 475.9980 0.5838 476.1000 0.7326 476.2980 0.7326 476.4000 0.8951 476.5980 0.8951 476.7000 1.0223 476.8980 1.0223 477.0000 0.9722 477.1980 0.9722 477.3000 0.5095 477.4980 0.5095 477.6000 0.6608 477.7980 0.6608 477.9000 0.8046 478.0980 0.8046 478.2000 1.0954 478.3980 1.0954 478.5000 0.8831 478.6980 0.8831 478.8000 0.9960 478.9980 0.9960 479.1000 0.9835 479.2980 0.9835 479.4000 0.9471 479.5980 0.9471 479.7000 1.0374 479.8980 1.0374 480.0000 1.3489 480.1980 1.3489 480.3000 0.9163 480.4980 0.9163 480.6000 0.9688 480.7980 0.9688 480.9000 0.8247 481.0980 0.8247 481.2000 1.0204 481.3980 1.0204 481.5000 0.6670 481.6980 0.6670 481.8000 0.7327 481.9980 0.7327 482.1000 0.8027 482.2980 0.8027 482.4000 1.0307 482.5980 1.0307 482.7000 0.7115 482.8980 0.7115 483.0000 0.7664 483.1980 0.7664 483.3000 1.0944 483.4980 1.0944 483.6000 1.1378 483.7980 1.1378 483.9000 0.9829 484.0980 0.9829 484.2000 1.0336 484.3980 1.0336 484.5000 1.0903 484.6980 1.0903 484.8000 0.9204 484.9980 0.9204 485.1000 1.1430 485.2980 1.1430 485.4000 0.8651 485.5980 0.8651 485.7000 0.8453 485.8980 0.8453 486.0000 0.9064 486.1980 0.9064 486.3000 1.1466 486.4980 1.1466 486.6000 0.6079 486.7980 0.6079 486.9000 1.0068 487.0980 1.0068 487.2000 0.7961 487.3980 0.7961 487.5000 1.0684 487.6980 1.0684 487.8000 1.0703 487.9980 1.0703 488.1000 1.0515 488.2980 1.0515 488.4000 0.6093 488.5980 0.6093 488.7000 1.0267 488.8980 1.0267 489.0000 0.7863 489.1980 0.7863 489.3000 1.0404 489.4980 1.0404 489.6000 0.6547 489.7980 0.6547 489.9000 0.6006 490.0980 0.6006 490.2000 0.6548 490.3980 0.6548 490.5000 0.5968 490.6980 0.5968 490.8000 0.5883 490.9980 0.5883 491.1000 0.6004 491.2980 0.6004 491.4000 0.5933 491.5980 0.5933 491.7000 0.5768 491.8980 0.5768 492.0000 0.6007 492.1980 0.6007 492.3000 0.6082 492.4980 0.6082 492.6000 0.7191 492.7980 0.7191 492.9000 0.7002 493.0980 0.7002 493.2000 0.7282 493.3980 0.7282 493.5000 0.7377 493.6980 0.7377 493.8000 0.5452 493.9980 0.5452 494.1000 0.5821 494.2980 0.5821 494.4000 0.5732 494.5980 0.5732 494.7000 0.6057 494.8980 0.6057 495.0000 0.7154 495.1980 0.7154 495.3000 0.6020 495.4980 0.6020 495.6000 0.5708 495.7980 0.5708 495.9000 0.5164 496.0980 0.5164 496.2000 0.5878 496.3980 0.5878 496.5000 0.5754 496.6980 0.5754 496.8000 0.9401 496.9980 0.9401 497.1000 0.7668 497.2980 0.7668 497.4000 0.5838 497.5980 0.5838 497.7000 0.7326 497.8980 0.7326 498.0000 0.8951 498.1980 0.8951 498.3000 1.0223 498.4980 1.0223 498.6000 0.9722 498.7980 0.9722 498.9000 0.5095 499.0980 0.5095 499.2000 0.6608 499.3980 0.6608 499.5000 0.8046 499.6980 0.8046 499.8000 1.0954 499.9980 1.0954 500.1000 0.8831 500.2980 0.8831 500.4000 0.9960 500.5980 0.9960 500.7000 0.9835 500.8980 0.9835 501.0000 0.9471 501.1980 0.9471 501.3000 1.0374 501.4980 1.0374 501.6000 1.3489 501.7980 1.3489 501.9000 0.9163 502.0980 0.9163 502.2000 0.9688 502.3980 0.9688 502.5000 0.8247 502.6980 0.8247 502.8000 1.0204 502.9980 1.0204 503.1000 0.6670 503.2980 0.6670 503.4000 0.7327 503.5980 0.7327 503.7000 0.8027 503.8980 0.8027 504.0000 1.0307 504.1980 1.0307 504.3000 0.7115 504.4980 0.7115 504.6000 0.7664 504.7980 0.7664 504.9000 1.0944 505.0980 1.0944 505.2000 1.1378 505.3980 1.1378 505.5000 0.9829 505.6980 0.9829 505.8000 1.0336 505.9980 1.0336 506.1000 1.0903 506.2980 1.0903 506.4000 0.9204 506.5980 0.9204 506.7000 1.1430 506.8980 1.1430 507.0000 0.8651 507.1980 0.8651 507.3000 0.8453 507.4980 0.8453 507.6000 0.9064 507.7980 0.9064 507.9000 1.1466 508.0980 1.1466 508.2000 0.6079 508.3980 0.6079 508.5000 1.0068 508.6980 1.0068 508.8000 0.7961 508.9980 0.7961 509.1000 1.0684 509.2980 1.0684 509.4000 1.0703 509.5980 1.0703 509.7000 1.0515 509.8980 1.0515 510.0000 0.6093 510.1980 0.6093 510.3000 1.0267 510.4980 1.0267 510.6000 0.7863 510.7980 0.7863 510.9000 1.0404 511.0980 1.0404 511.2000 0.6547 511.3980 0.6547 511.5000 0.6006 511.6980 0.6006 511.8000 0.6548 511.9980 0.6548 512.1000 0.5968 512.2980 0.5968 512.4000 0.5883 512.5980 0.5883 512.7000 0.6004 512.8980 0.6004 513.0000 0.5933 513.1980 0.5933 513.3000 0.5768 513.4980 0.5768 513.6000 0.6007 513.7980 0.6007 513.9000 0.6082 514.0980 0.6082 514.2000 0.7191 514.3980 0.7191 514.5000 0.7002 514.6980 0.7002 514.8000 0.7282 514.9980 0.7282 515.1000 0.7377 515.2980 0.7377 515.4000 0.5452 515.5980 0.5452 515.7000 0.5821 515.8980 0.5821 516.0000 0.5732 516.1980 0.5732 516.3000 0.6057 516.4980 0.6057 516.6000 0.7154 516.7980 0.7154 516.9000 0.6020 517.0980 0.6020 517.2000 0.5708 517.3980 0.5708 517.5000 0.5164 517.6980 0.5164 517.8000 0.5878 517.9980 0.5878 518.1000 0.5754 518.2980 0.5754 518.4000 0.9401 518.5980 0.9401 518.7000 0.7668 518.8980 0.7668 519.0000 0.5838 519.1980 0.5838 519.3000 0.7326 519.4980 0.7326 519.6000 0.8951 519.7980 0.8951 519.9000 1.0223 520.0980 1.0223 520.2000 0.9722 520.3980 0.9722 520.5000 0.5095 520.6980 0.5095 520.8000 0.6608 520.9980 0.6608 521.1000 0.8046 521.2980 0.8046 521.4000 1.0954 521.5980 1.0954 521.7000 0.8831 521.8980 0.8831 522.0000 0.9960 522.1980 0.9960 522.3000 0.9835 522.4980 0.9835 522.6000 0.9471 522.7980 0.9471 522.9000 1.0374 523.0980 1.0374 523.2000 1.3489 523.3980 1.3489 523.5000 0.9163 523.6980 0.9163 523.8000 0.9688 523.9980 0.9688 524.1000 0.8247 524.2980 0.8247 524.4000 1.0204 524.5980 1.0204 524.7000 0.6670 524.8980 0.6670 525.0000 0.7327 525.1980 0.7327 525.3000 0.8027 525.4980 0.8027 525.6000 1.0307 525.7980 1.0307 525.9000 0.7115 526.0980 0.7115 526.2000 0.7664 526.3980 0.7664 526.5000 1.0944 526.6980 1.0944 526.8000 1.1378 526.9980 1.1378 527.1000 0.9829 527.2980 0.9829 527.4000 1.0336 527.5980 1.0336 527.7000 1.0903 527.8980 1.0903 528.0000 0.9204 528.1980 0.9204 528.3000 1.1430 528.4980 1.1430 528.6000 0.8651 528.7980 0.8651 528.9000 0.8453 529.0980 0.8453 529.2000 0.9064 529.3980 0.9064 529.5000 1.1466 529.6980 1.1466 529.8000 0.6079 529.9980 0.6079 530.1000 1.0068 530.2980 1.0068 530.4000 0.7961 530.5980 0.7961 530.7000 1.0684 530.8980 1.0684 531.0000 1.0703 531.1980 1.0703 531.3000 1.0515 531.4980 1.0515 531.6000 0.6093 531.7980 0.6093 531.9000 1.0267 532.0980 1.0267 532.2000 0.7863 532.3980 0.7863 532.5000 1.0404 532.6980 1.0404 532.8000 0.6547 532.9980 0.6547 533.1000 0.6006 533.2980 0.6006 533.4000 0.6548 533.5980 0.6548 533.7000 0.5968 533.8980 0.5968 534.0000 0.5883 534.1980 0.5883 534.3000 0.6004 534.4980 0.6004 534.6000 0.5933 534.7980 0.5933 534.9000 0.5768 535.0980 0.5768 535.2000 0.6007 535.3980 0.6007 535.5000 0.6082 535.6980 0.6082 535.8000 0.7191 535.9980 0.7191 536.1000 0.7002 536.2980 0.7002 536.4000 0.7282 536.5980 0.7282 536.7000 0.7377 536.8980 0.7377 537.0000 0.5452 537.1980 0.5452 537.3000 0.5821 537.4980 0.5821 537.6000 0.5732 537.7980 0.5732 537.9000 0.6057 538.0980 0.6057 538.2000 0.7154 538.3980 0.7154 538.5000 0.6020 538.6980 0.6020 538.8000 0.5708 538.9980 0.5708 539.1000 0.5164 539.2980 0.5164 539.4000 0.5878 539.5980 0.5878 539.7000 0.5754 539.8980 0.5754 540.0000 0.9401 540.1980 0.9401 540.3000 0.7668 540.4980 0.7668 540.6000 0.5838 540.7980 0.5838 540.9000 0.7326 541.0980 0.7326 541.2000 0.8951 541.3980 0.8951 541.5000 1.0223 541.6980 1.0223 541.8000 0.9722 541.9980 0.9722 542.1000 0.5095 542.2980 0.5095 542.4000 0.6608 542.5980 0.6608 542.7000 0.8046 542.8980 0.8046 543.0000 1.0954 543.1980 1.0954 543.3000 0.8831 543.4980 0.8831 543.6000 0.9960 543.7980 0.9960 543.9000 0.9835 544.0980 0.9835 544.2000 0.9471 544.3980 0.9471 544.5000 1.0374 544.6980 1.0374 544.8000 1.3489 544.9980 1.3489 545.1000 0.9163 545.2980 0.9163 545.4000 0.9688 545.5980 0.9688 545.7000 0.8247 545.8980 0.8247 546.0000 1.0204 546.1980 1.0204 546.3000 0.6670 546.4980 0.6670 546.6000 0.7327 546.7980 0.7327 546.9000 0.8027 547.0980 0.8027 547.2000 1.0307 547.3980 1.0307 547.5000 0.7115 547.6980 0.7115 547.8000 0.7664 547.9980 0.7664 548.1000 1.0944 548.2980 1.0944 548.4000 1.1378 548.5980 1.1378 548.7000 0.9829 548.8980 0.9829 549.0000 1.0336 549.1980 1.0336 549.3000 1.0903 549.4980 1.0903 549.6000 0.9204 549.7980 0.9204 549.9000 1.1430 550.0980 1.1430 550.2000 0.8651 550.3980 0.8651 550.5000 0.8453 550.6980 0.8453 550.8000 0.9064 550.9980 0.9064 551.1000 1.1466 551.2980 1.1466 551.4000 0.6079 551.5980 0.6079 551.7000 1.0068 551.8980 1.0068 552.0000 0.7961 552.1980 0.7961 552.3000 1.0684 552.4980 1.0684 552.6000 1.0703 552.7980 1.0703 552.9000 1.0515 553.0980 1.0515 553.2000 0.6093 553.3980 0.6093 553.5000 1.0267 553.6980 1.0267 553.8000 0.7863 553.9980 0.7863 554.1000 1.0404 554.2980 1.0404 554.4000 0.6547 554.5980 0.6547 554.7000 0.6006 554.8980 0.6006 555.0000 0.6548 555.1980 0.6548 555.3000 0.5968 555.4980 0.5968 555.6000 0.5883 555.7980 0.5883 555.9000 0.6004 556.0980 0.6004 556.2000 0.5933 556.3980 0.5933 556.5000 0.5768 556.6980 0.5768 556.8000 0.6007 556.9980 0.6007 557.1000 0.6082 557.2980 0.6082 557.4000 0.7191 557.5980 0.7191 557.7000 0.7002 557.8980 0.7002 558.0000 0.7282 558.1980 0.7282 558.3000 0.7377 558.4980 0.7377 558.6000 0.5452 558.7980 0.5452 558.9000 0.5821 559.0980 0.5821 559.2000 0.5732 559.3980 0.5732 559.5000 0.6057 559.6980 0.6057 559.8000 0.7154 559.9980 0.7154 560.1000 0.6020 560.2980 0.6020 560.4000 0.5708 560.5980 0.5708 560.7000 0.5164 560.8980 0.5164 561.0000 0.5878 561.1980 0.5878 561.3000 0.5754 561.4980 0.5754 561.6000 0.9401 561.7980 0.9401 561.9000 0.7668 562.0980 0.7668 562.2000 0.5838 562.3980 0.5838 562.5000 0.7326 562.6980 0.7326 562.8000 0.8951 562.9980 0.8951 563.1000 1.0223 563.2980 1.0223 563.4000 0.9722 563.5980 0.9722 563.7000 0.5095 563.8980 0.5095 564.0000 0.6608 564.1980 0.6608 564.3000 0.8046 564.4980 0.8046 564.6000 1.0954 564.7980 1.0954 564.9000 0.8831 565.0980 0.8831 565.2000 0.9960 565.3980 0.9960 565.5000 0.9835 565.6980 0.9835 565.8000 0.9471 565.9980 0.9471 566.1000 1.0374 566.2980 1.0374 566.4000 1.3489 566.5980 1.3489 566.7000 0.9163 566.8980 0.9163 567.0000 0.9688 567.1980 0.9688 567.3000 0.8247 567.4980 0.8247 567.6000 1.0204 567.7980 1.0204 567.9000 0.6670 568.0980 0.6670 568.2000 0.7327 568.3980 0.7327 568.5000 0.8027 568.6980 0.8027 568.8000 1.0307 568.9980 1.0307 569.1000 0.7115 569.2980 0.7115 569.4000 0.7664 569.5980 0.7664 569.7000 1.0944 569.8980 1.0944 570.0000 1.1378 570.1980 1.1378 570.3000 0.9829 570.4980 0.9829 570.6000 1.0336 570.7980 1.0336 570.9000 1.0903 571.0980 1.0903 571.2000 0.9204 571.3980 0.9204 571.5000 1.1430 571.6980 1.1430 571.8000 0.8651 571.9980 0.8651 572.1000 0.8453 572.2980 0.8453 572.4000 0.9064 572.5980 0.9064 572.7000 1.1466 572.8980 1.1466 573.0000 0.6079 573.1980 0.6079 573.3000 1.0068 573.4980 1.0068 573.6000 0.7961 573.7980 0.7961 573.9000 1.0684 574.0980 1.0684 574.2000 1.0703 574.3980 1.0703 574.5000 1.0515 574.6980 1.0515 574.8000 0.6093 574.9980 0.6093 575.1000 1.0267 575.2980 1.0267 575.4000 0.7863 575.5980 0.7863 575.7000 1.0404 575.8980 1.0404 576.0000 0.6547 576.1980 0.6547 576.3000 0.6006 576.4980 0.6006 576.6000 0.6548 576.7980 0.6548 576.9000 0.5968 577.0980 0.5968 577.2000 0.5883 577.3980 0.5883 577.5000 0.6004 577.6980 0.6004 577.8000 0.5933 577.9980 0.5933 578.1000 0.5768 578.2980 0.5768 578.4000 0.6007 578.5980 0.6007 578.7000 0.6082 578.8980 0.6082 579.0000 0.7191 579.1980 0.7191 579.3000 0.7002 579.4980 0.7002 579.6000 0.7282 579.7980 0.7282 579.9000 0.7377 580.0980 0.7377 580.2000 0.5452 580.3980 0.5452 580.5000 0.5821 580.6980 0.5821 580.8000 0.5732 580.9980 0.5732 581.1000 0.6057 581.2980 0.6057 581.4000 0.7154 581.5980 0.7154 581.7000 0.6020 581.8980 0.6020 582.0000 0.5708 582.1980 0.5708 582.3000 0.5164 582.4980 0.5164 582.6000 0.5878 582.7980 0.5878 582.9000 0.5754 583.0980 0.5754 583.2000 0.9401 583.3980 0.9401 583.5000 0.7668 583.6980 0.7668 583.8000 0.5838 583.9980 0.5838 584.1000 0.7326 584.2980 0.7326 584.4000 0.8951 584.5980 0.8951 584.7000 1.0223 584.8980 1.0223 585.0000 0.9722 585.1980 0.9722 585.3000 0.5095 585.4980 0.5095 585.6000 0.6608 585.7980 0.6608 585.9000 0.8046 586.0980 0.8046 586.2000 1.0954 586.3980 1.0954 586.5000 0.8831 586.6980 0.8831 586.8000 0.9960 586.9980 0.9960 587.1000 0.9835 587.2980 0.9835 587.4000 0.9471 587.5980 0.9471 587.7000 1.0374 587.8980 1.0374 588.0000 1.3489 588.1980 1.3489 588.3000 0.9163 588.4980 0.9163 588.6000 0.9688 588.7980 0.9688 588.9000 0.8247 589.0980 0.8247 589.2000 1.0204 589.3980 1.0204 589.5000 0.6670 589.6980 0.6670 589.8000 0.7327 589.9980 0.7327 590.1000 0.8027 590.2980 0.8027 590.4000 1.0307 590.5980 1.0307 590.7000 0.7115 590.8980 0.7115 591.0000 0.7664 591.1980 0.7664 591.3000 1.0944 591.4980 1.0944 591.6000 1.1378 591.7980 1.1378 591.9000 0.9829 592.0980 0.9829 592.2000 1.0336 592.3980 1.0336 592.5000 1.0903 592.6980 1.0903 592.8000 0.9204 592.9980 0.9204 593.1000 1.1430 593.2980 1.1430 593.4000 0.8651 593.5980 0.8651 593.7000 0.8453 593.8980 0.8453 594.0000 0.9064 594.1980 0.9064 594.3000 1.1466 594.4980 1.1466 594.6000 0.6079 594.7980 0.6079 594.9000 1.0068 595.0980 1.0068 595.2000 0.7961 595.3980 0.7961 595.5000 1.0684 595.6980 1.0684 595.8000 1.0703 595.9980 1.0703 596.1000 1.0515 596.2980 1.0515 596.4000 0.6093 596.5980 0.6093 596.7000 1.0267 596.8980 1.0267 597.0000 0.7863 597.1980 0.7863 597.3000 1.0404 597.4980 1.0404 597.6000 0.6547 597.7980 0.6547 597.9000 0.6006 598.0980 0.6006 598.2000 0.6548 598.3980 0.6548 598.5000 0.5968 598.6980 0.5968 598.8000 0.5883 598.9980 0.5883 599.1000 0.6004 599.2980 0.6004 599.4000 0.5933 599.5980 0.5933 599.7000 0.5768 599.8980 0.5768 600.0000 0.5768)
Va3 a3 0 PWL(0.0000 0.3191 0.1980 0.3191 0.3000 0.4885 0.4980 0.4885 0.6000 0.4856 0.7980 0.4856 0.9000 0.3954 1.0980 0.3954 1.2000 0.6560 1.3980 0.6560 1.5000 0.3461 1.6980 0.3461 1.8000 0.4247 1.9980 0.4247 2.1000 0.5095 2.2980 0.5095 2.4000 0.3615 2.5980 0.3615 2.7000 0.3332 2.8980 0.3332 3.0000 0.5457 3.1980 0.5457 3.3000 0.4304 3.4980 0.4304 3.6000 0.4044 3.7980 0.4044 3.9000 0.4523 4.0980 0.4523 4.2000 0.4588 4.3980 0.4588 4.5000 0.5851 4.6980 0.5851 4.8000 0.4365 4.9980 0.4365 5.1000 0.3918 5.2980 0.3918 5.4000 0.5981 5.5980 0.5981 5.7000 0.6961 5.8980 0.6961 6.0000 0.4123 6.1980 0.4123 6.3000 0.5142 6.4980 0.5142 6.6000 0.4370 6.7980 0.4370 6.9000 0.4637 7.0980 0.4637 7.2000 0.5412 7.3980 0.5412 7.5000 0.5887 7.6980 0.5887 7.8000 0.9657 7.9980 0.9657 8.1000 0.5033 8.2980 0.5033 8.4000 0.5913 8.5980 0.5913 8.7000 0.6190 8.8980 0.6190 9.0000 0.5692 9.1980 0.5692 9.3000 0.5961 9.4980 0.5961 9.6000 0.6150 9.7980 0.6150 9.9000 0.5696 10.0980 0.5696 10.2000 0.6065 10.3980 0.6065 10.5000 0.6194 10.6980 0.6194 10.8000 0.5673 10.9980 0.5673 11.1000 0.6056 11.2980 0.6056 11.4000 0.5477 11.5980 0.5477 11.7000 0.5860 11.8980 0.5860 12.0000 0.5723 12.1980 0.5723 12.3000 0.6247 12.4980 0.6247 12.6000 0.5668 12.7980 0.5668 12.9000 0.6466 13.0980 0.6466 13.2000 0.5790 13.3980 0.5790 13.5000 0.6068 13.6980 0.6068 13.8000 0.5960 13.9980 0.5960 14.1000 0.6236 14.2980 0.6236 14.4000 0.5892 14.5980 0.5892 14.7000 0.6006 14.8980 0.6006 15.0000 0.5466 15.1980 0.5466 15.3000 0.5968 15.4980 0.5968 15.6000 0.5883 15.7980 0.5883 15.9000 0.6004 16.0980 0.6004 16.2000 0.5933 16.3980 0.5933 16.5000 0.5768 16.6980 0.5768 16.8000 0.6007 16.9980 0.6007 17.1000 0.6082 17.2980 0.6082 17.4000 0.5745 17.5980 0.5745 17.7000 0.5786 17.8980 0.5786 18.0000 0.6388 18.1980 0.6388 18.3000 0.6088 18.4980 0.6088 18.6000 0.5452 18.7980 0.5452 18.9000 0.5821 19.0980 0.5821 19.2000 0.5732 19.3980 0.5732 19.5000 0.6057 19.6980 0.6057 19.8000 0.5647 19.9980 0.5647 20.1000 0.6020 20.2980 0.6020 20.4000 0.5708 20.5980 0.5708 20.7000 0.5164 20.8980 0.5164 21.0000 0.5718 21.1980 0.5718 21.3000 0.5754 21.4980 0.5754 21.6000 0.3191 21.7980 0.3191 21.9000 0.4885 22.0980 0.4885 22.2000 0.4856 22.3980 0.4856 22.5000 0.3954 22.6980 0.3954 22.8000 0.6560 22.9980 0.6560 23.1000 0.3461 23.2980 0.3461 23.4000 0.4247 23.5980 0.4247 23.7000 0.5095 23.8980 0.5095 24.0000 0.3615 24.1980 0.3615 24.3000 0.3332 24.4980 0.3332 24.6000 0.5457 24.7980 0.5457 24.9000 0.4304 25.0980 0.4304 25.2000 0.4044 25.3980 0.4044 25.5000 0.4523 25.6980 0.4523 25.8000 0.4588 25.9980 0.4588 26.1000 0.5851 26.2980 0.5851 26.4000 0.4365 26.5980 0.4365 26.7000 0.3918 26.8980 0.3918 27.0000 0.5981 27.1980 0.5981 27.3000 0.6961 27.4980 0.6961 27.6000 0.4123 27.7980 0.4123 27.9000 0.5142 28.0980 0.5142 28.2000 0.4370 28.3980 0.4370 28.5000 0.4637 28.6980 0.4637 28.8000 0.5412 28.9980 0.5412 29.1000 0.5887 29.2980 0.5887 29.4000 0.9657 29.5980 0.9657 29.7000 0.5033 29.8980 0.5033 30.0000 0.5913 30.1980 0.5913 30.3000 0.6190 30.4980 0.6190 30.6000 0.5692 30.7980 0.5692 30.9000 0.5961 31.0980 0.5961 31.2000 0.6150 31.3980 0.6150 31.5000 0.5696 31.6980 0.5696 31.8000 0.6065 31.9980 0.6065 32.1000 0.6194 32.2980 0.6194 32.4000 0.5673 32.5980 0.5673 32.7000 0.6056 32.8980 0.6056 33.0000 0.5477 33.1980 0.5477 33.3000 0.5860 33.4980 0.5860 33.6000 0.5723 33.7980 0.5723 33.9000 0.6247 34.0980 0.6247 34.2000 0.5668 34.3980 0.5668 34.5000 0.6466 34.6980 0.6466 34.8000 0.5790 34.9980 0.5790 35.1000 0.6068 35.2980 0.6068 35.4000 0.5960 35.5980 0.5960 35.7000 0.6236 35.8980 0.6236 36.0000 0.5892 36.1980 0.5892 36.3000 0.6006 36.4980 0.6006 36.6000 0.5466 36.7980 0.5466 36.9000 0.5968 37.0980 0.5968 37.2000 0.5883 37.3980 0.5883 37.5000 0.6004 37.6980 0.6004 37.8000 0.5933 37.9980 0.5933 38.1000 0.5768 38.2980 0.5768 38.4000 0.6007 38.5980 0.6007 38.7000 0.6082 38.8980 0.6082 39.0000 0.5745 39.1980 0.5745 39.3000 0.5786 39.4980 0.5786 39.6000 0.6388 39.7980 0.6388 39.9000 0.6088 40.0980 0.6088 40.2000 0.5452 40.3980 0.5452 40.5000 0.5821 40.6980 0.5821 40.8000 0.5732 40.9980 0.5732 41.1000 0.6057 41.2980 0.6057 41.4000 0.5647 41.5980 0.5647 41.7000 0.6020 41.8980 0.6020 42.0000 0.5708 42.1980 0.5708 42.3000 0.5164 42.4980 0.5164 42.6000 0.5718 42.7980 0.5718 42.9000 0.5754 43.0980 0.5754 43.2000 0.3191 43.3980 0.3191 43.5000 0.4885 43.6980 0.4885 43.8000 0.4856 43.9980 0.4856 44.1000 0.3954 44.2980 0.3954 44.4000 0.6560 44.5980 0.6560 44.7000 0.3461 44.8980 0.3461 45.0000 0.4247 45.1980 0.4247 45.3000 0.5095 45.4980 0.5095 45.6000 0.3615 45.7980 0.3615 45.9000 0.3332 46.0980 0.3332 46.2000 0.5457 46.3980 0.5457 46.5000 0.4304 46.6980 0.4304 46.8000 0.4044 46.9980 0.4044 47.1000 0.4523 47.2980 0.4523 47.4000 0.4588 47.5980 0.4588 47.7000 0.5851 47.8980 0.5851 48.0000 0.4365 48.1980 0.4365 48.3000 0.3918 48.4980 0.3918 48.6000 0.5981 48.7980 0.5981 48.9000 0.6961 49.0980 0.6961 49.2000 0.4123 49.3980 0.4123 49.5000 0.5142 49.6980 0.5142 49.8000 0.4370 49.9980 0.4370 50.1000 0.4637 50.2980 0.4637 50.4000 0.5412 50.5980 0.5412 50.7000 0.5887 50.8980 0.5887 51.0000 0.9657 51.1980 0.9657 51.3000 0.5033 51.4980 0.5033 51.6000 0.5913 51.7980 0.5913 51.9000 0.6190 52.0980 0.6190 52.2000 0.5692 52.3980 0.5692 52.5000 0.5961 52.6980 0.5961 52.8000 0.6150 52.9980 0.6150 53.1000 0.5696 53.2980 0.5696 53.4000 0.6065 53.5980 0.6065 53.7000 0.6194 53.8980 0.6194 54.0000 0.5673 54.1980 0.5673 54.3000 0.6056 54.4980 0.6056 54.6000 0.5477 54.7980 0.5477 54.9000 0.5860 55.0980 0.5860 55.2000 0.5723 55.3980 0.5723 55.5000 0.6247 55.6980 0.6247 55.8000 0.5668 55.9980 0.5668 56.1000 0.6466 56.2980 0.6466 56.4000 0.5790 56.5980 0.5790 56.7000 0.6068 56.8980 0.6068 57.0000 0.5960 57.1980 0.5960 57.3000 0.6236 57.4980 0.6236 57.6000 0.5892 57.7980 0.5892 57.9000 0.6006 58.0980 0.6006 58.2000 0.5466 58.3980 0.5466 58.5000 0.5968 58.6980 0.5968 58.8000 0.5883 58.9980 0.5883 59.1000 0.6004 59.2980 0.6004 59.4000 0.5933 59.5980 0.5933 59.7000 0.5768 59.8980 0.5768 60.0000 0.6007 60.1980 0.6007 60.3000 0.6082 60.4980 0.6082 60.6000 0.5745 60.7980 0.5745 60.9000 0.5786 61.0980 0.5786 61.2000 0.6388 61.3980 0.6388 61.5000 0.6088 61.6980 0.6088 61.8000 0.5452 61.9980 0.5452 62.1000 0.5821 62.2980 0.5821 62.4000 0.5732 62.5980 0.5732 62.7000 0.6057 62.8980 0.6057 63.0000 0.5647 63.1980 0.5647 63.3000 0.6020 63.4980 0.6020 63.6000 0.5708 63.7980 0.5708 63.9000 0.5164 64.0980 0.5164 64.2000 0.5718 64.3980 0.5718 64.5000 0.5754 64.6980 0.5754 64.8000 0.3191 64.9980 0.3191 65.1000 0.4885 65.2980 0.4885 65.4000 0.4856 65.5980 0.4856 65.7000 0.3954 65.8980 0.3954 66.0000 0.6560 66.1980 0.6560 66.3000 0.3461 66.4980 0.3461 66.6000 0.4247 66.7980 0.4247 66.9000 0.5095 67.0980 0.5095 67.2000 0.3615 67.3980 0.3615 67.5000 0.3332 67.6980 0.3332 67.8000 0.5457 67.9980 0.5457 68.1000 0.4304 68.2980 0.4304 68.4000 0.4044 68.5980 0.4044 68.7000 0.4523 68.8980 0.4523 69.0000 0.4588 69.1980 0.4588 69.3000 0.5851 69.4980 0.5851 69.6000 0.4365 69.7980 0.4365 69.9000 0.3918 70.0980 0.3918 70.2000 0.5981 70.3980 0.5981 70.5000 0.6961 70.6980 0.6961 70.8000 0.4123 70.9980 0.4123 71.1000 0.5142 71.2980 0.5142 71.4000 0.4370 71.5980 0.4370 71.7000 0.4637 71.8980 0.4637 72.0000 0.5412 72.1980 0.5412 72.3000 0.5887 72.4980 0.5887 72.6000 0.9657 72.7980 0.9657 72.9000 0.5033 73.0980 0.5033 73.2000 0.5913 73.3980 0.5913 73.5000 0.6190 73.6980 0.6190 73.8000 0.5692 73.9980 0.5692 74.1000 0.5961 74.2980 0.5961 74.4000 0.6150 74.5980 0.6150 74.7000 0.5696 74.8980 0.5696 75.0000 0.6065 75.1980 0.6065 75.3000 0.6194 75.4980 0.6194 75.6000 0.5673 75.7980 0.5673 75.9000 0.6056 76.0980 0.6056 76.2000 0.5477 76.3980 0.5477 76.5000 0.5860 76.6980 0.5860 76.8000 0.5723 76.9980 0.5723 77.1000 0.6247 77.2980 0.6247 77.4000 0.5668 77.5980 0.5668 77.7000 0.6466 77.8980 0.6466 78.0000 0.5790 78.1980 0.5790 78.3000 0.6068 78.4980 0.6068 78.6000 0.5960 78.7980 0.5960 78.9000 0.6236 79.0980 0.6236 79.2000 0.5892 79.3980 0.5892 79.5000 0.6006 79.6980 0.6006 79.8000 0.5466 79.9980 0.5466 80.1000 0.5968 80.2980 0.5968 80.4000 0.5883 80.5980 0.5883 80.7000 0.6004 80.8980 0.6004 81.0000 0.5933 81.1980 0.5933 81.3000 0.5768 81.4980 0.5768 81.6000 0.6007 81.7980 0.6007 81.9000 0.6082 82.0980 0.6082 82.2000 0.5745 82.3980 0.5745 82.5000 0.5786 82.6980 0.5786 82.8000 0.6388 82.9980 0.6388 83.1000 0.6088 83.2980 0.6088 83.4000 0.5452 83.5980 0.5452 83.7000 0.5821 83.8980 0.5821 84.0000 0.5732 84.1980 0.5732 84.3000 0.6057 84.4980 0.6057 84.6000 0.5647 84.7980 0.5647 84.9000 0.6020 85.0980 0.6020 85.2000 0.5708 85.3980 0.5708 85.5000 0.5164 85.6980 0.5164 85.8000 0.5718 85.9980 0.5718 86.1000 0.5754 86.2980 0.5754 86.4000 0.3191 86.5980 0.3191 86.7000 0.4885 86.8980 0.4885 87.0000 0.4856 87.1980 0.4856 87.3000 0.3954 87.4980 0.3954 87.6000 0.6560 87.7980 0.6560 87.9000 0.3461 88.0980 0.3461 88.2000 0.4247 88.3980 0.4247 88.5000 0.5095 88.6980 0.5095 88.8000 0.3615 88.9980 0.3615 89.1000 0.3332 89.2980 0.3332 89.4000 0.5457 89.5980 0.5457 89.7000 0.4304 89.8980 0.4304 90.0000 0.4044 90.1980 0.4044 90.3000 0.4523 90.4980 0.4523 90.6000 0.4588 90.7980 0.4588 90.9000 0.5851 91.0980 0.5851 91.2000 0.4365 91.3980 0.4365 91.5000 0.3918 91.6980 0.3918 91.8000 0.5981 91.9980 0.5981 92.1000 0.6961 92.2980 0.6961 92.4000 0.4123 92.5980 0.4123 92.7000 0.5142 92.8980 0.5142 93.0000 0.4370 93.1980 0.4370 93.3000 0.4637 93.4980 0.4637 93.6000 0.5412 93.7980 0.5412 93.9000 0.5887 94.0980 0.5887 94.2000 0.9657 94.3980 0.9657 94.5000 0.5033 94.6980 0.5033 94.8000 0.5913 94.9980 0.5913 95.1000 0.6190 95.2980 0.6190 95.4000 0.5692 95.5980 0.5692 95.7000 0.5961 95.8980 0.5961 96.0000 0.6150 96.1980 0.6150 96.3000 0.5696 96.4980 0.5696 96.6000 0.6065 96.7980 0.6065 96.9000 0.6194 97.0980 0.6194 97.2000 0.5673 97.3980 0.5673 97.5000 0.6056 97.6980 0.6056 97.8000 0.5477 97.9980 0.5477 98.1000 0.5860 98.2980 0.5860 98.4000 0.5723 98.5980 0.5723 98.7000 0.6247 98.8980 0.6247 99.0000 0.5668 99.1980 0.5668 99.3000 0.6466 99.4980 0.6466 99.6000 0.5790 99.7980 0.5790 99.9000 0.6068 100.0980 0.6068 100.2000 0.5960 100.3980 0.5960 100.5000 0.6236 100.6980 0.6236 100.8000 0.5892 100.9980 0.5892 101.1000 0.6006 101.2980 0.6006 101.4000 0.5466 101.5980 0.5466 101.7000 0.5968 101.8980 0.5968 102.0000 0.5883 102.1980 0.5883 102.3000 0.6004 102.4980 0.6004 102.6000 0.5933 102.7980 0.5933 102.9000 0.5768 103.0980 0.5768 103.2000 0.6007 103.3980 0.6007 103.5000 0.6082 103.6980 0.6082 103.8000 0.5745 103.9980 0.5745 104.1000 0.5786 104.2980 0.5786 104.4000 0.6388 104.5980 0.6388 104.7000 0.6088 104.8980 0.6088 105.0000 0.5452 105.1980 0.5452 105.3000 0.5821 105.4980 0.5821 105.6000 0.5732 105.7980 0.5732 105.9000 0.6057 106.0980 0.6057 106.2000 0.5647 106.3980 0.5647 106.5000 0.6020 106.6980 0.6020 106.8000 0.5708 106.9980 0.5708 107.1000 0.5164 107.2980 0.5164 107.4000 0.5718 107.5980 0.5718 107.7000 0.5754 107.8980 0.5754 108.0000 0.3191 108.1980 0.3191 108.3000 0.4885 108.4980 0.4885 108.6000 0.4856 108.7980 0.4856 108.9000 0.3954 109.0980 0.3954 109.2000 0.6560 109.3980 0.6560 109.5000 0.3461 109.6980 0.3461 109.8000 0.4247 109.9980 0.4247 110.1000 0.5095 110.2980 0.5095 110.4000 0.3615 110.5980 0.3615 110.7000 0.3332 110.8980 0.3332 111.0000 0.5457 111.1980 0.5457 111.3000 0.4304 111.4980 0.4304 111.6000 0.4044 111.7980 0.4044 111.9000 0.4523 112.0980 0.4523 112.2000 0.4588 112.3980 0.4588 112.5000 0.5851 112.6980 0.5851 112.8000 0.4365 112.9980 0.4365 113.1000 0.3918 113.2980 0.3918 113.4000 0.5981 113.5980 0.5981 113.7000 0.6961 113.8980 0.6961 114.0000 0.4123 114.1980 0.4123 114.3000 0.5142 114.4980 0.5142 114.6000 0.4370 114.7980 0.4370 114.9000 0.4637 115.0980 0.4637 115.2000 0.5412 115.3980 0.5412 115.5000 0.5887 115.6980 0.5887 115.8000 0.9657 115.9980 0.9657 116.1000 0.5033 116.2980 0.5033 116.4000 0.5913 116.5980 0.5913 116.7000 0.6190 116.8980 0.6190 117.0000 0.5692 117.1980 0.5692 117.3000 0.5961 117.4980 0.5961 117.6000 0.6150 117.7980 0.6150 117.9000 0.5696 118.0980 0.5696 118.2000 0.6065 118.3980 0.6065 118.5000 0.6194 118.6980 0.6194 118.8000 0.5673 118.9980 0.5673 119.1000 0.6056 119.2980 0.6056 119.4000 0.5477 119.5980 0.5477 119.7000 0.5860 119.8980 0.5860 120.0000 0.5723 120.1980 0.5723 120.3000 0.6247 120.4980 0.6247 120.6000 0.5668 120.7980 0.5668 120.9000 0.6466 121.0980 0.6466 121.2000 0.5790 121.3980 0.5790 121.5000 0.6068 121.6980 0.6068 121.8000 0.5960 121.9980 0.5960 122.1000 0.6236 122.2980 0.6236 122.4000 0.5892 122.5980 0.5892 122.7000 0.6006 122.8980 0.6006 123.0000 0.5466 123.1980 0.5466 123.3000 0.5968 123.4980 0.5968 123.6000 0.5883 123.7980 0.5883 123.9000 0.6004 124.0980 0.6004 124.2000 0.5933 124.3980 0.5933 124.5000 0.5768 124.6980 0.5768 124.8000 0.6007 124.9980 0.6007 125.1000 0.6082 125.2980 0.6082 125.4000 0.5745 125.5980 0.5745 125.7000 0.5786 125.8980 0.5786 126.0000 0.6388 126.1980 0.6388 126.3000 0.6088 126.4980 0.6088 126.6000 0.5452 126.7980 0.5452 126.9000 0.5821 127.0980 0.5821 127.2000 0.5732 127.3980 0.5732 127.5000 0.6057 127.6980 0.6057 127.8000 0.5647 127.9980 0.5647 128.1000 0.6020 128.2980 0.6020 128.4000 0.5708 128.5980 0.5708 128.7000 0.5164 128.8980 0.5164 129.0000 0.5718 129.1980 0.5718 129.3000 0.5754 129.4980 0.5754 129.6000 0.3191 129.7980 0.3191 129.9000 0.4885 130.0980 0.4885 130.2000 0.4856 130.3980 0.4856 130.5000 0.3954 130.6980 0.3954 130.8000 0.6560 130.9980 0.6560 131.1000 0.3461 131.2980 0.3461 131.4000 0.4247 131.5980 0.4247 131.7000 0.5095 131.8980 0.5095 132.0000 0.3615 132.1980 0.3615 132.3000 0.3332 132.4980 0.3332 132.6000 0.5457 132.7980 0.5457 132.9000 0.4304 133.0980 0.4304 133.2000 0.4044 133.3980 0.4044 133.5000 0.4523 133.6980 0.4523 133.8000 0.4588 133.9980 0.4588 134.1000 0.5851 134.2980 0.5851 134.4000 0.4365 134.5980 0.4365 134.7000 0.3918 134.8980 0.3918 135.0000 0.5981 135.1980 0.5981 135.3000 0.6961 135.4980 0.6961 135.6000 0.4123 135.7980 0.4123 135.9000 0.5142 136.0980 0.5142 136.2000 0.4370 136.3980 0.4370 136.5000 0.4637 136.6980 0.4637 136.8000 0.5412 136.9980 0.5412 137.1000 0.5887 137.2980 0.5887 137.4000 0.9657 137.5980 0.9657 137.7000 0.5033 137.8980 0.5033 138.0000 0.5913 138.1980 0.5913 138.3000 0.6190 138.4980 0.6190 138.6000 0.5692 138.7980 0.5692 138.9000 0.5961 139.0980 0.5961 139.2000 0.6150 139.3980 0.6150 139.5000 0.5696 139.6980 0.5696 139.8000 0.6065 139.9980 0.6065 140.1000 0.6194 140.2980 0.6194 140.4000 0.5673 140.5980 0.5673 140.7000 0.6056 140.8980 0.6056 141.0000 0.5477 141.1980 0.5477 141.3000 0.5860 141.4980 0.5860 141.6000 0.5723 141.7980 0.5723 141.9000 0.6247 142.0980 0.6247 142.2000 0.5668 142.3980 0.5668 142.5000 0.6466 142.6980 0.6466 142.8000 0.5790 142.9980 0.5790 143.1000 0.6068 143.2980 0.6068 143.4000 0.5960 143.5980 0.5960 143.7000 0.6236 143.8980 0.6236 144.0000 0.5892 144.1980 0.5892 144.3000 0.6006 144.4980 0.6006 144.6000 0.5466 144.7980 0.5466 144.9000 0.5968 145.0980 0.5968 145.2000 0.5883 145.3980 0.5883 145.5000 0.6004 145.6980 0.6004 145.8000 0.5933 145.9980 0.5933 146.1000 0.5768 146.2980 0.5768 146.4000 0.6007 146.5980 0.6007 146.7000 0.6082 146.8980 0.6082 147.0000 0.5745 147.1980 0.5745 147.3000 0.5786 147.4980 0.5786 147.6000 0.6388 147.7980 0.6388 147.9000 0.6088 148.0980 0.6088 148.2000 0.5452 148.3980 0.5452 148.5000 0.5821 148.6980 0.5821 148.8000 0.5732 148.9980 0.5732 149.1000 0.6057 149.2980 0.6057 149.4000 0.5647 149.5980 0.5647 149.7000 0.6020 149.8980 0.6020 150.0000 0.5708 150.1980 0.5708 150.3000 0.5164 150.4980 0.5164 150.6000 0.5718 150.7980 0.5718 150.9000 0.5754 151.0980 0.5754 151.2000 0.3191 151.3980 0.3191 151.5000 0.4885 151.6980 0.4885 151.8000 0.4856 151.9980 0.4856 152.1000 0.3954 152.2980 0.3954 152.4000 0.6560 152.5980 0.6560 152.7000 0.3461 152.8980 0.3461 153.0000 0.4247 153.1980 0.4247 153.3000 0.5095 153.4980 0.5095 153.6000 0.3615 153.7980 0.3615 153.9000 0.3332 154.0980 0.3332 154.2000 0.5457 154.3980 0.5457 154.5000 0.4304 154.6980 0.4304 154.8000 0.4044 154.9980 0.4044 155.1000 0.4523 155.2980 0.4523 155.4000 0.4588 155.5980 0.4588 155.7000 0.5851 155.8980 0.5851 156.0000 0.4365 156.1980 0.4365 156.3000 0.3918 156.4980 0.3918 156.6000 0.5981 156.7980 0.5981 156.9000 0.6961 157.0980 0.6961 157.2000 0.4123 157.3980 0.4123 157.5000 0.5142 157.6980 0.5142 157.8000 0.4370 157.9980 0.4370 158.1000 0.4637 158.2980 0.4637 158.4000 0.5412 158.5980 0.5412 158.7000 0.5887 158.8980 0.5887 159.0000 0.9657 159.1980 0.9657 159.3000 0.5033 159.4980 0.5033 159.6000 0.5913 159.7980 0.5913 159.9000 0.6190 160.0980 0.6190 160.2000 0.5692 160.3980 0.5692 160.5000 0.5961 160.6980 0.5961 160.8000 0.6150 160.9980 0.6150 161.1000 0.5696 161.2980 0.5696 161.4000 0.6065 161.5980 0.6065 161.7000 0.6194 161.8980 0.6194 162.0000 0.5673 162.1980 0.5673 162.3000 0.6056 162.4980 0.6056 162.6000 0.5477 162.7980 0.5477 162.9000 0.5860 163.0980 0.5860 163.2000 0.5723 163.3980 0.5723 163.5000 0.6247 163.6980 0.6247 163.8000 0.5668 163.9980 0.5668 164.1000 0.6466 164.2980 0.6466 164.4000 0.5790 164.5980 0.5790 164.7000 0.6068 164.8980 0.6068 165.0000 0.5960 165.1980 0.5960 165.3000 0.6236 165.4980 0.6236 165.6000 0.5892 165.7980 0.5892 165.9000 0.6006 166.0980 0.6006 166.2000 0.5466 166.3980 0.5466 166.5000 0.5968 166.6980 0.5968 166.8000 0.5883 166.9980 0.5883 167.1000 0.6004 167.2980 0.6004 167.4000 0.5933 167.5980 0.5933 167.7000 0.5768 167.8980 0.5768 168.0000 0.6007 168.1980 0.6007 168.3000 0.6082 168.4980 0.6082 168.6000 0.5745 168.7980 0.5745 168.9000 0.5786 169.0980 0.5786 169.2000 0.6388 169.3980 0.6388 169.5000 0.6088 169.6980 0.6088 169.8000 0.5452 169.9980 0.5452 170.1000 0.5821 170.2980 0.5821 170.4000 0.5732 170.5980 0.5732 170.7000 0.6057 170.8980 0.6057 171.0000 0.5647 171.1980 0.5647 171.3000 0.6020 171.4980 0.6020 171.6000 0.5708 171.7980 0.5708 171.9000 0.5164 172.0980 0.5164 172.2000 0.5718 172.3980 0.5718 172.5000 0.5754 172.6980 0.5754 172.8000 0.3191 172.9980 0.3191 173.1000 0.4885 173.2980 0.4885 173.4000 0.4856 173.5980 0.4856 173.7000 0.3954 173.8980 0.3954 174.0000 0.6560 174.1980 0.6560 174.3000 0.3461 174.4980 0.3461 174.6000 0.4247 174.7980 0.4247 174.9000 0.5095 175.0980 0.5095 175.2000 0.3615 175.3980 0.3615 175.5000 0.3332 175.6980 0.3332 175.8000 0.5457 175.9980 0.5457 176.1000 0.4304 176.2980 0.4304 176.4000 0.4044 176.5980 0.4044 176.7000 0.4523 176.8980 0.4523 177.0000 0.4588 177.1980 0.4588 177.3000 0.5851 177.4980 0.5851 177.6000 0.4365 177.7980 0.4365 177.9000 0.3918 178.0980 0.3918 178.2000 0.5981 178.3980 0.5981 178.5000 0.6961 178.6980 0.6961 178.8000 0.4123 178.9980 0.4123 179.1000 0.5142 179.2980 0.5142 179.4000 0.4370 179.5980 0.4370 179.7000 0.4637 179.8980 0.4637 180.0000 0.5412 180.1980 0.5412 180.3000 0.5887 180.4980 0.5887 180.6000 0.9657 180.7980 0.9657 180.9000 0.5033 181.0980 0.5033 181.2000 0.5913 181.3980 0.5913 181.5000 0.6190 181.6980 0.6190 181.8000 0.5692 181.9980 0.5692 182.1000 0.5961 182.2980 0.5961 182.4000 0.6150 182.5980 0.6150 182.7000 0.5696 182.8980 0.5696 183.0000 0.6065 183.1980 0.6065 183.3000 0.6194 183.4980 0.6194 183.6000 0.5673 183.7980 0.5673 183.9000 0.6056 184.0980 0.6056 184.2000 0.5477 184.3980 0.5477 184.5000 0.5860 184.6980 0.5860 184.8000 0.5723 184.9980 0.5723 185.1000 0.6247 185.2980 0.6247 185.4000 0.5668 185.5980 0.5668 185.7000 0.6466 185.8980 0.6466 186.0000 0.5790 186.1980 0.5790 186.3000 0.6068 186.4980 0.6068 186.6000 0.5960 186.7980 0.5960 186.9000 0.6236 187.0980 0.6236 187.2000 0.5892 187.3980 0.5892 187.5000 0.6006 187.6980 0.6006 187.8000 0.5466 187.9980 0.5466 188.1000 0.5968 188.2980 0.5968 188.4000 0.5883 188.5980 0.5883 188.7000 0.6004 188.8980 0.6004 189.0000 0.5933 189.1980 0.5933 189.3000 0.5768 189.4980 0.5768 189.6000 0.6007 189.7980 0.6007 189.9000 0.6082 190.0980 0.6082 190.2000 0.5745 190.3980 0.5745 190.5000 0.5786 190.6980 0.5786 190.8000 0.6388 190.9980 0.6388 191.1000 0.6088 191.2980 0.6088 191.4000 0.5452 191.5980 0.5452 191.7000 0.5821 191.8980 0.5821 192.0000 0.5732 192.1980 0.5732 192.3000 0.6057 192.4980 0.6057 192.6000 0.5647 192.7980 0.5647 192.9000 0.6020 193.0980 0.6020 193.2000 0.5708 193.3980 0.5708 193.5000 0.5164 193.6980 0.5164 193.8000 0.5718 193.9980 0.5718 194.1000 0.5754 194.2980 0.5754 194.4000 0.3191 194.5980 0.3191 194.7000 0.4885 194.8980 0.4885 195.0000 0.4856 195.1980 0.4856 195.3000 0.3954 195.4980 0.3954 195.6000 0.6560 195.7980 0.6560 195.9000 0.3461 196.0980 0.3461 196.2000 0.4247 196.3980 0.4247 196.5000 0.5095 196.6980 0.5095 196.8000 0.3615 196.9980 0.3615 197.1000 0.3332 197.2980 0.3332 197.4000 0.5457 197.5980 0.5457 197.7000 0.4304 197.8980 0.4304 198.0000 0.4044 198.1980 0.4044 198.3000 0.4523 198.4980 0.4523 198.6000 0.4588 198.7980 0.4588 198.9000 0.5851 199.0980 0.5851 199.2000 0.4365 199.3980 0.4365 199.5000 0.3918 199.6980 0.3918 199.8000 0.5981 199.9980 0.5981 200.1000 0.6961 200.2980 0.6961 200.4000 0.4123 200.5980 0.4123 200.7000 0.5142 200.8980 0.5142 201.0000 0.4370 201.1980 0.4370 201.3000 0.4637 201.4980 0.4637 201.6000 0.5412 201.7980 0.5412 201.9000 0.5887 202.0980 0.5887 202.2000 0.9657 202.3980 0.9657 202.5000 0.5033 202.6980 0.5033 202.8000 0.5913 202.9980 0.5913 203.1000 0.6190 203.2980 0.6190 203.4000 0.5692 203.5980 0.5692 203.7000 0.5961 203.8980 0.5961 204.0000 0.6150 204.1980 0.6150 204.3000 0.5696 204.4980 0.5696 204.6000 0.6065 204.7980 0.6065 204.9000 0.6194 205.0980 0.6194 205.2000 0.5673 205.3980 0.5673 205.5000 0.6056 205.6980 0.6056 205.8000 0.5477 205.9980 0.5477 206.1000 0.5860 206.2980 0.5860 206.4000 0.5723 206.5980 0.5723 206.7000 0.6247 206.8980 0.6247 207.0000 0.5668 207.1980 0.5668 207.3000 0.6466 207.4980 0.6466 207.6000 0.5790 207.7980 0.5790 207.9000 0.6068 208.0980 0.6068 208.2000 0.5960 208.3980 0.5960 208.5000 0.6236 208.6980 0.6236 208.8000 0.5892 208.9980 0.5892 209.1000 0.6006 209.2980 0.6006 209.4000 0.5466 209.5980 0.5466 209.7000 0.5968 209.8980 0.5968 210.0000 0.5883 210.1980 0.5883 210.3000 0.6004 210.4980 0.6004 210.6000 0.5933 210.7980 0.5933 210.9000 0.5768 211.0980 0.5768 211.2000 0.6007 211.3980 0.6007 211.5000 0.6082 211.6980 0.6082 211.8000 0.5745 211.9980 0.5745 212.1000 0.5786 212.2980 0.5786 212.4000 0.6388 212.5980 0.6388 212.7000 0.6088 212.8980 0.6088 213.0000 0.5452 213.1980 0.5452 213.3000 0.5821 213.4980 0.5821 213.6000 0.5732 213.7980 0.5732 213.9000 0.6057 214.0980 0.6057 214.2000 0.5647 214.3980 0.5647 214.5000 0.6020 214.6980 0.6020 214.8000 0.5708 214.9980 0.5708 215.1000 0.5164 215.2980 0.5164 215.4000 0.5718 215.5980 0.5718 215.7000 0.5754 215.8980 0.5754 216.0000 0.3191 216.1980 0.3191 216.3000 0.4885 216.4980 0.4885 216.6000 0.4856 216.7980 0.4856 216.9000 0.3954 217.0980 0.3954 217.2000 0.6560 217.3980 0.6560 217.5000 0.3461 217.6980 0.3461 217.8000 0.4247 217.9980 0.4247 218.1000 0.5095 218.2980 0.5095 218.4000 0.3615 218.5980 0.3615 218.7000 0.3332 218.8980 0.3332 219.0000 0.5457 219.1980 0.5457 219.3000 0.4304 219.4980 0.4304 219.6000 0.4044 219.7980 0.4044 219.9000 0.4523 220.0980 0.4523 220.2000 0.4588 220.3980 0.4588 220.5000 0.5851 220.6980 0.5851 220.8000 0.4365 220.9980 0.4365 221.1000 0.3918 221.2980 0.3918 221.4000 0.5981 221.5980 0.5981 221.7000 0.6961 221.8980 0.6961 222.0000 0.4123 222.1980 0.4123 222.3000 0.5142 222.4980 0.5142 222.6000 0.4370 222.7980 0.4370 222.9000 0.4637 223.0980 0.4637 223.2000 0.5412 223.3980 0.5412 223.5000 0.5887 223.6980 0.5887 223.8000 0.9657 223.9980 0.9657 224.1000 0.5033 224.2980 0.5033 224.4000 0.5913 224.5980 0.5913 224.7000 0.6190 224.8980 0.6190 225.0000 0.5692 225.1980 0.5692 225.3000 0.5961 225.4980 0.5961 225.6000 0.6150 225.7980 0.6150 225.9000 0.5696 226.0980 0.5696 226.2000 0.6065 226.3980 0.6065 226.5000 0.6194 226.6980 0.6194 226.8000 0.5673 226.9980 0.5673 227.1000 0.6056 227.2980 0.6056 227.4000 0.5477 227.5980 0.5477 227.7000 0.5860 227.8980 0.5860 228.0000 0.5723 228.1980 0.5723 228.3000 0.6247 228.4980 0.6247 228.6000 0.5668 228.7980 0.5668 228.9000 0.6466 229.0980 0.6466 229.2000 0.5790 229.3980 0.5790 229.5000 0.6068 229.6980 0.6068 229.8000 0.5960 229.9980 0.5960 230.1000 0.6236 230.2980 0.6236 230.4000 0.5892 230.5980 0.5892 230.7000 0.6006 230.8980 0.6006 231.0000 0.5466 231.1980 0.5466 231.3000 0.5968 231.4980 0.5968 231.6000 0.5883 231.7980 0.5883 231.9000 0.6004 232.0980 0.6004 232.2000 0.5933 232.3980 0.5933 232.5000 0.5768 232.6980 0.5768 232.8000 0.6007 232.9980 0.6007 233.1000 0.6082 233.2980 0.6082 233.4000 0.5745 233.5980 0.5745 233.7000 0.5786 233.8980 0.5786 234.0000 0.6388 234.1980 0.6388 234.3000 0.6088 234.4980 0.6088 234.6000 0.5452 234.7980 0.5452 234.9000 0.5821 235.0980 0.5821 235.2000 0.5732 235.3980 0.5732 235.5000 0.6057 235.6980 0.6057 235.8000 0.5647 235.9980 0.5647 236.1000 0.6020 236.2980 0.6020 236.4000 0.5708 236.5980 0.5708 236.7000 0.5164 236.8980 0.5164 237.0000 0.5718 237.1980 0.5718 237.3000 0.5754 237.4980 0.5754 237.6000 0.3191 237.7980 0.3191 237.9000 0.4885 238.0980 0.4885 238.2000 0.4856 238.3980 0.4856 238.5000 0.3954 238.6980 0.3954 238.8000 0.6560 238.9980 0.6560 239.1000 0.3461 239.2980 0.3461 239.4000 0.4247 239.5980 0.4247 239.7000 0.5095 239.8980 0.5095 240.0000 0.3615 240.1980 0.3615 240.3000 0.3332 240.4980 0.3332 240.6000 0.5457 240.7980 0.5457 240.9000 0.4304 241.0980 0.4304 241.2000 0.4044 241.3980 0.4044 241.5000 0.4523 241.6980 0.4523 241.8000 0.4588 241.9980 0.4588 242.1000 0.5851 242.2980 0.5851 242.4000 0.4365 242.5980 0.4365 242.7000 0.3918 242.8980 0.3918 243.0000 0.5981 243.1980 0.5981 243.3000 0.6961 243.4980 0.6961 243.6000 0.4123 243.7980 0.4123 243.9000 0.5142 244.0980 0.5142 244.2000 0.4370 244.3980 0.4370 244.5000 0.4637 244.6980 0.4637 244.8000 0.5412 244.9980 0.5412 245.1000 0.5887 245.2980 0.5887 245.4000 0.9657 245.5980 0.9657 245.7000 0.5033 245.8980 0.5033 246.0000 0.5913 246.1980 0.5913 246.3000 0.6190 246.4980 0.6190 246.6000 0.5692 246.7980 0.5692 246.9000 0.5961 247.0980 0.5961 247.2000 0.6150 247.3980 0.6150 247.5000 0.5696 247.6980 0.5696 247.8000 0.6065 247.9980 0.6065 248.1000 0.6194 248.2980 0.6194 248.4000 0.5673 248.5980 0.5673 248.7000 0.6056 248.8980 0.6056 249.0000 0.5477 249.1980 0.5477 249.3000 0.5860 249.4980 0.5860 249.6000 0.5723 249.7980 0.5723 249.9000 0.6247 250.0980 0.6247 250.2000 0.5668 250.3980 0.5668 250.5000 0.6466 250.6980 0.6466 250.8000 0.5790 250.9980 0.5790 251.1000 0.6068 251.2980 0.6068 251.4000 0.5960 251.5980 0.5960 251.7000 0.6236 251.8980 0.6236 252.0000 0.5892 252.1980 0.5892 252.3000 0.6006 252.4980 0.6006 252.6000 0.5466 252.7980 0.5466 252.9000 0.5968 253.0980 0.5968 253.2000 0.5883 253.3980 0.5883 253.5000 0.6004 253.6980 0.6004 253.8000 0.5933 253.9980 0.5933 254.1000 0.5768 254.2980 0.5768 254.4000 0.6007 254.5980 0.6007 254.7000 0.6082 254.8980 0.6082 255.0000 0.5745 255.1980 0.5745 255.3000 0.5786 255.4980 0.5786 255.6000 0.6388 255.7980 0.6388 255.9000 0.6088 256.0980 0.6088 256.2000 0.5452 256.3980 0.5452 256.5000 0.5821 256.6980 0.5821 256.8000 0.5732 256.9980 0.5732 257.1000 0.6057 257.2980 0.6057 257.4000 0.5647 257.5980 0.5647 257.7000 0.6020 257.8980 0.6020 258.0000 0.5708 258.1980 0.5708 258.3000 0.5164 258.4980 0.5164 258.6000 0.5718 258.7980 0.5718 258.9000 0.5754 259.0980 0.5754 259.2000 0.3191 259.3980 0.3191 259.5000 0.4885 259.6980 0.4885 259.8000 0.4856 259.9980 0.4856 260.1000 0.3954 260.2980 0.3954 260.4000 0.6560 260.5980 0.6560 260.7000 0.3461 260.8980 0.3461 261.0000 0.4247 261.1980 0.4247 261.3000 0.5095 261.4980 0.5095 261.6000 0.3615 261.7980 0.3615 261.9000 0.3332 262.0980 0.3332 262.2000 0.5457 262.3980 0.5457 262.5000 0.4304 262.6980 0.4304 262.8000 0.4044 262.9980 0.4044 263.1000 0.4523 263.2980 0.4523 263.4000 0.4588 263.5980 0.4588 263.7000 0.5851 263.8980 0.5851 264.0000 0.4365 264.1980 0.4365 264.3000 0.3918 264.4980 0.3918 264.6000 0.5981 264.7980 0.5981 264.9000 0.6961 265.0980 0.6961 265.2000 0.4123 265.3980 0.4123 265.5000 0.5142 265.6980 0.5142 265.8000 0.4370 265.9980 0.4370 266.1000 0.4637 266.2980 0.4637 266.4000 0.5412 266.5980 0.5412 266.7000 0.5887 266.8980 0.5887 267.0000 0.9657 267.1980 0.9657 267.3000 0.5033 267.4980 0.5033 267.6000 0.5913 267.7980 0.5913 267.9000 0.6190 268.0980 0.6190 268.2000 0.5692 268.3980 0.5692 268.5000 0.5961 268.6980 0.5961 268.8000 0.6150 268.9980 0.6150 269.1000 0.5696 269.2980 0.5696 269.4000 0.6065 269.5980 0.6065 269.7000 0.6194 269.8980 0.6194 270.0000 0.5673 270.1980 0.5673 270.3000 0.6056 270.4980 0.6056 270.6000 0.5477 270.7980 0.5477 270.9000 0.5860 271.0980 0.5860 271.2000 0.5723 271.3980 0.5723 271.5000 0.6247 271.6980 0.6247 271.8000 0.5668 271.9980 0.5668 272.1000 0.6466 272.2980 0.6466 272.4000 0.5790 272.5980 0.5790 272.7000 0.6068 272.8980 0.6068 273.0000 0.5960 273.1980 0.5960 273.3000 0.6236 273.4980 0.6236 273.6000 0.5892 273.7980 0.5892 273.9000 0.6006 274.0980 0.6006 274.2000 0.5466 274.3980 0.5466 274.5000 0.5968 274.6980 0.5968 274.8000 0.5883 274.9980 0.5883 275.1000 0.6004 275.2980 0.6004 275.4000 0.5933 275.5980 0.5933 275.7000 0.5768 275.8980 0.5768 276.0000 0.6007 276.1980 0.6007 276.3000 0.6082 276.4980 0.6082 276.6000 0.5745 276.7980 0.5745 276.9000 0.5786 277.0980 0.5786 277.2000 0.6388 277.3980 0.6388 277.5000 0.6088 277.6980 0.6088 277.8000 0.5452 277.9980 0.5452 278.1000 0.5821 278.2980 0.5821 278.4000 0.5732 278.5980 0.5732 278.7000 0.6057 278.8980 0.6057 279.0000 0.5647 279.1980 0.5647 279.3000 0.6020 279.4980 0.6020 279.6000 0.5708 279.7980 0.5708 279.9000 0.5164 280.0980 0.5164 280.2000 0.5718 280.3980 0.5718 280.5000 0.5754 280.6980 0.5754 280.8000 0.3191 280.9980 0.3191 281.1000 0.4885 281.2980 0.4885 281.4000 0.4856 281.5980 0.4856 281.7000 0.3954 281.8980 0.3954 282.0000 0.6560 282.1980 0.6560 282.3000 0.3461 282.4980 0.3461 282.6000 0.4247 282.7980 0.4247 282.9000 0.5095 283.0980 0.5095 283.2000 0.3615 283.3980 0.3615 283.5000 0.3332 283.6980 0.3332 283.8000 0.5457 283.9980 0.5457 284.1000 0.4304 284.2980 0.4304 284.4000 0.4044 284.5980 0.4044 284.7000 0.4523 284.8980 0.4523 285.0000 0.4588 285.1980 0.4588 285.3000 0.5851 285.4980 0.5851 285.6000 0.4365 285.7980 0.4365 285.9000 0.3918 286.0980 0.3918 286.2000 0.5981 286.3980 0.5981 286.5000 0.6961 286.6980 0.6961 286.8000 0.4123 286.9980 0.4123 287.1000 0.5142 287.2980 0.5142 287.4000 0.4370 287.5980 0.4370 287.7000 0.4637 287.8980 0.4637 288.0000 0.5412 288.1980 0.5412 288.3000 0.5887 288.4980 0.5887 288.6000 0.9657 288.7980 0.9657 288.9000 0.5033 289.0980 0.5033 289.2000 0.5913 289.3980 0.5913 289.5000 0.6190 289.6980 0.6190 289.8000 0.5692 289.9980 0.5692 290.1000 0.5961 290.2980 0.5961 290.4000 0.6150 290.5980 0.6150 290.7000 0.5696 290.8980 0.5696 291.0000 0.6065 291.1980 0.6065 291.3000 0.6194 291.4980 0.6194 291.6000 0.5673 291.7980 0.5673 291.9000 0.6056 292.0980 0.6056 292.2000 0.5477 292.3980 0.5477 292.5000 0.5860 292.6980 0.5860 292.8000 0.5723 292.9980 0.5723 293.1000 0.6247 293.2980 0.6247 293.4000 0.5668 293.5980 0.5668 293.7000 0.6466 293.8980 0.6466 294.0000 0.5790 294.1980 0.5790 294.3000 0.6068 294.4980 0.6068 294.6000 0.5960 294.7980 0.5960 294.9000 0.6236 295.0980 0.6236 295.2000 0.5892 295.3980 0.5892 295.5000 0.6006 295.6980 0.6006 295.8000 0.5466 295.9980 0.5466 296.1000 0.5968 296.2980 0.5968 296.4000 0.5883 296.5980 0.5883 296.7000 0.6004 296.8980 0.6004 297.0000 0.5933 297.1980 0.5933 297.3000 0.5768 297.4980 0.5768 297.6000 0.6007 297.7980 0.6007 297.9000 0.6082 298.0980 0.6082 298.2000 0.5745 298.3980 0.5745 298.5000 0.5786 298.6980 0.5786 298.8000 0.6388 298.9980 0.6388 299.1000 0.6088 299.2980 0.6088 299.4000 0.5452 299.5980 0.5452 299.7000 0.5821 299.8980 0.5821 300.0000 0.5732 300.1980 0.5732 300.3000 0.6057 300.4980 0.6057 300.6000 0.5647 300.7980 0.5647 300.9000 0.6020 301.0980 0.6020 301.2000 0.5708 301.3980 0.5708 301.5000 0.5164 301.6980 0.5164 301.8000 0.5718 301.9980 0.5718 302.1000 0.5754 302.2980 0.5754 302.4000 0.3191 302.5980 0.3191 302.7000 0.4885 302.8980 0.4885 303.0000 0.4856 303.1980 0.4856 303.3000 0.3954 303.4980 0.3954 303.6000 0.6560 303.7980 0.6560 303.9000 0.3461 304.0980 0.3461 304.2000 0.4247 304.3980 0.4247 304.5000 0.5095 304.6980 0.5095 304.8000 0.3615 304.9980 0.3615 305.1000 0.3332 305.2980 0.3332 305.4000 0.5457 305.5980 0.5457 305.7000 0.4304 305.8980 0.4304 306.0000 0.4044 306.1980 0.4044 306.3000 0.4523 306.4980 0.4523 306.6000 0.4588 306.7980 0.4588 306.9000 0.5851 307.0980 0.5851 307.2000 0.4365 307.3980 0.4365 307.5000 0.3918 307.6980 0.3918 307.8000 0.5981 307.9980 0.5981 308.1000 0.6961 308.2980 0.6961 308.4000 0.4123 308.5980 0.4123 308.7000 0.5142 308.8980 0.5142 309.0000 0.4370 309.1980 0.4370 309.3000 0.4637 309.4980 0.4637 309.6000 0.5412 309.7980 0.5412 309.9000 0.5887 310.0980 0.5887 310.2000 0.9657 310.3980 0.9657 310.5000 0.5033 310.6980 0.5033 310.8000 0.5913 310.9980 0.5913 311.1000 0.6190 311.2980 0.6190 311.4000 0.5692 311.5980 0.5692 311.7000 0.5961 311.8980 0.5961 312.0000 0.6150 312.1980 0.6150 312.3000 0.5696 312.4980 0.5696 312.6000 0.6065 312.7980 0.6065 312.9000 0.6194 313.0980 0.6194 313.2000 0.5673 313.3980 0.5673 313.5000 0.6056 313.6980 0.6056 313.8000 0.5477 313.9980 0.5477 314.1000 0.5860 314.2980 0.5860 314.4000 0.5723 314.5980 0.5723 314.7000 0.6247 314.8980 0.6247 315.0000 0.5668 315.1980 0.5668 315.3000 0.6466 315.4980 0.6466 315.6000 0.5790 315.7980 0.5790 315.9000 0.6068 316.0980 0.6068 316.2000 0.5960 316.3980 0.5960 316.5000 0.6236 316.6980 0.6236 316.8000 0.5892 316.9980 0.5892 317.1000 0.6006 317.2980 0.6006 317.4000 0.5466 317.5980 0.5466 317.7000 0.5968 317.8980 0.5968 318.0000 0.5883 318.1980 0.5883 318.3000 0.6004 318.4980 0.6004 318.6000 0.5933 318.7980 0.5933 318.9000 0.5768 319.0980 0.5768 319.2000 0.6007 319.3980 0.6007 319.5000 0.6082 319.6980 0.6082 319.8000 0.5745 319.9980 0.5745 320.1000 0.5786 320.2980 0.5786 320.4000 0.6388 320.5980 0.6388 320.7000 0.6088 320.8980 0.6088 321.0000 0.5452 321.1980 0.5452 321.3000 0.5821 321.4980 0.5821 321.6000 0.5732 321.7980 0.5732 321.9000 0.6057 322.0980 0.6057 322.2000 0.5647 322.3980 0.5647 322.5000 0.6020 322.6980 0.6020 322.8000 0.5708 322.9980 0.5708 323.1000 0.5164 323.2980 0.5164 323.4000 0.5718 323.5980 0.5718 323.7000 0.5754 323.8980 0.5754 324.0000 0.3191 324.1980 0.3191 324.3000 0.4885 324.4980 0.4885 324.6000 0.4856 324.7980 0.4856 324.9000 0.3954 325.0980 0.3954 325.2000 0.6560 325.3980 0.6560 325.5000 0.3461 325.6980 0.3461 325.8000 0.4247 325.9980 0.4247 326.1000 0.5095 326.2980 0.5095 326.4000 0.3615 326.5980 0.3615 326.7000 0.3332 326.8980 0.3332 327.0000 0.5457 327.1980 0.5457 327.3000 0.4304 327.4980 0.4304 327.6000 0.4044 327.7980 0.4044 327.9000 0.4523 328.0980 0.4523 328.2000 0.4588 328.3980 0.4588 328.5000 0.5851 328.6980 0.5851 328.8000 0.4365 328.9980 0.4365 329.1000 0.3918 329.2980 0.3918 329.4000 0.5981 329.5980 0.5981 329.7000 0.6961 329.8980 0.6961 330.0000 0.4123 330.1980 0.4123 330.3000 0.5142 330.4980 0.5142 330.6000 0.4370 330.7980 0.4370 330.9000 0.4637 331.0980 0.4637 331.2000 0.5412 331.3980 0.5412 331.5000 0.5887 331.6980 0.5887 331.8000 0.9657 331.9980 0.9657 332.1000 0.5033 332.2980 0.5033 332.4000 0.5913 332.5980 0.5913 332.7000 0.6190 332.8980 0.6190 333.0000 0.5692 333.1980 0.5692 333.3000 0.5961 333.4980 0.5961 333.6000 0.6150 333.7980 0.6150 333.9000 0.5696 334.0980 0.5696 334.2000 0.6065 334.3980 0.6065 334.5000 0.6194 334.6980 0.6194 334.8000 0.5673 334.9980 0.5673 335.1000 0.6056 335.2980 0.6056 335.4000 0.5477 335.5980 0.5477 335.7000 0.5860 335.8980 0.5860 336.0000 0.5723 336.1980 0.5723 336.3000 0.6247 336.4980 0.6247 336.6000 0.5668 336.7980 0.5668 336.9000 0.6466 337.0980 0.6466 337.2000 0.5790 337.3980 0.5790 337.5000 0.6068 337.6980 0.6068 337.8000 0.5960 337.9980 0.5960 338.1000 0.6236 338.2980 0.6236 338.4000 0.5892 338.5980 0.5892 338.7000 0.6006 338.8980 0.6006 339.0000 0.5466 339.1980 0.5466 339.3000 0.5968 339.4980 0.5968 339.6000 0.5883 339.7980 0.5883 339.9000 0.6004 340.0980 0.6004 340.2000 0.5933 340.3980 0.5933 340.5000 0.5768 340.6980 0.5768 340.8000 0.6007 340.9980 0.6007 341.1000 0.6082 341.2980 0.6082 341.4000 0.5745 341.5980 0.5745 341.7000 0.5786 341.8980 0.5786 342.0000 0.6388 342.1980 0.6388 342.3000 0.6088 342.4980 0.6088 342.6000 0.5452 342.7980 0.5452 342.9000 0.5821 343.0980 0.5821 343.2000 0.5732 343.3980 0.5732 343.5000 0.6057 343.6980 0.6057 343.8000 0.5647 343.9980 0.5647 344.1000 0.6020 344.2980 0.6020 344.4000 0.5708 344.5980 0.5708 344.7000 0.5164 344.8980 0.5164 345.0000 0.5718 345.1980 0.5718 345.3000 0.5754 345.4980 0.5754 345.6000 0.3191 345.7980 0.3191 345.9000 0.4885 346.0980 0.4885 346.2000 0.4856 346.3980 0.4856 346.5000 0.3954 346.6980 0.3954 346.8000 0.6560 346.9980 0.6560 347.1000 0.3461 347.2980 0.3461 347.4000 0.4247 347.5980 0.4247 347.7000 0.5095 347.8980 0.5095 348.0000 0.3615 348.1980 0.3615 348.3000 0.3332 348.4980 0.3332 348.6000 0.5457 348.7980 0.5457 348.9000 0.4304 349.0980 0.4304 349.2000 0.4044 349.3980 0.4044 349.5000 0.4523 349.6980 0.4523 349.8000 0.4588 349.9980 0.4588 350.1000 0.5851 350.2980 0.5851 350.4000 0.4365 350.5980 0.4365 350.7000 0.3918 350.8980 0.3918 351.0000 0.5981 351.1980 0.5981 351.3000 0.6961 351.4980 0.6961 351.6000 0.4123 351.7980 0.4123 351.9000 0.5142 352.0980 0.5142 352.2000 0.4370 352.3980 0.4370 352.5000 0.4637 352.6980 0.4637 352.8000 0.5412 352.9980 0.5412 353.1000 0.5887 353.2980 0.5887 353.4000 0.9657 353.5980 0.9657 353.7000 0.5033 353.8980 0.5033 354.0000 0.5913 354.1980 0.5913 354.3000 0.6190 354.4980 0.6190 354.6000 0.5692 354.7980 0.5692 354.9000 0.5961 355.0980 0.5961 355.2000 0.6150 355.3980 0.6150 355.5000 0.5696 355.6980 0.5696 355.8000 0.6065 355.9980 0.6065 356.1000 0.6194 356.2980 0.6194 356.4000 0.5673 356.5980 0.5673 356.7000 0.6056 356.8980 0.6056 357.0000 0.5477 357.1980 0.5477 357.3000 0.5860 357.4980 0.5860 357.6000 0.5723 357.7980 0.5723 357.9000 0.6247 358.0980 0.6247 358.2000 0.5668 358.3980 0.5668 358.5000 0.6466 358.6980 0.6466 358.8000 0.5790 358.9980 0.5790 359.1000 0.6068 359.2980 0.6068 359.4000 0.5960 359.5980 0.5960 359.7000 0.6236 359.8980 0.6236 360.0000 0.5892 360.1980 0.5892 360.3000 0.6006 360.4980 0.6006 360.6000 0.5466 360.7980 0.5466 360.9000 0.5968 361.0980 0.5968 361.2000 0.5883 361.3980 0.5883 361.5000 0.6004 361.6980 0.6004 361.8000 0.5933 361.9980 0.5933 362.1000 0.5768 362.2980 0.5768 362.4000 0.6007 362.5980 0.6007 362.7000 0.6082 362.8980 0.6082 363.0000 0.5745 363.1980 0.5745 363.3000 0.5786 363.4980 0.5786 363.6000 0.6388 363.7980 0.6388 363.9000 0.6088 364.0980 0.6088 364.2000 0.5452 364.3980 0.5452 364.5000 0.5821 364.6980 0.5821 364.8000 0.5732 364.9980 0.5732 365.1000 0.6057 365.2980 0.6057 365.4000 0.5647 365.5980 0.5647 365.7000 0.6020 365.8980 0.6020 366.0000 0.5708 366.1980 0.5708 366.3000 0.5164 366.4980 0.5164 366.6000 0.5718 366.7980 0.5718 366.9000 0.5754 367.0980 0.5754 367.2000 0.3191 367.3980 0.3191 367.5000 0.4885 367.6980 0.4885 367.8000 0.4856 367.9980 0.4856 368.1000 0.3954 368.2980 0.3954 368.4000 0.6560 368.5980 0.6560 368.7000 0.3461 368.8980 0.3461 369.0000 0.4247 369.1980 0.4247 369.3000 0.5095 369.4980 0.5095 369.6000 0.3615 369.7980 0.3615 369.9000 0.3332 370.0980 0.3332 370.2000 0.5457 370.3980 0.5457 370.5000 0.4304 370.6980 0.4304 370.8000 0.4044 370.9980 0.4044 371.1000 0.4523 371.2980 0.4523 371.4000 0.4588 371.5980 0.4588 371.7000 0.5851 371.8980 0.5851 372.0000 0.4365 372.1980 0.4365 372.3000 0.3918 372.4980 0.3918 372.6000 0.5981 372.7980 0.5981 372.9000 0.6961 373.0980 0.6961 373.2000 0.4123 373.3980 0.4123 373.5000 0.5142 373.6980 0.5142 373.8000 0.4370 373.9980 0.4370 374.1000 0.4637 374.2980 0.4637 374.4000 0.5412 374.5980 0.5412 374.7000 0.5887 374.8980 0.5887 375.0000 0.9657 375.1980 0.9657 375.3000 0.5033 375.4980 0.5033 375.6000 0.5913 375.7980 0.5913 375.9000 0.6190 376.0980 0.6190 376.2000 0.5692 376.3980 0.5692 376.5000 0.5961 376.6980 0.5961 376.8000 0.6150 376.9980 0.6150 377.1000 0.5696 377.2980 0.5696 377.4000 0.6065 377.5980 0.6065 377.7000 0.6194 377.8980 0.6194 378.0000 0.5673 378.1980 0.5673 378.3000 0.6056 378.4980 0.6056 378.6000 0.5477 378.7980 0.5477 378.9000 0.5860 379.0980 0.5860 379.2000 0.5723 379.3980 0.5723 379.5000 0.6247 379.6980 0.6247 379.8000 0.5668 379.9980 0.5668 380.1000 0.6466 380.2980 0.6466 380.4000 0.5790 380.5980 0.5790 380.7000 0.6068 380.8980 0.6068 381.0000 0.5960 381.1980 0.5960 381.3000 0.6236 381.4980 0.6236 381.6000 0.5892 381.7980 0.5892 381.9000 0.6006 382.0980 0.6006 382.2000 0.5466 382.3980 0.5466 382.5000 0.5968 382.6980 0.5968 382.8000 0.5883 382.9980 0.5883 383.1000 0.6004 383.2980 0.6004 383.4000 0.5933 383.5980 0.5933 383.7000 0.5768 383.8980 0.5768 384.0000 0.6007 384.1980 0.6007 384.3000 0.6082 384.4980 0.6082 384.6000 0.5745 384.7980 0.5745 384.9000 0.5786 385.0980 0.5786 385.2000 0.6388 385.3980 0.6388 385.5000 0.6088 385.6980 0.6088 385.8000 0.5452 385.9980 0.5452 386.1000 0.5821 386.2980 0.5821 386.4000 0.5732 386.5980 0.5732 386.7000 0.6057 386.8980 0.6057 387.0000 0.5647 387.1980 0.5647 387.3000 0.6020 387.4980 0.6020 387.6000 0.5708 387.7980 0.5708 387.9000 0.5164 388.0980 0.5164 388.2000 0.5718 388.3980 0.5718 388.5000 0.5754 388.6980 0.5754 388.8000 0.3191 388.9980 0.3191 389.1000 0.4885 389.2980 0.4885 389.4000 0.4856 389.5980 0.4856 389.7000 0.3954 389.8980 0.3954 390.0000 0.6560 390.1980 0.6560 390.3000 0.3461 390.4980 0.3461 390.6000 0.4247 390.7980 0.4247 390.9000 0.5095 391.0980 0.5095 391.2000 0.3615 391.3980 0.3615 391.5000 0.3332 391.6980 0.3332 391.8000 0.5457 391.9980 0.5457 392.1000 0.4304 392.2980 0.4304 392.4000 0.4044 392.5980 0.4044 392.7000 0.4523 392.8980 0.4523 393.0000 0.4588 393.1980 0.4588 393.3000 0.5851 393.4980 0.5851 393.6000 0.4365 393.7980 0.4365 393.9000 0.3918 394.0980 0.3918 394.2000 0.5981 394.3980 0.5981 394.5000 0.6961 394.6980 0.6961 394.8000 0.4123 394.9980 0.4123 395.1000 0.5142 395.2980 0.5142 395.4000 0.4370 395.5980 0.4370 395.7000 0.4637 395.8980 0.4637 396.0000 0.5412 396.1980 0.5412 396.3000 0.5887 396.4980 0.5887 396.6000 0.9657 396.7980 0.9657 396.9000 0.5033 397.0980 0.5033 397.2000 0.5913 397.3980 0.5913 397.5000 0.6190 397.6980 0.6190 397.8000 0.5692 397.9980 0.5692 398.1000 0.5961 398.2980 0.5961 398.4000 0.6150 398.5980 0.6150 398.7000 0.5696 398.8980 0.5696 399.0000 0.6065 399.1980 0.6065 399.3000 0.6194 399.4980 0.6194 399.6000 0.5673 399.7980 0.5673 399.9000 0.6056 400.0980 0.6056 400.2000 0.5477 400.3980 0.5477 400.5000 0.5860 400.6980 0.5860 400.8000 0.5723 400.9980 0.5723 401.1000 0.6247 401.2980 0.6247 401.4000 0.5668 401.5980 0.5668 401.7000 0.6466 401.8980 0.6466 402.0000 0.5790 402.1980 0.5790 402.3000 0.6068 402.4980 0.6068 402.6000 0.5960 402.7980 0.5960 402.9000 0.6236 403.0980 0.6236 403.2000 0.5892 403.3980 0.5892 403.5000 0.6006 403.6980 0.6006 403.8000 0.5466 403.9980 0.5466 404.1000 0.5968 404.2980 0.5968 404.4000 0.5883 404.5980 0.5883 404.7000 0.6004 404.8980 0.6004 405.0000 0.5933 405.1980 0.5933 405.3000 0.5768 405.4980 0.5768 405.6000 0.6007 405.7980 0.6007 405.9000 0.6082 406.0980 0.6082 406.2000 0.5745 406.3980 0.5745 406.5000 0.5786 406.6980 0.5786 406.8000 0.6388 406.9980 0.6388 407.1000 0.6088 407.2980 0.6088 407.4000 0.5452 407.5980 0.5452 407.7000 0.5821 407.8980 0.5821 408.0000 0.5732 408.1980 0.5732 408.3000 0.6057 408.4980 0.6057 408.6000 0.5647 408.7980 0.5647 408.9000 0.6020 409.0980 0.6020 409.2000 0.5708 409.3980 0.5708 409.5000 0.5164 409.6980 0.5164 409.8000 0.5718 409.9980 0.5718 410.1000 0.5754 410.2980 0.5754 410.4000 0.3191 410.5980 0.3191 410.7000 0.4885 410.8980 0.4885 411.0000 0.4856 411.1980 0.4856 411.3000 0.3954 411.4980 0.3954 411.6000 0.6560 411.7980 0.6560 411.9000 0.3461 412.0980 0.3461 412.2000 0.4247 412.3980 0.4247 412.5000 0.5095 412.6980 0.5095 412.8000 0.3615 412.9980 0.3615 413.1000 0.3332 413.2980 0.3332 413.4000 0.5457 413.5980 0.5457 413.7000 0.4304 413.8980 0.4304 414.0000 0.4044 414.1980 0.4044 414.3000 0.4523 414.4980 0.4523 414.6000 0.4588 414.7980 0.4588 414.9000 0.5851 415.0980 0.5851 415.2000 0.4365 415.3980 0.4365 415.5000 0.3918 415.6980 0.3918 415.8000 0.5981 415.9980 0.5981 416.1000 0.6961 416.2980 0.6961 416.4000 0.4123 416.5980 0.4123 416.7000 0.5142 416.8980 0.5142 417.0000 0.4370 417.1980 0.4370 417.3000 0.4637 417.4980 0.4637 417.6000 0.5412 417.7980 0.5412 417.9000 0.5887 418.0980 0.5887 418.2000 0.9657 418.3980 0.9657 418.5000 0.5033 418.6980 0.5033 418.8000 0.5913 418.9980 0.5913 419.1000 0.6190 419.2980 0.6190 419.4000 0.5692 419.5980 0.5692 419.7000 0.5961 419.8980 0.5961 420.0000 0.6150 420.1980 0.6150 420.3000 0.5696 420.4980 0.5696 420.6000 0.6065 420.7980 0.6065 420.9000 0.6194 421.0980 0.6194 421.2000 0.5673 421.3980 0.5673 421.5000 0.6056 421.6980 0.6056 421.8000 0.5477 421.9980 0.5477 422.1000 0.5860 422.2980 0.5860 422.4000 0.5723 422.5980 0.5723 422.7000 0.6247 422.8980 0.6247 423.0000 0.5668 423.1980 0.5668 423.3000 0.6466 423.4980 0.6466 423.6000 0.5790 423.7980 0.5790 423.9000 0.6068 424.0980 0.6068 424.2000 0.5960 424.3980 0.5960 424.5000 0.6236 424.6980 0.6236 424.8000 0.5892 424.9980 0.5892 425.1000 0.6006 425.2980 0.6006 425.4000 0.5466 425.5980 0.5466 425.7000 0.5968 425.8980 0.5968 426.0000 0.5883 426.1980 0.5883 426.3000 0.6004 426.4980 0.6004 426.6000 0.5933 426.7980 0.5933 426.9000 0.5768 427.0980 0.5768 427.2000 0.6007 427.3980 0.6007 427.5000 0.6082 427.6980 0.6082 427.8000 0.5745 427.9980 0.5745 428.1000 0.5786 428.2980 0.5786 428.4000 0.6388 428.5980 0.6388 428.7000 0.6088 428.8980 0.6088 429.0000 0.5452 429.1980 0.5452 429.3000 0.5821 429.4980 0.5821 429.6000 0.5732 429.7980 0.5732 429.9000 0.6057 430.0980 0.6057 430.2000 0.5647 430.3980 0.5647 430.5000 0.6020 430.6980 0.6020 430.8000 0.5708 430.9980 0.5708 431.1000 0.5164 431.2980 0.5164 431.4000 0.5718 431.5980 0.5718 431.7000 0.5754 431.8980 0.5754 432.0000 0.3191 432.1980 0.3191 432.3000 0.4885 432.4980 0.4885 432.6000 0.4856 432.7980 0.4856 432.9000 0.3954 433.0980 0.3954 433.2000 0.6560 433.3980 0.6560 433.5000 0.3461 433.6980 0.3461 433.8000 0.4247 433.9980 0.4247 434.1000 0.5095 434.2980 0.5095 434.4000 0.3615 434.5980 0.3615 434.7000 0.3332 434.8980 0.3332 435.0000 0.5457 435.1980 0.5457 435.3000 0.4304 435.4980 0.4304 435.6000 0.4044 435.7980 0.4044 435.9000 0.4523 436.0980 0.4523 436.2000 0.4588 436.3980 0.4588 436.5000 0.5851 436.6980 0.5851 436.8000 0.4365 436.9980 0.4365 437.1000 0.3918 437.2980 0.3918 437.4000 0.5981 437.5980 0.5981 437.7000 0.6961 437.8980 0.6961 438.0000 0.4123 438.1980 0.4123 438.3000 0.5142 438.4980 0.5142 438.6000 0.4370 438.7980 0.4370 438.9000 0.4637 439.0980 0.4637 439.2000 0.5412 439.3980 0.5412 439.5000 0.5887 439.6980 0.5887 439.8000 0.9657 439.9980 0.9657 440.1000 0.5033 440.2980 0.5033 440.4000 0.5913 440.5980 0.5913 440.7000 0.6190 440.8980 0.6190 441.0000 0.5692 441.1980 0.5692 441.3000 0.5961 441.4980 0.5961 441.6000 0.6150 441.7980 0.6150 441.9000 0.5696 442.0980 0.5696 442.2000 0.6065 442.3980 0.6065 442.5000 0.6194 442.6980 0.6194 442.8000 0.5673 442.9980 0.5673 443.1000 0.6056 443.2980 0.6056 443.4000 0.5477 443.5980 0.5477 443.7000 0.5860 443.8980 0.5860 444.0000 0.5723 444.1980 0.5723 444.3000 0.6247 444.4980 0.6247 444.6000 0.5668 444.7980 0.5668 444.9000 0.6466 445.0980 0.6466 445.2000 0.5790 445.3980 0.5790 445.5000 0.6068 445.6980 0.6068 445.8000 0.5960 445.9980 0.5960 446.1000 0.6236 446.2980 0.6236 446.4000 0.5892 446.5980 0.5892 446.7000 0.6006 446.8980 0.6006 447.0000 0.5466 447.1980 0.5466 447.3000 0.5968 447.4980 0.5968 447.6000 0.5883 447.7980 0.5883 447.9000 0.6004 448.0980 0.6004 448.2000 0.5933 448.3980 0.5933 448.5000 0.5768 448.6980 0.5768 448.8000 0.6007 448.9980 0.6007 449.1000 0.6082 449.2980 0.6082 449.4000 0.5745 449.5980 0.5745 449.7000 0.5786 449.8980 0.5786 450.0000 0.6388 450.1980 0.6388 450.3000 0.6088 450.4980 0.6088 450.6000 0.5452 450.7980 0.5452 450.9000 0.5821 451.0980 0.5821 451.2000 0.5732 451.3980 0.5732 451.5000 0.6057 451.6980 0.6057 451.8000 0.5647 451.9980 0.5647 452.1000 0.6020 452.2980 0.6020 452.4000 0.5708 452.5980 0.5708 452.7000 0.5164 452.8980 0.5164 453.0000 0.5718 453.1980 0.5718 453.3000 0.5754 453.4980 0.5754 453.6000 0.3191 453.7980 0.3191 453.9000 0.4885 454.0980 0.4885 454.2000 0.4856 454.3980 0.4856 454.5000 0.3954 454.6980 0.3954 454.8000 0.6560 454.9980 0.6560 455.1000 0.3461 455.2980 0.3461 455.4000 0.4247 455.5980 0.4247 455.7000 0.5095 455.8980 0.5095 456.0000 0.3615 456.1980 0.3615 456.3000 0.3332 456.4980 0.3332 456.6000 0.5457 456.7980 0.5457 456.9000 0.4304 457.0980 0.4304 457.2000 0.4044 457.3980 0.4044 457.5000 0.4523 457.6980 0.4523 457.8000 0.4588 457.9980 0.4588 458.1000 0.5851 458.2980 0.5851 458.4000 0.4365 458.5980 0.4365 458.7000 0.3918 458.8980 0.3918 459.0000 0.5981 459.1980 0.5981 459.3000 0.6961 459.4980 0.6961 459.6000 0.4123 459.7980 0.4123 459.9000 0.5142 460.0980 0.5142 460.2000 0.4370 460.3980 0.4370 460.5000 0.4637 460.6980 0.4637 460.8000 0.5412 460.9980 0.5412 461.1000 0.5887 461.2980 0.5887 461.4000 0.9657 461.5980 0.9657 461.7000 0.5033 461.8980 0.5033 462.0000 0.5913 462.1980 0.5913 462.3000 0.6190 462.4980 0.6190 462.6000 0.5692 462.7980 0.5692 462.9000 0.5961 463.0980 0.5961 463.2000 0.6150 463.3980 0.6150 463.5000 0.5696 463.6980 0.5696 463.8000 0.6065 463.9980 0.6065 464.1000 0.6194 464.2980 0.6194 464.4000 0.5673 464.5980 0.5673 464.7000 0.6056 464.8980 0.6056 465.0000 0.5477 465.1980 0.5477 465.3000 0.5860 465.4980 0.5860 465.6000 0.5723 465.7980 0.5723 465.9000 0.6247 466.0980 0.6247 466.2000 0.5668 466.3980 0.5668 466.5000 0.6466 466.6980 0.6466 466.8000 0.5790 466.9980 0.5790 467.1000 0.6068 467.2980 0.6068 467.4000 0.5960 467.5980 0.5960 467.7000 0.6236 467.8980 0.6236 468.0000 0.5892 468.1980 0.5892 468.3000 0.6006 468.4980 0.6006 468.6000 0.5466 468.7980 0.5466 468.9000 0.5968 469.0980 0.5968 469.2000 0.5883 469.3980 0.5883 469.5000 0.6004 469.6980 0.6004 469.8000 0.5933 469.9980 0.5933 470.1000 0.5768 470.2980 0.5768 470.4000 0.6007 470.5980 0.6007 470.7000 0.6082 470.8980 0.6082 471.0000 0.5745 471.1980 0.5745 471.3000 0.5786 471.4980 0.5786 471.6000 0.6388 471.7980 0.6388 471.9000 0.6088 472.0980 0.6088 472.2000 0.5452 472.3980 0.5452 472.5000 0.5821 472.6980 0.5821 472.8000 0.5732 472.9980 0.5732 473.1000 0.6057 473.2980 0.6057 473.4000 0.5647 473.5980 0.5647 473.7000 0.6020 473.8980 0.6020 474.0000 0.5708 474.1980 0.5708 474.3000 0.5164 474.4980 0.5164 474.6000 0.5718 474.7980 0.5718 474.9000 0.5754 475.0980 0.5754 475.2000 0.3191 475.3980 0.3191 475.5000 0.4885 475.6980 0.4885 475.8000 0.4856 475.9980 0.4856 476.1000 0.3954 476.2980 0.3954 476.4000 0.6560 476.5980 0.6560 476.7000 0.3461 476.8980 0.3461 477.0000 0.4247 477.1980 0.4247 477.3000 0.5095 477.4980 0.5095 477.6000 0.3615 477.7980 0.3615 477.9000 0.3332 478.0980 0.3332 478.2000 0.5457 478.3980 0.5457 478.5000 0.4304 478.6980 0.4304 478.8000 0.4044 478.9980 0.4044 479.1000 0.4523 479.2980 0.4523 479.4000 0.4588 479.5980 0.4588 479.7000 0.5851 479.8980 0.5851 480.0000 0.4365 480.1980 0.4365 480.3000 0.3918 480.4980 0.3918 480.6000 0.5981 480.7980 0.5981 480.9000 0.6961 481.0980 0.6961 481.2000 0.4123 481.3980 0.4123 481.5000 0.5142 481.6980 0.5142 481.8000 0.4370 481.9980 0.4370 482.1000 0.4637 482.2980 0.4637 482.4000 0.5412 482.5980 0.5412 482.7000 0.5887 482.8980 0.5887 483.0000 0.9657 483.1980 0.9657 483.3000 0.5033 483.4980 0.5033 483.6000 0.5913 483.7980 0.5913 483.9000 0.6190 484.0980 0.6190 484.2000 0.5692 484.3980 0.5692 484.5000 0.5961 484.6980 0.5961 484.8000 0.6150 484.9980 0.6150 485.1000 0.5696 485.2980 0.5696 485.4000 0.6065 485.5980 0.6065 485.7000 0.6194 485.8980 0.6194 486.0000 0.5673 486.1980 0.5673 486.3000 0.6056 486.4980 0.6056 486.6000 0.5477 486.7980 0.5477 486.9000 0.5860 487.0980 0.5860 487.2000 0.5723 487.3980 0.5723 487.5000 0.6247 487.6980 0.6247 487.8000 0.5668 487.9980 0.5668 488.1000 0.6466 488.2980 0.6466 488.4000 0.5790 488.5980 0.5790 488.7000 0.6068 488.8980 0.6068 489.0000 0.5960 489.1980 0.5960 489.3000 0.6236 489.4980 0.6236 489.6000 0.5892 489.7980 0.5892 489.9000 0.6006 490.0980 0.6006 490.2000 0.5466 490.3980 0.5466 490.5000 0.5968 490.6980 0.5968 490.8000 0.5883 490.9980 0.5883 491.1000 0.6004 491.2980 0.6004 491.4000 0.5933 491.5980 0.5933 491.7000 0.5768 491.8980 0.5768 492.0000 0.6007 492.1980 0.6007 492.3000 0.6082 492.4980 0.6082 492.6000 0.5745 492.7980 0.5745 492.9000 0.5786 493.0980 0.5786 493.2000 0.6388 493.3980 0.6388 493.5000 0.6088 493.6980 0.6088 493.8000 0.5452 493.9980 0.5452 494.1000 0.5821 494.2980 0.5821 494.4000 0.5732 494.5980 0.5732 494.7000 0.6057 494.8980 0.6057 495.0000 0.5647 495.1980 0.5647 495.3000 0.6020 495.4980 0.6020 495.6000 0.5708 495.7980 0.5708 495.9000 0.5164 496.0980 0.5164 496.2000 0.5718 496.3980 0.5718 496.5000 0.5754 496.6980 0.5754 496.8000 0.3191 496.9980 0.3191 497.1000 0.4885 497.2980 0.4885 497.4000 0.4856 497.5980 0.4856 497.7000 0.3954 497.8980 0.3954 498.0000 0.6560 498.1980 0.6560 498.3000 0.3461 498.4980 0.3461 498.6000 0.4247 498.7980 0.4247 498.9000 0.5095 499.0980 0.5095 499.2000 0.3615 499.3980 0.3615 499.5000 0.3332 499.6980 0.3332 499.8000 0.5457 499.9980 0.5457 500.1000 0.4304 500.2980 0.4304 500.4000 0.4044 500.5980 0.4044 500.7000 0.4523 500.8980 0.4523 501.0000 0.4588 501.1980 0.4588 501.3000 0.5851 501.4980 0.5851 501.6000 0.4365 501.7980 0.4365 501.9000 0.3918 502.0980 0.3918 502.2000 0.5981 502.3980 0.5981 502.5000 0.6961 502.6980 0.6961 502.8000 0.4123 502.9980 0.4123 503.1000 0.5142 503.2980 0.5142 503.4000 0.4370 503.5980 0.4370 503.7000 0.4637 503.8980 0.4637 504.0000 0.5412 504.1980 0.5412 504.3000 0.5887 504.4980 0.5887 504.6000 0.9657 504.7980 0.9657 504.9000 0.5033 505.0980 0.5033 505.2000 0.5913 505.3980 0.5913 505.5000 0.6190 505.6980 0.6190 505.8000 0.5692 505.9980 0.5692 506.1000 0.5961 506.2980 0.5961 506.4000 0.6150 506.5980 0.6150 506.7000 0.5696 506.8980 0.5696 507.0000 0.6065 507.1980 0.6065 507.3000 0.6194 507.4980 0.6194 507.6000 0.5673 507.7980 0.5673 507.9000 0.6056 508.0980 0.6056 508.2000 0.5477 508.3980 0.5477 508.5000 0.5860 508.6980 0.5860 508.8000 0.5723 508.9980 0.5723 509.1000 0.6247 509.2980 0.6247 509.4000 0.5668 509.5980 0.5668 509.7000 0.6466 509.8980 0.6466 510.0000 0.5790 510.1980 0.5790 510.3000 0.6068 510.4980 0.6068 510.6000 0.5960 510.7980 0.5960 510.9000 0.6236 511.0980 0.6236 511.2000 0.5892 511.3980 0.5892 511.5000 0.6006 511.6980 0.6006 511.8000 0.5466 511.9980 0.5466 512.1000 0.5968 512.2980 0.5968 512.4000 0.5883 512.5980 0.5883 512.7000 0.6004 512.8980 0.6004 513.0000 0.5933 513.1980 0.5933 513.3000 0.5768 513.4980 0.5768 513.6000 0.6007 513.7980 0.6007 513.9000 0.6082 514.0980 0.6082 514.2000 0.5745 514.3980 0.5745 514.5000 0.5786 514.6980 0.5786 514.8000 0.6388 514.9980 0.6388 515.1000 0.6088 515.2980 0.6088 515.4000 0.5452 515.5980 0.5452 515.7000 0.5821 515.8980 0.5821 516.0000 0.5732 516.1980 0.5732 516.3000 0.6057 516.4980 0.6057 516.6000 0.5647 516.7980 0.5647 516.9000 0.6020 517.0980 0.6020 517.2000 0.5708 517.3980 0.5708 517.5000 0.5164 517.6980 0.5164 517.8000 0.5718 517.9980 0.5718 518.1000 0.5754 518.2980 0.5754 518.4000 0.3191 518.5980 0.3191 518.7000 0.4885 518.8980 0.4885 519.0000 0.4856 519.1980 0.4856 519.3000 0.3954 519.4980 0.3954 519.6000 0.6560 519.7980 0.6560 519.9000 0.3461 520.0980 0.3461 520.2000 0.4247 520.3980 0.4247 520.5000 0.5095 520.6980 0.5095 520.8000 0.3615 520.9980 0.3615 521.1000 0.3332 521.2980 0.3332 521.4000 0.5457 521.5980 0.5457 521.7000 0.4304 521.8980 0.4304 522.0000 0.4044 522.1980 0.4044 522.3000 0.4523 522.4980 0.4523 522.6000 0.4588 522.7980 0.4588 522.9000 0.5851 523.0980 0.5851 523.2000 0.4365 523.3980 0.4365 523.5000 0.3918 523.6980 0.3918 523.8000 0.5981 523.9980 0.5981 524.1000 0.6961 524.2980 0.6961 524.4000 0.4123 524.5980 0.4123 524.7000 0.5142 524.8980 0.5142 525.0000 0.4370 525.1980 0.4370 525.3000 0.4637 525.4980 0.4637 525.6000 0.5412 525.7980 0.5412 525.9000 0.5887 526.0980 0.5887 526.2000 0.9657 526.3980 0.9657 526.5000 0.5033 526.6980 0.5033 526.8000 0.5913 526.9980 0.5913 527.1000 0.6190 527.2980 0.6190 527.4000 0.5692 527.5980 0.5692 527.7000 0.5961 527.8980 0.5961 528.0000 0.6150 528.1980 0.6150 528.3000 0.5696 528.4980 0.5696 528.6000 0.6065 528.7980 0.6065 528.9000 0.6194 529.0980 0.6194 529.2000 0.5673 529.3980 0.5673 529.5000 0.6056 529.6980 0.6056 529.8000 0.5477 529.9980 0.5477 530.1000 0.5860 530.2980 0.5860 530.4000 0.5723 530.5980 0.5723 530.7000 0.6247 530.8980 0.6247 531.0000 0.5668 531.1980 0.5668 531.3000 0.6466 531.4980 0.6466 531.6000 0.5790 531.7980 0.5790 531.9000 0.6068 532.0980 0.6068 532.2000 0.5960 532.3980 0.5960 532.5000 0.6236 532.6980 0.6236 532.8000 0.5892 532.9980 0.5892 533.1000 0.6006 533.2980 0.6006 533.4000 0.5466 533.5980 0.5466 533.7000 0.5968 533.8980 0.5968 534.0000 0.5883 534.1980 0.5883 534.3000 0.6004 534.4980 0.6004 534.6000 0.5933 534.7980 0.5933 534.9000 0.5768 535.0980 0.5768 535.2000 0.6007 535.3980 0.6007 535.5000 0.6082 535.6980 0.6082 535.8000 0.5745 535.9980 0.5745 536.1000 0.5786 536.2980 0.5786 536.4000 0.6388 536.5980 0.6388 536.7000 0.6088 536.8980 0.6088 537.0000 0.5452 537.1980 0.5452 537.3000 0.5821 537.4980 0.5821 537.6000 0.5732 537.7980 0.5732 537.9000 0.6057 538.0980 0.6057 538.2000 0.5647 538.3980 0.5647 538.5000 0.6020 538.6980 0.6020 538.8000 0.5708 538.9980 0.5708 539.1000 0.5164 539.2980 0.5164 539.4000 0.5718 539.5980 0.5718 539.7000 0.5754 539.8980 0.5754 540.0000 0.3191 540.1980 0.3191 540.3000 0.4885 540.4980 0.4885 540.6000 0.4856 540.7980 0.4856 540.9000 0.3954 541.0980 0.3954 541.2000 0.6560 541.3980 0.6560 541.5000 0.3461 541.6980 0.3461 541.8000 0.4247 541.9980 0.4247 542.1000 0.5095 542.2980 0.5095 542.4000 0.3615 542.5980 0.3615 542.7000 0.3332 542.8980 0.3332 543.0000 0.5457 543.1980 0.5457 543.3000 0.4304 543.4980 0.4304 543.6000 0.4044 543.7980 0.4044 543.9000 0.4523 544.0980 0.4523 544.2000 0.4588 544.3980 0.4588 544.5000 0.5851 544.6980 0.5851 544.8000 0.4365 544.9980 0.4365 545.1000 0.3918 545.2980 0.3918 545.4000 0.5981 545.5980 0.5981 545.7000 0.6961 545.8980 0.6961 546.0000 0.4123 546.1980 0.4123 546.3000 0.5142 546.4980 0.5142 546.6000 0.4370 546.7980 0.4370 546.9000 0.4637 547.0980 0.4637 547.2000 0.5412 547.3980 0.5412 547.5000 0.5887 547.6980 0.5887 547.8000 0.9657 547.9980 0.9657 548.1000 0.5033 548.2980 0.5033 548.4000 0.5913 548.5980 0.5913 548.7000 0.6190 548.8980 0.6190 549.0000 0.5692 549.1980 0.5692 549.3000 0.5961 549.4980 0.5961 549.6000 0.6150 549.7980 0.6150 549.9000 0.5696 550.0980 0.5696 550.2000 0.6065 550.3980 0.6065 550.5000 0.6194 550.6980 0.6194 550.8000 0.5673 550.9980 0.5673 551.1000 0.6056 551.2980 0.6056 551.4000 0.5477 551.5980 0.5477 551.7000 0.5860 551.8980 0.5860 552.0000 0.5723 552.1980 0.5723 552.3000 0.6247 552.4980 0.6247 552.6000 0.5668 552.7980 0.5668 552.9000 0.6466 553.0980 0.6466 553.2000 0.5790 553.3980 0.5790 553.5000 0.6068 553.6980 0.6068 553.8000 0.5960 553.9980 0.5960 554.1000 0.6236 554.2980 0.6236 554.4000 0.5892 554.5980 0.5892 554.7000 0.6006 554.8980 0.6006 555.0000 0.5466 555.1980 0.5466 555.3000 0.5968 555.4980 0.5968 555.6000 0.5883 555.7980 0.5883 555.9000 0.6004 556.0980 0.6004 556.2000 0.5933 556.3980 0.5933 556.5000 0.5768 556.6980 0.5768 556.8000 0.6007 556.9980 0.6007 557.1000 0.6082 557.2980 0.6082 557.4000 0.5745 557.5980 0.5745 557.7000 0.5786 557.8980 0.5786 558.0000 0.6388 558.1980 0.6388 558.3000 0.6088 558.4980 0.6088 558.6000 0.5452 558.7980 0.5452 558.9000 0.5821 559.0980 0.5821 559.2000 0.5732 559.3980 0.5732 559.5000 0.6057 559.6980 0.6057 559.8000 0.5647 559.9980 0.5647 560.1000 0.6020 560.2980 0.6020 560.4000 0.5708 560.5980 0.5708 560.7000 0.5164 560.8980 0.5164 561.0000 0.5718 561.1980 0.5718 561.3000 0.5754 561.4980 0.5754 561.6000 0.3191 561.7980 0.3191 561.9000 0.4885 562.0980 0.4885 562.2000 0.4856 562.3980 0.4856 562.5000 0.3954 562.6980 0.3954 562.8000 0.6560 562.9980 0.6560 563.1000 0.3461 563.2980 0.3461 563.4000 0.4247 563.5980 0.4247 563.7000 0.5095 563.8980 0.5095 564.0000 0.3615 564.1980 0.3615 564.3000 0.3332 564.4980 0.3332 564.6000 0.5457 564.7980 0.5457 564.9000 0.4304 565.0980 0.4304 565.2000 0.4044 565.3980 0.4044 565.5000 0.4523 565.6980 0.4523 565.8000 0.4588 565.9980 0.4588 566.1000 0.5851 566.2980 0.5851 566.4000 0.4365 566.5980 0.4365 566.7000 0.3918 566.8980 0.3918 567.0000 0.5981 567.1980 0.5981 567.3000 0.6961 567.4980 0.6961 567.6000 0.4123 567.7980 0.4123 567.9000 0.5142 568.0980 0.5142 568.2000 0.4370 568.3980 0.4370 568.5000 0.4637 568.6980 0.4637 568.8000 0.5412 568.9980 0.5412 569.1000 0.5887 569.2980 0.5887 569.4000 0.9657 569.5980 0.9657 569.7000 0.5033 569.8980 0.5033 570.0000 0.5913 570.1980 0.5913 570.3000 0.6190 570.4980 0.6190 570.6000 0.5692 570.7980 0.5692 570.9000 0.5961 571.0980 0.5961 571.2000 0.6150 571.3980 0.6150 571.5000 0.5696 571.6980 0.5696 571.8000 0.6065 571.9980 0.6065 572.1000 0.6194 572.2980 0.6194 572.4000 0.5673 572.5980 0.5673 572.7000 0.6056 572.8980 0.6056 573.0000 0.5477 573.1980 0.5477 573.3000 0.5860 573.4980 0.5860 573.6000 0.5723 573.7980 0.5723 573.9000 0.6247 574.0980 0.6247 574.2000 0.5668 574.3980 0.5668 574.5000 0.6466 574.6980 0.6466 574.8000 0.5790 574.9980 0.5790 575.1000 0.6068 575.2980 0.6068 575.4000 0.5960 575.5980 0.5960 575.7000 0.6236 575.8980 0.6236 576.0000 0.5892 576.1980 0.5892 576.3000 0.6006 576.4980 0.6006 576.6000 0.5466 576.7980 0.5466 576.9000 0.5968 577.0980 0.5968 577.2000 0.5883 577.3980 0.5883 577.5000 0.6004 577.6980 0.6004 577.8000 0.5933 577.9980 0.5933 578.1000 0.5768 578.2980 0.5768 578.4000 0.6007 578.5980 0.6007 578.7000 0.6082 578.8980 0.6082 579.0000 0.5745 579.1980 0.5745 579.3000 0.5786 579.4980 0.5786 579.6000 0.6388 579.7980 0.6388 579.9000 0.6088 580.0980 0.6088 580.2000 0.5452 580.3980 0.5452 580.5000 0.5821 580.6980 0.5821 580.8000 0.5732 580.9980 0.5732 581.1000 0.6057 581.2980 0.6057 581.4000 0.5647 581.5980 0.5647 581.7000 0.6020 581.8980 0.6020 582.0000 0.5708 582.1980 0.5708 582.3000 0.5164 582.4980 0.5164 582.6000 0.5718 582.7980 0.5718 582.9000 0.5754 583.0980 0.5754 583.2000 0.3191 583.3980 0.3191 583.5000 0.4885 583.6980 0.4885 583.8000 0.4856 583.9980 0.4856 584.1000 0.3954 584.2980 0.3954 584.4000 0.6560 584.5980 0.6560 584.7000 0.3461 584.8980 0.3461 585.0000 0.4247 585.1980 0.4247 585.3000 0.5095 585.4980 0.5095 585.6000 0.3615 585.7980 0.3615 585.9000 0.3332 586.0980 0.3332 586.2000 0.5457 586.3980 0.5457 586.5000 0.4304 586.6980 0.4304 586.8000 0.4044 586.9980 0.4044 587.1000 0.4523 587.2980 0.4523 587.4000 0.4588 587.5980 0.4588 587.7000 0.5851 587.8980 0.5851 588.0000 0.4365 588.1980 0.4365 588.3000 0.3918 588.4980 0.3918 588.6000 0.5981 588.7980 0.5981 588.9000 0.6961 589.0980 0.6961 589.2000 0.4123 589.3980 0.4123 589.5000 0.5142 589.6980 0.5142 589.8000 0.4370 589.9980 0.4370 590.1000 0.4637 590.2980 0.4637 590.4000 0.5412 590.5980 0.5412 590.7000 0.5887 590.8980 0.5887 591.0000 0.9657 591.1980 0.9657 591.3000 0.5033 591.4980 0.5033 591.6000 0.5913 591.7980 0.5913 591.9000 0.6190 592.0980 0.6190 592.2000 0.5692 592.3980 0.5692 592.5000 0.5961 592.6980 0.5961 592.8000 0.6150 592.9980 0.6150 593.1000 0.5696 593.2980 0.5696 593.4000 0.6065 593.5980 0.6065 593.7000 0.6194 593.8980 0.6194 594.0000 0.5673 594.1980 0.5673 594.3000 0.6056 594.4980 0.6056 594.6000 0.5477 594.7980 0.5477 594.9000 0.5860 595.0980 0.5860 595.2000 0.5723 595.3980 0.5723 595.5000 0.6247 595.6980 0.6247 595.8000 0.5668 595.9980 0.5668 596.1000 0.6466 596.2980 0.6466 596.4000 0.5790 596.5980 0.5790 596.7000 0.6068 596.8980 0.6068 597.0000 0.5960 597.1980 0.5960 597.3000 0.6236 597.4980 0.6236 597.6000 0.5892 597.7980 0.5892 597.9000 0.6006 598.0980 0.6006 598.2000 0.5466 598.3980 0.5466 598.5000 0.5968 598.6980 0.5968 598.8000 0.5883 598.9980 0.5883 599.1000 0.6004 599.2980 0.6004 599.4000 0.5933 599.5980 0.5933 599.7000 0.5768 599.8980 0.5768 600.0000 0.5768)
Va4 a4 0 PWL(0.0000 0.7074 0.1980 0.7074 0.3000 0.4885 0.4980 0.4885 0.6000 0.6113 0.7980 0.6113 0.9000 0.4257 1.0980 0.4257 1.2000 0.3692 1.3980 0.3692 1.5000 0.5334 1.6980 0.5334 1.8000 0.3894 1.9980 0.3894 2.1000 0.5095 2.2980 0.5095 2.4000 0.6189 2.5980 0.6189 2.7000 0.5406 2.8980 0.5406 3.0000 0.5457 3.1980 0.5457 3.3000 0.3702 3.4980 0.3702 3.6000 0.4078 3.7980 0.4078 3.9000 0.4060 4.0980 0.4060 4.2000 0.4588 4.3980 0.4588 4.5000 0.3712 4.6980 0.3712 4.8000 0.4083 4.9980 0.4083 5.1000 0.3994 5.2980 0.3994 5.4000 0.4386 5.5980 0.4386 5.7000 0.4569 5.8980 0.4569 6.0000 0.3840 6.1980 0.3840 6.3000 0.5142 6.4980 0.5142 6.6000 0.4677 6.7980 0.4677 6.9000 0.4637 7.0980 0.4637 7.2000 0.5412 7.3980 0.5412 7.5000 0.5887 7.6980 0.5887 7.8000 0.5985 7.9980 0.5985 8.1000 0.5033 8.2980 0.5033 8.4000 0.5913 8.5980 0.5913 8.7000 0.6190 8.8980 0.6190 9.0000 0.5692 9.1980 0.5692 9.3000 0.5961 9.4980 0.5961 9.6000 0.6150 9.7980 0.6150 9.9000 0.5696 10.0980 0.5696 10.2000 0.6065 10.3980 0.6065 10.5000 0.6194 10.6980 0.6194 10.8000 0.5673 10.9980 0.5673 11.1000 0.6056 11.2980 0.6056 11.4000 0.5477 11.5980 0.5477 11.7000 0.5860 11.8980 0.5860 12.0000 0.5723 12.1980 0.5723 12.3000 0.6247 12.4980 0.6247 12.6000 0.5668 12.7980 0.5668 12.9000 0.5998 13.0980 0.5998 13.2000 0.5790 13.3980 0.5790 13.5000 0.6068 13.6980 0.6068 13.8000 0.5960 13.9980 0.5960 14.1000 0.6236 14.2980 0.6236 14.4000 0.5892 14.5980 0.5892 14.7000 0.6156 14.8980 0.6156 15.0000 0.8958 15.1980 0.8958 15.3000 0.5968 15.4980 0.5968 15.6000 0.9398 15.7980 0.9398 15.9000 0.6004 16.0980 0.6004 16.2000 0.9266 16.3980 0.9266 16.5000 0.5780 16.6980 0.5780 16.8000 0.6548 16.9980 0.6548 17.1000 0.6082 17.2980 0.6082 17.4000 0.5745 17.5980 0.5745 17.7000 0.5786 17.8980 0.5786 18.0000 0.5559 18.1980 0.5559 18.3000 0.6088 18.4980 0.6088 18.6000 0.7140 18.7980 0.7140 18.9000 0.6023 19.0980 0.6023 19.2000 0.5732 19.3980 0.5732 19.5000 0.6057 19.6980 0.6057 19.8000 0.5835 19.9980 0.5835 20.1000 0.8046 20.2980 0.8046 20.4000 0.5708 20.5980 0.5708 20.7000 1.1028 20.8980 1.1028 21.0000 0.6270 21.1980 0.6270 21.3000 1.1020 21.4980 1.1020 21.6000 0.7074 21.7980 0.7074 21.9000 0.4885 22.0980 0.4885 22.2000 0.6113 22.3980 0.6113 22.5000 0.4257 22.6980 0.4257 22.8000 0.3692 22.9980 0.3692 23.1000 0.5334 23.2980 0.5334 23.4000 0.3894 23.5980 0.3894 23.7000 0.5095 23.8980 0.5095 24.0000 0.6189 24.1980 0.6189 24.3000 0.5406 24.4980 0.5406 24.6000 0.5457 24.7980 0.5457 24.9000 0.3702 25.0980 0.3702 25.2000 0.4078 25.3980 0.4078 25.5000 0.4060 25.6980 0.4060 25.8000 0.4588 25.9980 0.4588 26.1000 0.3712 26.2980 0.3712 26.4000 0.4083 26.5980 0.4083 26.7000 0.3994 26.8980 0.3994 27.0000 0.4386 27.1980 0.4386 27.3000 0.4569 27.4980 0.4569 27.6000 0.3840 27.7980 0.3840 27.9000 0.5142 28.0980 0.5142 28.2000 0.4677 28.3980 0.4677 28.5000 0.4637 28.6980 0.4637 28.8000 0.5412 28.9980 0.5412 29.1000 0.5887 29.2980 0.5887 29.4000 0.5985 29.5980 0.5985 29.7000 0.5033 29.8980 0.5033 30.0000 0.5913 30.1980 0.5913 30.3000 0.6190 30.4980 0.6190 30.6000 0.5692 30.7980 0.5692 30.9000 0.5961 31.0980 0.5961 31.2000 0.6150 31.3980 0.6150 31.5000 0.5696 31.6980 0.5696 31.8000 0.6065 31.9980 0.6065 32.1000 0.6194 32.2980 0.6194 32.4000 0.5673 32.5980 0.5673 32.7000 0.6056 32.8980 0.6056 33.0000 0.5477 33.1980 0.5477 33.3000 0.5860 33.4980 0.5860 33.6000 0.5723 33.7980 0.5723 33.9000 0.6247 34.0980 0.6247 34.2000 0.5668 34.3980 0.5668 34.5000 0.5998 34.6980 0.5998 34.8000 0.5790 34.9980 0.5790 35.1000 0.6068 35.2980 0.6068 35.4000 0.5960 35.5980 0.5960 35.7000 0.6236 35.8980 0.6236 36.0000 0.5892 36.1980 0.5892 36.3000 0.6156 36.4980 0.6156 36.6000 0.8958 36.7980 0.8958 36.9000 0.5968 37.0980 0.5968 37.2000 0.9398 37.3980 0.9398 37.5000 0.6004 37.6980 0.6004 37.8000 0.9266 37.9980 0.9266 38.1000 0.5780 38.2980 0.5780 38.4000 0.6548 38.5980 0.6548 38.7000 0.6082 38.8980 0.6082 39.0000 0.5745 39.1980 0.5745 39.3000 0.5786 39.4980 0.5786 39.6000 0.5559 39.7980 0.5559 39.9000 0.6088 40.0980 0.6088 40.2000 0.7140 40.3980 0.7140 40.5000 0.6023 40.6980 0.6023 40.8000 0.5732 40.9980 0.5732 41.1000 0.6057 41.2980 0.6057 41.4000 0.5835 41.5980 0.5835 41.7000 0.8046 41.8980 0.8046 42.0000 0.5708 42.1980 0.5708 42.3000 1.1028 42.4980 1.1028 42.6000 0.6270 42.7980 0.6270 42.9000 1.1020 43.0980 1.1020 43.2000 0.7074 43.3980 0.7074 43.5000 0.4885 43.6980 0.4885 43.8000 0.6113 43.9980 0.6113 44.1000 0.4257 44.2980 0.4257 44.4000 0.3692 44.5980 0.3692 44.7000 0.5334 44.8980 0.5334 45.0000 0.3894 45.1980 0.3894 45.3000 0.5095 45.4980 0.5095 45.6000 0.6189 45.7980 0.6189 45.9000 0.5406 46.0980 0.5406 46.2000 0.5457 46.3980 0.5457 46.5000 0.3702 46.6980 0.3702 46.8000 0.4078 46.9980 0.4078 47.1000 0.4060 47.2980 0.4060 47.4000 0.4588 47.5980 0.4588 47.7000 0.3712 47.8980 0.3712 48.0000 0.4083 48.1980 0.4083 48.3000 0.3994 48.4980 0.3994 48.6000 0.4386 48.7980 0.4386 48.9000 0.4569 49.0980 0.4569 49.2000 0.3840 49.3980 0.3840 49.5000 0.5142 49.6980 0.5142 49.8000 0.4677 49.9980 0.4677 50.1000 0.4637 50.2980 0.4637 50.4000 0.5412 50.5980 0.5412 50.7000 0.5887 50.8980 0.5887 51.0000 0.5985 51.1980 0.5985 51.3000 0.5033 51.4980 0.5033 51.6000 0.5913 51.7980 0.5913 51.9000 0.6190 52.0980 0.6190 52.2000 0.5692 52.3980 0.5692 52.5000 0.5961 52.6980 0.5961 52.8000 0.6150 52.9980 0.6150 53.1000 0.5696 53.2980 0.5696 53.4000 0.6065 53.5980 0.6065 53.7000 0.6194 53.8980 0.6194 54.0000 0.5673 54.1980 0.5673 54.3000 0.6056 54.4980 0.6056 54.6000 0.5477 54.7980 0.5477 54.9000 0.5860 55.0980 0.5860 55.2000 0.5723 55.3980 0.5723 55.5000 0.6247 55.6980 0.6247 55.8000 0.5668 55.9980 0.5668 56.1000 0.5998 56.2980 0.5998 56.4000 0.5790 56.5980 0.5790 56.7000 0.6068 56.8980 0.6068 57.0000 0.5960 57.1980 0.5960 57.3000 0.6236 57.4980 0.6236 57.6000 0.5892 57.7980 0.5892 57.9000 0.6156 58.0980 0.6156 58.2000 0.8958 58.3980 0.8958 58.5000 0.5968 58.6980 0.5968 58.8000 0.9398 58.9980 0.9398 59.1000 0.6004 59.2980 0.6004 59.4000 0.9266 59.5980 0.9266 59.7000 0.5780 59.8980 0.5780 60.0000 0.6548 60.1980 0.6548 60.3000 0.6082 60.4980 0.6082 60.6000 0.5745 60.7980 0.5745 60.9000 0.5786 61.0980 0.5786 61.2000 0.5559 61.3980 0.5559 61.5000 0.6088 61.6980 0.6088 61.8000 0.7140 61.9980 0.7140 62.1000 0.6023 62.2980 0.6023 62.4000 0.5732 62.5980 0.5732 62.7000 0.6057 62.8980 0.6057 63.0000 0.5835 63.1980 0.5835 63.3000 0.8046 63.4980 0.8046 63.6000 0.5708 63.7980 0.5708 63.9000 1.1028 64.0980 1.1028 64.2000 0.6270 64.3980 0.6270 64.5000 1.1020 64.6980 1.1020 64.8000 0.7074 64.9980 0.7074 65.1000 0.4885 65.2980 0.4885 65.4000 0.6113 65.5980 0.6113 65.7000 0.4257 65.8980 0.4257 66.0000 0.3692 66.1980 0.3692 66.3000 0.5334 66.4980 0.5334 66.6000 0.3894 66.7980 0.3894 66.9000 0.5095 67.0980 0.5095 67.2000 0.6189 67.3980 0.6189 67.5000 0.5406 67.6980 0.5406 67.8000 0.5457 67.9980 0.5457 68.1000 0.3702 68.2980 0.3702 68.4000 0.4078 68.5980 0.4078 68.7000 0.4060 68.8980 0.4060 69.0000 0.4588 69.1980 0.4588 69.3000 0.3712 69.4980 0.3712 69.6000 0.4083 69.7980 0.4083 69.9000 0.3994 70.0980 0.3994 70.2000 0.4386 70.3980 0.4386 70.5000 0.4569 70.6980 0.4569 70.8000 0.3840 70.9980 0.3840 71.1000 0.5142 71.2980 0.5142 71.4000 0.4677 71.5980 0.4677 71.7000 0.4637 71.8980 0.4637 72.0000 0.5412 72.1980 0.5412 72.3000 0.5887 72.4980 0.5887 72.6000 0.5985 72.7980 0.5985 72.9000 0.5033 73.0980 0.5033 73.2000 0.5913 73.3980 0.5913 73.5000 0.6190 73.6980 0.6190 73.8000 0.5692 73.9980 0.5692 74.1000 0.5961 74.2980 0.5961 74.4000 0.6150 74.5980 0.6150 74.7000 0.5696 74.8980 0.5696 75.0000 0.6065 75.1980 0.6065 75.3000 0.6194 75.4980 0.6194 75.6000 0.5673 75.7980 0.5673 75.9000 0.6056 76.0980 0.6056 76.2000 0.5477 76.3980 0.5477 76.5000 0.5860 76.6980 0.5860 76.8000 0.5723 76.9980 0.5723 77.1000 0.6247 77.2980 0.6247 77.4000 0.5668 77.5980 0.5668 77.7000 0.5998 77.8980 0.5998 78.0000 0.5790 78.1980 0.5790 78.3000 0.6068 78.4980 0.6068 78.6000 0.5960 78.7980 0.5960 78.9000 0.6236 79.0980 0.6236 79.2000 0.5892 79.3980 0.5892 79.5000 0.6156 79.6980 0.6156 79.8000 0.8958 79.9980 0.8958 80.1000 0.5968 80.2980 0.5968 80.4000 0.9398 80.5980 0.9398 80.7000 0.6004 80.8980 0.6004 81.0000 0.9266 81.1980 0.9266 81.3000 0.5780 81.4980 0.5780 81.6000 0.6548 81.7980 0.6548 81.9000 0.6082 82.0980 0.6082 82.2000 0.5745 82.3980 0.5745 82.5000 0.5786 82.6980 0.5786 82.8000 0.5559 82.9980 0.5559 83.1000 0.6088 83.2980 0.6088 83.4000 0.7140 83.5980 0.7140 83.7000 0.6023 83.8980 0.6023 84.0000 0.5732 84.1980 0.5732 84.3000 0.6057 84.4980 0.6057 84.6000 0.5835 84.7980 0.5835 84.9000 0.8046 85.0980 0.8046 85.2000 0.5708 85.3980 0.5708 85.5000 1.1028 85.6980 1.1028 85.8000 0.6270 85.9980 0.6270 86.1000 1.1020 86.2980 1.1020 86.4000 0.7074 86.5980 0.7074 86.7000 0.4885 86.8980 0.4885 87.0000 0.6113 87.1980 0.6113 87.3000 0.4257 87.4980 0.4257 87.6000 0.3692 87.7980 0.3692 87.9000 0.5334 88.0980 0.5334 88.2000 0.3894 88.3980 0.3894 88.5000 0.5095 88.6980 0.5095 88.8000 0.6189 88.9980 0.6189 89.1000 0.5406 89.2980 0.5406 89.4000 0.5457 89.5980 0.5457 89.7000 0.3702 89.8980 0.3702 90.0000 0.4078 90.1980 0.4078 90.3000 0.4060 90.4980 0.4060 90.6000 0.4588 90.7980 0.4588 90.9000 0.3712 91.0980 0.3712 91.2000 0.4083 91.3980 0.4083 91.5000 0.3994 91.6980 0.3994 91.8000 0.4386 91.9980 0.4386 92.1000 0.4569 92.2980 0.4569 92.4000 0.3840 92.5980 0.3840 92.7000 0.5142 92.8980 0.5142 93.0000 0.4677 93.1980 0.4677 93.3000 0.4637 93.4980 0.4637 93.6000 0.5412 93.7980 0.5412 93.9000 0.5887 94.0980 0.5887 94.2000 0.5985 94.3980 0.5985 94.5000 0.5033 94.6980 0.5033 94.8000 0.5913 94.9980 0.5913 95.1000 0.6190 95.2980 0.6190 95.4000 0.5692 95.5980 0.5692 95.7000 0.5961 95.8980 0.5961 96.0000 0.6150 96.1980 0.6150 96.3000 0.5696 96.4980 0.5696 96.6000 0.6065 96.7980 0.6065 96.9000 0.6194 97.0980 0.6194 97.2000 0.5673 97.3980 0.5673 97.5000 0.6056 97.6980 0.6056 97.8000 0.5477 97.9980 0.5477 98.1000 0.5860 98.2980 0.5860 98.4000 0.5723 98.5980 0.5723 98.7000 0.6247 98.8980 0.6247 99.0000 0.5668 99.1980 0.5668 99.3000 0.5998 99.4980 0.5998 99.6000 0.5790 99.7980 0.5790 99.9000 0.6068 100.0980 0.6068 100.2000 0.5960 100.3980 0.5960 100.5000 0.6236 100.6980 0.6236 100.8000 0.5892 100.9980 0.5892 101.1000 0.6156 101.2980 0.6156 101.4000 0.8958 101.5980 0.8958 101.7000 0.5968 101.8980 0.5968 102.0000 0.9398 102.1980 0.9398 102.3000 0.6004 102.4980 0.6004 102.6000 0.9266 102.7980 0.9266 102.9000 0.5780 103.0980 0.5780 103.2000 0.6548 103.3980 0.6548 103.5000 0.6082 103.6980 0.6082 103.8000 0.5745 103.9980 0.5745 104.1000 0.5786 104.2980 0.5786 104.4000 0.5559 104.5980 0.5559 104.7000 0.6088 104.8980 0.6088 105.0000 0.7140 105.1980 0.7140 105.3000 0.6023 105.4980 0.6023 105.6000 0.5732 105.7980 0.5732 105.9000 0.6057 106.0980 0.6057 106.2000 0.5835 106.3980 0.5835 106.5000 0.8046 106.6980 0.8046 106.8000 0.5708 106.9980 0.5708 107.1000 1.1028 107.2980 1.1028 107.4000 0.6270 107.5980 0.6270 107.7000 1.1020 107.8980 1.1020 108.0000 0.7074 108.1980 0.7074 108.3000 0.4885 108.4980 0.4885 108.6000 0.6113 108.7980 0.6113 108.9000 0.4257 109.0980 0.4257 109.2000 0.3692 109.3980 0.3692 109.5000 0.5334 109.6980 0.5334 109.8000 0.3894 109.9980 0.3894 110.1000 0.5095 110.2980 0.5095 110.4000 0.6189 110.5980 0.6189 110.7000 0.5406 110.8980 0.5406 111.0000 0.5457 111.1980 0.5457 111.3000 0.3702 111.4980 0.3702 111.6000 0.4078 111.7980 0.4078 111.9000 0.4060 112.0980 0.4060 112.2000 0.4588 112.3980 0.4588 112.5000 0.3712 112.6980 0.3712 112.8000 0.4083 112.9980 0.4083 113.1000 0.3994 113.2980 0.3994 113.4000 0.4386 113.5980 0.4386 113.7000 0.4569 113.8980 0.4569 114.0000 0.3840 114.1980 0.3840 114.3000 0.5142 114.4980 0.5142 114.6000 0.4677 114.7980 0.4677 114.9000 0.4637 115.0980 0.4637 115.2000 0.5412 115.3980 0.5412 115.5000 0.5887 115.6980 0.5887 115.8000 0.5985 115.9980 0.5985 116.1000 0.5033 116.2980 0.5033 116.4000 0.5913 116.5980 0.5913 116.7000 0.6190 116.8980 0.6190 117.0000 0.5692 117.1980 0.5692 117.3000 0.5961 117.4980 0.5961 117.6000 0.6150 117.7980 0.6150 117.9000 0.5696 118.0980 0.5696 118.2000 0.6065 118.3980 0.6065 118.5000 0.6194 118.6980 0.6194 118.8000 0.5673 118.9980 0.5673 119.1000 0.6056 119.2980 0.6056 119.4000 0.5477 119.5980 0.5477 119.7000 0.5860 119.8980 0.5860 120.0000 0.5723 120.1980 0.5723 120.3000 0.6247 120.4980 0.6247 120.6000 0.5668 120.7980 0.5668 120.9000 0.5998 121.0980 0.5998 121.2000 0.5790 121.3980 0.5790 121.5000 0.6068 121.6980 0.6068 121.8000 0.5960 121.9980 0.5960 122.1000 0.6236 122.2980 0.6236 122.4000 0.5892 122.5980 0.5892 122.7000 0.6156 122.8980 0.6156 123.0000 0.8958 123.1980 0.8958 123.3000 0.5968 123.4980 0.5968 123.6000 0.9398 123.7980 0.9398 123.9000 0.6004 124.0980 0.6004 124.2000 0.9266 124.3980 0.9266 124.5000 0.5780 124.6980 0.5780 124.8000 0.6548 124.9980 0.6548 125.1000 0.6082 125.2980 0.6082 125.4000 0.5745 125.5980 0.5745 125.7000 0.5786 125.8980 0.5786 126.0000 0.5559 126.1980 0.5559 126.3000 0.6088 126.4980 0.6088 126.6000 0.7140 126.7980 0.7140 126.9000 0.6023 127.0980 0.6023 127.2000 0.5732 127.3980 0.5732 127.5000 0.6057 127.6980 0.6057 127.8000 0.5835 127.9980 0.5835 128.1000 0.8046 128.2980 0.8046 128.4000 0.5708 128.5980 0.5708 128.7000 1.1028 128.8980 1.1028 129.0000 0.6270 129.1980 0.6270 129.3000 1.1020 129.4980 1.1020 129.6000 0.7074 129.7980 0.7074 129.9000 0.4885 130.0980 0.4885 130.2000 0.6113 130.3980 0.6113 130.5000 0.4257 130.6980 0.4257 130.8000 0.3692 130.9980 0.3692 131.1000 0.5334 131.2980 0.5334 131.4000 0.3894 131.5980 0.3894 131.7000 0.5095 131.8980 0.5095 132.0000 0.6189 132.1980 0.6189 132.3000 0.5406 132.4980 0.5406 132.6000 0.5457 132.7980 0.5457 132.9000 0.3702 133.0980 0.3702 133.2000 0.4078 133.3980 0.4078 133.5000 0.4060 133.6980 0.4060 133.8000 0.4588 133.9980 0.4588 134.1000 0.3712 134.2980 0.3712 134.4000 0.4083 134.5980 0.4083 134.7000 0.3994 134.8980 0.3994 135.0000 0.4386 135.1980 0.4386 135.3000 0.4569 135.4980 0.4569 135.6000 0.3840 135.7980 0.3840 135.9000 0.5142 136.0980 0.5142 136.2000 0.4677 136.3980 0.4677 136.5000 0.4637 136.6980 0.4637 136.8000 0.5412 136.9980 0.5412 137.1000 0.5887 137.2980 0.5887 137.4000 0.5985 137.5980 0.5985 137.7000 0.5033 137.8980 0.5033 138.0000 0.5913 138.1980 0.5913 138.3000 0.6190 138.4980 0.6190 138.6000 0.5692 138.7980 0.5692 138.9000 0.5961 139.0980 0.5961 139.2000 0.6150 139.3980 0.6150 139.5000 0.5696 139.6980 0.5696 139.8000 0.6065 139.9980 0.6065 140.1000 0.6194 140.2980 0.6194 140.4000 0.5673 140.5980 0.5673 140.7000 0.6056 140.8980 0.6056 141.0000 0.5477 141.1980 0.5477 141.3000 0.5860 141.4980 0.5860 141.6000 0.5723 141.7980 0.5723 141.9000 0.6247 142.0980 0.6247 142.2000 0.5668 142.3980 0.5668 142.5000 0.5998 142.6980 0.5998 142.8000 0.5790 142.9980 0.5790 143.1000 0.6068 143.2980 0.6068 143.4000 0.5960 143.5980 0.5960 143.7000 0.6236 143.8980 0.6236 144.0000 0.5892 144.1980 0.5892 144.3000 0.6156 144.4980 0.6156 144.6000 0.8958 144.7980 0.8958 144.9000 0.5968 145.0980 0.5968 145.2000 0.9398 145.3980 0.9398 145.5000 0.6004 145.6980 0.6004 145.8000 0.9266 145.9980 0.9266 146.1000 0.5780 146.2980 0.5780 146.4000 0.6548 146.5980 0.6548 146.7000 0.6082 146.8980 0.6082 147.0000 0.5745 147.1980 0.5745 147.3000 0.5786 147.4980 0.5786 147.6000 0.5559 147.7980 0.5559 147.9000 0.6088 148.0980 0.6088 148.2000 0.7140 148.3980 0.7140 148.5000 0.6023 148.6980 0.6023 148.8000 0.5732 148.9980 0.5732 149.1000 0.6057 149.2980 0.6057 149.4000 0.5835 149.5980 0.5835 149.7000 0.8046 149.8980 0.8046 150.0000 0.5708 150.1980 0.5708 150.3000 1.1028 150.4980 1.1028 150.6000 0.6270 150.7980 0.6270 150.9000 1.1020 151.0980 1.1020 151.2000 0.7074 151.3980 0.7074 151.5000 0.4885 151.6980 0.4885 151.8000 0.6113 151.9980 0.6113 152.1000 0.4257 152.2980 0.4257 152.4000 0.3692 152.5980 0.3692 152.7000 0.5334 152.8980 0.5334 153.0000 0.3894 153.1980 0.3894 153.3000 0.5095 153.4980 0.5095 153.6000 0.6189 153.7980 0.6189 153.9000 0.5406 154.0980 0.5406 154.2000 0.5457 154.3980 0.5457 154.5000 0.3702 154.6980 0.3702 154.8000 0.4078 154.9980 0.4078 155.1000 0.4060 155.2980 0.4060 155.4000 0.4588 155.5980 0.4588 155.7000 0.3712 155.8980 0.3712 156.0000 0.4083 156.1980 0.4083 156.3000 0.3994 156.4980 0.3994 156.6000 0.4386 156.7980 0.4386 156.9000 0.4569 157.0980 0.4569 157.2000 0.3840 157.3980 0.3840 157.5000 0.5142 157.6980 0.5142 157.8000 0.4677 157.9980 0.4677 158.1000 0.4637 158.2980 0.4637 158.4000 0.5412 158.5980 0.5412 158.7000 0.5887 158.8980 0.5887 159.0000 0.5985 159.1980 0.5985 159.3000 0.5033 159.4980 0.5033 159.6000 0.5913 159.7980 0.5913 159.9000 0.6190 160.0980 0.6190 160.2000 0.5692 160.3980 0.5692 160.5000 0.5961 160.6980 0.5961 160.8000 0.6150 160.9980 0.6150 161.1000 0.5696 161.2980 0.5696 161.4000 0.6065 161.5980 0.6065 161.7000 0.6194 161.8980 0.6194 162.0000 0.5673 162.1980 0.5673 162.3000 0.6056 162.4980 0.6056 162.6000 0.5477 162.7980 0.5477 162.9000 0.5860 163.0980 0.5860 163.2000 0.5723 163.3980 0.5723 163.5000 0.6247 163.6980 0.6247 163.8000 0.5668 163.9980 0.5668 164.1000 0.5998 164.2980 0.5998 164.4000 0.5790 164.5980 0.5790 164.7000 0.6068 164.8980 0.6068 165.0000 0.5960 165.1980 0.5960 165.3000 0.6236 165.4980 0.6236 165.6000 0.5892 165.7980 0.5892 165.9000 0.6156 166.0980 0.6156 166.2000 0.8958 166.3980 0.8958 166.5000 0.5968 166.6980 0.5968 166.8000 0.9398 166.9980 0.9398 167.1000 0.6004 167.2980 0.6004 167.4000 0.9266 167.5980 0.9266 167.7000 0.5780 167.8980 0.5780 168.0000 0.6548 168.1980 0.6548 168.3000 0.6082 168.4980 0.6082 168.6000 0.5745 168.7980 0.5745 168.9000 0.5786 169.0980 0.5786 169.2000 0.5559 169.3980 0.5559 169.5000 0.6088 169.6980 0.6088 169.8000 0.7140 169.9980 0.7140 170.1000 0.6023 170.2980 0.6023 170.4000 0.5732 170.5980 0.5732 170.7000 0.6057 170.8980 0.6057 171.0000 0.5835 171.1980 0.5835 171.3000 0.8046 171.4980 0.8046 171.6000 0.5708 171.7980 0.5708 171.9000 1.1028 172.0980 1.1028 172.2000 0.6270 172.3980 0.6270 172.5000 1.1020 172.6980 1.1020 172.8000 0.7074 172.9980 0.7074 173.1000 0.4885 173.2980 0.4885 173.4000 0.6113 173.5980 0.6113 173.7000 0.4257 173.8980 0.4257 174.0000 0.3692 174.1980 0.3692 174.3000 0.5334 174.4980 0.5334 174.6000 0.3894 174.7980 0.3894 174.9000 0.5095 175.0980 0.5095 175.2000 0.6189 175.3980 0.6189 175.5000 0.5406 175.6980 0.5406 175.8000 0.5457 175.9980 0.5457 176.1000 0.3702 176.2980 0.3702 176.4000 0.4078 176.5980 0.4078 176.7000 0.4060 176.8980 0.4060 177.0000 0.4588 177.1980 0.4588 177.3000 0.3712 177.4980 0.3712 177.6000 0.4083 177.7980 0.4083 177.9000 0.3994 178.0980 0.3994 178.2000 0.4386 178.3980 0.4386 178.5000 0.4569 178.6980 0.4569 178.8000 0.3840 178.9980 0.3840 179.1000 0.5142 179.2980 0.5142 179.4000 0.4677 179.5980 0.4677 179.7000 0.4637 179.8980 0.4637 180.0000 0.5412 180.1980 0.5412 180.3000 0.5887 180.4980 0.5887 180.6000 0.5985 180.7980 0.5985 180.9000 0.5033 181.0980 0.5033 181.2000 0.5913 181.3980 0.5913 181.5000 0.6190 181.6980 0.6190 181.8000 0.5692 181.9980 0.5692 182.1000 0.5961 182.2980 0.5961 182.4000 0.6150 182.5980 0.6150 182.7000 0.5696 182.8980 0.5696 183.0000 0.6065 183.1980 0.6065 183.3000 0.6194 183.4980 0.6194 183.6000 0.5673 183.7980 0.5673 183.9000 0.6056 184.0980 0.6056 184.2000 0.5477 184.3980 0.5477 184.5000 0.5860 184.6980 0.5860 184.8000 0.5723 184.9980 0.5723 185.1000 0.6247 185.2980 0.6247 185.4000 0.5668 185.5980 0.5668 185.7000 0.5998 185.8980 0.5998 186.0000 0.5790 186.1980 0.5790 186.3000 0.6068 186.4980 0.6068 186.6000 0.5960 186.7980 0.5960 186.9000 0.6236 187.0980 0.6236 187.2000 0.5892 187.3980 0.5892 187.5000 0.6156 187.6980 0.6156 187.8000 0.8958 187.9980 0.8958 188.1000 0.5968 188.2980 0.5968 188.4000 0.9398 188.5980 0.9398 188.7000 0.6004 188.8980 0.6004 189.0000 0.9266 189.1980 0.9266 189.3000 0.5780 189.4980 0.5780 189.6000 0.6548 189.7980 0.6548 189.9000 0.6082 190.0980 0.6082 190.2000 0.5745 190.3980 0.5745 190.5000 0.5786 190.6980 0.5786 190.8000 0.5559 190.9980 0.5559 191.1000 0.6088 191.2980 0.6088 191.4000 0.7140 191.5980 0.7140 191.7000 0.6023 191.8980 0.6023 192.0000 0.5732 192.1980 0.5732 192.3000 0.6057 192.4980 0.6057 192.6000 0.5835 192.7980 0.5835 192.9000 0.8046 193.0980 0.8046 193.2000 0.5708 193.3980 0.5708 193.5000 1.1028 193.6980 1.1028 193.8000 0.6270 193.9980 0.6270 194.1000 1.1020 194.2980 1.1020 194.4000 0.7074 194.5980 0.7074 194.7000 0.4885 194.8980 0.4885 195.0000 0.6113 195.1980 0.6113 195.3000 0.4257 195.4980 0.4257 195.6000 0.3692 195.7980 0.3692 195.9000 0.5334 196.0980 0.5334 196.2000 0.3894 196.3980 0.3894 196.5000 0.5095 196.6980 0.5095 196.8000 0.6189 196.9980 0.6189 197.1000 0.5406 197.2980 0.5406 197.4000 0.5457 197.5980 0.5457 197.7000 0.3702 197.8980 0.3702 198.0000 0.4078 198.1980 0.4078 198.3000 0.4060 198.4980 0.4060 198.6000 0.4588 198.7980 0.4588 198.9000 0.3712 199.0980 0.3712 199.2000 0.4083 199.3980 0.4083 199.5000 0.3994 199.6980 0.3994 199.8000 0.4386 199.9980 0.4386 200.1000 0.4569 200.2980 0.4569 200.4000 0.3840 200.5980 0.3840 200.7000 0.5142 200.8980 0.5142 201.0000 0.4677 201.1980 0.4677 201.3000 0.4637 201.4980 0.4637 201.6000 0.5412 201.7980 0.5412 201.9000 0.5887 202.0980 0.5887 202.2000 0.5985 202.3980 0.5985 202.5000 0.5033 202.6980 0.5033 202.8000 0.5913 202.9980 0.5913 203.1000 0.6190 203.2980 0.6190 203.4000 0.5692 203.5980 0.5692 203.7000 0.5961 203.8980 0.5961 204.0000 0.6150 204.1980 0.6150 204.3000 0.5696 204.4980 0.5696 204.6000 0.6065 204.7980 0.6065 204.9000 0.6194 205.0980 0.6194 205.2000 0.5673 205.3980 0.5673 205.5000 0.6056 205.6980 0.6056 205.8000 0.5477 205.9980 0.5477 206.1000 0.5860 206.2980 0.5860 206.4000 0.5723 206.5980 0.5723 206.7000 0.6247 206.8980 0.6247 207.0000 0.5668 207.1980 0.5668 207.3000 0.5998 207.4980 0.5998 207.6000 0.5790 207.7980 0.5790 207.9000 0.6068 208.0980 0.6068 208.2000 0.5960 208.3980 0.5960 208.5000 0.6236 208.6980 0.6236 208.8000 0.5892 208.9980 0.5892 209.1000 0.6156 209.2980 0.6156 209.4000 0.8958 209.5980 0.8958 209.7000 0.5968 209.8980 0.5968 210.0000 0.9398 210.1980 0.9398 210.3000 0.6004 210.4980 0.6004 210.6000 0.9266 210.7980 0.9266 210.9000 0.5780 211.0980 0.5780 211.2000 0.6548 211.3980 0.6548 211.5000 0.6082 211.6980 0.6082 211.8000 0.5745 211.9980 0.5745 212.1000 0.5786 212.2980 0.5786 212.4000 0.5559 212.5980 0.5559 212.7000 0.6088 212.8980 0.6088 213.0000 0.7140 213.1980 0.7140 213.3000 0.6023 213.4980 0.6023 213.6000 0.5732 213.7980 0.5732 213.9000 0.6057 214.0980 0.6057 214.2000 0.5835 214.3980 0.5835 214.5000 0.8046 214.6980 0.8046 214.8000 0.5708 214.9980 0.5708 215.1000 1.1028 215.2980 1.1028 215.4000 0.6270 215.5980 0.6270 215.7000 1.1020 215.8980 1.1020 216.0000 0.7074 216.1980 0.7074 216.3000 0.4885 216.4980 0.4885 216.6000 0.6113 216.7980 0.6113 216.9000 0.4257 217.0980 0.4257 217.2000 0.3692 217.3980 0.3692 217.5000 0.5334 217.6980 0.5334 217.8000 0.3894 217.9980 0.3894 218.1000 0.5095 218.2980 0.5095 218.4000 0.6189 218.5980 0.6189 218.7000 0.5406 218.8980 0.5406 219.0000 0.5457 219.1980 0.5457 219.3000 0.3702 219.4980 0.3702 219.6000 0.4078 219.7980 0.4078 219.9000 0.4060 220.0980 0.4060 220.2000 0.4588 220.3980 0.4588 220.5000 0.3712 220.6980 0.3712 220.8000 0.4083 220.9980 0.4083 221.1000 0.3994 221.2980 0.3994 221.4000 0.4386 221.5980 0.4386 221.7000 0.4569 221.8980 0.4569 222.0000 0.3840 222.1980 0.3840 222.3000 0.5142 222.4980 0.5142 222.6000 0.4677 222.7980 0.4677 222.9000 0.4637 223.0980 0.4637 223.2000 0.5412 223.3980 0.5412 223.5000 0.5887 223.6980 0.5887 223.8000 0.5985 223.9980 0.5985 224.1000 0.5033 224.2980 0.5033 224.4000 0.5913 224.5980 0.5913 224.7000 0.6190 224.8980 0.6190 225.0000 0.5692 225.1980 0.5692 225.3000 0.5961 225.4980 0.5961 225.6000 0.6150 225.7980 0.6150 225.9000 0.5696 226.0980 0.5696 226.2000 0.6065 226.3980 0.6065 226.5000 0.6194 226.6980 0.6194 226.8000 0.5673 226.9980 0.5673 227.1000 0.6056 227.2980 0.6056 227.4000 0.5477 227.5980 0.5477 227.7000 0.5860 227.8980 0.5860 228.0000 0.5723 228.1980 0.5723 228.3000 0.6247 228.4980 0.6247 228.6000 0.5668 228.7980 0.5668 228.9000 0.5998 229.0980 0.5998 229.2000 0.5790 229.3980 0.5790 229.5000 0.6068 229.6980 0.6068 229.8000 0.5960 229.9980 0.5960 230.1000 0.6236 230.2980 0.6236 230.4000 0.5892 230.5980 0.5892 230.7000 0.6156 230.8980 0.6156 231.0000 0.8958 231.1980 0.8958 231.3000 0.5968 231.4980 0.5968 231.6000 0.9398 231.7980 0.9398 231.9000 0.6004 232.0980 0.6004 232.2000 0.9266 232.3980 0.9266 232.5000 0.5780 232.6980 0.5780 232.8000 0.6548 232.9980 0.6548 233.1000 0.6082 233.2980 0.6082 233.4000 0.5745 233.5980 0.5745 233.7000 0.5786 233.8980 0.5786 234.0000 0.5559 234.1980 0.5559 234.3000 0.6088 234.4980 0.6088 234.6000 0.7140 234.7980 0.7140 234.9000 0.6023 235.0980 0.6023 235.2000 0.5732 235.3980 0.5732 235.5000 0.6057 235.6980 0.6057 235.8000 0.5835 235.9980 0.5835 236.1000 0.8046 236.2980 0.8046 236.4000 0.5708 236.5980 0.5708 236.7000 1.1028 236.8980 1.1028 237.0000 0.6270 237.1980 0.6270 237.3000 1.1020 237.4980 1.1020 237.6000 0.7074 237.7980 0.7074 237.9000 0.4885 238.0980 0.4885 238.2000 0.6113 238.3980 0.6113 238.5000 0.4257 238.6980 0.4257 238.8000 0.3692 238.9980 0.3692 239.1000 0.5334 239.2980 0.5334 239.4000 0.3894 239.5980 0.3894 239.7000 0.5095 239.8980 0.5095 240.0000 0.6189 240.1980 0.6189 240.3000 0.5406 240.4980 0.5406 240.6000 0.5457 240.7980 0.5457 240.9000 0.3702 241.0980 0.3702 241.2000 0.4078 241.3980 0.4078 241.5000 0.4060 241.6980 0.4060 241.8000 0.4588 241.9980 0.4588 242.1000 0.3712 242.2980 0.3712 242.4000 0.4083 242.5980 0.4083 242.7000 0.3994 242.8980 0.3994 243.0000 0.4386 243.1980 0.4386 243.3000 0.4569 243.4980 0.4569 243.6000 0.3840 243.7980 0.3840 243.9000 0.5142 244.0980 0.5142 244.2000 0.4677 244.3980 0.4677 244.5000 0.4637 244.6980 0.4637 244.8000 0.5412 244.9980 0.5412 245.1000 0.5887 245.2980 0.5887 245.4000 0.5985 245.5980 0.5985 245.7000 0.5033 245.8980 0.5033 246.0000 0.5913 246.1980 0.5913 246.3000 0.6190 246.4980 0.6190 246.6000 0.5692 246.7980 0.5692 246.9000 0.5961 247.0980 0.5961 247.2000 0.6150 247.3980 0.6150 247.5000 0.5696 247.6980 0.5696 247.8000 0.6065 247.9980 0.6065 248.1000 0.6194 248.2980 0.6194 248.4000 0.5673 248.5980 0.5673 248.7000 0.6056 248.8980 0.6056 249.0000 0.5477 249.1980 0.5477 249.3000 0.5860 249.4980 0.5860 249.6000 0.5723 249.7980 0.5723 249.9000 0.6247 250.0980 0.6247 250.2000 0.5668 250.3980 0.5668 250.5000 0.5998 250.6980 0.5998 250.8000 0.5790 250.9980 0.5790 251.1000 0.6068 251.2980 0.6068 251.4000 0.5960 251.5980 0.5960 251.7000 0.6236 251.8980 0.6236 252.0000 0.5892 252.1980 0.5892 252.3000 0.6156 252.4980 0.6156 252.6000 0.8958 252.7980 0.8958 252.9000 0.5968 253.0980 0.5968 253.2000 0.9398 253.3980 0.9398 253.5000 0.6004 253.6980 0.6004 253.8000 0.9266 253.9980 0.9266 254.1000 0.5780 254.2980 0.5780 254.4000 0.6548 254.5980 0.6548 254.7000 0.6082 254.8980 0.6082 255.0000 0.5745 255.1980 0.5745 255.3000 0.5786 255.4980 0.5786 255.6000 0.5559 255.7980 0.5559 255.9000 0.6088 256.0980 0.6088 256.2000 0.7140 256.3980 0.7140 256.5000 0.6023 256.6980 0.6023 256.8000 0.5732 256.9980 0.5732 257.1000 0.6057 257.2980 0.6057 257.4000 0.5835 257.5980 0.5835 257.7000 0.8046 257.8980 0.8046 258.0000 0.5708 258.1980 0.5708 258.3000 1.1028 258.4980 1.1028 258.6000 0.6270 258.7980 0.6270 258.9000 1.1020 259.0980 1.1020 259.2000 0.7074 259.3980 0.7074 259.5000 0.4885 259.6980 0.4885 259.8000 0.6113 259.9980 0.6113 260.1000 0.4257 260.2980 0.4257 260.4000 0.3692 260.5980 0.3692 260.7000 0.5334 260.8980 0.5334 261.0000 0.3894 261.1980 0.3894 261.3000 0.5095 261.4980 0.5095 261.6000 0.6189 261.7980 0.6189 261.9000 0.5406 262.0980 0.5406 262.2000 0.5457 262.3980 0.5457 262.5000 0.3702 262.6980 0.3702 262.8000 0.4078 262.9980 0.4078 263.1000 0.4060 263.2980 0.4060 263.4000 0.4588 263.5980 0.4588 263.7000 0.3712 263.8980 0.3712 264.0000 0.4083 264.1980 0.4083 264.3000 0.3994 264.4980 0.3994 264.6000 0.4386 264.7980 0.4386 264.9000 0.4569 265.0980 0.4569 265.2000 0.3840 265.3980 0.3840 265.5000 0.5142 265.6980 0.5142 265.8000 0.4677 265.9980 0.4677 266.1000 0.4637 266.2980 0.4637 266.4000 0.5412 266.5980 0.5412 266.7000 0.5887 266.8980 0.5887 267.0000 0.5985 267.1980 0.5985 267.3000 0.5033 267.4980 0.5033 267.6000 0.5913 267.7980 0.5913 267.9000 0.6190 268.0980 0.6190 268.2000 0.5692 268.3980 0.5692 268.5000 0.5961 268.6980 0.5961 268.8000 0.6150 268.9980 0.6150 269.1000 0.5696 269.2980 0.5696 269.4000 0.6065 269.5980 0.6065 269.7000 0.6194 269.8980 0.6194 270.0000 0.5673 270.1980 0.5673 270.3000 0.6056 270.4980 0.6056 270.6000 0.5477 270.7980 0.5477 270.9000 0.5860 271.0980 0.5860 271.2000 0.5723 271.3980 0.5723 271.5000 0.6247 271.6980 0.6247 271.8000 0.5668 271.9980 0.5668 272.1000 0.5998 272.2980 0.5998 272.4000 0.5790 272.5980 0.5790 272.7000 0.6068 272.8980 0.6068 273.0000 0.5960 273.1980 0.5960 273.3000 0.6236 273.4980 0.6236 273.6000 0.5892 273.7980 0.5892 273.9000 0.6156 274.0980 0.6156 274.2000 0.8958 274.3980 0.8958 274.5000 0.5968 274.6980 0.5968 274.8000 0.9398 274.9980 0.9398 275.1000 0.6004 275.2980 0.6004 275.4000 0.9266 275.5980 0.9266 275.7000 0.5780 275.8980 0.5780 276.0000 0.6548 276.1980 0.6548 276.3000 0.6082 276.4980 0.6082 276.6000 0.5745 276.7980 0.5745 276.9000 0.5786 277.0980 0.5786 277.2000 0.5559 277.3980 0.5559 277.5000 0.6088 277.6980 0.6088 277.8000 0.7140 277.9980 0.7140 278.1000 0.6023 278.2980 0.6023 278.4000 0.5732 278.5980 0.5732 278.7000 0.6057 278.8980 0.6057 279.0000 0.5835 279.1980 0.5835 279.3000 0.8046 279.4980 0.8046 279.6000 0.5708 279.7980 0.5708 279.9000 1.1028 280.0980 1.1028 280.2000 0.6270 280.3980 0.6270 280.5000 1.1020 280.6980 1.1020 280.8000 0.7074 280.9980 0.7074 281.1000 0.4885 281.2980 0.4885 281.4000 0.6113 281.5980 0.6113 281.7000 0.4257 281.8980 0.4257 282.0000 0.3692 282.1980 0.3692 282.3000 0.5334 282.4980 0.5334 282.6000 0.3894 282.7980 0.3894 282.9000 0.5095 283.0980 0.5095 283.2000 0.6189 283.3980 0.6189 283.5000 0.5406 283.6980 0.5406 283.8000 0.5457 283.9980 0.5457 284.1000 0.3702 284.2980 0.3702 284.4000 0.4078 284.5980 0.4078 284.7000 0.4060 284.8980 0.4060 285.0000 0.4588 285.1980 0.4588 285.3000 0.3712 285.4980 0.3712 285.6000 0.4083 285.7980 0.4083 285.9000 0.3994 286.0980 0.3994 286.2000 0.4386 286.3980 0.4386 286.5000 0.4569 286.6980 0.4569 286.8000 0.3840 286.9980 0.3840 287.1000 0.5142 287.2980 0.5142 287.4000 0.4677 287.5980 0.4677 287.7000 0.4637 287.8980 0.4637 288.0000 0.5412 288.1980 0.5412 288.3000 0.5887 288.4980 0.5887 288.6000 0.5985 288.7980 0.5985 288.9000 0.5033 289.0980 0.5033 289.2000 0.5913 289.3980 0.5913 289.5000 0.6190 289.6980 0.6190 289.8000 0.5692 289.9980 0.5692 290.1000 0.5961 290.2980 0.5961 290.4000 0.6150 290.5980 0.6150 290.7000 0.5696 290.8980 0.5696 291.0000 0.6065 291.1980 0.6065 291.3000 0.6194 291.4980 0.6194 291.6000 0.5673 291.7980 0.5673 291.9000 0.6056 292.0980 0.6056 292.2000 0.5477 292.3980 0.5477 292.5000 0.5860 292.6980 0.5860 292.8000 0.5723 292.9980 0.5723 293.1000 0.6247 293.2980 0.6247 293.4000 0.5668 293.5980 0.5668 293.7000 0.5998 293.8980 0.5998 294.0000 0.5790 294.1980 0.5790 294.3000 0.6068 294.4980 0.6068 294.6000 0.5960 294.7980 0.5960 294.9000 0.6236 295.0980 0.6236 295.2000 0.5892 295.3980 0.5892 295.5000 0.6156 295.6980 0.6156 295.8000 0.8958 295.9980 0.8958 296.1000 0.5968 296.2980 0.5968 296.4000 0.9398 296.5980 0.9398 296.7000 0.6004 296.8980 0.6004 297.0000 0.9266 297.1980 0.9266 297.3000 0.5780 297.4980 0.5780 297.6000 0.6548 297.7980 0.6548 297.9000 0.6082 298.0980 0.6082 298.2000 0.5745 298.3980 0.5745 298.5000 0.5786 298.6980 0.5786 298.8000 0.5559 298.9980 0.5559 299.1000 0.6088 299.2980 0.6088 299.4000 0.7140 299.5980 0.7140 299.7000 0.6023 299.8980 0.6023 300.0000 0.5732 300.1980 0.5732 300.3000 0.6057 300.4980 0.6057 300.6000 0.5835 300.7980 0.5835 300.9000 0.8046 301.0980 0.8046 301.2000 0.5708 301.3980 0.5708 301.5000 1.1028 301.6980 1.1028 301.8000 0.6270 301.9980 0.6270 302.1000 1.1020 302.2980 1.1020 302.4000 0.7074 302.5980 0.7074 302.7000 0.4885 302.8980 0.4885 303.0000 0.6113 303.1980 0.6113 303.3000 0.4257 303.4980 0.4257 303.6000 0.3692 303.7980 0.3692 303.9000 0.5334 304.0980 0.5334 304.2000 0.3894 304.3980 0.3894 304.5000 0.5095 304.6980 0.5095 304.8000 0.6189 304.9980 0.6189 305.1000 0.5406 305.2980 0.5406 305.4000 0.5457 305.5980 0.5457 305.7000 0.3702 305.8980 0.3702 306.0000 0.4078 306.1980 0.4078 306.3000 0.4060 306.4980 0.4060 306.6000 0.4588 306.7980 0.4588 306.9000 0.3712 307.0980 0.3712 307.2000 0.4083 307.3980 0.4083 307.5000 0.3994 307.6980 0.3994 307.8000 0.4386 307.9980 0.4386 308.1000 0.4569 308.2980 0.4569 308.4000 0.3840 308.5980 0.3840 308.7000 0.5142 308.8980 0.5142 309.0000 0.4677 309.1980 0.4677 309.3000 0.4637 309.4980 0.4637 309.6000 0.5412 309.7980 0.5412 309.9000 0.5887 310.0980 0.5887 310.2000 0.5985 310.3980 0.5985 310.5000 0.5033 310.6980 0.5033 310.8000 0.5913 310.9980 0.5913 311.1000 0.6190 311.2980 0.6190 311.4000 0.5692 311.5980 0.5692 311.7000 0.5961 311.8980 0.5961 312.0000 0.6150 312.1980 0.6150 312.3000 0.5696 312.4980 0.5696 312.6000 0.6065 312.7980 0.6065 312.9000 0.6194 313.0980 0.6194 313.2000 0.5673 313.3980 0.5673 313.5000 0.6056 313.6980 0.6056 313.8000 0.5477 313.9980 0.5477 314.1000 0.5860 314.2980 0.5860 314.4000 0.5723 314.5980 0.5723 314.7000 0.6247 314.8980 0.6247 315.0000 0.5668 315.1980 0.5668 315.3000 0.5998 315.4980 0.5998 315.6000 0.5790 315.7980 0.5790 315.9000 0.6068 316.0980 0.6068 316.2000 0.5960 316.3980 0.5960 316.5000 0.6236 316.6980 0.6236 316.8000 0.5892 316.9980 0.5892 317.1000 0.6156 317.2980 0.6156 317.4000 0.8958 317.5980 0.8958 317.7000 0.5968 317.8980 0.5968 318.0000 0.9398 318.1980 0.9398 318.3000 0.6004 318.4980 0.6004 318.6000 0.9266 318.7980 0.9266 318.9000 0.5780 319.0980 0.5780 319.2000 0.6548 319.3980 0.6548 319.5000 0.6082 319.6980 0.6082 319.8000 0.5745 319.9980 0.5745 320.1000 0.5786 320.2980 0.5786 320.4000 0.5559 320.5980 0.5559 320.7000 0.6088 320.8980 0.6088 321.0000 0.7140 321.1980 0.7140 321.3000 0.6023 321.4980 0.6023 321.6000 0.5732 321.7980 0.5732 321.9000 0.6057 322.0980 0.6057 322.2000 0.5835 322.3980 0.5835 322.5000 0.8046 322.6980 0.8046 322.8000 0.5708 322.9980 0.5708 323.1000 1.1028 323.2980 1.1028 323.4000 0.6270 323.5980 0.6270 323.7000 1.1020 323.8980 1.1020 324.0000 0.7074 324.1980 0.7074 324.3000 0.4885 324.4980 0.4885 324.6000 0.6113 324.7980 0.6113 324.9000 0.4257 325.0980 0.4257 325.2000 0.3692 325.3980 0.3692 325.5000 0.5334 325.6980 0.5334 325.8000 0.3894 325.9980 0.3894 326.1000 0.5095 326.2980 0.5095 326.4000 0.6189 326.5980 0.6189 326.7000 0.5406 326.8980 0.5406 327.0000 0.5457 327.1980 0.5457 327.3000 0.3702 327.4980 0.3702 327.6000 0.4078 327.7980 0.4078 327.9000 0.4060 328.0980 0.4060 328.2000 0.4588 328.3980 0.4588 328.5000 0.3712 328.6980 0.3712 328.8000 0.4083 328.9980 0.4083 329.1000 0.3994 329.2980 0.3994 329.4000 0.4386 329.5980 0.4386 329.7000 0.4569 329.8980 0.4569 330.0000 0.3840 330.1980 0.3840 330.3000 0.5142 330.4980 0.5142 330.6000 0.4677 330.7980 0.4677 330.9000 0.4637 331.0980 0.4637 331.2000 0.5412 331.3980 0.5412 331.5000 0.5887 331.6980 0.5887 331.8000 0.5985 331.9980 0.5985 332.1000 0.5033 332.2980 0.5033 332.4000 0.5913 332.5980 0.5913 332.7000 0.6190 332.8980 0.6190 333.0000 0.5692 333.1980 0.5692 333.3000 0.5961 333.4980 0.5961 333.6000 0.6150 333.7980 0.6150 333.9000 0.5696 334.0980 0.5696 334.2000 0.6065 334.3980 0.6065 334.5000 0.6194 334.6980 0.6194 334.8000 0.5673 334.9980 0.5673 335.1000 0.6056 335.2980 0.6056 335.4000 0.5477 335.5980 0.5477 335.7000 0.5860 335.8980 0.5860 336.0000 0.5723 336.1980 0.5723 336.3000 0.6247 336.4980 0.6247 336.6000 0.5668 336.7980 0.5668 336.9000 0.5998 337.0980 0.5998 337.2000 0.5790 337.3980 0.5790 337.5000 0.6068 337.6980 0.6068 337.8000 0.5960 337.9980 0.5960 338.1000 0.6236 338.2980 0.6236 338.4000 0.5892 338.5980 0.5892 338.7000 0.6156 338.8980 0.6156 339.0000 0.8958 339.1980 0.8958 339.3000 0.5968 339.4980 0.5968 339.6000 0.9398 339.7980 0.9398 339.9000 0.6004 340.0980 0.6004 340.2000 0.9266 340.3980 0.9266 340.5000 0.5780 340.6980 0.5780 340.8000 0.6548 340.9980 0.6548 341.1000 0.6082 341.2980 0.6082 341.4000 0.5745 341.5980 0.5745 341.7000 0.5786 341.8980 0.5786 342.0000 0.5559 342.1980 0.5559 342.3000 0.6088 342.4980 0.6088 342.6000 0.7140 342.7980 0.7140 342.9000 0.6023 343.0980 0.6023 343.2000 0.5732 343.3980 0.5732 343.5000 0.6057 343.6980 0.6057 343.8000 0.5835 343.9980 0.5835 344.1000 0.8046 344.2980 0.8046 344.4000 0.5708 344.5980 0.5708 344.7000 1.1028 344.8980 1.1028 345.0000 0.6270 345.1980 0.6270 345.3000 1.1020 345.4980 1.1020 345.6000 0.7074 345.7980 0.7074 345.9000 0.4885 346.0980 0.4885 346.2000 0.6113 346.3980 0.6113 346.5000 0.4257 346.6980 0.4257 346.8000 0.3692 346.9980 0.3692 347.1000 0.5334 347.2980 0.5334 347.4000 0.3894 347.5980 0.3894 347.7000 0.5095 347.8980 0.5095 348.0000 0.6189 348.1980 0.6189 348.3000 0.5406 348.4980 0.5406 348.6000 0.5457 348.7980 0.5457 348.9000 0.3702 349.0980 0.3702 349.2000 0.4078 349.3980 0.4078 349.5000 0.4060 349.6980 0.4060 349.8000 0.4588 349.9980 0.4588 350.1000 0.3712 350.2980 0.3712 350.4000 0.4083 350.5980 0.4083 350.7000 0.3994 350.8980 0.3994 351.0000 0.4386 351.1980 0.4386 351.3000 0.4569 351.4980 0.4569 351.6000 0.3840 351.7980 0.3840 351.9000 0.5142 352.0980 0.5142 352.2000 0.4677 352.3980 0.4677 352.5000 0.4637 352.6980 0.4637 352.8000 0.5412 352.9980 0.5412 353.1000 0.5887 353.2980 0.5887 353.4000 0.5985 353.5980 0.5985 353.7000 0.5033 353.8980 0.5033 354.0000 0.5913 354.1980 0.5913 354.3000 0.6190 354.4980 0.6190 354.6000 0.5692 354.7980 0.5692 354.9000 0.5961 355.0980 0.5961 355.2000 0.6150 355.3980 0.6150 355.5000 0.5696 355.6980 0.5696 355.8000 0.6065 355.9980 0.6065 356.1000 0.6194 356.2980 0.6194 356.4000 0.5673 356.5980 0.5673 356.7000 0.6056 356.8980 0.6056 357.0000 0.5477 357.1980 0.5477 357.3000 0.5860 357.4980 0.5860 357.6000 0.5723 357.7980 0.5723 357.9000 0.6247 358.0980 0.6247 358.2000 0.5668 358.3980 0.5668 358.5000 0.5998 358.6980 0.5998 358.8000 0.5790 358.9980 0.5790 359.1000 0.6068 359.2980 0.6068 359.4000 0.5960 359.5980 0.5960 359.7000 0.6236 359.8980 0.6236 360.0000 0.5892 360.1980 0.5892 360.3000 0.6156 360.4980 0.6156 360.6000 0.8958 360.7980 0.8958 360.9000 0.5968 361.0980 0.5968 361.2000 0.9398 361.3980 0.9398 361.5000 0.6004 361.6980 0.6004 361.8000 0.9266 361.9980 0.9266 362.1000 0.5780 362.2980 0.5780 362.4000 0.6548 362.5980 0.6548 362.7000 0.6082 362.8980 0.6082 363.0000 0.5745 363.1980 0.5745 363.3000 0.5786 363.4980 0.5786 363.6000 0.5559 363.7980 0.5559 363.9000 0.6088 364.0980 0.6088 364.2000 0.7140 364.3980 0.7140 364.5000 0.6023 364.6980 0.6023 364.8000 0.5732 364.9980 0.5732 365.1000 0.6057 365.2980 0.6057 365.4000 0.5835 365.5980 0.5835 365.7000 0.8046 365.8980 0.8046 366.0000 0.5708 366.1980 0.5708 366.3000 1.1028 366.4980 1.1028 366.6000 0.6270 366.7980 0.6270 366.9000 1.1020 367.0980 1.1020 367.2000 0.7074 367.3980 0.7074 367.5000 0.4885 367.6980 0.4885 367.8000 0.6113 367.9980 0.6113 368.1000 0.4257 368.2980 0.4257 368.4000 0.3692 368.5980 0.3692 368.7000 0.5334 368.8980 0.5334 369.0000 0.3894 369.1980 0.3894 369.3000 0.5095 369.4980 0.5095 369.6000 0.6189 369.7980 0.6189 369.9000 0.5406 370.0980 0.5406 370.2000 0.5457 370.3980 0.5457 370.5000 0.3702 370.6980 0.3702 370.8000 0.4078 370.9980 0.4078 371.1000 0.4060 371.2980 0.4060 371.4000 0.4588 371.5980 0.4588 371.7000 0.3712 371.8980 0.3712 372.0000 0.4083 372.1980 0.4083 372.3000 0.3994 372.4980 0.3994 372.6000 0.4386 372.7980 0.4386 372.9000 0.4569 373.0980 0.4569 373.2000 0.3840 373.3980 0.3840 373.5000 0.5142 373.6980 0.5142 373.8000 0.4677 373.9980 0.4677 374.1000 0.4637 374.2980 0.4637 374.4000 0.5412 374.5980 0.5412 374.7000 0.5887 374.8980 0.5887 375.0000 0.5985 375.1980 0.5985 375.3000 0.5033 375.4980 0.5033 375.6000 0.5913 375.7980 0.5913 375.9000 0.6190 376.0980 0.6190 376.2000 0.5692 376.3980 0.5692 376.5000 0.5961 376.6980 0.5961 376.8000 0.6150 376.9980 0.6150 377.1000 0.5696 377.2980 0.5696 377.4000 0.6065 377.5980 0.6065 377.7000 0.6194 377.8980 0.6194 378.0000 0.5673 378.1980 0.5673 378.3000 0.6056 378.4980 0.6056 378.6000 0.5477 378.7980 0.5477 378.9000 0.5860 379.0980 0.5860 379.2000 0.5723 379.3980 0.5723 379.5000 0.6247 379.6980 0.6247 379.8000 0.5668 379.9980 0.5668 380.1000 0.5998 380.2980 0.5998 380.4000 0.5790 380.5980 0.5790 380.7000 0.6068 380.8980 0.6068 381.0000 0.5960 381.1980 0.5960 381.3000 0.6236 381.4980 0.6236 381.6000 0.5892 381.7980 0.5892 381.9000 0.6156 382.0980 0.6156 382.2000 0.8958 382.3980 0.8958 382.5000 0.5968 382.6980 0.5968 382.8000 0.9398 382.9980 0.9398 383.1000 0.6004 383.2980 0.6004 383.4000 0.9266 383.5980 0.9266 383.7000 0.5780 383.8980 0.5780 384.0000 0.6548 384.1980 0.6548 384.3000 0.6082 384.4980 0.6082 384.6000 0.5745 384.7980 0.5745 384.9000 0.5786 385.0980 0.5786 385.2000 0.5559 385.3980 0.5559 385.5000 0.6088 385.6980 0.6088 385.8000 0.7140 385.9980 0.7140 386.1000 0.6023 386.2980 0.6023 386.4000 0.5732 386.5980 0.5732 386.7000 0.6057 386.8980 0.6057 387.0000 0.5835 387.1980 0.5835 387.3000 0.8046 387.4980 0.8046 387.6000 0.5708 387.7980 0.5708 387.9000 1.1028 388.0980 1.1028 388.2000 0.6270 388.3980 0.6270 388.5000 1.1020 388.6980 1.1020 388.8000 0.7074 388.9980 0.7074 389.1000 0.4885 389.2980 0.4885 389.4000 0.6113 389.5980 0.6113 389.7000 0.4257 389.8980 0.4257 390.0000 0.3692 390.1980 0.3692 390.3000 0.5334 390.4980 0.5334 390.6000 0.3894 390.7980 0.3894 390.9000 0.5095 391.0980 0.5095 391.2000 0.6189 391.3980 0.6189 391.5000 0.5406 391.6980 0.5406 391.8000 0.5457 391.9980 0.5457 392.1000 0.3702 392.2980 0.3702 392.4000 0.4078 392.5980 0.4078 392.7000 0.4060 392.8980 0.4060 393.0000 0.4588 393.1980 0.4588 393.3000 0.3712 393.4980 0.3712 393.6000 0.4083 393.7980 0.4083 393.9000 0.3994 394.0980 0.3994 394.2000 0.4386 394.3980 0.4386 394.5000 0.4569 394.6980 0.4569 394.8000 0.3840 394.9980 0.3840 395.1000 0.5142 395.2980 0.5142 395.4000 0.4677 395.5980 0.4677 395.7000 0.4637 395.8980 0.4637 396.0000 0.5412 396.1980 0.5412 396.3000 0.5887 396.4980 0.5887 396.6000 0.5985 396.7980 0.5985 396.9000 0.5033 397.0980 0.5033 397.2000 0.5913 397.3980 0.5913 397.5000 0.6190 397.6980 0.6190 397.8000 0.5692 397.9980 0.5692 398.1000 0.5961 398.2980 0.5961 398.4000 0.6150 398.5980 0.6150 398.7000 0.5696 398.8980 0.5696 399.0000 0.6065 399.1980 0.6065 399.3000 0.6194 399.4980 0.6194 399.6000 0.5673 399.7980 0.5673 399.9000 0.6056 400.0980 0.6056 400.2000 0.5477 400.3980 0.5477 400.5000 0.5860 400.6980 0.5860 400.8000 0.5723 400.9980 0.5723 401.1000 0.6247 401.2980 0.6247 401.4000 0.5668 401.5980 0.5668 401.7000 0.5998 401.8980 0.5998 402.0000 0.5790 402.1980 0.5790 402.3000 0.6068 402.4980 0.6068 402.6000 0.5960 402.7980 0.5960 402.9000 0.6236 403.0980 0.6236 403.2000 0.5892 403.3980 0.5892 403.5000 0.6156 403.6980 0.6156 403.8000 0.8958 403.9980 0.8958 404.1000 0.5968 404.2980 0.5968 404.4000 0.9398 404.5980 0.9398 404.7000 0.6004 404.8980 0.6004 405.0000 0.9266 405.1980 0.9266 405.3000 0.5780 405.4980 0.5780 405.6000 0.6548 405.7980 0.6548 405.9000 0.6082 406.0980 0.6082 406.2000 0.5745 406.3980 0.5745 406.5000 0.5786 406.6980 0.5786 406.8000 0.5559 406.9980 0.5559 407.1000 0.6088 407.2980 0.6088 407.4000 0.7140 407.5980 0.7140 407.7000 0.6023 407.8980 0.6023 408.0000 0.5732 408.1980 0.5732 408.3000 0.6057 408.4980 0.6057 408.6000 0.5835 408.7980 0.5835 408.9000 0.8046 409.0980 0.8046 409.2000 0.5708 409.3980 0.5708 409.5000 1.1028 409.6980 1.1028 409.8000 0.6270 409.9980 0.6270 410.1000 1.1020 410.2980 1.1020 410.4000 0.7074 410.5980 0.7074 410.7000 0.4885 410.8980 0.4885 411.0000 0.6113 411.1980 0.6113 411.3000 0.4257 411.4980 0.4257 411.6000 0.3692 411.7980 0.3692 411.9000 0.5334 412.0980 0.5334 412.2000 0.3894 412.3980 0.3894 412.5000 0.5095 412.6980 0.5095 412.8000 0.6189 412.9980 0.6189 413.1000 0.5406 413.2980 0.5406 413.4000 0.5457 413.5980 0.5457 413.7000 0.3702 413.8980 0.3702 414.0000 0.4078 414.1980 0.4078 414.3000 0.4060 414.4980 0.4060 414.6000 0.4588 414.7980 0.4588 414.9000 0.3712 415.0980 0.3712 415.2000 0.4083 415.3980 0.4083 415.5000 0.3994 415.6980 0.3994 415.8000 0.4386 415.9980 0.4386 416.1000 0.4569 416.2980 0.4569 416.4000 0.3840 416.5980 0.3840 416.7000 0.5142 416.8980 0.5142 417.0000 0.4677 417.1980 0.4677 417.3000 0.4637 417.4980 0.4637 417.6000 0.5412 417.7980 0.5412 417.9000 0.5887 418.0980 0.5887 418.2000 0.5985 418.3980 0.5985 418.5000 0.5033 418.6980 0.5033 418.8000 0.5913 418.9980 0.5913 419.1000 0.6190 419.2980 0.6190 419.4000 0.5692 419.5980 0.5692 419.7000 0.5961 419.8980 0.5961 420.0000 0.6150 420.1980 0.6150 420.3000 0.5696 420.4980 0.5696 420.6000 0.6065 420.7980 0.6065 420.9000 0.6194 421.0980 0.6194 421.2000 0.5673 421.3980 0.5673 421.5000 0.6056 421.6980 0.6056 421.8000 0.5477 421.9980 0.5477 422.1000 0.5860 422.2980 0.5860 422.4000 0.5723 422.5980 0.5723 422.7000 0.6247 422.8980 0.6247 423.0000 0.5668 423.1980 0.5668 423.3000 0.5998 423.4980 0.5998 423.6000 0.5790 423.7980 0.5790 423.9000 0.6068 424.0980 0.6068 424.2000 0.5960 424.3980 0.5960 424.5000 0.6236 424.6980 0.6236 424.8000 0.5892 424.9980 0.5892 425.1000 0.6156 425.2980 0.6156 425.4000 0.8958 425.5980 0.8958 425.7000 0.5968 425.8980 0.5968 426.0000 0.9398 426.1980 0.9398 426.3000 0.6004 426.4980 0.6004 426.6000 0.9266 426.7980 0.9266 426.9000 0.5780 427.0980 0.5780 427.2000 0.6548 427.3980 0.6548 427.5000 0.6082 427.6980 0.6082 427.8000 0.5745 427.9980 0.5745 428.1000 0.5786 428.2980 0.5786 428.4000 0.5559 428.5980 0.5559 428.7000 0.6088 428.8980 0.6088 429.0000 0.7140 429.1980 0.7140 429.3000 0.6023 429.4980 0.6023 429.6000 0.5732 429.7980 0.5732 429.9000 0.6057 430.0980 0.6057 430.2000 0.5835 430.3980 0.5835 430.5000 0.8046 430.6980 0.8046 430.8000 0.5708 430.9980 0.5708 431.1000 1.1028 431.2980 1.1028 431.4000 0.6270 431.5980 0.6270 431.7000 1.1020 431.8980 1.1020 432.0000 0.7074 432.1980 0.7074 432.3000 0.4885 432.4980 0.4885 432.6000 0.6113 432.7980 0.6113 432.9000 0.4257 433.0980 0.4257 433.2000 0.3692 433.3980 0.3692 433.5000 0.5334 433.6980 0.5334 433.8000 0.3894 433.9980 0.3894 434.1000 0.5095 434.2980 0.5095 434.4000 0.6189 434.5980 0.6189 434.7000 0.5406 434.8980 0.5406 435.0000 0.5457 435.1980 0.5457 435.3000 0.3702 435.4980 0.3702 435.6000 0.4078 435.7980 0.4078 435.9000 0.4060 436.0980 0.4060 436.2000 0.4588 436.3980 0.4588 436.5000 0.3712 436.6980 0.3712 436.8000 0.4083 436.9980 0.4083 437.1000 0.3994 437.2980 0.3994 437.4000 0.4386 437.5980 0.4386 437.7000 0.4569 437.8980 0.4569 438.0000 0.3840 438.1980 0.3840 438.3000 0.5142 438.4980 0.5142 438.6000 0.4677 438.7980 0.4677 438.9000 0.4637 439.0980 0.4637 439.2000 0.5412 439.3980 0.5412 439.5000 0.5887 439.6980 0.5887 439.8000 0.5985 439.9980 0.5985 440.1000 0.5033 440.2980 0.5033 440.4000 0.5913 440.5980 0.5913 440.7000 0.6190 440.8980 0.6190 441.0000 0.5692 441.1980 0.5692 441.3000 0.5961 441.4980 0.5961 441.6000 0.6150 441.7980 0.6150 441.9000 0.5696 442.0980 0.5696 442.2000 0.6065 442.3980 0.6065 442.5000 0.6194 442.6980 0.6194 442.8000 0.5673 442.9980 0.5673 443.1000 0.6056 443.2980 0.6056 443.4000 0.5477 443.5980 0.5477 443.7000 0.5860 443.8980 0.5860 444.0000 0.5723 444.1980 0.5723 444.3000 0.6247 444.4980 0.6247 444.6000 0.5668 444.7980 0.5668 444.9000 0.5998 445.0980 0.5998 445.2000 0.5790 445.3980 0.5790 445.5000 0.6068 445.6980 0.6068 445.8000 0.5960 445.9980 0.5960 446.1000 0.6236 446.2980 0.6236 446.4000 0.5892 446.5980 0.5892 446.7000 0.6156 446.8980 0.6156 447.0000 0.8958 447.1980 0.8958 447.3000 0.5968 447.4980 0.5968 447.6000 0.9398 447.7980 0.9398 447.9000 0.6004 448.0980 0.6004 448.2000 0.9266 448.3980 0.9266 448.5000 0.5780 448.6980 0.5780 448.8000 0.6548 448.9980 0.6548 449.1000 0.6082 449.2980 0.6082 449.4000 0.5745 449.5980 0.5745 449.7000 0.5786 449.8980 0.5786 450.0000 0.5559 450.1980 0.5559 450.3000 0.6088 450.4980 0.6088 450.6000 0.7140 450.7980 0.7140 450.9000 0.6023 451.0980 0.6023 451.2000 0.5732 451.3980 0.5732 451.5000 0.6057 451.6980 0.6057 451.8000 0.5835 451.9980 0.5835 452.1000 0.8046 452.2980 0.8046 452.4000 0.5708 452.5980 0.5708 452.7000 1.1028 452.8980 1.1028 453.0000 0.6270 453.1980 0.6270 453.3000 1.1020 453.4980 1.1020 453.6000 0.7074 453.7980 0.7074 453.9000 0.4885 454.0980 0.4885 454.2000 0.6113 454.3980 0.6113 454.5000 0.4257 454.6980 0.4257 454.8000 0.3692 454.9980 0.3692 455.1000 0.5334 455.2980 0.5334 455.4000 0.3894 455.5980 0.3894 455.7000 0.5095 455.8980 0.5095 456.0000 0.6189 456.1980 0.6189 456.3000 0.5406 456.4980 0.5406 456.6000 0.5457 456.7980 0.5457 456.9000 0.3702 457.0980 0.3702 457.2000 0.4078 457.3980 0.4078 457.5000 0.4060 457.6980 0.4060 457.8000 0.4588 457.9980 0.4588 458.1000 0.3712 458.2980 0.3712 458.4000 0.4083 458.5980 0.4083 458.7000 0.3994 458.8980 0.3994 459.0000 0.4386 459.1980 0.4386 459.3000 0.4569 459.4980 0.4569 459.6000 0.3840 459.7980 0.3840 459.9000 0.5142 460.0980 0.5142 460.2000 0.4677 460.3980 0.4677 460.5000 0.4637 460.6980 0.4637 460.8000 0.5412 460.9980 0.5412 461.1000 0.5887 461.2980 0.5887 461.4000 0.5985 461.5980 0.5985 461.7000 0.5033 461.8980 0.5033 462.0000 0.5913 462.1980 0.5913 462.3000 0.6190 462.4980 0.6190 462.6000 0.5692 462.7980 0.5692 462.9000 0.5961 463.0980 0.5961 463.2000 0.6150 463.3980 0.6150 463.5000 0.5696 463.6980 0.5696 463.8000 0.6065 463.9980 0.6065 464.1000 0.6194 464.2980 0.6194 464.4000 0.5673 464.5980 0.5673 464.7000 0.6056 464.8980 0.6056 465.0000 0.5477 465.1980 0.5477 465.3000 0.5860 465.4980 0.5860 465.6000 0.5723 465.7980 0.5723 465.9000 0.6247 466.0980 0.6247 466.2000 0.5668 466.3980 0.5668 466.5000 0.5998 466.6980 0.5998 466.8000 0.5790 466.9980 0.5790 467.1000 0.6068 467.2980 0.6068 467.4000 0.5960 467.5980 0.5960 467.7000 0.6236 467.8980 0.6236 468.0000 0.5892 468.1980 0.5892 468.3000 0.6156 468.4980 0.6156 468.6000 0.8958 468.7980 0.8958 468.9000 0.5968 469.0980 0.5968 469.2000 0.9398 469.3980 0.9398 469.5000 0.6004 469.6980 0.6004 469.8000 0.9266 469.9980 0.9266 470.1000 0.5780 470.2980 0.5780 470.4000 0.6548 470.5980 0.6548 470.7000 0.6082 470.8980 0.6082 471.0000 0.5745 471.1980 0.5745 471.3000 0.5786 471.4980 0.5786 471.6000 0.5559 471.7980 0.5559 471.9000 0.6088 472.0980 0.6088 472.2000 0.7140 472.3980 0.7140 472.5000 0.6023 472.6980 0.6023 472.8000 0.5732 472.9980 0.5732 473.1000 0.6057 473.2980 0.6057 473.4000 0.5835 473.5980 0.5835 473.7000 0.8046 473.8980 0.8046 474.0000 0.5708 474.1980 0.5708 474.3000 1.1028 474.4980 1.1028 474.6000 0.6270 474.7980 0.6270 474.9000 1.1020 475.0980 1.1020 475.2000 0.7074 475.3980 0.7074 475.5000 0.4885 475.6980 0.4885 475.8000 0.6113 475.9980 0.6113 476.1000 0.4257 476.2980 0.4257 476.4000 0.3692 476.5980 0.3692 476.7000 0.5334 476.8980 0.5334 477.0000 0.3894 477.1980 0.3894 477.3000 0.5095 477.4980 0.5095 477.6000 0.6189 477.7980 0.6189 477.9000 0.5406 478.0980 0.5406 478.2000 0.5457 478.3980 0.5457 478.5000 0.3702 478.6980 0.3702 478.8000 0.4078 478.9980 0.4078 479.1000 0.4060 479.2980 0.4060 479.4000 0.4588 479.5980 0.4588 479.7000 0.3712 479.8980 0.3712 480.0000 0.4083 480.1980 0.4083 480.3000 0.3994 480.4980 0.3994 480.6000 0.4386 480.7980 0.4386 480.9000 0.4569 481.0980 0.4569 481.2000 0.3840 481.3980 0.3840 481.5000 0.5142 481.6980 0.5142 481.8000 0.4677 481.9980 0.4677 482.1000 0.4637 482.2980 0.4637 482.4000 0.5412 482.5980 0.5412 482.7000 0.5887 482.8980 0.5887 483.0000 0.5985 483.1980 0.5985 483.3000 0.5033 483.4980 0.5033 483.6000 0.5913 483.7980 0.5913 483.9000 0.6190 484.0980 0.6190 484.2000 0.5692 484.3980 0.5692 484.5000 0.5961 484.6980 0.5961 484.8000 0.6150 484.9980 0.6150 485.1000 0.5696 485.2980 0.5696 485.4000 0.6065 485.5980 0.6065 485.7000 0.6194 485.8980 0.6194 486.0000 0.5673 486.1980 0.5673 486.3000 0.6056 486.4980 0.6056 486.6000 0.5477 486.7980 0.5477 486.9000 0.5860 487.0980 0.5860 487.2000 0.5723 487.3980 0.5723 487.5000 0.6247 487.6980 0.6247 487.8000 0.5668 487.9980 0.5668 488.1000 0.5998 488.2980 0.5998 488.4000 0.5790 488.5980 0.5790 488.7000 0.6068 488.8980 0.6068 489.0000 0.5960 489.1980 0.5960 489.3000 0.6236 489.4980 0.6236 489.6000 0.5892 489.7980 0.5892 489.9000 0.6156 490.0980 0.6156 490.2000 0.8958 490.3980 0.8958 490.5000 0.5968 490.6980 0.5968 490.8000 0.9398 490.9980 0.9398 491.1000 0.6004 491.2980 0.6004 491.4000 0.9266 491.5980 0.9266 491.7000 0.5780 491.8980 0.5780 492.0000 0.6548 492.1980 0.6548 492.3000 0.6082 492.4980 0.6082 492.6000 0.5745 492.7980 0.5745 492.9000 0.5786 493.0980 0.5786 493.2000 0.5559 493.3980 0.5559 493.5000 0.6088 493.6980 0.6088 493.8000 0.7140 493.9980 0.7140 494.1000 0.6023 494.2980 0.6023 494.4000 0.5732 494.5980 0.5732 494.7000 0.6057 494.8980 0.6057 495.0000 0.5835 495.1980 0.5835 495.3000 0.8046 495.4980 0.8046 495.6000 0.5708 495.7980 0.5708 495.9000 1.1028 496.0980 1.1028 496.2000 0.6270 496.3980 0.6270 496.5000 1.1020 496.6980 1.1020 496.8000 0.7074 496.9980 0.7074 497.1000 0.4885 497.2980 0.4885 497.4000 0.6113 497.5980 0.6113 497.7000 0.4257 497.8980 0.4257 498.0000 0.3692 498.1980 0.3692 498.3000 0.5334 498.4980 0.5334 498.6000 0.3894 498.7980 0.3894 498.9000 0.5095 499.0980 0.5095 499.2000 0.6189 499.3980 0.6189 499.5000 0.5406 499.6980 0.5406 499.8000 0.5457 499.9980 0.5457 500.1000 0.3702 500.2980 0.3702 500.4000 0.4078 500.5980 0.4078 500.7000 0.4060 500.8980 0.4060 501.0000 0.4588 501.1980 0.4588 501.3000 0.3712 501.4980 0.3712 501.6000 0.4083 501.7980 0.4083 501.9000 0.3994 502.0980 0.3994 502.2000 0.4386 502.3980 0.4386 502.5000 0.4569 502.6980 0.4569 502.8000 0.3840 502.9980 0.3840 503.1000 0.5142 503.2980 0.5142 503.4000 0.4677 503.5980 0.4677 503.7000 0.4637 503.8980 0.4637 504.0000 0.5412 504.1980 0.5412 504.3000 0.5887 504.4980 0.5887 504.6000 0.5985 504.7980 0.5985 504.9000 0.5033 505.0980 0.5033 505.2000 0.5913 505.3980 0.5913 505.5000 0.6190 505.6980 0.6190 505.8000 0.5692 505.9980 0.5692 506.1000 0.5961 506.2980 0.5961 506.4000 0.6150 506.5980 0.6150 506.7000 0.5696 506.8980 0.5696 507.0000 0.6065 507.1980 0.6065 507.3000 0.6194 507.4980 0.6194 507.6000 0.5673 507.7980 0.5673 507.9000 0.6056 508.0980 0.6056 508.2000 0.5477 508.3980 0.5477 508.5000 0.5860 508.6980 0.5860 508.8000 0.5723 508.9980 0.5723 509.1000 0.6247 509.2980 0.6247 509.4000 0.5668 509.5980 0.5668 509.7000 0.5998 509.8980 0.5998 510.0000 0.5790 510.1980 0.5790 510.3000 0.6068 510.4980 0.6068 510.6000 0.5960 510.7980 0.5960 510.9000 0.6236 511.0980 0.6236 511.2000 0.5892 511.3980 0.5892 511.5000 0.6156 511.6980 0.6156 511.8000 0.8958 511.9980 0.8958 512.1000 0.5968 512.2980 0.5968 512.4000 0.9398 512.5980 0.9398 512.7000 0.6004 512.8980 0.6004 513.0000 0.9266 513.1980 0.9266 513.3000 0.5780 513.4980 0.5780 513.6000 0.6548 513.7980 0.6548 513.9000 0.6082 514.0980 0.6082 514.2000 0.5745 514.3980 0.5745 514.5000 0.5786 514.6980 0.5786 514.8000 0.5559 514.9980 0.5559 515.1000 0.6088 515.2980 0.6088 515.4000 0.7140 515.5980 0.7140 515.7000 0.6023 515.8980 0.6023 516.0000 0.5732 516.1980 0.5732 516.3000 0.6057 516.4980 0.6057 516.6000 0.5835 516.7980 0.5835 516.9000 0.8046 517.0980 0.8046 517.2000 0.5708 517.3980 0.5708 517.5000 1.1028 517.6980 1.1028 517.8000 0.6270 517.9980 0.6270 518.1000 1.1020 518.2980 1.1020 518.4000 0.7074 518.5980 0.7074 518.7000 0.4885 518.8980 0.4885 519.0000 0.6113 519.1980 0.6113 519.3000 0.4257 519.4980 0.4257 519.6000 0.3692 519.7980 0.3692 519.9000 0.5334 520.0980 0.5334 520.2000 0.3894 520.3980 0.3894 520.5000 0.5095 520.6980 0.5095 520.8000 0.6189 520.9980 0.6189 521.1000 0.5406 521.2980 0.5406 521.4000 0.5457 521.5980 0.5457 521.7000 0.3702 521.8980 0.3702 522.0000 0.4078 522.1980 0.4078 522.3000 0.4060 522.4980 0.4060 522.6000 0.4588 522.7980 0.4588 522.9000 0.3712 523.0980 0.3712 523.2000 0.4083 523.3980 0.4083 523.5000 0.3994 523.6980 0.3994 523.8000 0.4386 523.9980 0.4386 524.1000 0.4569 524.2980 0.4569 524.4000 0.3840 524.5980 0.3840 524.7000 0.5142 524.8980 0.5142 525.0000 0.4677 525.1980 0.4677 525.3000 0.4637 525.4980 0.4637 525.6000 0.5412 525.7980 0.5412 525.9000 0.5887 526.0980 0.5887 526.2000 0.5985 526.3980 0.5985 526.5000 0.5033 526.6980 0.5033 526.8000 0.5913 526.9980 0.5913 527.1000 0.6190 527.2980 0.6190 527.4000 0.5692 527.5980 0.5692 527.7000 0.5961 527.8980 0.5961 528.0000 0.6150 528.1980 0.6150 528.3000 0.5696 528.4980 0.5696 528.6000 0.6065 528.7980 0.6065 528.9000 0.6194 529.0980 0.6194 529.2000 0.5673 529.3980 0.5673 529.5000 0.6056 529.6980 0.6056 529.8000 0.5477 529.9980 0.5477 530.1000 0.5860 530.2980 0.5860 530.4000 0.5723 530.5980 0.5723 530.7000 0.6247 530.8980 0.6247 531.0000 0.5668 531.1980 0.5668 531.3000 0.5998 531.4980 0.5998 531.6000 0.5790 531.7980 0.5790 531.9000 0.6068 532.0980 0.6068 532.2000 0.5960 532.3980 0.5960 532.5000 0.6236 532.6980 0.6236 532.8000 0.5892 532.9980 0.5892 533.1000 0.6156 533.2980 0.6156 533.4000 0.8958 533.5980 0.8958 533.7000 0.5968 533.8980 0.5968 534.0000 0.9398 534.1980 0.9398 534.3000 0.6004 534.4980 0.6004 534.6000 0.9266 534.7980 0.9266 534.9000 0.5780 535.0980 0.5780 535.2000 0.6548 535.3980 0.6548 535.5000 0.6082 535.6980 0.6082 535.8000 0.5745 535.9980 0.5745 536.1000 0.5786 536.2980 0.5786 536.4000 0.5559 536.5980 0.5559 536.7000 0.6088 536.8980 0.6088 537.0000 0.7140 537.1980 0.7140 537.3000 0.6023 537.4980 0.6023 537.6000 0.5732 537.7980 0.5732 537.9000 0.6057 538.0980 0.6057 538.2000 0.5835 538.3980 0.5835 538.5000 0.8046 538.6980 0.8046 538.8000 0.5708 538.9980 0.5708 539.1000 1.1028 539.2980 1.1028 539.4000 0.6270 539.5980 0.6270 539.7000 1.1020 539.8980 1.1020 540.0000 0.7074 540.1980 0.7074 540.3000 0.4885 540.4980 0.4885 540.6000 0.6113 540.7980 0.6113 540.9000 0.4257 541.0980 0.4257 541.2000 0.3692 541.3980 0.3692 541.5000 0.5334 541.6980 0.5334 541.8000 0.3894 541.9980 0.3894 542.1000 0.5095 542.2980 0.5095 542.4000 0.6189 542.5980 0.6189 542.7000 0.5406 542.8980 0.5406 543.0000 0.5457 543.1980 0.5457 543.3000 0.3702 543.4980 0.3702 543.6000 0.4078 543.7980 0.4078 543.9000 0.4060 544.0980 0.4060 544.2000 0.4588 544.3980 0.4588 544.5000 0.3712 544.6980 0.3712 544.8000 0.4083 544.9980 0.4083 545.1000 0.3994 545.2980 0.3994 545.4000 0.4386 545.5980 0.4386 545.7000 0.4569 545.8980 0.4569 546.0000 0.3840 546.1980 0.3840 546.3000 0.5142 546.4980 0.5142 546.6000 0.4677 546.7980 0.4677 546.9000 0.4637 547.0980 0.4637 547.2000 0.5412 547.3980 0.5412 547.5000 0.5887 547.6980 0.5887 547.8000 0.5985 547.9980 0.5985 548.1000 0.5033 548.2980 0.5033 548.4000 0.5913 548.5980 0.5913 548.7000 0.6190 548.8980 0.6190 549.0000 0.5692 549.1980 0.5692 549.3000 0.5961 549.4980 0.5961 549.6000 0.6150 549.7980 0.6150 549.9000 0.5696 550.0980 0.5696 550.2000 0.6065 550.3980 0.6065 550.5000 0.6194 550.6980 0.6194 550.8000 0.5673 550.9980 0.5673 551.1000 0.6056 551.2980 0.6056 551.4000 0.5477 551.5980 0.5477 551.7000 0.5860 551.8980 0.5860 552.0000 0.5723 552.1980 0.5723 552.3000 0.6247 552.4980 0.6247 552.6000 0.5668 552.7980 0.5668 552.9000 0.5998 553.0980 0.5998 553.2000 0.5790 553.3980 0.5790 553.5000 0.6068 553.6980 0.6068 553.8000 0.5960 553.9980 0.5960 554.1000 0.6236 554.2980 0.6236 554.4000 0.5892 554.5980 0.5892 554.7000 0.6156 554.8980 0.6156 555.0000 0.8958 555.1980 0.8958 555.3000 0.5968 555.4980 0.5968 555.6000 0.9398 555.7980 0.9398 555.9000 0.6004 556.0980 0.6004 556.2000 0.9266 556.3980 0.9266 556.5000 0.5780 556.6980 0.5780 556.8000 0.6548 556.9980 0.6548 557.1000 0.6082 557.2980 0.6082 557.4000 0.5745 557.5980 0.5745 557.7000 0.5786 557.8980 0.5786 558.0000 0.5559 558.1980 0.5559 558.3000 0.6088 558.4980 0.6088 558.6000 0.7140 558.7980 0.7140 558.9000 0.6023 559.0980 0.6023 559.2000 0.5732 559.3980 0.5732 559.5000 0.6057 559.6980 0.6057 559.8000 0.5835 559.9980 0.5835 560.1000 0.8046 560.2980 0.8046 560.4000 0.5708 560.5980 0.5708 560.7000 1.1028 560.8980 1.1028 561.0000 0.6270 561.1980 0.6270 561.3000 1.1020 561.4980 1.1020 561.6000 0.7074 561.7980 0.7074 561.9000 0.4885 562.0980 0.4885 562.2000 0.6113 562.3980 0.6113 562.5000 0.4257 562.6980 0.4257 562.8000 0.3692 562.9980 0.3692 563.1000 0.5334 563.2980 0.5334 563.4000 0.3894 563.5980 0.3894 563.7000 0.5095 563.8980 0.5095 564.0000 0.6189 564.1980 0.6189 564.3000 0.5406 564.4980 0.5406 564.6000 0.5457 564.7980 0.5457 564.9000 0.3702 565.0980 0.3702 565.2000 0.4078 565.3980 0.4078 565.5000 0.4060 565.6980 0.4060 565.8000 0.4588 565.9980 0.4588 566.1000 0.3712 566.2980 0.3712 566.4000 0.4083 566.5980 0.4083 566.7000 0.3994 566.8980 0.3994 567.0000 0.4386 567.1980 0.4386 567.3000 0.4569 567.4980 0.4569 567.6000 0.3840 567.7980 0.3840 567.9000 0.5142 568.0980 0.5142 568.2000 0.4677 568.3980 0.4677 568.5000 0.4637 568.6980 0.4637 568.8000 0.5412 568.9980 0.5412 569.1000 0.5887 569.2980 0.5887 569.4000 0.5985 569.5980 0.5985 569.7000 0.5033 569.8980 0.5033 570.0000 0.5913 570.1980 0.5913 570.3000 0.6190 570.4980 0.6190 570.6000 0.5692 570.7980 0.5692 570.9000 0.5961 571.0980 0.5961 571.2000 0.6150 571.3980 0.6150 571.5000 0.5696 571.6980 0.5696 571.8000 0.6065 571.9980 0.6065 572.1000 0.6194 572.2980 0.6194 572.4000 0.5673 572.5980 0.5673 572.7000 0.6056 572.8980 0.6056 573.0000 0.5477 573.1980 0.5477 573.3000 0.5860 573.4980 0.5860 573.6000 0.5723 573.7980 0.5723 573.9000 0.6247 574.0980 0.6247 574.2000 0.5668 574.3980 0.5668 574.5000 0.5998 574.6980 0.5998 574.8000 0.5790 574.9980 0.5790 575.1000 0.6068 575.2980 0.6068 575.4000 0.5960 575.5980 0.5960 575.7000 0.6236 575.8980 0.6236 576.0000 0.5892 576.1980 0.5892 576.3000 0.6156 576.4980 0.6156 576.6000 0.8958 576.7980 0.8958 576.9000 0.5968 577.0980 0.5968 577.2000 0.9398 577.3980 0.9398 577.5000 0.6004 577.6980 0.6004 577.8000 0.9266 577.9980 0.9266 578.1000 0.5780 578.2980 0.5780 578.4000 0.6548 578.5980 0.6548 578.7000 0.6082 578.8980 0.6082 579.0000 0.5745 579.1980 0.5745 579.3000 0.5786 579.4980 0.5786 579.6000 0.5559 579.7980 0.5559 579.9000 0.6088 580.0980 0.6088 580.2000 0.7140 580.3980 0.7140 580.5000 0.6023 580.6980 0.6023 580.8000 0.5732 580.9980 0.5732 581.1000 0.6057 581.2980 0.6057 581.4000 0.5835 581.5980 0.5835 581.7000 0.8046 581.8980 0.8046 582.0000 0.5708 582.1980 0.5708 582.3000 1.1028 582.4980 1.1028 582.6000 0.6270 582.7980 0.6270 582.9000 1.1020 583.0980 1.1020 583.2000 0.7074 583.3980 0.7074 583.5000 0.4885 583.6980 0.4885 583.8000 0.6113 583.9980 0.6113 584.1000 0.4257 584.2980 0.4257 584.4000 0.3692 584.5980 0.3692 584.7000 0.5334 584.8980 0.5334 585.0000 0.3894 585.1980 0.3894 585.3000 0.5095 585.4980 0.5095 585.6000 0.6189 585.7980 0.6189 585.9000 0.5406 586.0980 0.5406 586.2000 0.5457 586.3980 0.5457 586.5000 0.3702 586.6980 0.3702 586.8000 0.4078 586.9980 0.4078 587.1000 0.4060 587.2980 0.4060 587.4000 0.4588 587.5980 0.4588 587.7000 0.3712 587.8980 0.3712 588.0000 0.4083 588.1980 0.4083 588.3000 0.3994 588.4980 0.3994 588.6000 0.4386 588.7980 0.4386 588.9000 0.4569 589.0980 0.4569 589.2000 0.3840 589.3980 0.3840 589.5000 0.5142 589.6980 0.5142 589.8000 0.4677 589.9980 0.4677 590.1000 0.4637 590.2980 0.4637 590.4000 0.5412 590.5980 0.5412 590.7000 0.5887 590.8980 0.5887 591.0000 0.5985 591.1980 0.5985 591.3000 0.5033 591.4980 0.5033 591.6000 0.5913 591.7980 0.5913 591.9000 0.6190 592.0980 0.6190 592.2000 0.5692 592.3980 0.5692 592.5000 0.5961 592.6980 0.5961 592.8000 0.6150 592.9980 0.6150 593.1000 0.5696 593.2980 0.5696 593.4000 0.6065 593.5980 0.6065 593.7000 0.6194 593.8980 0.6194 594.0000 0.5673 594.1980 0.5673 594.3000 0.6056 594.4980 0.6056 594.6000 0.5477 594.7980 0.5477 594.9000 0.5860 595.0980 0.5860 595.2000 0.5723 595.3980 0.5723 595.5000 0.6247 595.6980 0.6247 595.8000 0.5668 595.9980 0.5668 596.1000 0.5998 596.2980 0.5998 596.4000 0.5790 596.5980 0.5790 596.7000 0.6068 596.8980 0.6068 597.0000 0.5960 597.1980 0.5960 597.3000 0.6236 597.4980 0.6236 597.6000 0.5892 597.7980 0.5892 597.9000 0.6156 598.0980 0.6156 598.2000 0.8958 598.3980 0.8958 598.5000 0.5968 598.6980 0.5968 598.8000 0.9398 598.9980 0.9398 599.1000 0.6004 599.2980 0.6004 599.4000 0.9266 599.5980 0.9266 599.7000 0.5780 599.8980 0.5780 600.0000 0.5780)
Va5 a5 0 PWL(0.0000 1.6046 0.1980 1.6046 0.3000 1.7000 0.4980 1.7000 0.6000 1.4777 0.7980 1.4777 0.9000 1.6410 1.0980 1.6410 1.2000 1.5713 1.3980 1.5713 1.5000 1.6263 1.6980 1.6263 1.8000 1.5847 1.9980 1.5847 2.1000 0.9412 2.2980 0.9412 2.4000 1.4821 2.5980 1.4821 2.7000 1.6853 2.8980 1.6853 3.0000 1.3267 3.1980 1.3267 3.3000 1.7000 3.4980 1.7000 3.6000 1.4289 3.7980 1.4289 3.9000 1.6885 4.0980 1.6885 4.2000 1.5314 4.3980 1.5314 4.5000 1.4298 4.6980 1.4298 4.8000 1.5272 4.9980 1.5272 5.1000 1.7000 5.2980 1.7000 5.4000 1.6961 5.5980 1.6961 5.7000 1.3377 5.8980 1.3377 6.0000 1.2777 6.1980 1.2777 6.3000 1.4991 6.4980 1.4991 6.6000 1.7000 6.7980 1.7000 6.9000 1.6417 7.0980 1.6417 7.2000 1.1915 7.3980 1.1915 7.5000 1.1005 7.6980 1.1005 7.8000 0.6180 7.9980 0.6180 8.1000 1.0660 8.2980 1.0660 8.4000 0.7378 8.5980 0.7378 8.7000 0.6382 8.8980 0.6382 9.0000 1.0527 9.1980 1.0527 9.3000 0.6596 9.4980 0.6596 9.6000 0.6613 9.7980 0.6613 9.9000 0.9981 10.0980 0.9981 10.2000 1.4257 10.3980 1.4257 10.5000 0.6601 10.6980 0.6601 10.8000 0.8645 10.9980 0.8645 11.1000 0.6407 11.2980 0.6407 11.4000 1.6989 11.5980 1.6989 11.7000 0.7538 11.8980 0.7538 12.0000 1.2474 12.1980 1.2474 12.3000 0.6750 12.4980 0.6750 12.6000 1.2621 12.7980 1.2621 12.9000 0.6567 13.0980 0.6567 13.2000 1.4675 13.3980 1.4675 13.5000 0.6205 13.6980 0.6205 13.8000 0.8425 13.9980 0.8425 14.1000 0.7513 14.2980 0.7513 14.4000 1.7000 14.5980 1.7000 14.7000 1.4349 14.8980 1.4349 15.0000 1.3321 15.1980 1.3321 15.3000 1.7000 15.4980 1.7000 15.6000 1.7000 15.7980 1.7000 15.9000 1.2229 16.0980 1.2229 16.2000 1.5817 16.3980 1.5817 16.5000 1.5788 16.6980 1.5788 16.8000 1.5637 16.9980 1.5637 17.1000 1.4325 17.2980 1.4325 17.4000 1.3749 17.5980 1.3749 17.7000 1.6693 17.8980 1.6693 18.0000 1.2535 18.1980 1.2535 18.3000 0.7481 18.4980 0.7481 18.6000 1.4976 18.7980 1.4976 18.9000 1.4709 19.0980 1.4709 19.2000 1.2411 19.3980 1.2411 19.5000 1.4328 19.6980 1.4328 19.8000 1.5626 19.9980 1.5626 20.1000 1.7000 20.2980 1.7000 20.4000 1.4233 20.5980 1.4233 20.7000 1.7000 20.8980 1.7000 21.0000 1.7000 21.1980 1.7000 21.3000 1.5984 21.4980 1.5984 21.6000 1.6046 21.7980 1.6046 21.9000 1.7000 22.0980 1.7000 22.2000 1.4777 22.3980 1.4777 22.5000 1.6410 22.6980 1.6410 22.8000 1.5713 22.9980 1.5713 23.1000 1.6263 23.2980 1.6263 23.4000 1.5847 23.5980 1.5847 23.7000 0.9412 23.8980 0.9412 24.0000 1.4821 24.1980 1.4821 24.3000 1.6853 24.4980 1.6853 24.6000 1.3267 24.7980 1.3267 24.9000 1.7000 25.0980 1.7000 25.2000 1.4289 25.3980 1.4289 25.5000 1.6885 25.6980 1.6885 25.8000 1.5314 25.9980 1.5314 26.1000 1.4298 26.2980 1.4298 26.4000 1.5272 26.5980 1.5272 26.7000 1.7000 26.8980 1.7000 27.0000 1.6961 27.1980 1.6961 27.3000 1.3377 27.4980 1.3377 27.6000 1.2777 27.7980 1.2777 27.9000 1.4991 28.0980 1.4991 28.2000 1.7000 28.3980 1.7000 28.5000 1.6417 28.6980 1.6417 28.8000 1.1915 28.9980 1.1915 29.1000 1.1005 29.2980 1.1005 29.4000 0.6180 29.5980 0.6180 29.7000 1.0660 29.8980 1.0660 30.0000 0.7378 30.1980 0.7378 30.3000 0.6382 30.4980 0.6382 30.6000 1.0527 30.7980 1.0527 30.9000 0.6596 31.0980 0.6596 31.2000 0.6613 31.3980 0.6613 31.5000 0.9981 31.6980 0.9981 31.8000 1.4257 31.9980 1.4257 32.1000 0.6601 32.2980 0.6601 32.4000 0.8645 32.5980 0.8645 32.7000 0.6407 32.8980 0.6407 33.0000 1.6989 33.1980 1.6989 33.3000 0.7538 33.4980 0.7538 33.6000 1.2474 33.7980 1.2474 33.9000 0.6750 34.0980 0.6750 34.2000 1.2621 34.3980 1.2621 34.5000 0.6567 34.6980 0.6567 34.8000 1.4675 34.9980 1.4675 35.1000 0.6205 35.2980 0.6205 35.4000 0.8425 35.5980 0.8425 35.7000 0.7513 35.8980 0.7513 36.0000 1.7000 36.1980 1.7000 36.3000 1.4349 36.4980 1.4349 36.6000 1.3321 36.7980 1.3321 36.9000 1.7000 37.0980 1.7000 37.2000 1.7000 37.3980 1.7000 37.5000 1.2229 37.6980 1.2229 37.8000 1.5817 37.9980 1.5817 38.1000 1.5788 38.2980 1.5788 38.4000 1.5637 38.5980 1.5637 38.7000 1.4325 38.8980 1.4325 39.0000 1.3749 39.1980 1.3749 39.3000 1.6693 39.4980 1.6693 39.6000 1.2535 39.7980 1.2535 39.9000 0.7481 40.0980 0.7481 40.2000 1.4976 40.3980 1.4976 40.5000 1.4709 40.6980 1.4709 40.8000 1.2411 40.9980 1.2411 41.1000 1.4328 41.2980 1.4328 41.4000 1.5626 41.5980 1.5626 41.7000 1.7000 41.8980 1.7000 42.0000 1.4233 42.1980 1.4233 42.3000 1.7000 42.4980 1.7000 42.6000 1.7000 42.7980 1.7000 42.9000 1.5984 43.0980 1.5984 43.2000 1.6046 43.3980 1.6046 43.5000 1.7000 43.6980 1.7000 43.8000 1.4777 43.9980 1.4777 44.1000 1.6410 44.2980 1.6410 44.4000 1.5713 44.5980 1.5713 44.7000 1.6263 44.8980 1.6263 45.0000 1.5847 45.1980 1.5847 45.3000 0.9412 45.4980 0.9412 45.6000 1.4821 45.7980 1.4821 45.9000 1.6853 46.0980 1.6853 46.2000 1.3267 46.3980 1.3267 46.5000 1.7000 46.6980 1.7000 46.8000 1.4289 46.9980 1.4289 47.1000 1.6885 47.2980 1.6885 47.4000 1.5314 47.5980 1.5314 47.7000 1.4298 47.8980 1.4298 48.0000 1.5272 48.1980 1.5272 48.3000 1.7000 48.4980 1.7000 48.6000 1.6961 48.7980 1.6961 48.9000 1.3377 49.0980 1.3377 49.2000 1.2777 49.3980 1.2777 49.5000 1.4991 49.6980 1.4991 49.8000 1.7000 49.9980 1.7000 50.1000 1.6417 50.2980 1.6417 50.4000 1.1915 50.5980 1.1915 50.7000 1.1005 50.8980 1.1005 51.0000 0.6180 51.1980 0.6180 51.3000 1.0660 51.4980 1.0660 51.6000 0.7378 51.7980 0.7378 51.9000 0.6382 52.0980 0.6382 52.2000 1.0527 52.3980 1.0527 52.5000 0.6596 52.6980 0.6596 52.8000 0.6613 52.9980 0.6613 53.1000 0.9981 53.2980 0.9981 53.4000 1.4257 53.5980 1.4257 53.7000 0.6601 53.8980 0.6601 54.0000 0.8645 54.1980 0.8645 54.3000 0.6407 54.4980 0.6407 54.6000 1.6989 54.7980 1.6989 54.9000 0.7538 55.0980 0.7538 55.2000 1.2474 55.3980 1.2474 55.5000 0.6750 55.6980 0.6750 55.8000 1.2621 55.9980 1.2621 56.1000 0.6567 56.2980 0.6567 56.4000 1.4675 56.5980 1.4675 56.7000 0.6205 56.8980 0.6205 57.0000 0.8425 57.1980 0.8425 57.3000 0.7513 57.4980 0.7513 57.6000 1.7000 57.7980 1.7000 57.9000 1.4349 58.0980 1.4349 58.2000 1.3321 58.3980 1.3321 58.5000 1.7000 58.6980 1.7000 58.8000 1.7000 58.9980 1.7000 59.1000 1.2229 59.2980 1.2229 59.4000 1.5817 59.5980 1.5817 59.7000 1.5788 59.8980 1.5788 60.0000 1.5637 60.1980 1.5637 60.3000 1.4325 60.4980 1.4325 60.6000 1.3749 60.7980 1.3749 60.9000 1.6693 61.0980 1.6693 61.2000 1.2535 61.3980 1.2535 61.5000 0.7481 61.6980 0.7481 61.8000 1.4976 61.9980 1.4976 62.1000 1.4709 62.2980 1.4709 62.4000 1.2411 62.5980 1.2411 62.7000 1.4328 62.8980 1.4328 63.0000 1.5626 63.1980 1.5626 63.3000 1.7000 63.4980 1.7000 63.6000 1.4233 63.7980 1.4233 63.9000 1.7000 64.0980 1.7000 64.2000 1.7000 64.3980 1.7000 64.5000 1.5984 64.6980 1.5984 64.8000 1.6046 64.9980 1.6046 65.1000 1.7000 65.2980 1.7000 65.4000 1.4777 65.5980 1.4777 65.7000 1.6410 65.8980 1.6410 66.0000 1.5713 66.1980 1.5713 66.3000 1.6263 66.4980 1.6263 66.6000 1.5847 66.7980 1.5847 66.9000 0.9412 67.0980 0.9412 67.2000 1.4821 67.3980 1.4821 67.5000 1.6853 67.6980 1.6853 67.8000 1.3267 67.9980 1.3267 68.1000 1.7000 68.2980 1.7000 68.4000 1.4289 68.5980 1.4289 68.7000 1.6885 68.8980 1.6885 69.0000 1.5314 69.1980 1.5314 69.3000 1.4298 69.4980 1.4298 69.6000 1.5272 69.7980 1.5272 69.9000 1.7000 70.0980 1.7000 70.2000 1.6961 70.3980 1.6961 70.5000 1.3377 70.6980 1.3377 70.8000 1.2777 70.9980 1.2777 71.1000 1.4991 71.2980 1.4991 71.4000 1.7000 71.5980 1.7000 71.7000 1.6417 71.8980 1.6417 72.0000 1.1915 72.1980 1.1915 72.3000 1.1005 72.4980 1.1005 72.6000 0.6180 72.7980 0.6180 72.9000 1.0660 73.0980 1.0660 73.2000 0.7378 73.3980 0.7378 73.5000 0.6382 73.6980 0.6382 73.8000 1.0527 73.9980 1.0527 74.1000 0.6596 74.2980 0.6596 74.4000 0.6613 74.5980 0.6613 74.7000 0.9981 74.8980 0.9981 75.0000 1.4257 75.1980 1.4257 75.3000 0.6601 75.4980 0.6601 75.6000 0.8645 75.7980 0.8645 75.9000 0.6407 76.0980 0.6407 76.2000 1.6989 76.3980 1.6989 76.5000 0.7538 76.6980 0.7538 76.8000 1.2474 76.9980 1.2474 77.1000 0.6750 77.2980 0.6750 77.4000 1.2621 77.5980 1.2621 77.7000 0.6567 77.8980 0.6567 78.0000 1.4675 78.1980 1.4675 78.3000 0.6205 78.4980 0.6205 78.6000 0.8425 78.7980 0.8425 78.9000 0.7513 79.0980 0.7513 79.2000 1.7000 79.3980 1.7000 79.5000 1.4349 79.6980 1.4349 79.8000 1.3321 79.9980 1.3321 80.1000 1.7000 80.2980 1.7000 80.4000 1.7000 80.5980 1.7000 80.7000 1.2229 80.8980 1.2229 81.0000 1.5817 81.1980 1.5817 81.3000 1.5788 81.4980 1.5788 81.6000 1.5637 81.7980 1.5637 81.9000 1.4325 82.0980 1.4325 82.2000 1.3749 82.3980 1.3749 82.5000 1.6693 82.6980 1.6693 82.8000 1.2535 82.9980 1.2535 83.1000 0.7481 83.2980 0.7481 83.4000 1.4976 83.5980 1.4976 83.7000 1.4709 83.8980 1.4709 84.0000 1.2411 84.1980 1.2411 84.3000 1.4328 84.4980 1.4328 84.6000 1.5626 84.7980 1.5626 84.9000 1.7000 85.0980 1.7000 85.2000 1.4233 85.3980 1.4233 85.5000 1.7000 85.6980 1.7000 85.8000 1.7000 85.9980 1.7000 86.1000 1.5984 86.2980 1.5984 86.4000 1.6046 86.5980 1.6046 86.7000 1.7000 86.8980 1.7000 87.0000 1.4777 87.1980 1.4777 87.3000 1.6410 87.4980 1.6410 87.6000 1.5713 87.7980 1.5713 87.9000 1.6263 88.0980 1.6263 88.2000 1.5847 88.3980 1.5847 88.5000 0.9412 88.6980 0.9412 88.8000 1.4821 88.9980 1.4821 89.1000 1.6853 89.2980 1.6853 89.4000 1.3267 89.5980 1.3267 89.7000 1.7000 89.8980 1.7000 90.0000 1.4289 90.1980 1.4289 90.3000 1.6885 90.4980 1.6885 90.6000 1.5314 90.7980 1.5314 90.9000 1.4298 91.0980 1.4298 91.2000 1.5272 91.3980 1.5272 91.5000 1.7000 91.6980 1.7000 91.8000 1.6961 91.9980 1.6961 92.1000 1.3377 92.2980 1.3377 92.4000 1.2777 92.5980 1.2777 92.7000 1.4991 92.8980 1.4991 93.0000 1.7000 93.1980 1.7000 93.3000 1.6417 93.4980 1.6417 93.6000 1.1915 93.7980 1.1915 93.9000 1.1005 94.0980 1.1005 94.2000 0.6180 94.3980 0.6180 94.5000 1.0660 94.6980 1.0660 94.8000 0.7378 94.9980 0.7378 95.1000 0.6382 95.2980 0.6382 95.4000 1.0527 95.5980 1.0527 95.7000 0.6596 95.8980 0.6596 96.0000 0.6613 96.1980 0.6613 96.3000 0.9981 96.4980 0.9981 96.6000 1.4257 96.7980 1.4257 96.9000 0.6601 97.0980 0.6601 97.2000 0.8645 97.3980 0.8645 97.5000 0.6407 97.6980 0.6407 97.8000 1.6989 97.9980 1.6989 98.1000 0.7538 98.2980 0.7538 98.4000 1.2474 98.5980 1.2474 98.7000 0.6750 98.8980 0.6750 99.0000 1.2621 99.1980 1.2621 99.3000 0.6567 99.4980 0.6567 99.6000 1.4675 99.7980 1.4675 99.9000 0.6205 100.0980 0.6205 100.2000 0.8425 100.3980 0.8425 100.5000 0.7513 100.6980 0.7513 100.8000 1.7000 100.9980 1.7000 101.1000 1.4349 101.2980 1.4349 101.4000 1.3321 101.5980 1.3321 101.7000 1.7000 101.8980 1.7000 102.0000 1.7000 102.1980 1.7000 102.3000 1.2229 102.4980 1.2229 102.6000 1.5817 102.7980 1.5817 102.9000 1.5788 103.0980 1.5788 103.2000 1.5637 103.3980 1.5637 103.5000 1.4325 103.6980 1.4325 103.8000 1.3749 103.9980 1.3749 104.1000 1.6693 104.2980 1.6693 104.4000 1.2535 104.5980 1.2535 104.7000 0.7481 104.8980 0.7481 105.0000 1.4976 105.1980 1.4976 105.3000 1.4709 105.4980 1.4709 105.6000 1.2411 105.7980 1.2411 105.9000 1.4328 106.0980 1.4328 106.2000 1.5626 106.3980 1.5626 106.5000 1.7000 106.6980 1.7000 106.8000 1.4233 106.9980 1.4233 107.1000 1.7000 107.2980 1.7000 107.4000 1.7000 107.5980 1.7000 107.7000 1.5984 107.8980 1.5984 108.0000 1.6046 108.1980 1.6046 108.3000 1.7000 108.4980 1.7000 108.6000 1.4777 108.7980 1.4777 108.9000 1.6410 109.0980 1.6410 109.2000 1.5713 109.3980 1.5713 109.5000 1.6263 109.6980 1.6263 109.8000 1.5847 109.9980 1.5847 110.1000 0.9412 110.2980 0.9412 110.4000 1.4821 110.5980 1.4821 110.7000 1.6853 110.8980 1.6853 111.0000 1.3267 111.1980 1.3267 111.3000 1.7000 111.4980 1.7000 111.6000 1.4289 111.7980 1.4289 111.9000 1.6885 112.0980 1.6885 112.2000 1.5314 112.3980 1.5314 112.5000 1.4298 112.6980 1.4298 112.8000 1.5272 112.9980 1.5272 113.1000 1.7000 113.2980 1.7000 113.4000 1.6961 113.5980 1.6961 113.7000 1.3377 113.8980 1.3377 114.0000 1.2777 114.1980 1.2777 114.3000 1.4991 114.4980 1.4991 114.6000 1.7000 114.7980 1.7000 114.9000 1.6417 115.0980 1.6417 115.2000 1.1915 115.3980 1.1915 115.5000 1.1005 115.6980 1.1005 115.8000 0.6180 115.9980 0.6180 116.1000 1.0660 116.2980 1.0660 116.4000 0.7378 116.5980 0.7378 116.7000 0.6382 116.8980 0.6382 117.0000 1.0527 117.1980 1.0527 117.3000 0.6596 117.4980 0.6596 117.6000 0.6613 117.7980 0.6613 117.9000 0.9981 118.0980 0.9981 118.2000 1.4257 118.3980 1.4257 118.5000 0.6601 118.6980 0.6601 118.8000 0.8645 118.9980 0.8645 119.1000 0.6407 119.2980 0.6407 119.4000 1.6989 119.5980 1.6989 119.7000 0.7538 119.8980 0.7538 120.0000 1.2474 120.1980 1.2474 120.3000 0.6750 120.4980 0.6750 120.6000 1.2621 120.7980 1.2621 120.9000 0.6567 121.0980 0.6567 121.2000 1.4675 121.3980 1.4675 121.5000 0.6205 121.6980 0.6205 121.8000 0.8425 121.9980 0.8425 122.1000 0.7513 122.2980 0.7513 122.4000 1.7000 122.5980 1.7000 122.7000 1.4349 122.8980 1.4349 123.0000 1.3321 123.1980 1.3321 123.3000 1.7000 123.4980 1.7000 123.6000 1.7000 123.7980 1.7000 123.9000 1.2229 124.0980 1.2229 124.2000 1.5817 124.3980 1.5817 124.5000 1.5788 124.6980 1.5788 124.8000 1.5637 124.9980 1.5637 125.1000 1.4325 125.2980 1.4325 125.4000 1.3749 125.5980 1.3749 125.7000 1.6693 125.8980 1.6693 126.0000 1.2535 126.1980 1.2535 126.3000 0.7481 126.4980 0.7481 126.6000 1.4976 126.7980 1.4976 126.9000 1.4709 127.0980 1.4709 127.2000 1.2411 127.3980 1.2411 127.5000 1.4328 127.6980 1.4328 127.8000 1.5626 127.9980 1.5626 128.1000 1.7000 128.2980 1.7000 128.4000 1.4233 128.5980 1.4233 128.7000 1.7000 128.8980 1.7000 129.0000 1.7000 129.1980 1.7000 129.3000 1.5984 129.4980 1.5984 129.6000 1.6046 129.7980 1.6046 129.9000 1.7000 130.0980 1.7000 130.2000 1.4777 130.3980 1.4777 130.5000 1.6410 130.6980 1.6410 130.8000 1.5713 130.9980 1.5713 131.1000 1.6263 131.2980 1.6263 131.4000 1.5847 131.5980 1.5847 131.7000 0.9412 131.8980 0.9412 132.0000 1.4821 132.1980 1.4821 132.3000 1.6853 132.4980 1.6853 132.6000 1.3267 132.7980 1.3267 132.9000 1.7000 133.0980 1.7000 133.2000 1.4289 133.3980 1.4289 133.5000 1.6885 133.6980 1.6885 133.8000 1.5314 133.9980 1.5314 134.1000 1.4298 134.2980 1.4298 134.4000 1.5272 134.5980 1.5272 134.7000 1.7000 134.8980 1.7000 135.0000 1.6961 135.1980 1.6961 135.3000 1.3377 135.4980 1.3377 135.6000 1.2777 135.7980 1.2777 135.9000 1.4991 136.0980 1.4991 136.2000 1.7000 136.3980 1.7000 136.5000 1.6417 136.6980 1.6417 136.8000 1.1915 136.9980 1.1915 137.1000 1.1005 137.2980 1.1005 137.4000 0.6180 137.5980 0.6180 137.7000 1.0660 137.8980 1.0660 138.0000 0.7378 138.1980 0.7378 138.3000 0.6382 138.4980 0.6382 138.6000 1.0527 138.7980 1.0527 138.9000 0.6596 139.0980 0.6596 139.2000 0.6613 139.3980 0.6613 139.5000 0.9981 139.6980 0.9981 139.8000 1.4257 139.9980 1.4257 140.1000 0.6601 140.2980 0.6601 140.4000 0.8645 140.5980 0.8645 140.7000 0.6407 140.8980 0.6407 141.0000 1.6989 141.1980 1.6989 141.3000 0.7538 141.4980 0.7538 141.6000 1.2474 141.7980 1.2474 141.9000 0.6750 142.0980 0.6750 142.2000 1.2621 142.3980 1.2621 142.5000 0.6567 142.6980 0.6567 142.8000 1.4675 142.9980 1.4675 143.1000 0.6205 143.2980 0.6205 143.4000 0.8425 143.5980 0.8425 143.7000 0.7513 143.8980 0.7513 144.0000 1.7000 144.1980 1.7000 144.3000 1.4349 144.4980 1.4349 144.6000 1.3321 144.7980 1.3321 144.9000 1.7000 145.0980 1.7000 145.2000 1.7000 145.3980 1.7000 145.5000 1.2229 145.6980 1.2229 145.8000 1.5817 145.9980 1.5817 146.1000 1.5788 146.2980 1.5788 146.4000 1.5637 146.5980 1.5637 146.7000 1.4325 146.8980 1.4325 147.0000 1.3749 147.1980 1.3749 147.3000 1.6693 147.4980 1.6693 147.6000 1.2535 147.7980 1.2535 147.9000 0.7481 148.0980 0.7481 148.2000 1.4976 148.3980 1.4976 148.5000 1.4709 148.6980 1.4709 148.8000 1.2411 148.9980 1.2411 149.1000 1.4328 149.2980 1.4328 149.4000 1.5626 149.5980 1.5626 149.7000 1.7000 149.8980 1.7000 150.0000 1.4233 150.1980 1.4233 150.3000 1.7000 150.4980 1.7000 150.6000 1.7000 150.7980 1.7000 150.9000 1.5984 151.0980 1.5984 151.2000 1.6046 151.3980 1.6046 151.5000 1.7000 151.6980 1.7000 151.8000 1.4777 151.9980 1.4777 152.1000 1.6410 152.2980 1.6410 152.4000 1.5713 152.5980 1.5713 152.7000 1.6263 152.8980 1.6263 153.0000 1.5847 153.1980 1.5847 153.3000 0.9412 153.4980 0.9412 153.6000 1.4821 153.7980 1.4821 153.9000 1.6853 154.0980 1.6853 154.2000 1.3267 154.3980 1.3267 154.5000 1.7000 154.6980 1.7000 154.8000 1.4289 154.9980 1.4289 155.1000 1.6885 155.2980 1.6885 155.4000 1.5314 155.5980 1.5314 155.7000 1.4298 155.8980 1.4298 156.0000 1.5272 156.1980 1.5272 156.3000 1.7000 156.4980 1.7000 156.6000 1.6961 156.7980 1.6961 156.9000 1.3377 157.0980 1.3377 157.2000 1.2777 157.3980 1.2777 157.5000 1.4991 157.6980 1.4991 157.8000 1.7000 157.9980 1.7000 158.1000 1.6417 158.2980 1.6417 158.4000 1.1915 158.5980 1.1915 158.7000 1.1005 158.8980 1.1005 159.0000 0.6180 159.1980 0.6180 159.3000 1.0660 159.4980 1.0660 159.6000 0.7378 159.7980 0.7378 159.9000 0.6382 160.0980 0.6382 160.2000 1.0527 160.3980 1.0527 160.5000 0.6596 160.6980 0.6596 160.8000 0.6613 160.9980 0.6613 161.1000 0.9981 161.2980 0.9981 161.4000 1.4257 161.5980 1.4257 161.7000 0.6601 161.8980 0.6601 162.0000 0.8645 162.1980 0.8645 162.3000 0.6407 162.4980 0.6407 162.6000 1.6989 162.7980 1.6989 162.9000 0.7538 163.0980 0.7538 163.2000 1.2474 163.3980 1.2474 163.5000 0.6750 163.6980 0.6750 163.8000 1.2621 163.9980 1.2621 164.1000 0.6567 164.2980 0.6567 164.4000 1.4675 164.5980 1.4675 164.7000 0.6205 164.8980 0.6205 165.0000 0.8425 165.1980 0.8425 165.3000 0.7513 165.4980 0.7513 165.6000 1.7000 165.7980 1.7000 165.9000 1.4349 166.0980 1.4349 166.2000 1.3321 166.3980 1.3321 166.5000 1.7000 166.6980 1.7000 166.8000 1.7000 166.9980 1.7000 167.1000 1.2229 167.2980 1.2229 167.4000 1.5817 167.5980 1.5817 167.7000 1.5788 167.8980 1.5788 168.0000 1.5637 168.1980 1.5637 168.3000 1.4325 168.4980 1.4325 168.6000 1.3749 168.7980 1.3749 168.9000 1.6693 169.0980 1.6693 169.2000 1.2535 169.3980 1.2535 169.5000 0.7481 169.6980 0.7481 169.8000 1.4976 169.9980 1.4976 170.1000 1.4709 170.2980 1.4709 170.4000 1.2411 170.5980 1.2411 170.7000 1.4328 170.8980 1.4328 171.0000 1.5626 171.1980 1.5626 171.3000 1.7000 171.4980 1.7000 171.6000 1.4233 171.7980 1.4233 171.9000 1.7000 172.0980 1.7000 172.2000 1.7000 172.3980 1.7000 172.5000 1.5984 172.6980 1.5984 172.8000 1.6046 172.9980 1.6046 173.1000 1.7000 173.2980 1.7000 173.4000 1.4777 173.5980 1.4777 173.7000 1.6410 173.8980 1.6410 174.0000 1.5713 174.1980 1.5713 174.3000 1.6263 174.4980 1.6263 174.6000 1.5847 174.7980 1.5847 174.9000 0.9412 175.0980 0.9412 175.2000 1.4821 175.3980 1.4821 175.5000 1.6853 175.6980 1.6853 175.8000 1.3267 175.9980 1.3267 176.1000 1.7000 176.2980 1.7000 176.4000 1.4289 176.5980 1.4289 176.7000 1.6885 176.8980 1.6885 177.0000 1.5314 177.1980 1.5314 177.3000 1.4298 177.4980 1.4298 177.6000 1.5272 177.7980 1.5272 177.9000 1.7000 178.0980 1.7000 178.2000 1.6961 178.3980 1.6961 178.5000 1.3377 178.6980 1.3377 178.8000 1.2777 178.9980 1.2777 179.1000 1.4991 179.2980 1.4991 179.4000 1.7000 179.5980 1.7000 179.7000 1.6417 179.8980 1.6417 180.0000 1.1915 180.1980 1.1915 180.3000 1.1005 180.4980 1.1005 180.6000 0.6180 180.7980 0.6180 180.9000 1.0660 181.0980 1.0660 181.2000 0.7378 181.3980 0.7378 181.5000 0.6382 181.6980 0.6382 181.8000 1.0527 181.9980 1.0527 182.1000 0.6596 182.2980 0.6596 182.4000 0.6613 182.5980 0.6613 182.7000 0.9981 182.8980 0.9981 183.0000 1.4257 183.1980 1.4257 183.3000 0.6601 183.4980 0.6601 183.6000 0.8645 183.7980 0.8645 183.9000 0.6407 184.0980 0.6407 184.2000 1.6989 184.3980 1.6989 184.5000 0.7538 184.6980 0.7538 184.8000 1.2474 184.9980 1.2474 185.1000 0.6750 185.2980 0.6750 185.4000 1.2621 185.5980 1.2621 185.7000 0.6567 185.8980 0.6567 186.0000 1.4675 186.1980 1.4675 186.3000 0.6205 186.4980 0.6205 186.6000 0.8425 186.7980 0.8425 186.9000 0.7513 187.0980 0.7513 187.2000 1.7000 187.3980 1.7000 187.5000 1.4349 187.6980 1.4349 187.8000 1.3321 187.9980 1.3321 188.1000 1.7000 188.2980 1.7000 188.4000 1.7000 188.5980 1.7000 188.7000 1.2229 188.8980 1.2229 189.0000 1.5817 189.1980 1.5817 189.3000 1.5788 189.4980 1.5788 189.6000 1.5637 189.7980 1.5637 189.9000 1.4325 190.0980 1.4325 190.2000 1.3749 190.3980 1.3749 190.5000 1.6693 190.6980 1.6693 190.8000 1.2535 190.9980 1.2535 191.1000 0.7481 191.2980 0.7481 191.4000 1.4976 191.5980 1.4976 191.7000 1.4709 191.8980 1.4709 192.0000 1.2411 192.1980 1.2411 192.3000 1.4328 192.4980 1.4328 192.6000 1.5626 192.7980 1.5626 192.9000 1.7000 193.0980 1.7000 193.2000 1.4233 193.3980 1.4233 193.5000 1.7000 193.6980 1.7000 193.8000 1.7000 193.9980 1.7000 194.1000 1.5984 194.2980 1.5984 194.4000 1.6046 194.5980 1.6046 194.7000 1.7000 194.8980 1.7000 195.0000 1.4777 195.1980 1.4777 195.3000 1.6410 195.4980 1.6410 195.6000 1.5713 195.7980 1.5713 195.9000 1.6263 196.0980 1.6263 196.2000 1.5847 196.3980 1.5847 196.5000 0.9412 196.6980 0.9412 196.8000 1.4821 196.9980 1.4821 197.1000 1.6853 197.2980 1.6853 197.4000 1.3267 197.5980 1.3267 197.7000 1.7000 197.8980 1.7000 198.0000 1.4289 198.1980 1.4289 198.3000 1.6885 198.4980 1.6885 198.6000 1.5314 198.7980 1.5314 198.9000 1.4298 199.0980 1.4298 199.2000 1.5272 199.3980 1.5272 199.5000 1.7000 199.6980 1.7000 199.8000 1.6961 199.9980 1.6961 200.1000 1.3377 200.2980 1.3377 200.4000 1.2777 200.5980 1.2777 200.7000 1.4991 200.8980 1.4991 201.0000 1.7000 201.1980 1.7000 201.3000 1.6417 201.4980 1.6417 201.6000 1.1915 201.7980 1.1915 201.9000 1.1005 202.0980 1.1005 202.2000 0.6180 202.3980 0.6180 202.5000 1.0660 202.6980 1.0660 202.8000 0.7378 202.9980 0.7378 203.1000 0.6382 203.2980 0.6382 203.4000 1.0527 203.5980 1.0527 203.7000 0.6596 203.8980 0.6596 204.0000 0.6613 204.1980 0.6613 204.3000 0.9981 204.4980 0.9981 204.6000 1.4257 204.7980 1.4257 204.9000 0.6601 205.0980 0.6601 205.2000 0.8645 205.3980 0.8645 205.5000 0.6407 205.6980 0.6407 205.8000 1.6989 205.9980 1.6989 206.1000 0.7538 206.2980 0.7538 206.4000 1.2474 206.5980 1.2474 206.7000 0.6750 206.8980 0.6750 207.0000 1.2621 207.1980 1.2621 207.3000 0.6567 207.4980 0.6567 207.6000 1.4675 207.7980 1.4675 207.9000 0.6205 208.0980 0.6205 208.2000 0.8425 208.3980 0.8425 208.5000 0.7513 208.6980 0.7513 208.8000 1.7000 208.9980 1.7000 209.1000 1.4349 209.2980 1.4349 209.4000 1.3321 209.5980 1.3321 209.7000 1.7000 209.8980 1.7000 210.0000 1.7000 210.1980 1.7000 210.3000 1.2229 210.4980 1.2229 210.6000 1.5817 210.7980 1.5817 210.9000 1.5788 211.0980 1.5788 211.2000 1.5637 211.3980 1.5637 211.5000 1.4325 211.6980 1.4325 211.8000 1.3749 211.9980 1.3749 212.1000 1.6693 212.2980 1.6693 212.4000 1.2535 212.5980 1.2535 212.7000 0.7481 212.8980 0.7481 213.0000 1.4976 213.1980 1.4976 213.3000 1.4709 213.4980 1.4709 213.6000 1.2411 213.7980 1.2411 213.9000 1.4328 214.0980 1.4328 214.2000 1.5626 214.3980 1.5626 214.5000 1.7000 214.6980 1.7000 214.8000 1.4233 214.9980 1.4233 215.1000 1.7000 215.2980 1.7000 215.4000 1.7000 215.5980 1.7000 215.7000 1.5984 215.8980 1.5984 216.0000 1.6046 216.1980 1.6046 216.3000 1.7000 216.4980 1.7000 216.6000 1.4777 216.7980 1.4777 216.9000 1.6410 217.0980 1.6410 217.2000 1.5713 217.3980 1.5713 217.5000 1.6263 217.6980 1.6263 217.8000 1.5847 217.9980 1.5847 218.1000 0.9412 218.2980 0.9412 218.4000 1.4821 218.5980 1.4821 218.7000 1.6853 218.8980 1.6853 219.0000 1.3267 219.1980 1.3267 219.3000 1.7000 219.4980 1.7000 219.6000 1.4289 219.7980 1.4289 219.9000 1.6885 220.0980 1.6885 220.2000 1.5314 220.3980 1.5314 220.5000 1.4298 220.6980 1.4298 220.8000 1.5272 220.9980 1.5272 221.1000 1.7000 221.2980 1.7000 221.4000 1.6961 221.5980 1.6961 221.7000 1.3377 221.8980 1.3377 222.0000 1.2777 222.1980 1.2777 222.3000 1.4991 222.4980 1.4991 222.6000 1.7000 222.7980 1.7000 222.9000 1.6417 223.0980 1.6417 223.2000 1.1915 223.3980 1.1915 223.5000 1.1005 223.6980 1.1005 223.8000 0.6180 223.9980 0.6180 224.1000 1.0660 224.2980 1.0660 224.4000 0.7378 224.5980 0.7378 224.7000 0.6382 224.8980 0.6382 225.0000 1.0527 225.1980 1.0527 225.3000 0.6596 225.4980 0.6596 225.6000 0.6613 225.7980 0.6613 225.9000 0.9981 226.0980 0.9981 226.2000 1.4257 226.3980 1.4257 226.5000 0.6601 226.6980 0.6601 226.8000 0.8645 226.9980 0.8645 227.1000 0.6407 227.2980 0.6407 227.4000 1.6989 227.5980 1.6989 227.7000 0.7538 227.8980 0.7538 228.0000 1.2474 228.1980 1.2474 228.3000 0.6750 228.4980 0.6750 228.6000 1.2621 228.7980 1.2621 228.9000 0.6567 229.0980 0.6567 229.2000 1.4675 229.3980 1.4675 229.5000 0.6205 229.6980 0.6205 229.8000 0.8425 229.9980 0.8425 230.1000 0.7513 230.2980 0.7513 230.4000 1.7000 230.5980 1.7000 230.7000 1.4349 230.8980 1.4349 231.0000 1.3321 231.1980 1.3321 231.3000 1.7000 231.4980 1.7000 231.6000 1.7000 231.7980 1.7000 231.9000 1.2229 232.0980 1.2229 232.2000 1.5817 232.3980 1.5817 232.5000 1.5788 232.6980 1.5788 232.8000 1.5637 232.9980 1.5637 233.1000 1.4325 233.2980 1.4325 233.4000 1.3749 233.5980 1.3749 233.7000 1.6693 233.8980 1.6693 234.0000 1.2535 234.1980 1.2535 234.3000 0.7481 234.4980 0.7481 234.6000 1.4976 234.7980 1.4976 234.9000 1.4709 235.0980 1.4709 235.2000 1.2411 235.3980 1.2411 235.5000 1.4328 235.6980 1.4328 235.8000 1.5626 235.9980 1.5626 236.1000 1.7000 236.2980 1.7000 236.4000 1.4233 236.5980 1.4233 236.7000 1.7000 236.8980 1.7000 237.0000 1.7000 237.1980 1.7000 237.3000 1.5984 237.4980 1.5984 237.6000 1.6046 237.7980 1.6046 237.9000 1.7000 238.0980 1.7000 238.2000 1.4777 238.3980 1.4777 238.5000 1.6410 238.6980 1.6410 238.8000 1.5713 238.9980 1.5713 239.1000 1.6263 239.2980 1.6263 239.4000 1.5847 239.5980 1.5847 239.7000 0.9412 239.8980 0.9412 240.0000 1.4821 240.1980 1.4821 240.3000 1.6853 240.4980 1.6853 240.6000 1.3267 240.7980 1.3267 240.9000 1.7000 241.0980 1.7000 241.2000 1.4289 241.3980 1.4289 241.5000 1.6885 241.6980 1.6885 241.8000 1.5314 241.9980 1.5314 242.1000 1.4298 242.2980 1.4298 242.4000 1.5272 242.5980 1.5272 242.7000 1.7000 242.8980 1.7000 243.0000 1.6961 243.1980 1.6961 243.3000 1.3377 243.4980 1.3377 243.6000 1.2777 243.7980 1.2777 243.9000 1.4991 244.0980 1.4991 244.2000 1.7000 244.3980 1.7000 244.5000 1.6417 244.6980 1.6417 244.8000 1.1915 244.9980 1.1915 245.1000 1.1005 245.2980 1.1005 245.4000 0.6180 245.5980 0.6180 245.7000 1.0660 245.8980 1.0660 246.0000 0.7378 246.1980 0.7378 246.3000 0.6382 246.4980 0.6382 246.6000 1.0527 246.7980 1.0527 246.9000 0.6596 247.0980 0.6596 247.2000 0.6613 247.3980 0.6613 247.5000 0.9981 247.6980 0.9981 247.8000 1.4257 247.9980 1.4257 248.1000 0.6601 248.2980 0.6601 248.4000 0.8645 248.5980 0.8645 248.7000 0.6407 248.8980 0.6407 249.0000 1.6989 249.1980 1.6989 249.3000 0.7538 249.4980 0.7538 249.6000 1.2474 249.7980 1.2474 249.9000 0.6750 250.0980 0.6750 250.2000 1.2621 250.3980 1.2621 250.5000 0.6567 250.6980 0.6567 250.8000 1.4675 250.9980 1.4675 251.1000 0.6205 251.2980 0.6205 251.4000 0.8425 251.5980 0.8425 251.7000 0.7513 251.8980 0.7513 252.0000 1.7000 252.1980 1.7000 252.3000 1.4349 252.4980 1.4349 252.6000 1.3321 252.7980 1.3321 252.9000 1.7000 253.0980 1.7000 253.2000 1.7000 253.3980 1.7000 253.5000 1.2229 253.6980 1.2229 253.8000 1.5817 253.9980 1.5817 254.1000 1.5788 254.2980 1.5788 254.4000 1.5637 254.5980 1.5637 254.7000 1.4325 254.8980 1.4325 255.0000 1.3749 255.1980 1.3749 255.3000 1.6693 255.4980 1.6693 255.6000 1.2535 255.7980 1.2535 255.9000 0.7481 256.0980 0.7481 256.2000 1.4976 256.3980 1.4976 256.5000 1.4709 256.6980 1.4709 256.8000 1.2411 256.9980 1.2411 257.1000 1.4328 257.2980 1.4328 257.4000 1.5626 257.5980 1.5626 257.7000 1.7000 257.8980 1.7000 258.0000 1.4233 258.1980 1.4233 258.3000 1.7000 258.4980 1.7000 258.6000 1.7000 258.7980 1.7000 258.9000 1.5984 259.0980 1.5984 259.2000 1.6046 259.3980 1.6046 259.5000 1.7000 259.6980 1.7000 259.8000 1.4777 259.9980 1.4777 260.1000 1.6410 260.2980 1.6410 260.4000 1.5713 260.5980 1.5713 260.7000 1.6263 260.8980 1.6263 261.0000 1.5847 261.1980 1.5847 261.3000 0.9412 261.4980 0.9412 261.6000 1.4821 261.7980 1.4821 261.9000 1.6853 262.0980 1.6853 262.2000 1.3267 262.3980 1.3267 262.5000 1.7000 262.6980 1.7000 262.8000 1.4289 262.9980 1.4289 263.1000 1.6885 263.2980 1.6885 263.4000 1.5314 263.5980 1.5314 263.7000 1.4298 263.8980 1.4298 264.0000 1.5272 264.1980 1.5272 264.3000 1.7000 264.4980 1.7000 264.6000 1.6961 264.7980 1.6961 264.9000 1.3377 265.0980 1.3377 265.2000 1.2777 265.3980 1.2777 265.5000 1.4991 265.6980 1.4991 265.8000 1.7000 265.9980 1.7000 266.1000 1.6417 266.2980 1.6417 266.4000 1.1915 266.5980 1.1915 266.7000 1.1005 266.8980 1.1005 267.0000 0.6180 267.1980 0.6180 267.3000 1.0660 267.4980 1.0660 267.6000 0.7378 267.7980 0.7378 267.9000 0.6382 268.0980 0.6382 268.2000 1.0527 268.3980 1.0527 268.5000 0.6596 268.6980 0.6596 268.8000 0.6613 268.9980 0.6613 269.1000 0.9981 269.2980 0.9981 269.4000 1.4257 269.5980 1.4257 269.7000 0.6601 269.8980 0.6601 270.0000 0.8645 270.1980 0.8645 270.3000 0.6407 270.4980 0.6407 270.6000 1.6989 270.7980 1.6989 270.9000 0.7538 271.0980 0.7538 271.2000 1.2474 271.3980 1.2474 271.5000 0.6750 271.6980 0.6750 271.8000 1.2621 271.9980 1.2621 272.1000 0.6567 272.2980 0.6567 272.4000 1.4675 272.5980 1.4675 272.7000 0.6205 272.8980 0.6205 273.0000 0.8425 273.1980 0.8425 273.3000 0.7513 273.4980 0.7513 273.6000 1.7000 273.7980 1.7000 273.9000 1.4349 274.0980 1.4349 274.2000 1.3321 274.3980 1.3321 274.5000 1.7000 274.6980 1.7000 274.8000 1.7000 274.9980 1.7000 275.1000 1.2229 275.2980 1.2229 275.4000 1.5817 275.5980 1.5817 275.7000 1.5788 275.8980 1.5788 276.0000 1.5637 276.1980 1.5637 276.3000 1.4325 276.4980 1.4325 276.6000 1.3749 276.7980 1.3749 276.9000 1.6693 277.0980 1.6693 277.2000 1.2535 277.3980 1.2535 277.5000 0.7481 277.6980 0.7481 277.8000 1.4976 277.9980 1.4976 278.1000 1.4709 278.2980 1.4709 278.4000 1.2411 278.5980 1.2411 278.7000 1.4328 278.8980 1.4328 279.0000 1.5626 279.1980 1.5626 279.3000 1.7000 279.4980 1.7000 279.6000 1.4233 279.7980 1.4233 279.9000 1.7000 280.0980 1.7000 280.2000 1.7000 280.3980 1.7000 280.5000 1.5984 280.6980 1.5984 280.8000 1.6046 280.9980 1.6046 281.1000 1.7000 281.2980 1.7000 281.4000 1.4777 281.5980 1.4777 281.7000 1.6410 281.8980 1.6410 282.0000 1.5713 282.1980 1.5713 282.3000 1.6263 282.4980 1.6263 282.6000 1.5847 282.7980 1.5847 282.9000 0.9412 283.0980 0.9412 283.2000 1.4821 283.3980 1.4821 283.5000 1.6853 283.6980 1.6853 283.8000 1.3267 283.9980 1.3267 284.1000 1.7000 284.2980 1.7000 284.4000 1.4289 284.5980 1.4289 284.7000 1.6885 284.8980 1.6885 285.0000 1.5314 285.1980 1.5314 285.3000 1.4298 285.4980 1.4298 285.6000 1.5272 285.7980 1.5272 285.9000 1.7000 286.0980 1.7000 286.2000 1.6961 286.3980 1.6961 286.5000 1.3377 286.6980 1.3377 286.8000 1.2777 286.9980 1.2777 287.1000 1.4991 287.2980 1.4991 287.4000 1.7000 287.5980 1.7000 287.7000 1.6417 287.8980 1.6417 288.0000 1.1915 288.1980 1.1915 288.3000 1.1005 288.4980 1.1005 288.6000 0.6180 288.7980 0.6180 288.9000 1.0660 289.0980 1.0660 289.2000 0.7378 289.3980 0.7378 289.5000 0.6382 289.6980 0.6382 289.8000 1.0527 289.9980 1.0527 290.1000 0.6596 290.2980 0.6596 290.4000 0.6613 290.5980 0.6613 290.7000 0.9981 290.8980 0.9981 291.0000 1.4257 291.1980 1.4257 291.3000 0.6601 291.4980 0.6601 291.6000 0.8645 291.7980 0.8645 291.9000 0.6407 292.0980 0.6407 292.2000 1.6989 292.3980 1.6989 292.5000 0.7538 292.6980 0.7538 292.8000 1.2474 292.9980 1.2474 293.1000 0.6750 293.2980 0.6750 293.4000 1.2621 293.5980 1.2621 293.7000 0.6567 293.8980 0.6567 294.0000 1.4675 294.1980 1.4675 294.3000 0.6205 294.4980 0.6205 294.6000 0.8425 294.7980 0.8425 294.9000 0.7513 295.0980 0.7513 295.2000 1.7000 295.3980 1.7000 295.5000 1.4349 295.6980 1.4349 295.8000 1.3321 295.9980 1.3321 296.1000 1.7000 296.2980 1.7000 296.4000 1.7000 296.5980 1.7000 296.7000 1.2229 296.8980 1.2229 297.0000 1.5817 297.1980 1.5817 297.3000 1.5788 297.4980 1.5788 297.6000 1.5637 297.7980 1.5637 297.9000 1.4325 298.0980 1.4325 298.2000 1.3749 298.3980 1.3749 298.5000 1.6693 298.6980 1.6693 298.8000 1.2535 298.9980 1.2535 299.1000 0.7481 299.2980 0.7481 299.4000 1.4976 299.5980 1.4976 299.7000 1.4709 299.8980 1.4709 300.0000 1.2411 300.1980 1.2411 300.3000 1.4328 300.4980 1.4328 300.6000 1.5626 300.7980 1.5626 300.9000 1.7000 301.0980 1.7000 301.2000 1.4233 301.3980 1.4233 301.5000 1.7000 301.6980 1.7000 301.8000 1.7000 301.9980 1.7000 302.1000 1.5984 302.2980 1.5984 302.4000 1.6046 302.5980 1.6046 302.7000 1.7000 302.8980 1.7000 303.0000 1.4777 303.1980 1.4777 303.3000 1.6410 303.4980 1.6410 303.6000 1.5713 303.7980 1.5713 303.9000 1.6263 304.0980 1.6263 304.2000 1.5847 304.3980 1.5847 304.5000 0.9412 304.6980 0.9412 304.8000 1.4821 304.9980 1.4821 305.1000 1.6853 305.2980 1.6853 305.4000 1.3267 305.5980 1.3267 305.7000 1.7000 305.8980 1.7000 306.0000 1.4289 306.1980 1.4289 306.3000 1.6885 306.4980 1.6885 306.6000 1.5314 306.7980 1.5314 306.9000 1.4298 307.0980 1.4298 307.2000 1.5272 307.3980 1.5272 307.5000 1.7000 307.6980 1.7000 307.8000 1.6961 307.9980 1.6961 308.1000 1.3377 308.2980 1.3377 308.4000 1.2777 308.5980 1.2777 308.7000 1.4991 308.8980 1.4991 309.0000 1.7000 309.1980 1.7000 309.3000 1.6417 309.4980 1.6417 309.6000 1.1915 309.7980 1.1915 309.9000 1.1005 310.0980 1.1005 310.2000 0.6180 310.3980 0.6180 310.5000 1.0660 310.6980 1.0660 310.8000 0.7378 310.9980 0.7378 311.1000 0.6382 311.2980 0.6382 311.4000 1.0527 311.5980 1.0527 311.7000 0.6596 311.8980 0.6596 312.0000 0.6613 312.1980 0.6613 312.3000 0.9981 312.4980 0.9981 312.6000 1.4257 312.7980 1.4257 312.9000 0.6601 313.0980 0.6601 313.2000 0.8645 313.3980 0.8645 313.5000 0.6407 313.6980 0.6407 313.8000 1.6989 313.9980 1.6989 314.1000 0.7538 314.2980 0.7538 314.4000 1.2474 314.5980 1.2474 314.7000 0.6750 314.8980 0.6750 315.0000 1.2621 315.1980 1.2621 315.3000 0.6567 315.4980 0.6567 315.6000 1.4675 315.7980 1.4675 315.9000 0.6205 316.0980 0.6205 316.2000 0.8425 316.3980 0.8425 316.5000 0.7513 316.6980 0.7513 316.8000 1.7000 316.9980 1.7000 317.1000 1.4349 317.2980 1.4349 317.4000 1.3321 317.5980 1.3321 317.7000 1.7000 317.8980 1.7000 318.0000 1.7000 318.1980 1.7000 318.3000 1.2229 318.4980 1.2229 318.6000 1.5817 318.7980 1.5817 318.9000 1.5788 319.0980 1.5788 319.2000 1.5637 319.3980 1.5637 319.5000 1.4325 319.6980 1.4325 319.8000 1.3749 319.9980 1.3749 320.1000 1.6693 320.2980 1.6693 320.4000 1.2535 320.5980 1.2535 320.7000 0.7481 320.8980 0.7481 321.0000 1.4976 321.1980 1.4976 321.3000 1.4709 321.4980 1.4709 321.6000 1.2411 321.7980 1.2411 321.9000 1.4328 322.0980 1.4328 322.2000 1.5626 322.3980 1.5626 322.5000 1.7000 322.6980 1.7000 322.8000 1.4233 322.9980 1.4233 323.1000 1.7000 323.2980 1.7000 323.4000 1.7000 323.5980 1.7000 323.7000 1.5984 323.8980 1.5984 324.0000 1.6046 324.1980 1.6046 324.3000 1.7000 324.4980 1.7000 324.6000 1.4777 324.7980 1.4777 324.9000 1.6410 325.0980 1.6410 325.2000 1.5713 325.3980 1.5713 325.5000 1.6263 325.6980 1.6263 325.8000 1.5847 325.9980 1.5847 326.1000 0.9412 326.2980 0.9412 326.4000 1.4821 326.5980 1.4821 326.7000 1.6853 326.8980 1.6853 327.0000 1.3267 327.1980 1.3267 327.3000 1.7000 327.4980 1.7000 327.6000 1.4289 327.7980 1.4289 327.9000 1.6885 328.0980 1.6885 328.2000 1.5314 328.3980 1.5314 328.5000 1.4298 328.6980 1.4298 328.8000 1.5272 328.9980 1.5272 329.1000 1.7000 329.2980 1.7000 329.4000 1.6961 329.5980 1.6961 329.7000 1.3377 329.8980 1.3377 330.0000 1.2777 330.1980 1.2777 330.3000 1.4991 330.4980 1.4991 330.6000 1.7000 330.7980 1.7000 330.9000 1.6417 331.0980 1.6417 331.2000 1.1915 331.3980 1.1915 331.5000 1.1005 331.6980 1.1005 331.8000 0.6180 331.9980 0.6180 332.1000 1.0660 332.2980 1.0660 332.4000 0.7378 332.5980 0.7378 332.7000 0.6382 332.8980 0.6382 333.0000 1.0527 333.1980 1.0527 333.3000 0.6596 333.4980 0.6596 333.6000 0.6613 333.7980 0.6613 333.9000 0.9981 334.0980 0.9981 334.2000 1.4257 334.3980 1.4257 334.5000 0.6601 334.6980 0.6601 334.8000 0.8645 334.9980 0.8645 335.1000 0.6407 335.2980 0.6407 335.4000 1.6989 335.5980 1.6989 335.7000 0.7538 335.8980 0.7538 336.0000 1.2474 336.1980 1.2474 336.3000 0.6750 336.4980 0.6750 336.6000 1.2621 336.7980 1.2621 336.9000 0.6567 337.0980 0.6567 337.2000 1.4675 337.3980 1.4675 337.5000 0.6205 337.6980 0.6205 337.8000 0.8425 337.9980 0.8425 338.1000 0.7513 338.2980 0.7513 338.4000 1.7000 338.5980 1.7000 338.7000 1.4349 338.8980 1.4349 339.0000 1.3321 339.1980 1.3321 339.3000 1.7000 339.4980 1.7000 339.6000 1.7000 339.7980 1.7000 339.9000 1.2229 340.0980 1.2229 340.2000 1.5817 340.3980 1.5817 340.5000 1.5788 340.6980 1.5788 340.8000 1.5637 340.9980 1.5637 341.1000 1.4325 341.2980 1.4325 341.4000 1.3749 341.5980 1.3749 341.7000 1.6693 341.8980 1.6693 342.0000 1.2535 342.1980 1.2535 342.3000 0.7481 342.4980 0.7481 342.6000 1.4976 342.7980 1.4976 342.9000 1.4709 343.0980 1.4709 343.2000 1.2411 343.3980 1.2411 343.5000 1.4328 343.6980 1.4328 343.8000 1.5626 343.9980 1.5626 344.1000 1.7000 344.2980 1.7000 344.4000 1.4233 344.5980 1.4233 344.7000 1.7000 344.8980 1.7000 345.0000 1.7000 345.1980 1.7000 345.3000 1.5984 345.4980 1.5984 345.6000 1.6046 345.7980 1.6046 345.9000 1.7000 346.0980 1.7000 346.2000 1.4777 346.3980 1.4777 346.5000 1.6410 346.6980 1.6410 346.8000 1.5713 346.9980 1.5713 347.1000 1.6263 347.2980 1.6263 347.4000 1.5847 347.5980 1.5847 347.7000 0.9412 347.8980 0.9412 348.0000 1.4821 348.1980 1.4821 348.3000 1.6853 348.4980 1.6853 348.6000 1.3267 348.7980 1.3267 348.9000 1.7000 349.0980 1.7000 349.2000 1.4289 349.3980 1.4289 349.5000 1.6885 349.6980 1.6885 349.8000 1.5314 349.9980 1.5314 350.1000 1.4298 350.2980 1.4298 350.4000 1.5272 350.5980 1.5272 350.7000 1.7000 350.8980 1.7000 351.0000 1.6961 351.1980 1.6961 351.3000 1.3377 351.4980 1.3377 351.6000 1.2777 351.7980 1.2777 351.9000 1.4991 352.0980 1.4991 352.2000 1.7000 352.3980 1.7000 352.5000 1.6417 352.6980 1.6417 352.8000 1.1915 352.9980 1.1915 353.1000 1.1005 353.2980 1.1005 353.4000 0.6180 353.5980 0.6180 353.7000 1.0660 353.8980 1.0660 354.0000 0.7378 354.1980 0.7378 354.3000 0.6382 354.4980 0.6382 354.6000 1.0527 354.7980 1.0527 354.9000 0.6596 355.0980 0.6596 355.2000 0.6613 355.3980 0.6613 355.5000 0.9981 355.6980 0.9981 355.8000 1.4257 355.9980 1.4257 356.1000 0.6601 356.2980 0.6601 356.4000 0.8645 356.5980 0.8645 356.7000 0.6407 356.8980 0.6407 357.0000 1.6989 357.1980 1.6989 357.3000 0.7538 357.4980 0.7538 357.6000 1.2474 357.7980 1.2474 357.9000 0.6750 358.0980 0.6750 358.2000 1.2621 358.3980 1.2621 358.5000 0.6567 358.6980 0.6567 358.8000 1.4675 358.9980 1.4675 359.1000 0.6205 359.2980 0.6205 359.4000 0.8425 359.5980 0.8425 359.7000 0.7513 359.8980 0.7513 360.0000 1.7000 360.1980 1.7000 360.3000 1.4349 360.4980 1.4349 360.6000 1.3321 360.7980 1.3321 360.9000 1.7000 361.0980 1.7000 361.2000 1.7000 361.3980 1.7000 361.5000 1.2229 361.6980 1.2229 361.8000 1.5817 361.9980 1.5817 362.1000 1.5788 362.2980 1.5788 362.4000 1.5637 362.5980 1.5637 362.7000 1.4325 362.8980 1.4325 363.0000 1.3749 363.1980 1.3749 363.3000 1.6693 363.4980 1.6693 363.6000 1.2535 363.7980 1.2535 363.9000 0.7481 364.0980 0.7481 364.2000 1.4976 364.3980 1.4976 364.5000 1.4709 364.6980 1.4709 364.8000 1.2411 364.9980 1.2411 365.1000 1.4328 365.2980 1.4328 365.4000 1.5626 365.5980 1.5626 365.7000 1.7000 365.8980 1.7000 366.0000 1.4233 366.1980 1.4233 366.3000 1.7000 366.4980 1.7000 366.6000 1.7000 366.7980 1.7000 366.9000 1.5984 367.0980 1.5984 367.2000 1.6046 367.3980 1.6046 367.5000 1.7000 367.6980 1.7000 367.8000 1.4777 367.9980 1.4777 368.1000 1.6410 368.2980 1.6410 368.4000 1.5713 368.5980 1.5713 368.7000 1.6263 368.8980 1.6263 369.0000 1.5847 369.1980 1.5847 369.3000 0.9412 369.4980 0.9412 369.6000 1.4821 369.7980 1.4821 369.9000 1.6853 370.0980 1.6853 370.2000 1.3267 370.3980 1.3267 370.5000 1.7000 370.6980 1.7000 370.8000 1.4289 370.9980 1.4289 371.1000 1.6885 371.2980 1.6885 371.4000 1.5314 371.5980 1.5314 371.7000 1.4298 371.8980 1.4298 372.0000 1.5272 372.1980 1.5272 372.3000 1.7000 372.4980 1.7000 372.6000 1.6961 372.7980 1.6961 372.9000 1.3377 373.0980 1.3377 373.2000 1.2777 373.3980 1.2777 373.5000 1.4991 373.6980 1.4991 373.8000 1.7000 373.9980 1.7000 374.1000 1.6417 374.2980 1.6417 374.4000 1.1915 374.5980 1.1915 374.7000 1.1005 374.8980 1.1005 375.0000 0.6180 375.1980 0.6180 375.3000 1.0660 375.4980 1.0660 375.6000 0.7378 375.7980 0.7378 375.9000 0.6382 376.0980 0.6382 376.2000 1.0527 376.3980 1.0527 376.5000 0.6596 376.6980 0.6596 376.8000 0.6613 376.9980 0.6613 377.1000 0.9981 377.2980 0.9981 377.4000 1.4257 377.5980 1.4257 377.7000 0.6601 377.8980 0.6601 378.0000 0.8645 378.1980 0.8645 378.3000 0.6407 378.4980 0.6407 378.6000 1.6989 378.7980 1.6989 378.9000 0.7538 379.0980 0.7538 379.2000 1.2474 379.3980 1.2474 379.5000 0.6750 379.6980 0.6750 379.8000 1.2621 379.9980 1.2621 380.1000 0.6567 380.2980 0.6567 380.4000 1.4675 380.5980 1.4675 380.7000 0.6205 380.8980 0.6205 381.0000 0.8425 381.1980 0.8425 381.3000 0.7513 381.4980 0.7513 381.6000 1.7000 381.7980 1.7000 381.9000 1.4349 382.0980 1.4349 382.2000 1.3321 382.3980 1.3321 382.5000 1.7000 382.6980 1.7000 382.8000 1.7000 382.9980 1.7000 383.1000 1.2229 383.2980 1.2229 383.4000 1.5817 383.5980 1.5817 383.7000 1.5788 383.8980 1.5788 384.0000 1.5637 384.1980 1.5637 384.3000 1.4325 384.4980 1.4325 384.6000 1.3749 384.7980 1.3749 384.9000 1.6693 385.0980 1.6693 385.2000 1.2535 385.3980 1.2535 385.5000 0.7481 385.6980 0.7481 385.8000 1.4976 385.9980 1.4976 386.1000 1.4709 386.2980 1.4709 386.4000 1.2411 386.5980 1.2411 386.7000 1.4328 386.8980 1.4328 387.0000 1.5626 387.1980 1.5626 387.3000 1.7000 387.4980 1.7000 387.6000 1.4233 387.7980 1.4233 387.9000 1.7000 388.0980 1.7000 388.2000 1.7000 388.3980 1.7000 388.5000 1.5984 388.6980 1.5984 388.8000 1.6046 388.9980 1.6046 389.1000 1.7000 389.2980 1.7000 389.4000 1.4777 389.5980 1.4777 389.7000 1.6410 389.8980 1.6410 390.0000 1.5713 390.1980 1.5713 390.3000 1.6263 390.4980 1.6263 390.6000 1.5847 390.7980 1.5847 390.9000 0.9412 391.0980 0.9412 391.2000 1.4821 391.3980 1.4821 391.5000 1.6853 391.6980 1.6853 391.8000 1.3267 391.9980 1.3267 392.1000 1.7000 392.2980 1.7000 392.4000 1.4289 392.5980 1.4289 392.7000 1.6885 392.8980 1.6885 393.0000 1.5314 393.1980 1.5314 393.3000 1.4298 393.4980 1.4298 393.6000 1.5272 393.7980 1.5272 393.9000 1.7000 394.0980 1.7000 394.2000 1.6961 394.3980 1.6961 394.5000 1.3377 394.6980 1.3377 394.8000 1.2777 394.9980 1.2777 395.1000 1.4991 395.2980 1.4991 395.4000 1.7000 395.5980 1.7000 395.7000 1.6417 395.8980 1.6417 396.0000 1.1915 396.1980 1.1915 396.3000 1.1005 396.4980 1.1005 396.6000 0.6180 396.7980 0.6180 396.9000 1.0660 397.0980 1.0660 397.2000 0.7378 397.3980 0.7378 397.5000 0.6382 397.6980 0.6382 397.8000 1.0527 397.9980 1.0527 398.1000 0.6596 398.2980 0.6596 398.4000 0.6613 398.5980 0.6613 398.7000 0.9981 398.8980 0.9981 399.0000 1.4257 399.1980 1.4257 399.3000 0.6601 399.4980 0.6601 399.6000 0.8645 399.7980 0.8645 399.9000 0.6407 400.0980 0.6407 400.2000 1.6989 400.3980 1.6989 400.5000 0.7538 400.6980 0.7538 400.8000 1.2474 400.9980 1.2474 401.1000 0.6750 401.2980 0.6750 401.4000 1.2621 401.5980 1.2621 401.7000 0.6567 401.8980 0.6567 402.0000 1.4675 402.1980 1.4675 402.3000 0.6205 402.4980 0.6205 402.6000 0.8425 402.7980 0.8425 402.9000 0.7513 403.0980 0.7513 403.2000 1.7000 403.3980 1.7000 403.5000 1.4349 403.6980 1.4349 403.8000 1.3321 403.9980 1.3321 404.1000 1.7000 404.2980 1.7000 404.4000 1.7000 404.5980 1.7000 404.7000 1.2229 404.8980 1.2229 405.0000 1.5817 405.1980 1.5817 405.3000 1.5788 405.4980 1.5788 405.6000 1.5637 405.7980 1.5637 405.9000 1.4325 406.0980 1.4325 406.2000 1.3749 406.3980 1.3749 406.5000 1.6693 406.6980 1.6693 406.8000 1.2535 406.9980 1.2535 407.1000 0.7481 407.2980 0.7481 407.4000 1.4976 407.5980 1.4976 407.7000 1.4709 407.8980 1.4709 408.0000 1.2411 408.1980 1.2411 408.3000 1.4328 408.4980 1.4328 408.6000 1.5626 408.7980 1.5626 408.9000 1.7000 409.0980 1.7000 409.2000 1.4233 409.3980 1.4233 409.5000 1.7000 409.6980 1.7000 409.8000 1.7000 409.9980 1.7000 410.1000 1.5984 410.2980 1.5984 410.4000 1.6046 410.5980 1.6046 410.7000 1.7000 410.8980 1.7000 411.0000 1.4777 411.1980 1.4777 411.3000 1.6410 411.4980 1.6410 411.6000 1.5713 411.7980 1.5713 411.9000 1.6263 412.0980 1.6263 412.2000 1.5847 412.3980 1.5847 412.5000 0.9412 412.6980 0.9412 412.8000 1.4821 412.9980 1.4821 413.1000 1.6853 413.2980 1.6853 413.4000 1.3267 413.5980 1.3267 413.7000 1.7000 413.8980 1.7000 414.0000 1.4289 414.1980 1.4289 414.3000 1.6885 414.4980 1.6885 414.6000 1.5314 414.7980 1.5314 414.9000 1.4298 415.0980 1.4298 415.2000 1.5272 415.3980 1.5272 415.5000 1.7000 415.6980 1.7000 415.8000 1.6961 415.9980 1.6961 416.1000 1.3377 416.2980 1.3377 416.4000 1.2777 416.5980 1.2777 416.7000 1.4991 416.8980 1.4991 417.0000 1.7000 417.1980 1.7000 417.3000 1.6417 417.4980 1.6417 417.6000 1.1915 417.7980 1.1915 417.9000 1.1005 418.0980 1.1005 418.2000 0.6180 418.3980 0.6180 418.5000 1.0660 418.6980 1.0660 418.8000 0.7378 418.9980 0.7378 419.1000 0.6382 419.2980 0.6382 419.4000 1.0527 419.5980 1.0527 419.7000 0.6596 419.8980 0.6596 420.0000 0.6613 420.1980 0.6613 420.3000 0.9981 420.4980 0.9981 420.6000 1.4257 420.7980 1.4257 420.9000 0.6601 421.0980 0.6601 421.2000 0.8645 421.3980 0.8645 421.5000 0.6407 421.6980 0.6407 421.8000 1.6989 421.9980 1.6989 422.1000 0.7538 422.2980 0.7538 422.4000 1.2474 422.5980 1.2474 422.7000 0.6750 422.8980 0.6750 423.0000 1.2621 423.1980 1.2621 423.3000 0.6567 423.4980 0.6567 423.6000 1.4675 423.7980 1.4675 423.9000 0.6205 424.0980 0.6205 424.2000 0.8425 424.3980 0.8425 424.5000 0.7513 424.6980 0.7513 424.8000 1.7000 424.9980 1.7000 425.1000 1.4349 425.2980 1.4349 425.4000 1.3321 425.5980 1.3321 425.7000 1.7000 425.8980 1.7000 426.0000 1.7000 426.1980 1.7000 426.3000 1.2229 426.4980 1.2229 426.6000 1.5817 426.7980 1.5817 426.9000 1.5788 427.0980 1.5788 427.2000 1.5637 427.3980 1.5637 427.5000 1.4325 427.6980 1.4325 427.8000 1.3749 427.9980 1.3749 428.1000 1.6693 428.2980 1.6693 428.4000 1.2535 428.5980 1.2535 428.7000 0.7481 428.8980 0.7481 429.0000 1.4976 429.1980 1.4976 429.3000 1.4709 429.4980 1.4709 429.6000 1.2411 429.7980 1.2411 429.9000 1.4328 430.0980 1.4328 430.2000 1.5626 430.3980 1.5626 430.5000 1.7000 430.6980 1.7000 430.8000 1.4233 430.9980 1.4233 431.1000 1.7000 431.2980 1.7000 431.4000 1.7000 431.5980 1.7000 431.7000 1.5984 431.8980 1.5984 432.0000 1.6046 432.1980 1.6046 432.3000 1.7000 432.4980 1.7000 432.6000 1.4777 432.7980 1.4777 432.9000 1.6410 433.0980 1.6410 433.2000 1.5713 433.3980 1.5713 433.5000 1.6263 433.6980 1.6263 433.8000 1.5847 433.9980 1.5847 434.1000 0.9412 434.2980 0.9412 434.4000 1.4821 434.5980 1.4821 434.7000 1.6853 434.8980 1.6853 435.0000 1.3267 435.1980 1.3267 435.3000 1.7000 435.4980 1.7000 435.6000 1.4289 435.7980 1.4289 435.9000 1.6885 436.0980 1.6885 436.2000 1.5314 436.3980 1.5314 436.5000 1.4298 436.6980 1.4298 436.8000 1.5272 436.9980 1.5272 437.1000 1.7000 437.2980 1.7000 437.4000 1.6961 437.5980 1.6961 437.7000 1.3377 437.8980 1.3377 438.0000 1.2777 438.1980 1.2777 438.3000 1.4991 438.4980 1.4991 438.6000 1.7000 438.7980 1.7000 438.9000 1.6417 439.0980 1.6417 439.2000 1.1915 439.3980 1.1915 439.5000 1.1005 439.6980 1.1005 439.8000 0.6180 439.9980 0.6180 440.1000 1.0660 440.2980 1.0660 440.4000 0.7378 440.5980 0.7378 440.7000 0.6382 440.8980 0.6382 441.0000 1.0527 441.1980 1.0527 441.3000 0.6596 441.4980 0.6596 441.6000 0.6613 441.7980 0.6613 441.9000 0.9981 442.0980 0.9981 442.2000 1.4257 442.3980 1.4257 442.5000 0.6601 442.6980 0.6601 442.8000 0.8645 442.9980 0.8645 443.1000 0.6407 443.2980 0.6407 443.4000 1.6989 443.5980 1.6989 443.7000 0.7538 443.8980 0.7538 444.0000 1.2474 444.1980 1.2474 444.3000 0.6750 444.4980 0.6750 444.6000 1.2621 444.7980 1.2621 444.9000 0.6567 445.0980 0.6567 445.2000 1.4675 445.3980 1.4675 445.5000 0.6205 445.6980 0.6205 445.8000 0.8425 445.9980 0.8425 446.1000 0.7513 446.2980 0.7513 446.4000 1.7000 446.5980 1.7000 446.7000 1.4349 446.8980 1.4349 447.0000 1.3321 447.1980 1.3321 447.3000 1.7000 447.4980 1.7000 447.6000 1.7000 447.7980 1.7000 447.9000 1.2229 448.0980 1.2229 448.2000 1.5817 448.3980 1.5817 448.5000 1.5788 448.6980 1.5788 448.8000 1.5637 448.9980 1.5637 449.1000 1.4325 449.2980 1.4325 449.4000 1.3749 449.5980 1.3749 449.7000 1.6693 449.8980 1.6693 450.0000 1.2535 450.1980 1.2535 450.3000 0.7481 450.4980 0.7481 450.6000 1.4976 450.7980 1.4976 450.9000 1.4709 451.0980 1.4709 451.2000 1.2411 451.3980 1.2411 451.5000 1.4328 451.6980 1.4328 451.8000 1.5626 451.9980 1.5626 452.1000 1.7000 452.2980 1.7000 452.4000 1.4233 452.5980 1.4233 452.7000 1.7000 452.8980 1.7000 453.0000 1.7000 453.1980 1.7000 453.3000 1.5984 453.4980 1.5984 453.6000 1.6046 453.7980 1.6046 453.9000 1.7000 454.0980 1.7000 454.2000 1.4777 454.3980 1.4777 454.5000 1.6410 454.6980 1.6410 454.8000 1.5713 454.9980 1.5713 455.1000 1.6263 455.2980 1.6263 455.4000 1.5847 455.5980 1.5847 455.7000 0.9412 455.8980 0.9412 456.0000 1.4821 456.1980 1.4821 456.3000 1.6853 456.4980 1.6853 456.6000 1.3267 456.7980 1.3267 456.9000 1.7000 457.0980 1.7000 457.2000 1.4289 457.3980 1.4289 457.5000 1.6885 457.6980 1.6885 457.8000 1.5314 457.9980 1.5314 458.1000 1.4298 458.2980 1.4298 458.4000 1.5272 458.5980 1.5272 458.7000 1.7000 458.8980 1.7000 459.0000 1.6961 459.1980 1.6961 459.3000 1.3377 459.4980 1.3377 459.6000 1.2777 459.7980 1.2777 459.9000 1.4991 460.0980 1.4991 460.2000 1.7000 460.3980 1.7000 460.5000 1.6417 460.6980 1.6417 460.8000 1.1915 460.9980 1.1915 461.1000 1.1005 461.2980 1.1005 461.4000 0.6180 461.5980 0.6180 461.7000 1.0660 461.8980 1.0660 462.0000 0.7378 462.1980 0.7378 462.3000 0.6382 462.4980 0.6382 462.6000 1.0527 462.7980 1.0527 462.9000 0.6596 463.0980 0.6596 463.2000 0.6613 463.3980 0.6613 463.5000 0.9981 463.6980 0.9981 463.8000 1.4257 463.9980 1.4257 464.1000 0.6601 464.2980 0.6601 464.4000 0.8645 464.5980 0.8645 464.7000 0.6407 464.8980 0.6407 465.0000 1.6989 465.1980 1.6989 465.3000 0.7538 465.4980 0.7538 465.6000 1.2474 465.7980 1.2474 465.9000 0.6750 466.0980 0.6750 466.2000 1.2621 466.3980 1.2621 466.5000 0.6567 466.6980 0.6567 466.8000 1.4675 466.9980 1.4675 467.1000 0.6205 467.2980 0.6205 467.4000 0.8425 467.5980 0.8425 467.7000 0.7513 467.8980 0.7513 468.0000 1.7000 468.1980 1.7000 468.3000 1.4349 468.4980 1.4349 468.6000 1.3321 468.7980 1.3321 468.9000 1.7000 469.0980 1.7000 469.2000 1.7000 469.3980 1.7000 469.5000 1.2229 469.6980 1.2229 469.8000 1.5817 469.9980 1.5817 470.1000 1.5788 470.2980 1.5788 470.4000 1.5637 470.5980 1.5637 470.7000 1.4325 470.8980 1.4325 471.0000 1.3749 471.1980 1.3749 471.3000 1.6693 471.4980 1.6693 471.6000 1.2535 471.7980 1.2535 471.9000 0.7481 472.0980 0.7481 472.2000 1.4976 472.3980 1.4976 472.5000 1.4709 472.6980 1.4709 472.8000 1.2411 472.9980 1.2411 473.1000 1.4328 473.2980 1.4328 473.4000 1.5626 473.5980 1.5626 473.7000 1.7000 473.8980 1.7000 474.0000 1.4233 474.1980 1.4233 474.3000 1.7000 474.4980 1.7000 474.6000 1.7000 474.7980 1.7000 474.9000 1.5984 475.0980 1.5984 475.2000 1.6046 475.3980 1.6046 475.5000 1.7000 475.6980 1.7000 475.8000 1.4777 475.9980 1.4777 476.1000 1.6410 476.2980 1.6410 476.4000 1.5713 476.5980 1.5713 476.7000 1.6263 476.8980 1.6263 477.0000 1.5847 477.1980 1.5847 477.3000 0.9412 477.4980 0.9412 477.6000 1.4821 477.7980 1.4821 477.9000 1.6853 478.0980 1.6853 478.2000 1.3267 478.3980 1.3267 478.5000 1.7000 478.6980 1.7000 478.8000 1.4289 478.9980 1.4289 479.1000 1.6885 479.2980 1.6885 479.4000 1.5314 479.5980 1.5314 479.7000 1.4298 479.8980 1.4298 480.0000 1.5272 480.1980 1.5272 480.3000 1.7000 480.4980 1.7000 480.6000 1.6961 480.7980 1.6961 480.9000 1.3377 481.0980 1.3377 481.2000 1.2777 481.3980 1.2777 481.5000 1.4991 481.6980 1.4991 481.8000 1.7000 481.9980 1.7000 482.1000 1.6417 482.2980 1.6417 482.4000 1.1915 482.5980 1.1915 482.7000 1.1005 482.8980 1.1005 483.0000 0.6180 483.1980 0.6180 483.3000 1.0660 483.4980 1.0660 483.6000 0.7378 483.7980 0.7378 483.9000 0.6382 484.0980 0.6382 484.2000 1.0527 484.3980 1.0527 484.5000 0.6596 484.6980 0.6596 484.8000 0.6613 484.9980 0.6613 485.1000 0.9981 485.2980 0.9981 485.4000 1.4257 485.5980 1.4257 485.7000 0.6601 485.8980 0.6601 486.0000 0.8645 486.1980 0.8645 486.3000 0.6407 486.4980 0.6407 486.6000 1.6989 486.7980 1.6989 486.9000 0.7538 487.0980 0.7538 487.2000 1.2474 487.3980 1.2474 487.5000 0.6750 487.6980 0.6750 487.8000 1.2621 487.9980 1.2621 488.1000 0.6567 488.2980 0.6567 488.4000 1.4675 488.5980 1.4675 488.7000 0.6205 488.8980 0.6205 489.0000 0.8425 489.1980 0.8425 489.3000 0.7513 489.4980 0.7513 489.6000 1.7000 489.7980 1.7000 489.9000 1.4349 490.0980 1.4349 490.2000 1.3321 490.3980 1.3321 490.5000 1.7000 490.6980 1.7000 490.8000 1.7000 490.9980 1.7000 491.1000 1.2229 491.2980 1.2229 491.4000 1.5817 491.5980 1.5817 491.7000 1.5788 491.8980 1.5788 492.0000 1.5637 492.1980 1.5637 492.3000 1.4325 492.4980 1.4325 492.6000 1.3749 492.7980 1.3749 492.9000 1.6693 493.0980 1.6693 493.2000 1.2535 493.3980 1.2535 493.5000 0.7481 493.6980 0.7481 493.8000 1.4976 493.9980 1.4976 494.1000 1.4709 494.2980 1.4709 494.4000 1.2411 494.5980 1.2411 494.7000 1.4328 494.8980 1.4328 495.0000 1.5626 495.1980 1.5626 495.3000 1.7000 495.4980 1.7000 495.6000 1.4233 495.7980 1.4233 495.9000 1.7000 496.0980 1.7000 496.2000 1.7000 496.3980 1.7000 496.5000 1.5984 496.6980 1.5984 496.8000 1.6046 496.9980 1.6046 497.1000 1.7000 497.2980 1.7000 497.4000 1.4777 497.5980 1.4777 497.7000 1.6410 497.8980 1.6410 498.0000 1.5713 498.1980 1.5713 498.3000 1.6263 498.4980 1.6263 498.6000 1.5847 498.7980 1.5847 498.9000 0.9412 499.0980 0.9412 499.2000 1.4821 499.3980 1.4821 499.5000 1.6853 499.6980 1.6853 499.8000 1.3267 499.9980 1.3267 500.1000 1.7000 500.2980 1.7000 500.4000 1.4289 500.5980 1.4289 500.7000 1.6885 500.8980 1.6885 501.0000 1.5314 501.1980 1.5314 501.3000 1.4298 501.4980 1.4298 501.6000 1.5272 501.7980 1.5272 501.9000 1.7000 502.0980 1.7000 502.2000 1.6961 502.3980 1.6961 502.5000 1.3377 502.6980 1.3377 502.8000 1.2777 502.9980 1.2777 503.1000 1.4991 503.2980 1.4991 503.4000 1.7000 503.5980 1.7000 503.7000 1.6417 503.8980 1.6417 504.0000 1.1915 504.1980 1.1915 504.3000 1.1005 504.4980 1.1005 504.6000 0.6180 504.7980 0.6180 504.9000 1.0660 505.0980 1.0660 505.2000 0.7378 505.3980 0.7378 505.5000 0.6382 505.6980 0.6382 505.8000 1.0527 505.9980 1.0527 506.1000 0.6596 506.2980 0.6596 506.4000 0.6613 506.5980 0.6613 506.7000 0.9981 506.8980 0.9981 507.0000 1.4257 507.1980 1.4257 507.3000 0.6601 507.4980 0.6601 507.6000 0.8645 507.7980 0.8645 507.9000 0.6407 508.0980 0.6407 508.2000 1.6989 508.3980 1.6989 508.5000 0.7538 508.6980 0.7538 508.8000 1.2474 508.9980 1.2474 509.1000 0.6750 509.2980 0.6750 509.4000 1.2621 509.5980 1.2621 509.7000 0.6567 509.8980 0.6567 510.0000 1.4675 510.1980 1.4675 510.3000 0.6205 510.4980 0.6205 510.6000 0.8425 510.7980 0.8425 510.9000 0.7513 511.0980 0.7513 511.2000 1.7000 511.3980 1.7000 511.5000 1.4349 511.6980 1.4349 511.8000 1.3321 511.9980 1.3321 512.1000 1.7000 512.2980 1.7000 512.4000 1.7000 512.5980 1.7000 512.7000 1.2229 512.8980 1.2229 513.0000 1.5817 513.1980 1.5817 513.3000 1.5788 513.4980 1.5788 513.6000 1.5637 513.7980 1.5637 513.9000 1.4325 514.0980 1.4325 514.2000 1.3749 514.3980 1.3749 514.5000 1.6693 514.6980 1.6693 514.8000 1.2535 514.9980 1.2535 515.1000 0.7481 515.2980 0.7481 515.4000 1.4976 515.5980 1.4976 515.7000 1.4709 515.8980 1.4709 516.0000 1.2411 516.1980 1.2411 516.3000 1.4328 516.4980 1.4328 516.6000 1.5626 516.7980 1.5626 516.9000 1.7000 517.0980 1.7000 517.2000 1.4233 517.3980 1.4233 517.5000 1.7000 517.6980 1.7000 517.8000 1.7000 517.9980 1.7000 518.1000 1.5984 518.2980 1.5984 518.4000 1.6046 518.5980 1.6046 518.7000 1.7000 518.8980 1.7000 519.0000 1.4777 519.1980 1.4777 519.3000 1.6410 519.4980 1.6410 519.6000 1.5713 519.7980 1.5713 519.9000 1.6263 520.0980 1.6263 520.2000 1.5847 520.3980 1.5847 520.5000 0.9412 520.6980 0.9412 520.8000 1.4821 520.9980 1.4821 521.1000 1.6853 521.2980 1.6853 521.4000 1.3267 521.5980 1.3267 521.7000 1.7000 521.8980 1.7000 522.0000 1.4289 522.1980 1.4289 522.3000 1.6885 522.4980 1.6885 522.6000 1.5314 522.7980 1.5314 522.9000 1.4298 523.0980 1.4298 523.2000 1.5272 523.3980 1.5272 523.5000 1.7000 523.6980 1.7000 523.8000 1.6961 523.9980 1.6961 524.1000 1.3377 524.2980 1.3377 524.4000 1.2777 524.5980 1.2777 524.7000 1.4991 524.8980 1.4991 525.0000 1.7000 525.1980 1.7000 525.3000 1.6417 525.4980 1.6417 525.6000 1.1915 525.7980 1.1915 525.9000 1.1005 526.0980 1.1005 526.2000 0.6180 526.3980 0.6180 526.5000 1.0660 526.6980 1.0660 526.8000 0.7378 526.9980 0.7378 527.1000 0.6382 527.2980 0.6382 527.4000 1.0527 527.5980 1.0527 527.7000 0.6596 527.8980 0.6596 528.0000 0.6613 528.1980 0.6613 528.3000 0.9981 528.4980 0.9981 528.6000 1.4257 528.7980 1.4257 528.9000 0.6601 529.0980 0.6601 529.2000 0.8645 529.3980 0.8645 529.5000 0.6407 529.6980 0.6407 529.8000 1.6989 529.9980 1.6989 530.1000 0.7538 530.2980 0.7538 530.4000 1.2474 530.5980 1.2474 530.7000 0.6750 530.8980 0.6750 531.0000 1.2621 531.1980 1.2621 531.3000 0.6567 531.4980 0.6567 531.6000 1.4675 531.7980 1.4675 531.9000 0.6205 532.0980 0.6205 532.2000 0.8425 532.3980 0.8425 532.5000 0.7513 532.6980 0.7513 532.8000 1.7000 532.9980 1.7000 533.1000 1.4349 533.2980 1.4349 533.4000 1.3321 533.5980 1.3321 533.7000 1.7000 533.8980 1.7000 534.0000 1.7000 534.1980 1.7000 534.3000 1.2229 534.4980 1.2229 534.6000 1.5817 534.7980 1.5817 534.9000 1.5788 535.0980 1.5788 535.2000 1.5637 535.3980 1.5637 535.5000 1.4325 535.6980 1.4325 535.8000 1.3749 535.9980 1.3749 536.1000 1.6693 536.2980 1.6693 536.4000 1.2535 536.5980 1.2535 536.7000 0.7481 536.8980 0.7481 537.0000 1.4976 537.1980 1.4976 537.3000 1.4709 537.4980 1.4709 537.6000 1.2411 537.7980 1.2411 537.9000 1.4328 538.0980 1.4328 538.2000 1.5626 538.3980 1.5626 538.5000 1.7000 538.6980 1.7000 538.8000 1.4233 538.9980 1.4233 539.1000 1.7000 539.2980 1.7000 539.4000 1.7000 539.5980 1.7000 539.7000 1.5984 539.8980 1.5984 540.0000 1.6046 540.1980 1.6046 540.3000 1.7000 540.4980 1.7000 540.6000 1.4777 540.7980 1.4777 540.9000 1.6410 541.0980 1.6410 541.2000 1.5713 541.3980 1.5713 541.5000 1.6263 541.6980 1.6263 541.8000 1.5847 541.9980 1.5847 542.1000 0.9412 542.2980 0.9412 542.4000 1.4821 542.5980 1.4821 542.7000 1.6853 542.8980 1.6853 543.0000 1.3267 543.1980 1.3267 543.3000 1.7000 543.4980 1.7000 543.6000 1.4289 543.7980 1.4289 543.9000 1.6885 544.0980 1.6885 544.2000 1.5314 544.3980 1.5314 544.5000 1.4298 544.6980 1.4298 544.8000 1.5272 544.9980 1.5272 545.1000 1.7000 545.2980 1.7000 545.4000 1.6961 545.5980 1.6961 545.7000 1.3377 545.8980 1.3377 546.0000 1.2777 546.1980 1.2777 546.3000 1.4991 546.4980 1.4991 546.6000 1.7000 546.7980 1.7000 546.9000 1.6417 547.0980 1.6417 547.2000 1.1915 547.3980 1.1915 547.5000 1.1005 547.6980 1.1005 547.8000 0.6180 547.9980 0.6180 548.1000 1.0660 548.2980 1.0660 548.4000 0.7378 548.5980 0.7378 548.7000 0.6382 548.8980 0.6382 549.0000 1.0527 549.1980 1.0527 549.3000 0.6596 549.4980 0.6596 549.6000 0.6613 549.7980 0.6613 549.9000 0.9981 550.0980 0.9981 550.2000 1.4257 550.3980 1.4257 550.5000 0.6601 550.6980 0.6601 550.8000 0.8645 550.9980 0.8645 551.1000 0.6407 551.2980 0.6407 551.4000 1.6989 551.5980 1.6989 551.7000 0.7538 551.8980 0.7538 552.0000 1.2474 552.1980 1.2474 552.3000 0.6750 552.4980 0.6750 552.6000 1.2621 552.7980 1.2621 552.9000 0.6567 553.0980 0.6567 553.2000 1.4675 553.3980 1.4675 553.5000 0.6205 553.6980 0.6205 553.8000 0.8425 553.9980 0.8425 554.1000 0.7513 554.2980 0.7513 554.4000 1.7000 554.5980 1.7000 554.7000 1.4349 554.8980 1.4349 555.0000 1.3321 555.1980 1.3321 555.3000 1.7000 555.4980 1.7000 555.6000 1.7000 555.7980 1.7000 555.9000 1.2229 556.0980 1.2229 556.2000 1.5817 556.3980 1.5817 556.5000 1.5788 556.6980 1.5788 556.8000 1.5637 556.9980 1.5637 557.1000 1.4325 557.2980 1.4325 557.4000 1.3749 557.5980 1.3749 557.7000 1.6693 557.8980 1.6693 558.0000 1.2535 558.1980 1.2535 558.3000 0.7481 558.4980 0.7481 558.6000 1.4976 558.7980 1.4976 558.9000 1.4709 559.0980 1.4709 559.2000 1.2411 559.3980 1.2411 559.5000 1.4328 559.6980 1.4328 559.8000 1.5626 559.9980 1.5626 560.1000 1.7000 560.2980 1.7000 560.4000 1.4233 560.5980 1.4233 560.7000 1.7000 560.8980 1.7000 561.0000 1.7000 561.1980 1.7000 561.3000 1.5984 561.4980 1.5984 561.6000 1.6046 561.7980 1.6046 561.9000 1.7000 562.0980 1.7000 562.2000 1.4777 562.3980 1.4777 562.5000 1.6410 562.6980 1.6410 562.8000 1.5713 562.9980 1.5713 563.1000 1.6263 563.2980 1.6263 563.4000 1.5847 563.5980 1.5847 563.7000 0.9412 563.8980 0.9412 564.0000 1.4821 564.1980 1.4821 564.3000 1.6853 564.4980 1.6853 564.6000 1.3267 564.7980 1.3267 564.9000 1.7000 565.0980 1.7000 565.2000 1.4289 565.3980 1.4289 565.5000 1.6885 565.6980 1.6885 565.8000 1.5314 565.9980 1.5314 566.1000 1.4298 566.2980 1.4298 566.4000 1.5272 566.5980 1.5272 566.7000 1.7000 566.8980 1.7000 567.0000 1.6961 567.1980 1.6961 567.3000 1.3377 567.4980 1.3377 567.6000 1.2777 567.7980 1.2777 567.9000 1.4991 568.0980 1.4991 568.2000 1.7000 568.3980 1.7000 568.5000 1.6417 568.6980 1.6417 568.8000 1.1915 568.9980 1.1915 569.1000 1.1005 569.2980 1.1005 569.4000 0.6180 569.5980 0.6180 569.7000 1.0660 569.8980 1.0660 570.0000 0.7378 570.1980 0.7378 570.3000 0.6382 570.4980 0.6382 570.6000 1.0527 570.7980 1.0527 570.9000 0.6596 571.0980 0.6596 571.2000 0.6613 571.3980 0.6613 571.5000 0.9981 571.6980 0.9981 571.8000 1.4257 571.9980 1.4257 572.1000 0.6601 572.2980 0.6601 572.4000 0.8645 572.5980 0.8645 572.7000 0.6407 572.8980 0.6407 573.0000 1.6989 573.1980 1.6989 573.3000 0.7538 573.4980 0.7538 573.6000 1.2474 573.7980 1.2474 573.9000 0.6750 574.0980 0.6750 574.2000 1.2621 574.3980 1.2621 574.5000 0.6567 574.6980 0.6567 574.8000 1.4675 574.9980 1.4675 575.1000 0.6205 575.2980 0.6205 575.4000 0.8425 575.5980 0.8425 575.7000 0.7513 575.8980 0.7513 576.0000 1.7000 576.1980 1.7000 576.3000 1.4349 576.4980 1.4349 576.6000 1.3321 576.7980 1.3321 576.9000 1.7000 577.0980 1.7000 577.2000 1.7000 577.3980 1.7000 577.5000 1.2229 577.6980 1.2229 577.8000 1.5817 577.9980 1.5817 578.1000 1.5788 578.2980 1.5788 578.4000 1.5637 578.5980 1.5637 578.7000 1.4325 578.8980 1.4325 579.0000 1.3749 579.1980 1.3749 579.3000 1.6693 579.4980 1.6693 579.6000 1.2535 579.7980 1.2535 579.9000 0.7481 580.0980 0.7481 580.2000 1.4976 580.3980 1.4976 580.5000 1.4709 580.6980 1.4709 580.8000 1.2411 580.9980 1.2411 581.1000 1.4328 581.2980 1.4328 581.4000 1.5626 581.5980 1.5626 581.7000 1.7000 581.8980 1.7000 582.0000 1.4233 582.1980 1.4233 582.3000 1.7000 582.4980 1.7000 582.6000 1.7000 582.7980 1.7000 582.9000 1.5984 583.0980 1.5984 583.2000 1.6046 583.3980 1.6046 583.5000 1.7000 583.6980 1.7000 583.8000 1.4777 583.9980 1.4777 584.1000 1.6410 584.2980 1.6410 584.4000 1.5713 584.5980 1.5713 584.7000 1.6263 584.8980 1.6263 585.0000 1.5847 585.1980 1.5847 585.3000 0.9412 585.4980 0.9412 585.6000 1.4821 585.7980 1.4821 585.9000 1.6853 586.0980 1.6853 586.2000 1.3267 586.3980 1.3267 586.5000 1.7000 586.6980 1.7000 586.8000 1.4289 586.9980 1.4289 587.1000 1.6885 587.2980 1.6885 587.4000 1.5314 587.5980 1.5314 587.7000 1.4298 587.8980 1.4298 588.0000 1.5272 588.1980 1.5272 588.3000 1.7000 588.4980 1.7000 588.6000 1.6961 588.7980 1.6961 588.9000 1.3377 589.0980 1.3377 589.2000 1.2777 589.3980 1.2777 589.5000 1.4991 589.6980 1.4991 589.8000 1.7000 589.9980 1.7000 590.1000 1.6417 590.2980 1.6417 590.4000 1.1915 590.5980 1.1915 590.7000 1.1005 590.8980 1.1005 591.0000 0.6180 591.1980 0.6180 591.3000 1.0660 591.4980 1.0660 591.6000 0.7378 591.7980 0.7378 591.9000 0.6382 592.0980 0.6382 592.2000 1.0527 592.3980 1.0527 592.5000 0.6596 592.6980 0.6596 592.8000 0.6613 592.9980 0.6613 593.1000 0.9981 593.2980 0.9981 593.4000 1.4257 593.5980 1.4257 593.7000 0.6601 593.8980 0.6601 594.0000 0.8645 594.1980 0.8645 594.3000 0.6407 594.4980 0.6407 594.6000 1.6989 594.7980 1.6989 594.9000 0.7538 595.0980 0.7538 595.2000 1.2474 595.3980 1.2474 595.5000 0.6750 595.6980 0.6750 595.8000 1.2621 595.9980 1.2621 596.1000 0.6567 596.2980 0.6567 596.4000 1.4675 596.5980 1.4675 596.7000 0.6205 596.8980 0.6205 597.0000 0.8425 597.1980 0.8425 597.3000 0.7513 597.4980 0.7513 597.6000 1.7000 597.7980 1.7000 597.9000 1.4349 598.0980 1.4349 598.2000 1.3321 598.3980 1.3321 598.5000 1.7000 598.6980 1.7000 598.8000 1.7000 598.9980 1.7000 599.1000 1.2229 599.2980 1.2229 599.4000 1.5817 599.5980 1.5817 599.7000 1.5788 599.8980 1.5788 600.0000 1.5788)
Va6 a6 0 PWL(0.0000 0.7429 0.1980 0.7429 0.3000 1.5601 0.4980 1.5601 0.6000 1.4614 0.7980 1.4614 0.9000 1.3138 1.0980 1.3138 1.2000 1.4830 1.3980 1.4830 1.5000 1.2359 1.6980 1.2359 1.8000 1.0681 1.9980 1.0681 2.1000 1.6071 2.2980 1.6071 2.4000 1.5028 2.5980 1.5028 2.7000 1.4491 2.8980 1.4491 3.0000 1.4337 3.1980 1.4337 3.3000 1.5056 3.4980 1.5056 3.6000 1.6606 3.7980 1.6606 3.9000 0.8614 4.0980 0.8614 4.2000 1.7000 4.3980 1.7000 4.5000 1.3429 4.6980 1.3429 4.8000 0.5742 4.9980 0.5742 5.1000 1.4221 5.2980 1.4221 5.4000 1.5060 5.5980 1.5060 5.7000 1.3075 5.8980 1.3075 6.0000 1.5427 6.1980 1.5427 6.3000 1.7000 6.4980 1.7000 6.6000 1.6251 6.7980 1.6251 6.9000 1.3175 7.0980 1.3175 7.2000 1.7000 7.3980 1.7000 7.5000 1.6160 7.6980 1.6160 7.8000 1.7000 7.9980 1.7000 8.1000 1.7000 8.2980 1.7000 8.4000 1.7000 8.5980 1.7000 8.7000 1.7000 8.8980 1.7000 9.0000 1.7000 9.1980 1.7000 9.3000 1.7000 9.4980 1.7000 9.6000 1.7000 9.7980 1.7000 9.9000 1.7000 10.0980 1.7000 10.2000 1.7000 10.3980 1.7000 10.5000 1.7000 10.6980 1.7000 10.8000 1.7000 10.9980 1.7000 11.1000 1.7000 11.2980 1.7000 11.4000 1.3587 11.5980 1.3587 11.7000 1.7000 11.8980 1.7000 12.0000 1.6236 12.1980 1.6236 12.3000 1.7000 12.4980 1.7000 12.6000 1.7000 12.7980 1.7000 12.9000 1.7000 13.0980 1.7000 13.2000 1.3112 13.3980 1.3112 13.5000 1.7000 13.6980 1.7000 13.8000 1.7000 13.9980 1.7000 14.1000 1.7000 14.2980 1.7000 14.4000 1.7000 14.5980 1.7000 14.7000 1.7000 14.8980 1.7000 15.0000 1.7000 15.1980 1.7000 15.3000 1.7000 15.4980 1.7000 15.6000 1.3043 15.7980 1.3043 15.9000 1.7000 16.0980 1.7000 16.2000 1.7000 16.3980 1.7000 16.5000 1.7000 16.6980 1.7000 16.8000 1.7000 16.9980 1.7000 17.1000 1.7000 17.2980 1.7000 17.4000 1.6092 17.5980 1.6092 17.7000 1.6928 17.8980 1.6928 18.0000 1.7000 18.1980 1.7000 18.3000 1.7000 18.4980 1.7000 18.6000 1.4328 18.7980 1.4328 18.9000 1.7000 19.0980 1.7000 19.2000 1.7000 19.3980 1.7000 19.5000 1.7000 19.6980 1.7000 19.8000 1.7000 19.9980 1.7000 20.1000 1.6713 20.2980 1.6713 20.4000 1.7000 20.5980 1.7000 20.7000 1.3017 20.8980 1.3017 21.0000 1.5894 21.1980 1.5894 21.3000 1.7000 21.4980 1.7000 21.6000 0.7429 21.7980 0.7429 21.9000 1.5601 22.0980 1.5601 22.2000 1.4614 22.3980 1.4614 22.5000 1.3138 22.6980 1.3138 22.8000 1.4830 22.9980 1.4830 23.1000 1.2359 23.2980 1.2359 23.4000 1.0681 23.5980 1.0681 23.7000 1.6071 23.8980 1.6071 24.0000 1.5028 24.1980 1.5028 24.3000 1.4491 24.4980 1.4491 24.6000 1.4337 24.7980 1.4337 24.9000 1.5056 25.0980 1.5056 25.2000 1.6606 25.3980 1.6606 25.5000 0.8614 25.6980 0.8614 25.8000 1.7000 25.9980 1.7000 26.1000 1.3429 26.2980 1.3429 26.4000 0.5742 26.5980 0.5742 26.7000 1.4221 26.8980 1.4221 27.0000 1.5060 27.1980 1.5060 27.3000 1.3075 27.4980 1.3075 27.6000 1.5427 27.7980 1.5427 27.9000 1.7000 28.0980 1.7000 28.2000 1.6251 28.3980 1.6251 28.5000 1.3175 28.6980 1.3175 28.8000 1.7000 28.9980 1.7000 29.1000 1.6160 29.2980 1.6160 29.4000 1.7000 29.5980 1.7000 29.7000 1.7000 29.8980 1.7000 30.0000 1.7000 30.1980 1.7000 30.3000 1.7000 30.4980 1.7000 30.6000 1.7000 30.7980 1.7000 30.9000 1.7000 31.0980 1.7000 31.2000 1.7000 31.3980 1.7000 31.5000 1.7000 31.6980 1.7000 31.8000 1.7000 31.9980 1.7000 32.1000 1.7000 32.2980 1.7000 32.4000 1.7000 32.5980 1.7000 32.7000 1.7000 32.8980 1.7000 33.0000 1.3587 33.1980 1.3587 33.3000 1.7000 33.4980 1.7000 33.6000 1.6236 33.7980 1.6236 33.9000 1.7000 34.0980 1.7000 34.2000 1.7000 34.3980 1.7000 34.5000 1.7000 34.6980 1.7000 34.8000 1.3112 34.9980 1.3112 35.1000 1.7000 35.2980 1.7000 35.4000 1.7000 35.5980 1.7000 35.7000 1.7000 35.8980 1.7000 36.0000 1.7000 36.1980 1.7000 36.3000 1.7000 36.4980 1.7000 36.6000 1.7000 36.7980 1.7000 36.9000 1.7000 37.0980 1.7000 37.2000 1.3043 37.3980 1.3043 37.5000 1.7000 37.6980 1.7000 37.8000 1.7000 37.9980 1.7000 38.1000 1.7000 38.2980 1.7000 38.4000 1.7000 38.5980 1.7000 38.7000 1.7000 38.8980 1.7000 39.0000 1.6092 39.1980 1.6092 39.3000 1.6928 39.4980 1.6928 39.6000 1.7000 39.7980 1.7000 39.9000 1.7000 40.0980 1.7000 40.2000 1.4328 40.3980 1.4328 40.5000 1.7000 40.6980 1.7000 40.8000 1.7000 40.9980 1.7000 41.1000 1.7000 41.2980 1.7000 41.4000 1.7000 41.5980 1.7000 41.7000 1.6713 41.8980 1.6713 42.0000 1.7000 42.1980 1.7000 42.3000 1.3017 42.4980 1.3017 42.6000 1.5894 42.7980 1.5894 42.9000 1.7000 43.0980 1.7000 43.2000 0.7429 43.3980 0.7429 43.5000 1.5601 43.6980 1.5601 43.8000 1.4614 43.9980 1.4614 44.1000 1.3138 44.2980 1.3138 44.4000 1.4830 44.5980 1.4830 44.7000 1.2359 44.8980 1.2359 45.0000 1.0681 45.1980 1.0681 45.3000 1.6071 45.4980 1.6071 45.6000 1.5028 45.7980 1.5028 45.9000 1.4491 46.0980 1.4491 46.2000 1.4337 46.3980 1.4337 46.5000 1.5056 46.6980 1.5056 46.8000 1.6606 46.9980 1.6606 47.1000 0.8614 47.2980 0.8614 47.4000 1.7000 47.5980 1.7000 47.7000 1.3429 47.8980 1.3429 48.0000 0.5742 48.1980 0.5742 48.3000 1.4221 48.4980 1.4221 48.6000 1.5060 48.7980 1.5060 48.9000 1.3075 49.0980 1.3075 49.2000 1.5427 49.3980 1.5427 49.5000 1.7000 49.6980 1.7000 49.8000 1.6251 49.9980 1.6251 50.1000 1.3175 50.2980 1.3175 50.4000 1.7000 50.5980 1.7000 50.7000 1.6160 50.8980 1.6160 51.0000 1.7000 51.1980 1.7000 51.3000 1.7000 51.4980 1.7000 51.6000 1.7000 51.7980 1.7000 51.9000 1.7000 52.0980 1.7000 52.2000 1.7000 52.3980 1.7000 52.5000 1.7000 52.6980 1.7000 52.8000 1.7000 52.9980 1.7000 53.1000 1.7000 53.2980 1.7000 53.4000 1.7000 53.5980 1.7000 53.7000 1.7000 53.8980 1.7000 54.0000 1.7000 54.1980 1.7000 54.3000 1.7000 54.4980 1.7000 54.6000 1.3587 54.7980 1.3587 54.9000 1.7000 55.0980 1.7000 55.2000 1.6236 55.3980 1.6236 55.5000 1.7000 55.6980 1.7000 55.8000 1.7000 55.9980 1.7000 56.1000 1.7000 56.2980 1.7000 56.4000 1.3112 56.5980 1.3112 56.7000 1.7000 56.8980 1.7000 57.0000 1.7000 57.1980 1.7000 57.3000 1.7000 57.4980 1.7000 57.6000 1.7000 57.7980 1.7000 57.9000 1.7000 58.0980 1.7000 58.2000 1.7000 58.3980 1.7000 58.5000 1.7000 58.6980 1.7000 58.8000 1.3043 58.9980 1.3043 59.1000 1.7000 59.2980 1.7000 59.4000 1.7000 59.5980 1.7000 59.7000 1.7000 59.8980 1.7000 60.0000 1.7000 60.1980 1.7000 60.3000 1.7000 60.4980 1.7000 60.6000 1.6092 60.7980 1.6092 60.9000 1.6928 61.0980 1.6928 61.2000 1.7000 61.3980 1.7000 61.5000 1.7000 61.6980 1.7000 61.8000 1.4328 61.9980 1.4328 62.1000 1.7000 62.2980 1.7000 62.4000 1.7000 62.5980 1.7000 62.7000 1.7000 62.8980 1.7000 63.0000 1.7000 63.1980 1.7000 63.3000 1.6713 63.4980 1.6713 63.6000 1.7000 63.7980 1.7000 63.9000 1.3017 64.0980 1.3017 64.2000 1.5894 64.3980 1.5894 64.5000 1.7000 64.6980 1.7000 64.8000 0.7429 64.9980 0.7429 65.1000 1.5601 65.2980 1.5601 65.4000 1.4614 65.5980 1.4614 65.7000 1.3138 65.8980 1.3138 66.0000 1.4830 66.1980 1.4830 66.3000 1.2359 66.4980 1.2359 66.6000 1.0681 66.7980 1.0681 66.9000 1.6071 67.0980 1.6071 67.2000 1.5028 67.3980 1.5028 67.5000 1.4491 67.6980 1.4491 67.8000 1.4337 67.9980 1.4337 68.1000 1.5056 68.2980 1.5056 68.4000 1.6606 68.5980 1.6606 68.7000 0.8614 68.8980 0.8614 69.0000 1.7000 69.1980 1.7000 69.3000 1.3429 69.4980 1.3429 69.6000 0.5742 69.7980 0.5742 69.9000 1.4221 70.0980 1.4221 70.2000 1.5060 70.3980 1.5060 70.5000 1.3075 70.6980 1.3075 70.8000 1.5427 70.9980 1.5427 71.1000 1.7000 71.2980 1.7000 71.4000 1.6251 71.5980 1.6251 71.7000 1.3175 71.8980 1.3175 72.0000 1.7000 72.1980 1.7000 72.3000 1.6160 72.4980 1.6160 72.6000 1.7000 72.7980 1.7000 72.9000 1.7000 73.0980 1.7000 73.2000 1.7000 73.3980 1.7000 73.5000 1.7000 73.6980 1.7000 73.8000 1.7000 73.9980 1.7000 74.1000 1.7000 74.2980 1.7000 74.4000 1.7000 74.5980 1.7000 74.7000 1.7000 74.8980 1.7000 75.0000 1.7000 75.1980 1.7000 75.3000 1.7000 75.4980 1.7000 75.6000 1.7000 75.7980 1.7000 75.9000 1.7000 76.0980 1.7000 76.2000 1.3587 76.3980 1.3587 76.5000 1.7000 76.6980 1.7000 76.8000 1.6236 76.9980 1.6236 77.1000 1.7000 77.2980 1.7000 77.4000 1.7000 77.5980 1.7000 77.7000 1.7000 77.8980 1.7000 78.0000 1.3112 78.1980 1.3112 78.3000 1.7000 78.4980 1.7000 78.6000 1.7000 78.7980 1.7000 78.9000 1.7000 79.0980 1.7000 79.2000 1.7000 79.3980 1.7000 79.5000 1.7000 79.6980 1.7000 79.8000 1.7000 79.9980 1.7000 80.1000 1.7000 80.2980 1.7000 80.4000 1.3043 80.5980 1.3043 80.7000 1.7000 80.8980 1.7000 81.0000 1.7000 81.1980 1.7000 81.3000 1.7000 81.4980 1.7000 81.6000 1.7000 81.7980 1.7000 81.9000 1.7000 82.0980 1.7000 82.2000 1.6092 82.3980 1.6092 82.5000 1.6928 82.6980 1.6928 82.8000 1.7000 82.9980 1.7000 83.1000 1.7000 83.2980 1.7000 83.4000 1.4328 83.5980 1.4328 83.7000 1.7000 83.8980 1.7000 84.0000 1.7000 84.1980 1.7000 84.3000 1.7000 84.4980 1.7000 84.6000 1.7000 84.7980 1.7000 84.9000 1.6713 85.0980 1.6713 85.2000 1.7000 85.3980 1.7000 85.5000 1.3017 85.6980 1.3017 85.8000 1.5894 85.9980 1.5894 86.1000 1.7000 86.2980 1.7000 86.4000 0.7429 86.5980 0.7429 86.7000 1.5601 86.8980 1.5601 87.0000 1.4614 87.1980 1.4614 87.3000 1.3138 87.4980 1.3138 87.6000 1.4830 87.7980 1.4830 87.9000 1.2359 88.0980 1.2359 88.2000 1.0681 88.3980 1.0681 88.5000 1.6071 88.6980 1.6071 88.8000 1.5028 88.9980 1.5028 89.1000 1.4491 89.2980 1.4491 89.4000 1.4337 89.5980 1.4337 89.7000 1.5056 89.8980 1.5056 90.0000 1.6606 90.1980 1.6606 90.3000 0.8614 90.4980 0.8614 90.6000 1.7000 90.7980 1.7000 90.9000 1.3429 91.0980 1.3429 91.2000 0.5742 91.3980 0.5742 91.5000 1.4221 91.6980 1.4221 91.8000 1.5060 91.9980 1.5060 92.1000 1.3075 92.2980 1.3075 92.4000 1.5427 92.5980 1.5427 92.7000 1.7000 92.8980 1.7000 93.0000 1.6251 93.1980 1.6251 93.3000 1.3175 93.4980 1.3175 93.6000 1.7000 93.7980 1.7000 93.9000 1.6160 94.0980 1.6160 94.2000 1.7000 94.3980 1.7000 94.5000 1.7000 94.6980 1.7000 94.8000 1.7000 94.9980 1.7000 95.1000 1.7000 95.2980 1.7000 95.4000 1.7000 95.5980 1.7000 95.7000 1.7000 95.8980 1.7000 96.0000 1.7000 96.1980 1.7000 96.3000 1.7000 96.4980 1.7000 96.6000 1.7000 96.7980 1.7000 96.9000 1.7000 97.0980 1.7000 97.2000 1.7000 97.3980 1.7000 97.5000 1.7000 97.6980 1.7000 97.8000 1.3587 97.9980 1.3587 98.1000 1.7000 98.2980 1.7000 98.4000 1.6236 98.5980 1.6236 98.7000 1.7000 98.8980 1.7000 99.0000 1.7000 99.1980 1.7000 99.3000 1.7000 99.4980 1.7000 99.6000 1.3112 99.7980 1.3112 99.9000 1.7000 100.0980 1.7000 100.2000 1.7000 100.3980 1.7000 100.5000 1.7000 100.6980 1.7000 100.8000 1.7000 100.9980 1.7000 101.1000 1.7000 101.2980 1.7000 101.4000 1.7000 101.5980 1.7000 101.7000 1.7000 101.8980 1.7000 102.0000 1.3043 102.1980 1.3043 102.3000 1.7000 102.4980 1.7000 102.6000 1.7000 102.7980 1.7000 102.9000 1.7000 103.0980 1.7000 103.2000 1.7000 103.3980 1.7000 103.5000 1.7000 103.6980 1.7000 103.8000 1.6092 103.9980 1.6092 104.1000 1.6928 104.2980 1.6928 104.4000 1.7000 104.5980 1.7000 104.7000 1.7000 104.8980 1.7000 105.0000 1.4328 105.1980 1.4328 105.3000 1.7000 105.4980 1.7000 105.6000 1.7000 105.7980 1.7000 105.9000 1.7000 106.0980 1.7000 106.2000 1.7000 106.3980 1.7000 106.5000 1.6713 106.6980 1.6713 106.8000 1.7000 106.9980 1.7000 107.1000 1.3017 107.2980 1.3017 107.4000 1.5894 107.5980 1.5894 107.7000 1.7000 107.8980 1.7000 108.0000 0.7429 108.1980 0.7429 108.3000 1.5601 108.4980 1.5601 108.6000 1.4614 108.7980 1.4614 108.9000 1.3138 109.0980 1.3138 109.2000 1.4830 109.3980 1.4830 109.5000 1.2359 109.6980 1.2359 109.8000 1.0681 109.9980 1.0681 110.1000 1.6071 110.2980 1.6071 110.4000 1.5028 110.5980 1.5028 110.7000 1.4491 110.8980 1.4491 111.0000 1.4337 111.1980 1.4337 111.3000 1.5056 111.4980 1.5056 111.6000 1.6606 111.7980 1.6606 111.9000 0.8614 112.0980 0.8614 112.2000 1.7000 112.3980 1.7000 112.5000 1.3429 112.6980 1.3429 112.8000 0.5742 112.9980 0.5742 113.1000 1.4221 113.2980 1.4221 113.4000 1.5060 113.5980 1.5060 113.7000 1.3075 113.8980 1.3075 114.0000 1.5427 114.1980 1.5427 114.3000 1.7000 114.4980 1.7000 114.6000 1.6251 114.7980 1.6251 114.9000 1.3175 115.0980 1.3175 115.2000 1.7000 115.3980 1.7000 115.5000 1.6160 115.6980 1.6160 115.8000 1.7000 115.9980 1.7000 116.1000 1.7000 116.2980 1.7000 116.4000 1.7000 116.5980 1.7000 116.7000 1.7000 116.8980 1.7000 117.0000 1.7000 117.1980 1.7000 117.3000 1.7000 117.4980 1.7000 117.6000 1.7000 117.7980 1.7000 117.9000 1.7000 118.0980 1.7000 118.2000 1.7000 118.3980 1.7000 118.5000 1.7000 118.6980 1.7000 118.8000 1.7000 118.9980 1.7000 119.1000 1.7000 119.2980 1.7000 119.4000 1.3587 119.5980 1.3587 119.7000 1.7000 119.8980 1.7000 120.0000 1.6236 120.1980 1.6236 120.3000 1.7000 120.4980 1.7000 120.6000 1.7000 120.7980 1.7000 120.9000 1.7000 121.0980 1.7000 121.2000 1.3112 121.3980 1.3112 121.5000 1.7000 121.6980 1.7000 121.8000 1.7000 121.9980 1.7000 122.1000 1.7000 122.2980 1.7000 122.4000 1.7000 122.5980 1.7000 122.7000 1.7000 122.8980 1.7000 123.0000 1.7000 123.1980 1.7000 123.3000 1.7000 123.4980 1.7000 123.6000 1.3043 123.7980 1.3043 123.9000 1.7000 124.0980 1.7000 124.2000 1.7000 124.3980 1.7000 124.5000 1.7000 124.6980 1.7000 124.8000 1.7000 124.9980 1.7000 125.1000 1.7000 125.2980 1.7000 125.4000 1.6092 125.5980 1.6092 125.7000 1.6928 125.8980 1.6928 126.0000 1.7000 126.1980 1.7000 126.3000 1.7000 126.4980 1.7000 126.6000 1.4328 126.7980 1.4328 126.9000 1.7000 127.0980 1.7000 127.2000 1.7000 127.3980 1.7000 127.5000 1.7000 127.6980 1.7000 127.8000 1.7000 127.9980 1.7000 128.1000 1.6713 128.2980 1.6713 128.4000 1.7000 128.5980 1.7000 128.7000 1.3017 128.8980 1.3017 129.0000 1.5894 129.1980 1.5894 129.3000 1.7000 129.4980 1.7000 129.6000 0.7429 129.7980 0.7429 129.9000 1.5601 130.0980 1.5601 130.2000 1.4614 130.3980 1.4614 130.5000 1.3138 130.6980 1.3138 130.8000 1.4830 130.9980 1.4830 131.1000 1.2359 131.2980 1.2359 131.4000 1.0681 131.5980 1.0681 131.7000 1.6071 131.8980 1.6071 132.0000 1.5028 132.1980 1.5028 132.3000 1.4491 132.4980 1.4491 132.6000 1.4337 132.7980 1.4337 132.9000 1.5056 133.0980 1.5056 133.2000 1.6606 133.3980 1.6606 133.5000 0.8614 133.6980 0.8614 133.8000 1.7000 133.9980 1.7000 134.1000 1.3429 134.2980 1.3429 134.4000 0.5742 134.5980 0.5742 134.7000 1.4221 134.8980 1.4221 135.0000 1.5060 135.1980 1.5060 135.3000 1.3075 135.4980 1.3075 135.6000 1.5427 135.7980 1.5427 135.9000 1.7000 136.0980 1.7000 136.2000 1.6251 136.3980 1.6251 136.5000 1.3175 136.6980 1.3175 136.8000 1.7000 136.9980 1.7000 137.1000 1.6160 137.2980 1.6160 137.4000 1.7000 137.5980 1.7000 137.7000 1.7000 137.8980 1.7000 138.0000 1.7000 138.1980 1.7000 138.3000 1.7000 138.4980 1.7000 138.6000 1.7000 138.7980 1.7000 138.9000 1.7000 139.0980 1.7000 139.2000 1.7000 139.3980 1.7000 139.5000 1.7000 139.6980 1.7000 139.8000 1.7000 139.9980 1.7000 140.1000 1.7000 140.2980 1.7000 140.4000 1.7000 140.5980 1.7000 140.7000 1.7000 140.8980 1.7000 141.0000 1.3587 141.1980 1.3587 141.3000 1.7000 141.4980 1.7000 141.6000 1.6236 141.7980 1.6236 141.9000 1.7000 142.0980 1.7000 142.2000 1.7000 142.3980 1.7000 142.5000 1.7000 142.6980 1.7000 142.8000 1.3112 142.9980 1.3112 143.1000 1.7000 143.2980 1.7000 143.4000 1.7000 143.5980 1.7000 143.7000 1.7000 143.8980 1.7000 144.0000 1.7000 144.1980 1.7000 144.3000 1.7000 144.4980 1.7000 144.6000 1.7000 144.7980 1.7000 144.9000 1.7000 145.0980 1.7000 145.2000 1.3043 145.3980 1.3043 145.5000 1.7000 145.6980 1.7000 145.8000 1.7000 145.9980 1.7000 146.1000 1.7000 146.2980 1.7000 146.4000 1.7000 146.5980 1.7000 146.7000 1.7000 146.8980 1.7000 147.0000 1.6092 147.1980 1.6092 147.3000 1.6928 147.4980 1.6928 147.6000 1.7000 147.7980 1.7000 147.9000 1.7000 148.0980 1.7000 148.2000 1.4328 148.3980 1.4328 148.5000 1.7000 148.6980 1.7000 148.8000 1.7000 148.9980 1.7000 149.1000 1.7000 149.2980 1.7000 149.4000 1.7000 149.5980 1.7000 149.7000 1.6713 149.8980 1.6713 150.0000 1.7000 150.1980 1.7000 150.3000 1.3017 150.4980 1.3017 150.6000 1.5894 150.7980 1.5894 150.9000 1.7000 151.0980 1.7000 151.2000 0.7429 151.3980 0.7429 151.5000 1.5601 151.6980 1.5601 151.8000 1.4614 151.9980 1.4614 152.1000 1.3138 152.2980 1.3138 152.4000 1.4830 152.5980 1.4830 152.7000 1.2359 152.8980 1.2359 153.0000 1.0681 153.1980 1.0681 153.3000 1.6071 153.4980 1.6071 153.6000 1.5028 153.7980 1.5028 153.9000 1.4491 154.0980 1.4491 154.2000 1.4337 154.3980 1.4337 154.5000 1.5056 154.6980 1.5056 154.8000 1.6606 154.9980 1.6606 155.1000 0.8614 155.2980 0.8614 155.4000 1.7000 155.5980 1.7000 155.7000 1.3429 155.8980 1.3429 156.0000 0.5742 156.1980 0.5742 156.3000 1.4221 156.4980 1.4221 156.6000 1.5060 156.7980 1.5060 156.9000 1.3075 157.0980 1.3075 157.2000 1.5427 157.3980 1.5427 157.5000 1.7000 157.6980 1.7000 157.8000 1.6251 157.9980 1.6251 158.1000 1.3175 158.2980 1.3175 158.4000 1.7000 158.5980 1.7000 158.7000 1.6160 158.8980 1.6160 159.0000 1.7000 159.1980 1.7000 159.3000 1.7000 159.4980 1.7000 159.6000 1.7000 159.7980 1.7000 159.9000 1.7000 160.0980 1.7000 160.2000 1.7000 160.3980 1.7000 160.5000 1.7000 160.6980 1.7000 160.8000 1.7000 160.9980 1.7000 161.1000 1.7000 161.2980 1.7000 161.4000 1.7000 161.5980 1.7000 161.7000 1.7000 161.8980 1.7000 162.0000 1.7000 162.1980 1.7000 162.3000 1.7000 162.4980 1.7000 162.6000 1.3587 162.7980 1.3587 162.9000 1.7000 163.0980 1.7000 163.2000 1.6236 163.3980 1.6236 163.5000 1.7000 163.6980 1.7000 163.8000 1.7000 163.9980 1.7000 164.1000 1.7000 164.2980 1.7000 164.4000 1.3112 164.5980 1.3112 164.7000 1.7000 164.8980 1.7000 165.0000 1.7000 165.1980 1.7000 165.3000 1.7000 165.4980 1.7000 165.6000 1.7000 165.7980 1.7000 165.9000 1.7000 166.0980 1.7000 166.2000 1.7000 166.3980 1.7000 166.5000 1.7000 166.6980 1.7000 166.8000 1.3043 166.9980 1.3043 167.1000 1.7000 167.2980 1.7000 167.4000 1.7000 167.5980 1.7000 167.7000 1.7000 167.8980 1.7000 168.0000 1.7000 168.1980 1.7000 168.3000 1.7000 168.4980 1.7000 168.6000 1.6092 168.7980 1.6092 168.9000 1.6928 169.0980 1.6928 169.2000 1.7000 169.3980 1.7000 169.5000 1.7000 169.6980 1.7000 169.8000 1.4328 169.9980 1.4328 170.1000 1.7000 170.2980 1.7000 170.4000 1.7000 170.5980 1.7000 170.7000 1.7000 170.8980 1.7000 171.0000 1.7000 171.1980 1.7000 171.3000 1.6713 171.4980 1.6713 171.6000 1.7000 171.7980 1.7000 171.9000 1.3017 172.0980 1.3017 172.2000 1.5894 172.3980 1.5894 172.5000 1.7000 172.6980 1.7000 172.8000 0.7429 172.9980 0.7429 173.1000 1.5601 173.2980 1.5601 173.4000 1.4614 173.5980 1.4614 173.7000 1.3138 173.8980 1.3138 174.0000 1.4830 174.1980 1.4830 174.3000 1.2359 174.4980 1.2359 174.6000 1.0681 174.7980 1.0681 174.9000 1.6071 175.0980 1.6071 175.2000 1.5028 175.3980 1.5028 175.5000 1.4491 175.6980 1.4491 175.8000 1.4337 175.9980 1.4337 176.1000 1.5056 176.2980 1.5056 176.4000 1.6606 176.5980 1.6606 176.7000 0.8614 176.8980 0.8614 177.0000 1.7000 177.1980 1.7000 177.3000 1.3429 177.4980 1.3429 177.6000 0.5742 177.7980 0.5742 177.9000 1.4221 178.0980 1.4221 178.2000 1.5060 178.3980 1.5060 178.5000 1.3075 178.6980 1.3075 178.8000 1.5427 178.9980 1.5427 179.1000 1.7000 179.2980 1.7000 179.4000 1.6251 179.5980 1.6251 179.7000 1.3175 179.8980 1.3175 180.0000 1.7000 180.1980 1.7000 180.3000 1.6160 180.4980 1.6160 180.6000 1.7000 180.7980 1.7000 180.9000 1.7000 181.0980 1.7000 181.2000 1.7000 181.3980 1.7000 181.5000 1.7000 181.6980 1.7000 181.8000 1.7000 181.9980 1.7000 182.1000 1.7000 182.2980 1.7000 182.4000 1.7000 182.5980 1.7000 182.7000 1.7000 182.8980 1.7000 183.0000 1.7000 183.1980 1.7000 183.3000 1.7000 183.4980 1.7000 183.6000 1.7000 183.7980 1.7000 183.9000 1.7000 184.0980 1.7000 184.2000 1.3587 184.3980 1.3587 184.5000 1.7000 184.6980 1.7000 184.8000 1.6236 184.9980 1.6236 185.1000 1.7000 185.2980 1.7000 185.4000 1.7000 185.5980 1.7000 185.7000 1.7000 185.8980 1.7000 186.0000 1.3112 186.1980 1.3112 186.3000 1.7000 186.4980 1.7000 186.6000 1.7000 186.7980 1.7000 186.9000 1.7000 187.0980 1.7000 187.2000 1.7000 187.3980 1.7000 187.5000 1.7000 187.6980 1.7000 187.8000 1.7000 187.9980 1.7000 188.1000 1.7000 188.2980 1.7000 188.4000 1.3043 188.5980 1.3043 188.7000 1.7000 188.8980 1.7000 189.0000 1.7000 189.1980 1.7000 189.3000 1.7000 189.4980 1.7000 189.6000 1.7000 189.7980 1.7000 189.9000 1.7000 190.0980 1.7000 190.2000 1.6092 190.3980 1.6092 190.5000 1.6928 190.6980 1.6928 190.8000 1.7000 190.9980 1.7000 191.1000 1.7000 191.2980 1.7000 191.4000 1.4328 191.5980 1.4328 191.7000 1.7000 191.8980 1.7000 192.0000 1.7000 192.1980 1.7000 192.3000 1.7000 192.4980 1.7000 192.6000 1.7000 192.7980 1.7000 192.9000 1.6713 193.0980 1.6713 193.2000 1.7000 193.3980 1.7000 193.5000 1.3017 193.6980 1.3017 193.8000 1.5894 193.9980 1.5894 194.1000 1.7000 194.2980 1.7000 194.4000 0.7429 194.5980 0.7429 194.7000 1.5601 194.8980 1.5601 195.0000 1.4614 195.1980 1.4614 195.3000 1.3138 195.4980 1.3138 195.6000 1.4830 195.7980 1.4830 195.9000 1.2359 196.0980 1.2359 196.2000 1.0681 196.3980 1.0681 196.5000 1.6071 196.6980 1.6071 196.8000 1.5028 196.9980 1.5028 197.1000 1.4491 197.2980 1.4491 197.4000 1.4337 197.5980 1.4337 197.7000 1.5056 197.8980 1.5056 198.0000 1.6606 198.1980 1.6606 198.3000 0.8614 198.4980 0.8614 198.6000 1.7000 198.7980 1.7000 198.9000 1.3429 199.0980 1.3429 199.2000 0.5742 199.3980 0.5742 199.5000 1.4221 199.6980 1.4221 199.8000 1.5060 199.9980 1.5060 200.1000 1.3075 200.2980 1.3075 200.4000 1.5427 200.5980 1.5427 200.7000 1.7000 200.8980 1.7000 201.0000 1.6251 201.1980 1.6251 201.3000 1.3175 201.4980 1.3175 201.6000 1.7000 201.7980 1.7000 201.9000 1.6160 202.0980 1.6160 202.2000 1.7000 202.3980 1.7000 202.5000 1.7000 202.6980 1.7000 202.8000 1.7000 202.9980 1.7000 203.1000 1.7000 203.2980 1.7000 203.4000 1.7000 203.5980 1.7000 203.7000 1.7000 203.8980 1.7000 204.0000 1.7000 204.1980 1.7000 204.3000 1.7000 204.4980 1.7000 204.6000 1.7000 204.7980 1.7000 204.9000 1.7000 205.0980 1.7000 205.2000 1.7000 205.3980 1.7000 205.5000 1.7000 205.6980 1.7000 205.8000 1.3587 205.9980 1.3587 206.1000 1.7000 206.2980 1.7000 206.4000 1.6236 206.5980 1.6236 206.7000 1.7000 206.8980 1.7000 207.0000 1.7000 207.1980 1.7000 207.3000 1.7000 207.4980 1.7000 207.6000 1.3112 207.7980 1.3112 207.9000 1.7000 208.0980 1.7000 208.2000 1.7000 208.3980 1.7000 208.5000 1.7000 208.6980 1.7000 208.8000 1.7000 208.9980 1.7000 209.1000 1.7000 209.2980 1.7000 209.4000 1.7000 209.5980 1.7000 209.7000 1.7000 209.8980 1.7000 210.0000 1.3043 210.1980 1.3043 210.3000 1.7000 210.4980 1.7000 210.6000 1.7000 210.7980 1.7000 210.9000 1.7000 211.0980 1.7000 211.2000 1.7000 211.3980 1.7000 211.5000 1.7000 211.6980 1.7000 211.8000 1.6092 211.9980 1.6092 212.1000 1.6928 212.2980 1.6928 212.4000 1.7000 212.5980 1.7000 212.7000 1.7000 212.8980 1.7000 213.0000 1.4328 213.1980 1.4328 213.3000 1.7000 213.4980 1.7000 213.6000 1.7000 213.7980 1.7000 213.9000 1.7000 214.0980 1.7000 214.2000 1.7000 214.3980 1.7000 214.5000 1.6713 214.6980 1.6713 214.8000 1.7000 214.9980 1.7000 215.1000 1.3017 215.2980 1.3017 215.4000 1.5894 215.5980 1.5894 215.7000 1.7000 215.8980 1.7000 216.0000 0.7429 216.1980 0.7429 216.3000 1.5601 216.4980 1.5601 216.6000 1.4614 216.7980 1.4614 216.9000 1.3138 217.0980 1.3138 217.2000 1.4830 217.3980 1.4830 217.5000 1.2359 217.6980 1.2359 217.8000 1.0681 217.9980 1.0681 218.1000 1.6071 218.2980 1.6071 218.4000 1.5028 218.5980 1.5028 218.7000 1.4491 218.8980 1.4491 219.0000 1.4337 219.1980 1.4337 219.3000 1.5056 219.4980 1.5056 219.6000 1.6606 219.7980 1.6606 219.9000 0.8614 220.0980 0.8614 220.2000 1.7000 220.3980 1.7000 220.5000 1.3429 220.6980 1.3429 220.8000 0.5742 220.9980 0.5742 221.1000 1.4221 221.2980 1.4221 221.4000 1.5060 221.5980 1.5060 221.7000 1.3075 221.8980 1.3075 222.0000 1.5427 222.1980 1.5427 222.3000 1.7000 222.4980 1.7000 222.6000 1.6251 222.7980 1.6251 222.9000 1.3175 223.0980 1.3175 223.2000 1.7000 223.3980 1.7000 223.5000 1.6160 223.6980 1.6160 223.8000 1.7000 223.9980 1.7000 224.1000 1.7000 224.2980 1.7000 224.4000 1.7000 224.5980 1.7000 224.7000 1.7000 224.8980 1.7000 225.0000 1.7000 225.1980 1.7000 225.3000 1.7000 225.4980 1.7000 225.6000 1.7000 225.7980 1.7000 225.9000 1.7000 226.0980 1.7000 226.2000 1.7000 226.3980 1.7000 226.5000 1.7000 226.6980 1.7000 226.8000 1.7000 226.9980 1.7000 227.1000 1.7000 227.2980 1.7000 227.4000 1.3587 227.5980 1.3587 227.7000 1.7000 227.8980 1.7000 228.0000 1.6236 228.1980 1.6236 228.3000 1.7000 228.4980 1.7000 228.6000 1.7000 228.7980 1.7000 228.9000 1.7000 229.0980 1.7000 229.2000 1.3112 229.3980 1.3112 229.5000 1.7000 229.6980 1.7000 229.8000 1.7000 229.9980 1.7000 230.1000 1.7000 230.2980 1.7000 230.4000 1.7000 230.5980 1.7000 230.7000 1.7000 230.8980 1.7000 231.0000 1.7000 231.1980 1.7000 231.3000 1.7000 231.4980 1.7000 231.6000 1.3043 231.7980 1.3043 231.9000 1.7000 232.0980 1.7000 232.2000 1.7000 232.3980 1.7000 232.5000 1.7000 232.6980 1.7000 232.8000 1.7000 232.9980 1.7000 233.1000 1.7000 233.2980 1.7000 233.4000 1.6092 233.5980 1.6092 233.7000 1.6928 233.8980 1.6928 234.0000 1.7000 234.1980 1.7000 234.3000 1.7000 234.4980 1.7000 234.6000 1.4328 234.7980 1.4328 234.9000 1.7000 235.0980 1.7000 235.2000 1.7000 235.3980 1.7000 235.5000 1.7000 235.6980 1.7000 235.8000 1.7000 235.9980 1.7000 236.1000 1.6713 236.2980 1.6713 236.4000 1.7000 236.5980 1.7000 236.7000 1.3017 236.8980 1.3017 237.0000 1.5894 237.1980 1.5894 237.3000 1.7000 237.4980 1.7000 237.6000 0.7429 237.7980 0.7429 237.9000 1.5601 238.0980 1.5601 238.2000 1.4614 238.3980 1.4614 238.5000 1.3138 238.6980 1.3138 238.8000 1.4830 238.9980 1.4830 239.1000 1.2359 239.2980 1.2359 239.4000 1.0681 239.5980 1.0681 239.7000 1.6071 239.8980 1.6071 240.0000 1.5028 240.1980 1.5028 240.3000 1.4491 240.4980 1.4491 240.6000 1.4337 240.7980 1.4337 240.9000 1.5056 241.0980 1.5056 241.2000 1.6606 241.3980 1.6606 241.5000 0.8614 241.6980 0.8614 241.8000 1.7000 241.9980 1.7000 242.1000 1.3429 242.2980 1.3429 242.4000 0.5742 242.5980 0.5742 242.7000 1.4221 242.8980 1.4221 243.0000 1.5060 243.1980 1.5060 243.3000 1.3075 243.4980 1.3075 243.6000 1.5427 243.7980 1.5427 243.9000 1.7000 244.0980 1.7000 244.2000 1.6251 244.3980 1.6251 244.5000 1.3175 244.6980 1.3175 244.8000 1.7000 244.9980 1.7000 245.1000 1.6160 245.2980 1.6160 245.4000 1.7000 245.5980 1.7000 245.7000 1.7000 245.8980 1.7000 246.0000 1.7000 246.1980 1.7000 246.3000 1.7000 246.4980 1.7000 246.6000 1.7000 246.7980 1.7000 246.9000 1.7000 247.0980 1.7000 247.2000 1.7000 247.3980 1.7000 247.5000 1.7000 247.6980 1.7000 247.8000 1.7000 247.9980 1.7000 248.1000 1.7000 248.2980 1.7000 248.4000 1.7000 248.5980 1.7000 248.7000 1.7000 248.8980 1.7000 249.0000 1.3587 249.1980 1.3587 249.3000 1.7000 249.4980 1.7000 249.6000 1.6236 249.7980 1.6236 249.9000 1.7000 250.0980 1.7000 250.2000 1.7000 250.3980 1.7000 250.5000 1.7000 250.6980 1.7000 250.8000 1.3112 250.9980 1.3112 251.1000 1.7000 251.2980 1.7000 251.4000 1.7000 251.5980 1.7000 251.7000 1.7000 251.8980 1.7000 252.0000 1.7000 252.1980 1.7000 252.3000 1.7000 252.4980 1.7000 252.6000 1.7000 252.7980 1.7000 252.9000 1.7000 253.0980 1.7000 253.2000 1.3043 253.3980 1.3043 253.5000 1.7000 253.6980 1.7000 253.8000 1.7000 253.9980 1.7000 254.1000 1.7000 254.2980 1.7000 254.4000 1.7000 254.5980 1.7000 254.7000 1.7000 254.8980 1.7000 255.0000 1.6092 255.1980 1.6092 255.3000 1.6928 255.4980 1.6928 255.6000 1.7000 255.7980 1.7000 255.9000 1.7000 256.0980 1.7000 256.2000 1.4328 256.3980 1.4328 256.5000 1.7000 256.6980 1.7000 256.8000 1.7000 256.9980 1.7000 257.1000 1.7000 257.2980 1.7000 257.4000 1.7000 257.5980 1.7000 257.7000 1.6713 257.8980 1.6713 258.0000 1.7000 258.1980 1.7000 258.3000 1.3017 258.4980 1.3017 258.6000 1.5894 258.7980 1.5894 258.9000 1.7000 259.0980 1.7000 259.2000 0.7429 259.3980 0.7429 259.5000 1.5601 259.6980 1.5601 259.8000 1.4614 259.9980 1.4614 260.1000 1.3138 260.2980 1.3138 260.4000 1.4830 260.5980 1.4830 260.7000 1.2359 260.8980 1.2359 261.0000 1.0681 261.1980 1.0681 261.3000 1.6071 261.4980 1.6071 261.6000 1.5028 261.7980 1.5028 261.9000 1.4491 262.0980 1.4491 262.2000 1.4337 262.3980 1.4337 262.5000 1.5056 262.6980 1.5056 262.8000 1.6606 262.9980 1.6606 263.1000 0.8614 263.2980 0.8614 263.4000 1.7000 263.5980 1.7000 263.7000 1.3429 263.8980 1.3429 264.0000 0.5742 264.1980 0.5742 264.3000 1.4221 264.4980 1.4221 264.6000 1.5060 264.7980 1.5060 264.9000 1.3075 265.0980 1.3075 265.2000 1.5427 265.3980 1.5427 265.5000 1.7000 265.6980 1.7000 265.8000 1.6251 265.9980 1.6251 266.1000 1.3175 266.2980 1.3175 266.4000 1.7000 266.5980 1.7000 266.7000 1.6160 266.8980 1.6160 267.0000 1.7000 267.1980 1.7000 267.3000 1.7000 267.4980 1.7000 267.6000 1.7000 267.7980 1.7000 267.9000 1.7000 268.0980 1.7000 268.2000 1.7000 268.3980 1.7000 268.5000 1.7000 268.6980 1.7000 268.8000 1.7000 268.9980 1.7000 269.1000 1.7000 269.2980 1.7000 269.4000 1.7000 269.5980 1.7000 269.7000 1.7000 269.8980 1.7000 270.0000 1.7000 270.1980 1.7000 270.3000 1.7000 270.4980 1.7000 270.6000 1.3587 270.7980 1.3587 270.9000 1.7000 271.0980 1.7000 271.2000 1.6236 271.3980 1.6236 271.5000 1.7000 271.6980 1.7000 271.8000 1.7000 271.9980 1.7000 272.1000 1.7000 272.2980 1.7000 272.4000 1.3112 272.5980 1.3112 272.7000 1.7000 272.8980 1.7000 273.0000 1.7000 273.1980 1.7000 273.3000 1.7000 273.4980 1.7000 273.6000 1.7000 273.7980 1.7000 273.9000 1.7000 274.0980 1.7000 274.2000 1.7000 274.3980 1.7000 274.5000 1.7000 274.6980 1.7000 274.8000 1.3043 274.9980 1.3043 275.1000 1.7000 275.2980 1.7000 275.4000 1.7000 275.5980 1.7000 275.7000 1.7000 275.8980 1.7000 276.0000 1.7000 276.1980 1.7000 276.3000 1.7000 276.4980 1.7000 276.6000 1.6092 276.7980 1.6092 276.9000 1.6928 277.0980 1.6928 277.2000 1.7000 277.3980 1.7000 277.5000 1.7000 277.6980 1.7000 277.8000 1.4328 277.9980 1.4328 278.1000 1.7000 278.2980 1.7000 278.4000 1.7000 278.5980 1.7000 278.7000 1.7000 278.8980 1.7000 279.0000 1.7000 279.1980 1.7000 279.3000 1.6713 279.4980 1.6713 279.6000 1.7000 279.7980 1.7000 279.9000 1.3017 280.0980 1.3017 280.2000 1.5894 280.3980 1.5894 280.5000 1.7000 280.6980 1.7000 280.8000 0.7429 280.9980 0.7429 281.1000 1.5601 281.2980 1.5601 281.4000 1.4614 281.5980 1.4614 281.7000 1.3138 281.8980 1.3138 282.0000 1.4830 282.1980 1.4830 282.3000 1.2359 282.4980 1.2359 282.6000 1.0681 282.7980 1.0681 282.9000 1.6071 283.0980 1.6071 283.2000 1.5028 283.3980 1.5028 283.5000 1.4491 283.6980 1.4491 283.8000 1.4337 283.9980 1.4337 284.1000 1.5056 284.2980 1.5056 284.4000 1.6606 284.5980 1.6606 284.7000 0.8614 284.8980 0.8614 285.0000 1.7000 285.1980 1.7000 285.3000 1.3429 285.4980 1.3429 285.6000 0.5742 285.7980 0.5742 285.9000 1.4221 286.0980 1.4221 286.2000 1.5060 286.3980 1.5060 286.5000 1.3075 286.6980 1.3075 286.8000 1.5427 286.9980 1.5427 287.1000 1.7000 287.2980 1.7000 287.4000 1.6251 287.5980 1.6251 287.7000 1.3175 287.8980 1.3175 288.0000 1.7000 288.1980 1.7000 288.3000 1.6160 288.4980 1.6160 288.6000 1.7000 288.7980 1.7000 288.9000 1.7000 289.0980 1.7000 289.2000 1.7000 289.3980 1.7000 289.5000 1.7000 289.6980 1.7000 289.8000 1.7000 289.9980 1.7000 290.1000 1.7000 290.2980 1.7000 290.4000 1.7000 290.5980 1.7000 290.7000 1.7000 290.8980 1.7000 291.0000 1.7000 291.1980 1.7000 291.3000 1.7000 291.4980 1.7000 291.6000 1.7000 291.7980 1.7000 291.9000 1.7000 292.0980 1.7000 292.2000 1.3587 292.3980 1.3587 292.5000 1.7000 292.6980 1.7000 292.8000 1.6236 292.9980 1.6236 293.1000 1.7000 293.2980 1.7000 293.4000 1.7000 293.5980 1.7000 293.7000 1.7000 293.8980 1.7000 294.0000 1.3112 294.1980 1.3112 294.3000 1.7000 294.4980 1.7000 294.6000 1.7000 294.7980 1.7000 294.9000 1.7000 295.0980 1.7000 295.2000 1.7000 295.3980 1.7000 295.5000 1.7000 295.6980 1.7000 295.8000 1.7000 295.9980 1.7000 296.1000 1.7000 296.2980 1.7000 296.4000 1.3043 296.5980 1.3043 296.7000 1.7000 296.8980 1.7000 297.0000 1.7000 297.1980 1.7000 297.3000 1.7000 297.4980 1.7000 297.6000 1.7000 297.7980 1.7000 297.9000 1.7000 298.0980 1.7000 298.2000 1.6092 298.3980 1.6092 298.5000 1.6928 298.6980 1.6928 298.8000 1.7000 298.9980 1.7000 299.1000 1.7000 299.2980 1.7000 299.4000 1.4328 299.5980 1.4328 299.7000 1.7000 299.8980 1.7000 300.0000 1.7000 300.1980 1.7000 300.3000 1.7000 300.4980 1.7000 300.6000 1.7000 300.7980 1.7000 300.9000 1.6713 301.0980 1.6713 301.2000 1.7000 301.3980 1.7000 301.5000 1.3017 301.6980 1.3017 301.8000 1.5894 301.9980 1.5894 302.1000 1.7000 302.2980 1.7000 302.4000 0.7429 302.5980 0.7429 302.7000 1.5601 302.8980 1.5601 303.0000 1.4614 303.1980 1.4614 303.3000 1.3138 303.4980 1.3138 303.6000 1.4830 303.7980 1.4830 303.9000 1.2359 304.0980 1.2359 304.2000 1.0681 304.3980 1.0681 304.5000 1.6071 304.6980 1.6071 304.8000 1.5028 304.9980 1.5028 305.1000 1.4491 305.2980 1.4491 305.4000 1.4337 305.5980 1.4337 305.7000 1.5056 305.8980 1.5056 306.0000 1.6606 306.1980 1.6606 306.3000 0.8614 306.4980 0.8614 306.6000 1.7000 306.7980 1.7000 306.9000 1.3429 307.0980 1.3429 307.2000 0.5742 307.3980 0.5742 307.5000 1.4221 307.6980 1.4221 307.8000 1.5060 307.9980 1.5060 308.1000 1.3075 308.2980 1.3075 308.4000 1.5427 308.5980 1.5427 308.7000 1.7000 308.8980 1.7000 309.0000 1.6251 309.1980 1.6251 309.3000 1.3175 309.4980 1.3175 309.6000 1.7000 309.7980 1.7000 309.9000 1.6160 310.0980 1.6160 310.2000 1.7000 310.3980 1.7000 310.5000 1.7000 310.6980 1.7000 310.8000 1.7000 310.9980 1.7000 311.1000 1.7000 311.2980 1.7000 311.4000 1.7000 311.5980 1.7000 311.7000 1.7000 311.8980 1.7000 312.0000 1.7000 312.1980 1.7000 312.3000 1.7000 312.4980 1.7000 312.6000 1.7000 312.7980 1.7000 312.9000 1.7000 313.0980 1.7000 313.2000 1.7000 313.3980 1.7000 313.5000 1.7000 313.6980 1.7000 313.8000 1.3587 313.9980 1.3587 314.1000 1.7000 314.2980 1.7000 314.4000 1.6236 314.5980 1.6236 314.7000 1.7000 314.8980 1.7000 315.0000 1.7000 315.1980 1.7000 315.3000 1.7000 315.4980 1.7000 315.6000 1.3112 315.7980 1.3112 315.9000 1.7000 316.0980 1.7000 316.2000 1.7000 316.3980 1.7000 316.5000 1.7000 316.6980 1.7000 316.8000 1.7000 316.9980 1.7000 317.1000 1.7000 317.2980 1.7000 317.4000 1.7000 317.5980 1.7000 317.7000 1.7000 317.8980 1.7000 318.0000 1.3043 318.1980 1.3043 318.3000 1.7000 318.4980 1.7000 318.6000 1.7000 318.7980 1.7000 318.9000 1.7000 319.0980 1.7000 319.2000 1.7000 319.3980 1.7000 319.5000 1.7000 319.6980 1.7000 319.8000 1.6092 319.9980 1.6092 320.1000 1.6928 320.2980 1.6928 320.4000 1.7000 320.5980 1.7000 320.7000 1.7000 320.8980 1.7000 321.0000 1.4328 321.1980 1.4328 321.3000 1.7000 321.4980 1.7000 321.6000 1.7000 321.7980 1.7000 321.9000 1.7000 322.0980 1.7000 322.2000 1.7000 322.3980 1.7000 322.5000 1.6713 322.6980 1.6713 322.8000 1.7000 322.9980 1.7000 323.1000 1.3017 323.2980 1.3017 323.4000 1.5894 323.5980 1.5894 323.7000 1.7000 323.8980 1.7000 324.0000 0.7429 324.1980 0.7429 324.3000 1.5601 324.4980 1.5601 324.6000 1.4614 324.7980 1.4614 324.9000 1.3138 325.0980 1.3138 325.2000 1.4830 325.3980 1.4830 325.5000 1.2359 325.6980 1.2359 325.8000 1.0681 325.9980 1.0681 326.1000 1.6071 326.2980 1.6071 326.4000 1.5028 326.5980 1.5028 326.7000 1.4491 326.8980 1.4491 327.0000 1.4337 327.1980 1.4337 327.3000 1.5056 327.4980 1.5056 327.6000 1.6606 327.7980 1.6606 327.9000 0.8614 328.0980 0.8614 328.2000 1.7000 328.3980 1.7000 328.5000 1.3429 328.6980 1.3429 328.8000 0.5742 328.9980 0.5742 329.1000 1.4221 329.2980 1.4221 329.4000 1.5060 329.5980 1.5060 329.7000 1.3075 329.8980 1.3075 330.0000 1.5427 330.1980 1.5427 330.3000 1.7000 330.4980 1.7000 330.6000 1.6251 330.7980 1.6251 330.9000 1.3175 331.0980 1.3175 331.2000 1.7000 331.3980 1.7000 331.5000 1.6160 331.6980 1.6160 331.8000 1.7000 331.9980 1.7000 332.1000 1.7000 332.2980 1.7000 332.4000 1.7000 332.5980 1.7000 332.7000 1.7000 332.8980 1.7000 333.0000 1.7000 333.1980 1.7000 333.3000 1.7000 333.4980 1.7000 333.6000 1.7000 333.7980 1.7000 333.9000 1.7000 334.0980 1.7000 334.2000 1.7000 334.3980 1.7000 334.5000 1.7000 334.6980 1.7000 334.8000 1.7000 334.9980 1.7000 335.1000 1.7000 335.2980 1.7000 335.4000 1.3587 335.5980 1.3587 335.7000 1.7000 335.8980 1.7000 336.0000 1.6236 336.1980 1.6236 336.3000 1.7000 336.4980 1.7000 336.6000 1.7000 336.7980 1.7000 336.9000 1.7000 337.0980 1.7000 337.2000 1.3112 337.3980 1.3112 337.5000 1.7000 337.6980 1.7000 337.8000 1.7000 337.9980 1.7000 338.1000 1.7000 338.2980 1.7000 338.4000 1.7000 338.5980 1.7000 338.7000 1.7000 338.8980 1.7000 339.0000 1.7000 339.1980 1.7000 339.3000 1.7000 339.4980 1.7000 339.6000 1.3043 339.7980 1.3043 339.9000 1.7000 340.0980 1.7000 340.2000 1.7000 340.3980 1.7000 340.5000 1.7000 340.6980 1.7000 340.8000 1.7000 340.9980 1.7000 341.1000 1.7000 341.2980 1.7000 341.4000 1.6092 341.5980 1.6092 341.7000 1.6928 341.8980 1.6928 342.0000 1.7000 342.1980 1.7000 342.3000 1.7000 342.4980 1.7000 342.6000 1.4328 342.7980 1.4328 342.9000 1.7000 343.0980 1.7000 343.2000 1.7000 343.3980 1.7000 343.5000 1.7000 343.6980 1.7000 343.8000 1.7000 343.9980 1.7000 344.1000 1.6713 344.2980 1.6713 344.4000 1.7000 344.5980 1.7000 344.7000 1.3017 344.8980 1.3017 345.0000 1.5894 345.1980 1.5894 345.3000 1.7000 345.4980 1.7000 345.6000 0.7429 345.7980 0.7429 345.9000 1.5601 346.0980 1.5601 346.2000 1.4614 346.3980 1.4614 346.5000 1.3138 346.6980 1.3138 346.8000 1.4830 346.9980 1.4830 347.1000 1.2359 347.2980 1.2359 347.4000 1.0681 347.5980 1.0681 347.7000 1.6071 347.8980 1.6071 348.0000 1.5028 348.1980 1.5028 348.3000 1.4491 348.4980 1.4491 348.6000 1.4337 348.7980 1.4337 348.9000 1.5056 349.0980 1.5056 349.2000 1.6606 349.3980 1.6606 349.5000 0.8614 349.6980 0.8614 349.8000 1.7000 349.9980 1.7000 350.1000 1.3429 350.2980 1.3429 350.4000 0.5742 350.5980 0.5742 350.7000 1.4221 350.8980 1.4221 351.0000 1.5060 351.1980 1.5060 351.3000 1.3075 351.4980 1.3075 351.6000 1.5427 351.7980 1.5427 351.9000 1.7000 352.0980 1.7000 352.2000 1.6251 352.3980 1.6251 352.5000 1.3175 352.6980 1.3175 352.8000 1.7000 352.9980 1.7000 353.1000 1.6160 353.2980 1.6160 353.4000 1.7000 353.5980 1.7000 353.7000 1.7000 353.8980 1.7000 354.0000 1.7000 354.1980 1.7000 354.3000 1.7000 354.4980 1.7000 354.6000 1.7000 354.7980 1.7000 354.9000 1.7000 355.0980 1.7000 355.2000 1.7000 355.3980 1.7000 355.5000 1.7000 355.6980 1.7000 355.8000 1.7000 355.9980 1.7000 356.1000 1.7000 356.2980 1.7000 356.4000 1.7000 356.5980 1.7000 356.7000 1.7000 356.8980 1.7000 357.0000 1.3587 357.1980 1.3587 357.3000 1.7000 357.4980 1.7000 357.6000 1.6236 357.7980 1.6236 357.9000 1.7000 358.0980 1.7000 358.2000 1.7000 358.3980 1.7000 358.5000 1.7000 358.6980 1.7000 358.8000 1.3112 358.9980 1.3112 359.1000 1.7000 359.2980 1.7000 359.4000 1.7000 359.5980 1.7000 359.7000 1.7000 359.8980 1.7000 360.0000 1.7000 360.1980 1.7000 360.3000 1.7000 360.4980 1.7000 360.6000 1.7000 360.7980 1.7000 360.9000 1.7000 361.0980 1.7000 361.2000 1.3043 361.3980 1.3043 361.5000 1.7000 361.6980 1.7000 361.8000 1.7000 361.9980 1.7000 362.1000 1.7000 362.2980 1.7000 362.4000 1.7000 362.5980 1.7000 362.7000 1.7000 362.8980 1.7000 363.0000 1.6092 363.1980 1.6092 363.3000 1.6928 363.4980 1.6928 363.6000 1.7000 363.7980 1.7000 363.9000 1.7000 364.0980 1.7000 364.2000 1.4328 364.3980 1.4328 364.5000 1.7000 364.6980 1.7000 364.8000 1.7000 364.9980 1.7000 365.1000 1.7000 365.2980 1.7000 365.4000 1.7000 365.5980 1.7000 365.7000 1.6713 365.8980 1.6713 366.0000 1.7000 366.1980 1.7000 366.3000 1.3017 366.4980 1.3017 366.6000 1.5894 366.7980 1.5894 366.9000 1.7000 367.0980 1.7000 367.2000 0.7429 367.3980 0.7429 367.5000 1.5601 367.6980 1.5601 367.8000 1.4614 367.9980 1.4614 368.1000 1.3138 368.2980 1.3138 368.4000 1.4830 368.5980 1.4830 368.7000 1.2359 368.8980 1.2359 369.0000 1.0681 369.1980 1.0681 369.3000 1.6071 369.4980 1.6071 369.6000 1.5028 369.7980 1.5028 369.9000 1.4491 370.0980 1.4491 370.2000 1.4337 370.3980 1.4337 370.5000 1.5056 370.6980 1.5056 370.8000 1.6606 370.9980 1.6606 371.1000 0.8614 371.2980 0.8614 371.4000 1.7000 371.5980 1.7000 371.7000 1.3429 371.8980 1.3429 372.0000 0.5742 372.1980 0.5742 372.3000 1.4221 372.4980 1.4221 372.6000 1.5060 372.7980 1.5060 372.9000 1.3075 373.0980 1.3075 373.2000 1.5427 373.3980 1.5427 373.5000 1.7000 373.6980 1.7000 373.8000 1.6251 373.9980 1.6251 374.1000 1.3175 374.2980 1.3175 374.4000 1.7000 374.5980 1.7000 374.7000 1.6160 374.8980 1.6160 375.0000 1.7000 375.1980 1.7000 375.3000 1.7000 375.4980 1.7000 375.6000 1.7000 375.7980 1.7000 375.9000 1.7000 376.0980 1.7000 376.2000 1.7000 376.3980 1.7000 376.5000 1.7000 376.6980 1.7000 376.8000 1.7000 376.9980 1.7000 377.1000 1.7000 377.2980 1.7000 377.4000 1.7000 377.5980 1.7000 377.7000 1.7000 377.8980 1.7000 378.0000 1.7000 378.1980 1.7000 378.3000 1.7000 378.4980 1.7000 378.6000 1.3587 378.7980 1.3587 378.9000 1.7000 379.0980 1.7000 379.2000 1.6236 379.3980 1.6236 379.5000 1.7000 379.6980 1.7000 379.8000 1.7000 379.9980 1.7000 380.1000 1.7000 380.2980 1.7000 380.4000 1.3112 380.5980 1.3112 380.7000 1.7000 380.8980 1.7000 381.0000 1.7000 381.1980 1.7000 381.3000 1.7000 381.4980 1.7000 381.6000 1.7000 381.7980 1.7000 381.9000 1.7000 382.0980 1.7000 382.2000 1.7000 382.3980 1.7000 382.5000 1.7000 382.6980 1.7000 382.8000 1.3043 382.9980 1.3043 383.1000 1.7000 383.2980 1.7000 383.4000 1.7000 383.5980 1.7000 383.7000 1.7000 383.8980 1.7000 384.0000 1.7000 384.1980 1.7000 384.3000 1.7000 384.4980 1.7000 384.6000 1.6092 384.7980 1.6092 384.9000 1.6928 385.0980 1.6928 385.2000 1.7000 385.3980 1.7000 385.5000 1.7000 385.6980 1.7000 385.8000 1.4328 385.9980 1.4328 386.1000 1.7000 386.2980 1.7000 386.4000 1.7000 386.5980 1.7000 386.7000 1.7000 386.8980 1.7000 387.0000 1.7000 387.1980 1.7000 387.3000 1.6713 387.4980 1.6713 387.6000 1.7000 387.7980 1.7000 387.9000 1.3017 388.0980 1.3017 388.2000 1.5894 388.3980 1.5894 388.5000 1.7000 388.6980 1.7000 388.8000 0.7429 388.9980 0.7429 389.1000 1.5601 389.2980 1.5601 389.4000 1.4614 389.5980 1.4614 389.7000 1.3138 389.8980 1.3138 390.0000 1.4830 390.1980 1.4830 390.3000 1.2359 390.4980 1.2359 390.6000 1.0681 390.7980 1.0681 390.9000 1.6071 391.0980 1.6071 391.2000 1.5028 391.3980 1.5028 391.5000 1.4491 391.6980 1.4491 391.8000 1.4337 391.9980 1.4337 392.1000 1.5056 392.2980 1.5056 392.4000 1.6606 392.5980 1.6606 392.7000 0.8614 392.8980 0.8614 393.0000 1.7000 393.1980 1.7000 393.3000 1.3429 393.4980 1.3429 393.6000 0.5742 393.7980 0.5742 393.9000 1.4221 394.0980 1.4221 394.2000 1.5060 394.3980 1.5060 394.5000 1.3075 394.6980 1.3075 394.8000 1.5427 394.9980 1.5427 395.1000 1.7000 395.2980 1.7000 395.4000 1.6251 395.5980 1.6251 395.7000 1.3175 395.8980 1.3175 396.0000 1.7000 396.1980 1.7000 396.3000 1.6160 396.4980 1.6160 396.6000 1.7000 396.7980 1.7000 396.9000 1.7000 397.0980 1.7000 397.2000 1.7000 397.3980 1.7000 397.5000 1.7000 397.6980 1.7000 397.8000 1.7000 397.9980 1.7000 398.1000 1.7000 398.2980 1.7000 398.4000 1.7000 398.5980 1.7000 398.7000 1.7000 398.8980 1.7000 399.0000 1.7000 399.1980 1.7000 399.3000 1.7000 399.4980 1.7000 399.6000 1.7000 399.7980 1.7000 399.9000 1.7000 400.0980 1.7000 400.2000 1.3587 400.3980 1.3587 400.5000 1.7000 400.6980 1.7000 400.8000 1.6236 400.9980 1.6236 401.1000 1.7000 401.2980 1.7000 401.4000 1.7000 401.5980 1.7000 401.7000 1.7000 401.8980 1.7000 402.0000 1.3112 402.1980 1.3112 402.3000 1.7000 402.4980 1.7000 402.6000 1.7000 402.7980 1.7000 402.9000 1.7000 403.0980 1.7000 403.2000 1.7000 403.3980 1.7000 403.5000 1.7000 403.6980 1.7000 403.8000 1.7000 403.9980 1.7000 404.1000 1.7000 404.2980 1.7000 404.4000 1.3043 404.5980 1.3043 404.7000 1.7000 404.8980 1.7000 405.0000 1.7000 405.1980 1.7000 405.3000 1.7000 405.4980 1.7000 405.6000 1.7000 405.7980 1.7000 405.9000 1.7000 406.0980 1.7000 406.2000 1.6092 406.3980 1.6092 406.5000 1.6928 406.6980 1.6928 406.8000 1.7000 406.9980 1.7000 407.1000 1.7000 407.2980 1.7000 407.4000 1.4328 407.5980 1.4328 407.7000 1.7000 407.8980 1.7000 408.0000 1.7000 408.1980 1.7000 408.3000 1.7000 408.4980 1.7000 408.6000 1.7000 408.7980 1.7000 408.9000 1.6713 409.0980 1.6713 409.2000 1.7000 409.3980 1.7000 409.5000 1.3017 409.6980 1.3017 409.8000 1.5894 409.9980 1.5894 410.1000 1.7000 410.2980 1.7000 410.4000 0.7429 410.5980 0.7429 410.7000 1.5601 410.8980 1.5601 411.0000 1.4614 411.1980 1.4614 411.3000 1.3138 411.4980 1.3138 411.6000 1.4830 411.7980 1.4830 411.9000 1.2359 412.0980 1.2359 412.2000 1.0681 412.3980 1.0681 412.5000 1.6071 412.6980 1.6071 412.8000 1.5028 412.9980 1.5028 413.1000 1.4491 413.2980 1.4491 413.4000 1.4337 413.5980 1.4337 413.7000 1.5056 413.8980 1.5056 414.0000 1.6606 414.1980 1.6606 414.3000 0.8614 414.4980 0.8614 414.6000 1.7000 414.7980 1.7000 414.9000 1.3429 415.0980 1.3429 415.2000 0.5742 415.3980 0.5742 415.5000 1.4221 415.6980 1.4221 415.8000 1.5060 415.9980 1.5060 416.1000 1.3075 416.2980 1.3075 416.4000 1.5427 416.5980 1.5427 416.7000 1.7000 416.8980 1.7000 417.0000 1.6251 417.1980 1.6251 417.3000 1.3175 417.4980 1.3175 417.6000 1.7000 417.7980 1.7000 417.9000 1.6160 418.0980 1.6160 418.2000 1.7000 418.3980 1.7000 418.5000 1.7000 418.6980 1.7000 418.8000 1.7000 418.9980 1.7000 419.1000 1.7000 419.2980 1.7000 419.4000 1.7000 419.5980 1.7000 419.7000 1.7000 419.8980 1.7000 420.0000 1.7000 420.1980 1.7000 420.3000 1.7000 420.4980 1.7000 420.6000 1.7000 420.7980 1.7000 420.9000 1.7000 421.0980 1.7000 421.2000 1.7000 421.3980 1.7000 421.5000 1.7000 421.6980 1.7000 421.8000 1.3587 421.9980 1.3587 422.1000 1.7000 422.2980 1.7000 422.4000 1.6236 422.5980 1.6236 422.7000 1.7000 422.8980 1.7000 423.0000 1.7000 423.1980 1.7000 423.3000 1.7000 423.4980 1.7000 423.6000 1.3112 423.7980 1.3112 423.9000 1.7000 424.0980 1.7000 424.2000 1.7000 424.3980 1.7000 424.5000 1.7000 424.6980 1.7000 424.8000 1.7000 424.9980 1.7000 425.1000 1.7000 425.2980 1.7000 425.4000 1.7000 425.5980 1.7000 425.7000 1.7000 425.8980 1.7000 426.0000 1.3043 426.1980 1.3043 426.3000 1.7000 426.4980 1.7000 426.6000 1.7000 426.7980 1.7000 426.9000 1.7000 427.0980 1.7000 427.2000 1.7000 427.3980 1.7000 427.5000 1.7000 427.6980 1.7000 427.8000 1.6092 427.9980 1.6092 428.1000 1.6928 428.2980 1.6928 428.4000 1.7000 428.5980 1.7000 428.7000 1.7000 428.8980 1.7000 429.0000 1.4328 429.1980 1.4328 429.3000 1.7000 429.4980 1.7000 429.6000 1.7000 429.7980 1.7000 429.9000 1.7000 430.0980 1.7000 430.2000 1.7000 430.3980 1.7000 430.5000 1.6713 430.6980 1.6713 430.8000 1.7000 430.9980 1.7000 431.1000 1.3017 431.2980 1.3017 431.4000 1.5894 431.5980 1.5894 431.7000 1.7000 431.8980 1.7000 432.0000 0.7429 432.1980 0.7429 432.3000 1.5601 432.4980 1.5601 432.6000 1.4614 432.7980 1.4614 432.9000 1.3138 433.0980 1.3138 433.2000 1.4830 433.3980 1.4830 433.5000 1.2359 433.6980 1.2359 433.8000 1.0681 433.9980 1.0681 434.1000 1.6071 434.2980 1.6071 434.4000 1.5028 434.5980 1.5028 434.7000 1.4491 434.8980 1.4491 435.0000 1.4337 435.1980 1.4337 435.3000 1.5056 435.4980 1.5056 435.6000 1.6606 435.7980 1.6606 435.9000 0.8614 436.0980 0.8614 436.2000 1.7000 436.3980 1.7000 436.5000 1.3429 436.6980 1.3429 436.8000 0.5742 436.9980 0.5742 437.1000 1.4221 437.2980 1.4221 437.4000 1.5060 437.5980 1.5060 437.7000 1.3075 437.8980 1.3075 438.0000 1.5427 438.1980 1.5427 438.3000 1.7000 438.4980 1.7000 438.6000 1.6251 438.7980 1.6251 438.9000 1.3175 439.0980 1.3175 439.2000 1.7000 439.3980 1.7000 439.5000 1.6160 439.6980 1.6160 439.8000 1.7000 439.9980 1.7000 440.1000 1.7000 440.2980 1.7000 440.4000 1.7000 440.5980 1.7000 440.7000 1.7000 440.8980 1.7000 441.0000 1.7000 441.1980 1.7000 441.3000 1.7000 441.4980 1.7000 441.6000 1.7000 441.7980 1.7000 441.9000 1.7000 442.0980 1.7000 442.2000 1.7000 442.3980 1.7000 442.5000 1.7000 442.6980 1.7000 442.8000 1.7000 442.9980 1.7000 443.1000 1.7000 443.2980 1.7000 443.4000 1.3587 443.5980 1.3587 443.7000 1.7000 443.8980 1.7000 444.0000 1.6236 444.1980 1.6236 444.3000 1.7000 444.4980 1.7000 444.6000 1.7000 444.7980 1.7000 444.9000 1.7000 445.0980 1.7000 445.2000 1.3112 445.3980 1.3112 445.5000 1.7000 445.6980 1.7000 445.8000 1.7000 445.9980 1.7000 446.1000 1.7000 446.2980 1.7000 446.4000 1.7000 446.5980 1.7000 446.7000 1.7000 446.8980 1.7000 447.0000 1.7000 447.1980 1.7000 447.3000 1.7000 447.4980 1.7000 447.6000 1.3043 447.7980 1.3043 447.9000 1.7000 448.0980 1.7000 448.2000 1.7000 448.3980 1.7000 448.5000 1.7000 448.6980 1.7000 448.8000 1.7000 448.9980 1.7000 449.1000 1.7000 449.2980 1.7000 449.4000 1.6092 449.5980 1.6092 449.7000 1.6928 449.8980 1.6928 450.0000 1.7000 450.1980 1.7000 450.3000 1.7000 450.4980 1.7000 450.6000 1.4328 450.7980 1.4328 450.9000 1.7000 451.0980 1.7000 451.2000 1.7000 451.3980 1.7000 451.5000 1.7000 451.6980 1.7000 451.8000 1.7000 451.9980 1.7000 452.1000 1.6713 452.2980 1.6713 452.4000 1.7000 452.5980 1.7000 452.7000 1.3017 452.8980 1.3017 453.0000 1.5894 453.1980 1.5894 453.3000 1.7000 453.4980 1.7000 453.6000 0.7429 453.7980 0.7429 453.9000 1.5601 454.0980 1.5601 454.2000 1.4614 454.3980 1.4614 454.5000 1.3138 454.6980 1.3138 454.8000 1.4830 454.9980 1.4830 455.1000 1.2359 455.2980 1.2359 455.4000 1.0681 455.5980 1.0681 455.7000 1.6071 455.8980 1.6071 456.0000 1.5028 456.1980 1.5028 456.3000 1.4491 456.4980 1.4491 456.6000 1.4337 456.7980 1.4337 456.9000 1.5056 457.0980 1.5056 457.2000 1.6606 457.3980 1.6606 457.5000 0.8614 457.6980 0.8614 457.8000 1.7000 457.9980 1.7000 458.1000 1.3429 458.2980 1.3429 458.4000 0.5742 458.5980 0.5742 458.7000 1.4221 458.8980 1.4221 459.0000 1.5060 459.1980 1.5060 459.3000 1.3075 459.4980 1.3075 459.6000 1.5427 459.7980 1.5427 459.9000 1.7000 460.0980 1.7000 460.2000 1.6251 460.3980 1.6251 460.5000 1.3175 460.6980 1.3175 460.8000 1.7000 460.9980 1.7000 461.1000 1.6160 461.2980 1.6160 461.4000 1.7000 461.5980 1.7000 461.7000 1.7000 461.8980 1.7000 462.0000 1.7000 462.1980 1.7000 462.3000 1.7000 462.4980 1.7000 462.6000 1.7000 462.7980 1.7000 462.9000 1.7000 463.0980 1.7000 463.2000 1.7000 463.3980 1.7000 463.5000 1.7000 463.6980 1.7000 463.8000 1.7000 463.9980 1.7000 464.1000 1.7000 464.2980 1.7000 464.4000 1.7000 464.5980 1.7000 464.7000 1.7000 464.8980 1.7000 465.0000 1.3587 465.1980 1.3587 465.3000 1.7000 465.4980 1.7000 465.6000 1.6236 465.7980 1.6236 465.9000 1.7000 466.0980 1.7000 466.2000 1.7000 466.3980 1.7000 466.5000 1.7000 466.6980 1.7000 466.8000 1.3112 466.9980 1.3112 467.1000 1.7000 467.2980 1.7000 467.4000 1.7000 467.5980 1.7000 467.7000 1.7000 467.8980 1.7000 468.0000 1.7000 468.1980 1.7000 468.3000 1.7000 468.4980 1.7000 468.6000 1.7000 468.7980 1.7000 468.9000 1.7000 469.0980 1.7000 469.2000 1.3043 469.3980 1.3043 469.5000 1.7000 469.6980 1.7000 469.8000 1.7000 469.9980 1.7000 470.1000 1.7000 470.2980 1.7000 470.4000 1.7000 470.5980 1.7000 470.7000 1.7000 470.8980 1.7000 471.0000 1.6092 471.1980 1.6092 471.3000 1.6928 471.4980 1.6928 471.6000 1.7000 471.7980 1.7000 471.9000 1.7000 472.0980 1.7000 472.2000 1.4328 472.3980 1.4328 472.5000 1.7000 472.6980 1.7000 472.8000 1.7000 472.9980 1.7000 473.1000 1.7000 473.2980 1.7000 473.4000 1.7000 473.5980 1.7000 473.7000 1.6713 473.8980 1.6713 474.0000 1.7000 474.1980 1.7000 474.3000 1.3017 474.4980 1.3017 474.6000 1.5894 474.7980 1.5894 474.9000 1.7000 475.0980 1.7000 475.2000 0.7429 475.3980 0.7429 475.5000 1.5601 475.6980 1.5601 475.8000 1.4614 475.9980 1.4614 476.1000 1.3138 476.2980 1.3138 476.4000 1.4830 476.5980 1.4830 476.7000 1.2359 476.8980 1.2359 477.0000 1.0681 477.1980 1.0681 477.3000 1.6071 477.4980 1.6071 477.6000 1.5028 477.7980 1.5028 477.9000 1.4491 478.0980 1.4491 478.2000 1.4337 478.3980 1.4337 478.5000 1.5056 478.6980 1.5056 478.8000 1.6606 478.9980 1.6606 479.1000 0.8614 479.2980 0.8614 479.4000 1.7000 479.5980 1.7000 479.7000 1.3429 479.8980 1.3429 480.0000 0.5742 480.1980 0.5742 480.3000 1.4221 480.4980 1.4221 480.6000 1.5060 480.7980 1.5060 480.9000 1.3075 481.0980 1.3075 481.2000 1.5427 481.3980 1.5427 481.5000 1.7000 481.6980 1.7000 481.8000 1.6251 481.9980 1.6251 482.1000 1.3175 482.2980 1.3175 482.4000 1.7000 482.5980 1.7000 482.7000 1.6160 482.8980 1.6160 483.0000 1.7000 483.1980 1.7000 483.3000 1.7000 483.4980 1.7000 483.6000 1.7000 483.7980 1.7000 483.9000 1.7000 484.0980 1.7000 484.2000 1.7000 484.3980 1.7000 484.5000 1.7000 484.6980 1.7000 484.8000 1.7000 484.9980 1.7000 485.1000 1.7000 485.2980 1.7000 485.4000 1.7000 485.5980 1.7000 485.7000 1.7000 485.8980 1.7000 486.0000 1.7000 486.1980 1.7000 486.3000 1.7000 486.4980 1.7000 486.6000 1.3587 486.7980 1.3587 486.9000 1.7000 487.0980 1.7000 487.2000 1.6236 487.3980 1.6236 487.5000 1.7000 487.6980 1.7000 487.8000 1.7000 487.9980 1.7000 488.1000 1.7000 488.2980 1.7000 488.4000 1.3112 488.5980 1.3112 488.7000 1.7000 488.8980 1.7000 489.0000 1.7000 489.1980 1.7000 489.3000 1.7000 489.4980 1.7000 489.6000 1.7000 489.7980 1.7000 489.9000 1.7000 490.0980 1.7000 490.2000 1.7000 490.3980 1.7000 490.5000 1.7000 490.6980 1.7000 490.8000 1.3043 490.9980 1.3043 491.1000 1.7000 491.2980 1.7000 491.4000 1.7000 491.5980 1.7000 491.7000 1.7000 491.8980 1.7000 492.0000 1.7000 492.1980 1.7000 492.3000 1.7000 492.4980 1.7000 492.6000 1.6092 492.7980 1.6092 492.9000 1.6928 493.0980 1.6928 493.2000 1.7000 493.3980 1.7000 493.5000 1.7000 493.6980 1.7000 493.8000 1.4328 493.9980 1.4328 494.1000 1.7000 494.2980 1.7000 494.4000 1.7000 494.5980 1.7000 494.7000 1.7000 494.8980 1.7000 495.0000 1.7000 495.1980 1.7000 495.3000 1.6713 495.4980 1.6713 495.6000 1.7000 495.7980 1.7000 495.9000 1.3017 496.0980 1.3017 496.2000 1.5894 496.3980 1.5894 496.5000 1.7000 496.6980 1.7000 496.8000 0.7429 496.9980 0.7429 497.1000 1.5601 497.2980 1.5601 497.4000 1.4614 497.5980 1.4614 497.7000 1.3138 497.8980 1.3138 498.0000 1.4830 498.1980 1.4830 498.3000 1.2359 498.4980 1.2359 498.6000 1.0681 498.7980 1.0681 498.9000 1.6071 499.0980 1.6071 499.2000 1.5028 499.3980 1.5028 499.5000 1.4491 499.6980 1.4491 499.8000 1.4337 499.9980 1.4337 500.1000 1.5056 500.2980 1.5056 500.4000 1.6606 500.5980 1.6606 500.7000 0.8614 500.8980 0.8614 501.0000 1.7000 501.1980 1.7000 501.3000 1.3429 501.4980 1.3429 501.6000 0.5742 501.7980 0.5742 501.9000 1.4221 502.0980 1.4221 502.2000 1.5060 502.3980 1.5060 502.5000 1.3075 502.6980 1.3075 502.8000 1.5427 502.9980 1.5427 503.1000 1.7000 503.2980 1.7000 503.4000 1.6251 503.5980 1.6251 503.7000 1.3175 503.8980 1.3175 504.0000 1.7000 504.1980 1.7000 504.3000 1.6160 504.4980 1.6160 504.6000 1.7000 504.7980 1.7000 504.9000 1.7000 505.0980 1.7000 505.2000 1.7000 505.3980 1.7000 505.5000 1.7000 505.6980 1.7000 505.8000 1.7000 505.9980 1.7000 506.1000 1.7000 506.2980 1.7000 506.4000 1.7000 506.5980 1.7000 506.7000 1.7000 506.8980 1.7000 507.0000 1.7000 507.1980 1.7000 507.3000 1.7000 507.4980 1.7000 507.6000 1.7000 507.7980 1.7000 507.9000 1.7000 508.0980 1.7000 508.2000 1.3587 508.3980 1.3587 508.5000 1.7000 508.6980 1.7000 508.8000 1.6236 508.9980 1.6236 509.1000 1.7000 509.2980 1.7000 509.4000 1.7000 509.5980 1.7000 509.7000 1.7000 509.8980 1.7000 510.0000 1.3112 510.1980 1.3112 510.3000 1.7000 510.4980 1.7000 510.6000 1.7000 510.7980 1.7000 510.9000 1.7000 511.0980 1.7000 511.2000 1.7000 511.3980 1.7000 511.5000 1.7000 511.6980 1.7000 511.8000 1.7000 511.9980 1.7000 512.1000 1.7000 512.2980 1.7000 512.4000 1.3043 512.5980 1.3043 512.7000 1.7000 512.8980 1.7000 513.0000 1.7000 513.1980 1.7000 513.3000 1.7000 513.4980 1.7000 513.6000 1.7000 513.7980 1.7000 513.9000 1.7000 514.0980 1.7000 514.2000 1.6092 514.3980 1.6092 514.5000 1.6928 514.6980 1.6928 514.8000 1.7000 514.9980 1.7000 515.1000 1.7000 515.2980 1.7000 515.4000 1.4328 515.5980 1.4328 515.7000 1.7000 515.8980 1.7000 516.0000 1.7000 516.1980 1.7000 516.3000 1.7000 516.4980 1.7000 516.6000 1.7000 516.7980 1.7000 516.9000 1.6713 517.0980 1.6713 517.2000 1.7000 517.3980 1.7000 517.5000 1.3017 517.6980 1.3017 517.8000 1.5894 517.9980 1.5894 518.1000 1.7000 518.2980 1.7000 518.4000 0.7429 518.5980 0.7429 518.7000 1.5601 518.8980 1.5601 519.0000 1.4614 519.1980 1.4614 519.3000 1.3138 519.4980 1.3138 519.6000 1.4830 519.7980 1.4830 519.9000 1.2359 520.0980 1.2359 520.2000 1.0681 520.3980 1.0681 520.5000 1.6071 520.6980 1.6071 520.8000 1.5028 520.9980 1.5028 521.1000 1.4491 521.2980 1.4491 521.4000 1.4337 521.5980 1.4337 521.7000 1.5056 521.8980 1.5056 522.0000 1.6606 522.1980 1.6606 522.3000 0.8614 522.4980 0.8614 522.6000 1.7000 522.7980 1.7000 522.9000 1.3429 523.0980 1.3429 523.2000 0.5742 523.3980 0.5742 523.5000 1.4221 523.6980 1.4221 523.8000 1.5060 523.9980 1.5060 524.1000 1.3075 524.2980 1.3075 524.4000 1.5427 524.5980 1.5427 524.7000 1.7000 524.8980 1.7000 525.0000 1.6251 525.1980 1.6251 525.3000 1.3175 525.4980 1.3175 525.6000 1.7000 525.7980 1.7000 525.9000 1.6160 526.0980 1.6160 526.2000 1.7000 526.3980 1.7000 526.5000 1.7000 526.6980 1.7000 526.8000 1.7000 526.9980 1.7000 527.1000 1.7000 527.2980 1.7000 527.4000 1.7000 527.5980 1.7000 527.7000 1.7000 527.8980 1.7000 528.0000 1.7000 528.1980 1.7000 528.3000 1.7000 528.4980 1.7000 528.6000 1.7000 528.7980 1.7000 528.9000 1.7000 529.0980 1.7000 529.2000 1.7000 529.3980 1.7000 529.5000 1.7000 529.6980 1.7000 529.8000 1.3587 529.9980 1.3587 530.1000 1.7000 530.2980 1.7000 530.4000 1.6236 530.5980 1.6236 530.7000 1.7000 530.8980 1.7000 531.0000 1.7000 531.1980 1.7000 531.3000 1.7000 531.4980 1.7000 531.6000 1.3112 531.7980 1.3112 531.9000 1.7000 532.0980 1.7000 532.2000 1.7000 532.3980 1.7000 532.5000 1.7000 532.6980 1.7000 532.8000 1.7000 532.9980 1.7000 533.1000 1.7000 533.2980 1.7000 533.4000 1.7000 533.5980 1.7000 533.7000 1.7000 533.8980 1.7000 534.0000 1.3043 534.1980 1.3043 534.3000 1.7000 534.4980 1.7000 534.6000 1.7000 534.7980 1.7000 534.9000 1.7000 535.0980 1.7000 535.2000 1.7000 535.3980 1.7000 535.5000 1.7000 535.6980 1.7000 535.8000 1.6092 535.9980 1.6092 536.1000 1.6928 536.2980 1.6928 536.4000 1.7000 536.5980 1.7000 536.7000 1.7000 536.8980 1.7000 537.0000 1.4328 537.1980 1.4328 537.3000 1.7000 537.4980 1.7000 537.6000 1.7000 537.7980 1.7000 537.9000 1.7000 538.0980 1.7000 538.2000 1.7000 538.3980 1.7000 538.5000 1.6713 538.6980 1.6713 538.8000 1.7000 538.9980 1.7000 539.1000 1.3017 539.2980 1.3017 539.4000 1.5894 539.5980 1.5894 539.7000 1.7000 539.8980 1.7000 540.0000 0.7429 540.1980 0.7429 540.3000 1.5601 540.4980 1.5601 540.6000 1.4614 540.7980 1.4614 540.9000 1.3138 541.0980 1.3138 541.2000 1.4830 541.3980 1.4830 541.5000 1.2359 541.6980 1.2359 541.8000 1.0681 541.9980 1.0681 542.1000 1.6071 542.2980 1.6071 542.4000 1.5028 542.5980 1.5028 542.7000 1.4491 542.8980 1.4491 543.0000 1.4337 543.1980 1.4337 543.3000 1.5056 543.4980 1.5056 543.6000 1.6606 543.7980 1.6606 543.9000 0.8614 544.0980 0.8614 544.2000 1.7000 544.3980 1.7000 544.5000 1.3429 544.6980 1.3429 544.8000 0.5742 544.9980 0.5742 545.1000 1.4221 545.2980 1.4221 545.4000 1.5060 545.5980 1.5060 545.7000 1.3075 545.8980 1.3075 546.0000 1.5427 546.1980 1.5427 546.3000 1.7000 546.4980 1.7000 546.6000 1.6251 546.7980 1.6251 546.9000 1.3175 547.0980 1.3175 547.2000 1.7000 547.3980 1.7000 547.5000 1.6160 547.6980 1.6160 547.8000 1.7000 547.9980 1.7000 548.1000 1.7000 548.2980 1.7000 548.4000 1.7000 548.5980 1.7000 548.7000 1.7000 548.8980 1.7000 549.0000 1.7000 549.1980 1.7000 549.3000 1.7000 549.4980 1.7000 549.6000 1.7000 549.7980 1.7000 549.9000 1.7000 550.0980 1.7000 550.2000 1.7000 550.3980 1.7000 550.5000 1.7000 550.6980 1.7000 550.8000 1.7000 550.9980 1.7000 551.1000 1.7000 551.2980 1.7000 551.4000 1.3587 551.5980 1.3587 551.7000 1.7000 551.8980 1.7000 552.0000 1.6236 552.1980 1.6236 552.3000 1.7000 552.4980 1.7000 552.6000 1.7000 552.7980 1.7000 552.9000 1.7000 553.0980 1.7000 553.2000 1.3112 553.3980 1.3112 553.5000 1.7000 553.6980 1.7000 553.8000 1.7000 553.9980 1.7000 554.1000 1.7000 554.2980 1.7000 554.4000 1.7000 554.5980 1.7000 554.7000 1.7000 554.8980 1.7000 555.0000 1.7000 555.1980 1.7000 555.3000 1.7000 555.4980 1.7000 555.6000 1.3043 555.7980 1.3043 555.9000 1.7000 556.0980 1.7000 556.2000 1.7000 556.3980 1.7000 556.5000 1.7000 556.6980 1.7000 556.8000 1.7000 556.9980 1.7000 557.1000 1.7000 557.2980 1.7000 557.4000 1.6092 557.5980 1.6092 557.7000 1.6928 557.8980 1.6928 558.0000 1.7000 558.1980 1.7000 558.3000 1.7000 558.4980 1.7000 558.6000 1.4328 558.7980 1.4328 558.9000 1.7000 559.0980 1.7000 559.2000 1.7000 559.3980 1.7000 559.5000 1.7000 559.6980 1.7000 559.8000 1.7000 559.9980 1.7000 560.1000 1.6713 560.2980 1.6713 560.4000 1.7000 560.5980 1.7000 560.7000 1.3017 560.8980 1.3017 561.0000 1.5894 561.1980 1.5894 561.3000 1.7000 561.4980 1.7000 561.6000 0.7429 561.7980 0.7429 561.9000 1.5601 562.0980 1.5601 562.2000 1.4614 562.3980 1.4614 562.5000 1.3138 562.6980 1.3138 562.8000 1.4830 562.9980 1.4830 563.1000 1.2359 563.2980 1.2359 563.4000 1.0681 563.5980 1.0681 563.7000 1.6071 563.8980 1.6071 564.0000 1.5028 564.1980 1.5028 564.3000 1.4491 564.4980 1.4491 564.6000 1.4337 564.7980 1.4337 564.9000 1.5056 565.0980 1.5056 565.2000 1.6606 565.3980 1.6606 565.5000 0.8614 565.6980 0.8614 565.8000 1.7000 565.9980 1.7000 566.1000 1.3429 566.2980 1.3429 566.4000 0.5742 566.5980 0.5742 566.7000 1.4221 566.8980 1.4221 567.0000 1.5060 567.1980 1.5060 567.3000 1.3075 567.4980 1.3075 567.6000 1.5427 567.7980 1.5427 567.9000 1.7000 568.0980 1.7000 568.2000 1.6251 568.3980 1.6251 568.5000 1.3175 568.6980 1.3175 568.8000 1.7000 568.9980 1.7000 569.1000 1.6160 569.2980 1.6160 569.4000 1.7000 569.5980 1.7000 569.7000 1.7000 569.8980 1.7000 570.0000 1.7000 570.1980 1.7000 570.3000 1.7000 570.4980 1.7000 570.6000 1.7000 570.7980 1.7000 570.9000 1.7000 571.0980 1.7000 571.2000 1.7000 571.3980 1.7000 571.5000 1.7000 571.6980 1.7000 571.8000 1.7000 571.9980 1.7000 572.1000 1.7000 572.2980 1.7000 572.4000 1.7000 572.5980 1.7000 572.7000 1.7000 572.8980 1.7000 573.0000 1.3587 573.1980 1.3587 573.3000 1.7000 573.4980 1.7000 573.6000 1.6236 573.7980 1.6236 573.9000 1.7000 574.0980 1.7000 574.2000 1.7000 574.3980 1.7000 574.5000 1.7000 574.6980 1.7000 574.8000 1.3112 574.9980 1.3112 575.1000 1.7000 575.2980 1.7000 575.4000 1.7000 575.5980 1.7000 575.7000 1.7000 575.8980 1.7000 576.0000 1.7000 576.1980 1.7000 576.3000 1.7000 576.4980 1.7000 576.6000 1.7000 576.7980 1.7000 576.9000 1.7000 577.0980 1.7000 577.2000 1.3043 577.3980 1.3043 577.5000 1.7000 577.6980 1.7000 577.8000 1.7000 577.9980 1.7000 578.1000 1.7000 578.2980 1.7000 578.4000 1.7000 578.5980 1.7000 578.7000 1.7000 578.8980 1.7000 579.0000 1.6092 579.1980 1.6092 579.3000 1.6928 579.4980 1.6928 579.6000 1.7000 579.7980 1.7000 579.9000 1.7000 580.0980 1.7000 580.2000 1.4328 580.3980 1.4328 580.5000 1.7000 580.6980 1.7000 580.8000 1.7000 580.9980 1.7000 581.1000 1.7000 581.2980 1.7000 581.4000 1.7000 581.5980 1.7000 581.7000 1.6713 581.8980 1.6713 582.0000 1.7000 582.1980 1.7000 582.3000 1.3017 582.4980 1.3017 582.6000 1.5894 582.7980 1.5894 582.9000 1.7000 583.0980 1.7000 583.2000 0.7429 583.3980 0.7429 583.5000 1.5601 583.6980 1.5601 583.8000 1.4614 583.9980 1.4614 584.1000 1.3138 584.2980 1.3138 584.4000 1.4830 584.5980 1.4830 584.7000 1.2359 584.8980 1.2359 585.0000 1.0681 585.1980 1.0681 585.3000 1.6071 585.4980 1.6071 585.6000 1.5028 585.7980 1.5028 585.9000 1.4491 586.0980 1.4491 586.2000 1.4337 586.3980 1.4337 586.5000 1.5056 586.6980 1.5056 586.8000 1.6606 586.9980 1.6606 587.1000 0.8614 587.2980 0.8614 587.4000 1.7000 587.5980 1.7000 587.7000 1.3429 587.8980 1.3429 588.0000 0.5742 588.1980 0.5742 588.3000 1.4221 588.4980 1.4221 588.6000 1.5060 588.7980 1.5060 588.9000 1.3075 589.0980 1.3075 589.2000 1.5427 589.3980 1.5427 589.5000 1.7000 589.6980 1.7000 589.8000 1.6251 589.9980 1.6251 590.1000 1.3175 590.2980 1.3175 590.4000 1.7000 590.5980 1.7000 590.7000 1.6160 590.8980 1.6160 591.0000 1.7000 591.1980 1.7000 591.3000 1.7000 591.4980 1.7000 591.6000 1.7000 591.7980 1.7000 591.9000 1.7000 592.0980 1.7000 592.2000 1.7000 592.3980 1.7000 592.5000 1.7000 592.6980 1.7000 592.8000 1.7000 592.9980 1.7000 593.1000 1.7000 593.2980 1.7000 593.4000 1.7000 593.5980 1.7000 593.7000 1.7000 593.8980 1.7000 594.0000 1.7000 594.1980 1.7000 594.3000 1.7000 594.4980 1.7000 594.6000 1.3587 594.7980 1.3587 594.9000 1.7000 595.0980 1.7000 595.2000 1.6236 595.3980 1.6236 595.5000 1.7000 595.6980 1.7000 595.8000 1.7000 595.9980 1.7000 596.1000 1.7000 596.2980 1.7000 596.4000 1.3112 596.5980 1.3112 596.7000 1.7000 596.8980 1.7000 597.0000 1.7000 597.1980 1.7000 597.3000 1.7000 597.4980 1.7000 597.6000 1.7000 597.7980 1.7000 597.9000 1.7000 598.0980 1.7000 598.2000 1.7000 598.3980 1.7000 598.5000 1.7000 598.6980 1.7000 598.8000 1.3043 598.9980 1.3043 599.1000 1.7000 599.2980 1.7000 599.4000 1.7000 599.5980 1.7000 599.7000 1.7000 599.8980 1.7000 600.0000 1.7000)
Va7 a7 0 PWL(0.0000 1.3786 0.1980 1.3786 0.3000 0.5820 0.4980 0.5820 0.6000 1.1272 0.7980 1.1272 0.9000 0.8952 1.0980 0.8952 1.2000 0.7470 1.3980 0.7470 1.5000 0.8368 1.6980 0.8368 1.8000 1.2710 1.9980 1.2710 2.1000 1.4098 2.2980 1.4098 2.4000 1.0574 2.5980 1.0574 2.7000 0.9045 2.8980 0.9045 3.0000 0.5457 3.1980 0.5457 3.3000 1.2497 3.4980 1.2497 3.6000 0.9090 3.7980 0.9090 3.9000 1.2523 4.0980 1.2523 4.2000 0.6574 4.3980 0.6574 4.5000 1.0266 4.6980 1.0266 4.8000 1.5482 4.9980 1.5482 5.1000 0.8369 5.2980 0.8369 5.4000 0.8953 5.5980 0.8953 5.7000 1.1319 5.8980 1.1319 6.0000 1.0691 6.1980 1.0691 6.3000 0.6974 6.4980 0.6974 6.6000 0.8277 6.7980 0.8277 6.9000 0.5462 7.0980 0.5462 7.2000 0.5412 7.3980 0.5412 7.5000 0.5887 7.6980 0.5887 7.8000 0.6782 7.9980 0.6782 8.1000 0.7543 8.2980 0.7543 8.4000 0.5913 8.5980 0.5913 8.7000 0.6190 8.8980 0.6190 9.0000 0.5692 9.1980 0.5692 9.3000 0.5961 9.4980 0.5961 9.6000 0.6150 9.7980 0.6150 9.9000 0.5696 10.0980 0.5696 10.2000 0.6065 10.3980 0.6065 10.5000 0.6194 10.6980 0.6194 10.8000 0.5673 10.9980 0.5673 11.1000 0.6056 11.2980 0.6056 11.4000 0.5477 11.5980 0.5477 11.7000 0.5860 11.8980 0.5860 12.0000 0.5723 12.1980 0.5723 12.3000 0.6247 12.4980 0.6247 12.6000 0.5668 12.7980 0.5668 12.9000 0.6160 13.0980 0.6160 13.2000 0.5790 13.3980 0.5790 13.5000 0.6068 13.6980 0.6068 13.8000 0.5960 13.9980 0.5960 14.1000 0.6236 14.2980 0.6236 14.4000 0.5892 14.5980 0.5892 14.7000 0.6006 14.8980 0.6006 15.0000 0.5466 15.1980 0.5466 15.3000 0.5968 15.4980 0.5968 15.6000 0.5883 15.7980 0.5883 15.9000 0.6004 16.0980 0.6004 16.2000 0.5933 16.3980 0.5933 16.5000 0.8301 16.6980 0.8301 16.8000 0.6131 16.9980 0.6131 17.1000 0.6082 17.2980 0.6082 17.4000 0.5745 17.5980 0.5745 17.7000 0.5786 17.8980 0.5786 18.0000 0.7627 18.1980 0.7627 18.3000 0.6088 18.4980 0.6088 18.6000 0.7124 18.7980 0.7124 18.9000 0.8198 19.0980 0.8198 19.2000 0.9262 19.3980 0.9262 19.5000 0.6409 19.6980 0.6409 19.8000 0.6683 19.9980 0.6683 20.1000 0.6020 20.2980 0.6020 20.4000 0.9248 20.5980 0.9248 20.7000 0.9426 20.8980 0.9426 21.0000 0.5737 21.1980 0.5737 21.3000 0.5754 21.4980 0.5754 21.6000 1.3786 21.7980 1.3786 21.9000 0.5820 22.0980 0.5820 22.2000 1.1272 22.3980 1.1272 22.5000 0.8952 22.6980 0.8952 22.8000 0.7470 22.9980 0.7470 23.1000 0.8368 23.2980 0.8368 23.4000 1.2710 23.5980 1.2710 23.7000 1.4098 23.8980 1.4098 24.0000 1.0574 24.1980 1.0574 24.3000 0.9045 24.4980 0.9045 24.6000 0.5457 24.7980 0.5457 24.9000 1.2497 25.0980 1.2497 25.2000 0.9090 25.3980 0.9090 25.5000 1.2523 25.6980 1.2523 25.8000 0.6574 25.9980 0.6574 26.1000 1.0266 26.2980 1.0266 26.4000 1.5482 26.5980 1.5482 26.7000 0.8369 26.8980 0.8369 27.0000 0.8953 27.1980 0.8953 27.3000 1.1319 27.4980 1.1319 27.6000 1.0691 27.7980 1.0691 27.9000 0.6974 28.0980 0.6974 28.2000 0.8277 28.3980 0.8277 28.5000 0.5462 28.6980 0.5462 28.8000 0.5412 28.9980 0.5412 29.1000 0.5887 29.2980 0.5887 29.4000 0.6782 29.5980 0.6782 29.7000 0.7543 29.8980 0.7543 30.0000 0.5913 30.1980 0.5913 30.3000 0.6190 30.4980 0.6190 30.6000 0.5692 30.7980 0.5692 30.9000 0.5961 31.0980 0.5961 31.2000 0.6150 31.3980 0.6150 31.5000 0.5696 31.6980 0.5696 31.8000 0.6065 31.9980 0.6065 32.1000 0.6194 32.2980 0.6194 32.4000 0.5673 32.5980 0.5673 32.7000 0.6056 32.8980 0.6056 33.0000 0.5477 33.1980 0.5477 33.3000 0.5860 33.4980 0.5860 33.6000 0.5723 33.7980 0.5723 33.9000 0.6247 34.0980 0.6247 34.2000 0.5668 34.3980 0.5668 34.5000 0.6160 34.6980 0.6160 34.8000 0.5790 34.9980 0.5790 35.1000 0.6068 35.2980 0.6068 35.4000 0.5960 35.5980 0.5960 35.7000 0.6236 35.8980 0.6236 36.0000 0.5892 36.1980 0.5892 36.3000 0.6006 36.4980 0.6006 36.6000 0.5466 36.7980 0.5466 36.9000 0.5968 37.0980 0.5968 37.2000 0.5883 37.3980 0.5883 37.5000 0.6004 37.6980 0.6004 37.8000 0.5933 37.9980 0.5933 38.1000 0.8301 38.2980 0.8301 38.4000 0.6131 38.5980 0.6131 38.7000 0.6082 38.8980 0.6082 39.0000 0.5745 39.1980 0.5745 39.3000 0.5786 39.4980 0.5786 39.6000 0.7627 39.7980 0.7627 39.9000 0.6088 40.0980 0.6088 40.2000 0.7124 40.3980 0.7124 40.5000 0.8198 40.6980 0.8198 40.8000 0.9262 40.9980 0.9262 41.1000 0.6409 41.2980 0.6409 41.4000 0.6683 41.5980 0.6683 41.7000 0.6020 41.8980 0.6020 42.0000 0.9248 42.1980 0.9248 42.3000 0.9426 42.4980 0.9426 42.6000 0.5737 42.7980 0.5737 42.9000 0.5754 43.0980 0.5754 43.2000 1.3786 43.3980 1.3786 43.5000 0.5820 43.6980 0.5820 43.8000 1.1272 43.9980 1.1272 44.1000 0.8952 44.2980 0.8952 44.4000 0.7470 44.5980 0.7470 44.7000 0.8368 44.8980 0.8368 45.0000 1.2710 45.1980 1.2710 45.3000 1.4098 45.4980 1.4098 45.6000 1.0574 45.7980 1.0574 45.9000 0.9045 46.0980 0.9045 46.2000 0.5457 46.3980 0.5457 46.5000 1.2497 46.6980 1.2497 46.8000 0.9090 46.9980 0.9090 47.1000 1.2523 47.2980 1.2523 47.4000 0.6574 47.5980 0.6574 47.7000 1.0266 47.8980 1.0266 48.0000 1.5482 48.1980 1.5482 48.3000 0.8369 48.4980 0.8369 48.6000 0.8953 48.7980 0.8953 48.9000 1.1319 49.0980 1.1319 49.2000 1.0691 49.3980 1.0691 49.5000 0.6974 49.6980 0.6974 49.8000 0.8277 49.9980 0.8277 50.1000 0.5462 50.2980 0.5462 50.4000 0.5412 50.5980 0.5412 50.7000 0.5887 50.8980 0.5887 51.0000 0.6782 51.1980 0.6782 51.3000 0.7543 51.4980 0.7543 51.6000 0.5913 51.7980 0.5913 51.9000 0.6190 52.0980 0.6190 52.2000 0.5692 52.3980 0.5692 52.5000 0.5961 52.6980 0.5961 52.8000 0.6150 52.9980 0.6150 53.1000 0.5696 53.2980 0.5696 53.4000 0.6065 53.5980 0.6065 53.7000 0.6194 53.8980 0.6194 54.0000 0.5673 54.1980 0.5673 54.3000 0.6056 54.4980 0.6056 54.6000 0.5477 54.7980 0.5477 54.9000 0.5860 55.0980 0.5860 55.2000 0.5723 55.3980 0.5723 55.5000 0.6247 55.6980 0.6247 55.8000 0.5668 55.9980 0.5668 56.1000 0.6160 56.2980 0.6160 56.4000 0.5790 56.5980 0.5790 56.7000 0.6068 56.8980 0.6068 57.0000 0.5960 57.1980 0.5960 57.3000 0.6236 57.4980 0.6236 57.6000 0.5892 57.7980 0.5892 57.9000 0.6006 58.0980 0.6006 58.2000 0.5466 58.3980 0.5466 58.5000 0.5968 58.6980 0.5968 58.8000 0.5883 58.9980 0.5883 59.1000 0.6004 59.2980 0.6004 59.4000 0.5933 59.5980 0.5933 59.7000 0.8301 59.8980 0.8301 60.0000 0.6131 60.1980 0.6131 60.3000 0.6082 60.4980 0.6082 60.6000 0.5745 60.7980 0.5745 60.9000 0.5786 61.0980 0.5786 61.2000 0.7627 61.3980 0.7627 61.5000 0.6088 61.6980 0.6088 61.8000 0.7124 61.9980 0.7124 62.1000 0.8198 62.2980 0.8198 62.4000 0.9262 62.5980 0.9262 62.7000 0.6409 62.8980 0.6409 63.0000 0.6683 63.1980 0.6683 63.3000 0.6020 63.4980 0.6020 63.6000 0.9248 63.7980 0.9248 63.9000 0.9426 64.0980 0.9426 64.2000 0.5737 64.3980 0.5737 64.5000 0.5754 64.6980 0.5754 64.8000 1.3786 64.9980 1.3786 65.1000 0.5820 65.2980 0.5820 65.4000 1.1272 65.5980 1.1272 65.7000 0.8952 65.8980 0.8952 66.0000 0.7470 66.1980 0.7470 66.3000 0.8368 66.4980 0.8368 66.6000 1.2710 66.7980 1.2710 66.9000 1.4098 67.0980 1.4098 67.2000 1.0574 67.3980 1.0574 67.5000 0.9045 67.6980 0.9045 67.8000 0.5457 67.9980 0.5457 68.1000 1.2497 68.2980 1.2497 68.4000 0.9090 68.5980 0.9090 68.7000 1.2523 68.8980 1.2523 69.0000 0.6574 69.1980 0.6574 69.3000 1.0266 69.4980 1.0266 69.6000 1.5482 69.7980 1.5482 69.9000 0.8369 70.0980 0.8369 70.2000 0.8953 70.3980 0.8953 70.5000 1.1319 70.6980 1.1319 70.8000 1.0691 70.9980 1.0691 71.1000 0.6974 71.2980 0.6974 71.4000 0.8277 71.5980 0.8277 71.7000 0.5462 71.8980 0.5462 72.0000 0.5412 72.1980 0.5412 72.3000 0.5887 72.4980 0.5887 72.6000 0.6782 72.7980 0.6782 72.9000 0.7543 73.0980 0.7543 73.2000 0.5913 73.3980 0.5913 73.5000 0.6190 73.6980 0.6190 73.8000 0.5692 73.9980 0.5692 74.1000 0.5961 74.2980 0.5961 74.4000 0.6150 74.5980 0.6150 74.7000 0.5696 74.8980 0.5696 75.0000 0.6065 75.1980 0.6065 75.3000 0.6194 75.4980 0.6194 75.6000 0.5673 75.7980 0.5673 75.9000 0.6056 76.0980 0.6056 76.2000 0.5477 76.3980 0.5477 76.5000 0.5860 76.6980 0.5860 76.8000 0.5723 76.9980 0.5723 77.1000 0.6247 77.2980 0.6247 77.4000 0.5668 77.5980 0.5668 77.7000 0.6160 77.8980 0.6160 78.0000 0.5790 78.1980 0.5790 78.3000 0.6068 78.4980 0.6068 78.6000 0.5960 78.7980 0.5960 78.9000 0.6236 79.0980 0.6236 79.2000 0.5892 79.3980 0.5892 79.5000 0.6006 79.6980 0.6006 79.8000 0.5466 79.9980 0.5466 80.1000 0.5968 80.2980 0.5968 80.4000 0.5883 80.5980 0.5883 80.7000 0.6004 80.8980 0.6004 81.0000 0.5933 81.1980 0.5933 81.3000 0.8301 81.4980 0.8301 81.6000 0.6131 81.7980 0.6131 81.9000 0.6082 82.0980 0.6082 82.2000 0.5745 82.3980 0.5745 82.5000 0.5786 82.6980 0.5786 82.8000 0.7627 82.9980 0.7627 83.1000 0.6088 83.2980 0.6088 83.4000 0.7124 83.5980 0.7124 83.7000 0.8198 83.8980 0.8198 84.0000 0.9262 84.1980 0.9262 84.3000 0.6409 84.4980 0.6409 84.6000 0.6683 84.7980 0.6683 84.9000 0.6020 85.0980 0.6020 85.2000 0.9248 85.3980 0.9248 85.5000 0.9426 85.6980 0.9426 85.8000 0.5737 85.9980 0.5737 86.1000 0.5754 86.2980 0.5754 86.4000 1.3786 86.5980 1.3786 86.7000 0.5820 86.8980 0.5820 87.0000 1.1272 87.1980 1.1272 87.3000 0.8952 87.4980 0.8952 87.6000 0.7470 87.7980 0.7470 87.9000 0.8368 88.0980 0.8368 88.2000 1.2710 88.3980 1.2710 88.5000 1.4098 88.6980 1.4098 88.8000 1.0574 88.9980 1.0574 89.1000 0.9045 89.2980 0.9045 89.4000 0.5457 89.5980 0.5457 89.7000 1.2497 89.8980 1.2497 90.0000 0.9090 90.1980 0.9090 90.3000 1.2523 90.4980 1.2523 90.6000 0.6574 90.7980 0.6574 90.9000 1.0266 91.0980 1.0266 91.2000 1.5482 91.3980 1.5482 91.5000 0.8369 91.6980 0.8369 91.8000 0.8953 91.9980 0.8953 92.1000 1.1319 92.2980 1.1319 92.4000 1.0691 92.5980 1.0691 92.7000 0.6974 92.8980 0.6974 93.0000 0.8277 93.1980 0.8277 93.3000 0.5462 93.4980 0.5462 93.6000 0.5412 93.7980 0.5412 93.9000 0.5887 94.0980 0.5887 94.2000 0.6782 94.3980 0.6782 94.5000 0.7543 94.6980 0.7543 94.8000 0.5913 94.9980 0.5913 95.1000 0.6190 95.2980 0.6190 95.4000 0.5692 95.5980 0.5692 95.7000 0.5961 95.8980 0.5961 96.0000 0.6150 96.1980 0.6150 96.3000 0.5696 96.4980 0.5696 96.6000 0.6065 96.7980 0.6065 96.9000 0.6194 97.0980 0.6194 97.2000 0.5673 97.3980 0.5673 97.5000 0.6056 97.6980 0.6056 97.8000 0.5477 97.9980 0.5477 98.1000 0.5860 98.2980 0.5860 98.4000 0.5723 98.5980 0.5723 98.7000 0.6247 98.8980 0.6247 99.0000 0.5668 99.1980 0.5668 99.3000 0.6160 99.4980 0.6160 99.6000 0.5790 99.7980 0.5790 99.9000 0.6068 100.0980 0.6068 100.2000 0.5960 100.3980 0.5960 100.5000 0.6236 100.6980 0.6236 100.8000 0.5892 100.9980 0.5892 101.1000 0.6006 101.2980 0.6006 101.4000 0.5466 101.5980 0.5466 101.7000 0.5968 101.8980 0.5968 102.0000 0.5883 102.1980 0.5883 102.3000 0.6004 102.4980 0.6004 102.6000 0.5933 102.7980 0.5933 102.9000 0.8301 103.0980 0.8301 103.2000 0.6131 103.3980 0.6131 103.5000 0.6082 103.6980 0.6082 103.8000 0.5745 103.9980 0.5745 104.1000 0.5786 104.2980 0.5786 104.4000 0.7627 104.5980 0.7627 104.7000 0.6088 104.8980 0.6088 105.0000 0.7124 105.1980 0.7124 105.3000 0.8198 105.4980 0.8198 105.6000 0.9262 105.7980 0.9262 105.9000 0.6409 106.0980 0.6409 106.2000 0.6683 106.3980 0.6683 106.5000 0.6020 106.6980 0.6020 106.8000 0.9248 106.9980 0.9248 107.1000 0.9426 107.2980 0.9426 107.4000 0.5737 107.5980 0.5737 107.7000 0.5754 107.8980 0.5754 108.0000 1.3786 108.1980 1.3786 108.3000 0.5820 108.4980 0.5820 108.6000 1.1272 108.7980 1.1272 108.9000 0.8952 109.0980 0.8952 109.2000 0.7470 109.3980 0.7470 109.5000 0.8368 109.6980 0.8368 109.8000 1.2710 109.9980 1.2710 110.1000 1.4098 110.2980 1.4098 110.4000 1.0574 110.5980 1.0574 110.7000 0.9045 110.8980 0.9045 111.0000 0.5457 111.1980 0.5457 111.3000 1.2497 111.4980 1.2497 111.6000 0.9090 111.7980 0.9090 111.9000 1.2523 112.0980 1.2523 112.2000 0.6574 112.3980 0.6574 112.5000 1.0266 112.6980 1.0266 112.8000 1.5482 112.9980 1.5482 113.1000 0.8369 113.2980 0.8369 113.4000 0.8953 113.5980 0.8953 113.7000 1.1319 113.8980 1.1319 114.0000 1.0691 114.1980 1.0691 114.3000 0.6974 114.4980 0.6974 114.6000 0.8277 114.7980 0.8277 114.9000 0.5462 115.0980 0.5462 115.2000 0.5412 115.3980 0.5412 115.5000 0.5887 115.6980 0.5887 115.8000 0.6782 115.9980 0.6782 116.1000 0.7543 116.2980 0.7543 116.4000 0.5913 116.5980 0.5913 116.7000 0.6190 116.8980 0.6190 117.0000 0.5692 117.1980 0.5692 117.3000 0.5961 117.4980 0.5961 117.6000 0.6150 117.7980 0.6150 117.9000 0.5696 118.0980 0.5696 118.2000 0.6065 118.3980 0.6065 118.5000 0.6194 118.6980 0.6194 118.8000 0.5673 118.9980 0.5673 119.1000 0.6056 119.2980 0.6056 119.4000 0.5477 119.5980 0.5477 119.7000 0.5860 119.8980 0.5860 120.0000 0.5723 120.1980 0.5723 120.3000 0.6247 120.4980 0.6247 120.6000 0.5668 120.7980 0.5668 120.9000 0.6160 121.0980 0.6160 121.2000 0.5790 121.3980 0.5790 121.5000 0.6068 121.6980 0.6068 121.8000 0.5960 121.9980 0.5960 122.1000 0.6236 122.2980 0.6236 122.4000 0.5892 122.5980 0.5892 122.7000 0.6006 122.8980 0.6006 123.0000 0.5466 123.1980 0.5466 123.3000 0.5968 123.4980 0.5968 123.6000 0.5883 123.7980 0.5883 123.9000 0.6004 124.0980 0.6004 124.2000 0.5933 124.3980 0.5933 124.5000 0.8301 124.6980 0.8301 124.8000 0.6131 124.9980 0.6131 125.1000 0.6082 125.2980 0.6082 125.4000 0.5745 125.5980 0.5745 125.7000 0.5786 125.8980 0.5786 126.0000 0.7627 126.1980 0.7627 126.3000 0.6088 126.4980 0.6088 126.6000 0.7124 126.7980 0.7124 126.9000 0.8198 127.0980 0.8198 127.2000 0.9262 127.3980 0.9262 127.5000 0.6409 127.6980 0.6409 127.8000 0.6683 127.9980 0.6683 128.1000 0.6020 128.2980 0.6020 128.4000 0.9248 128.5980 0.9248 128.7000 0.9426 128.8980 0.9426 129.0000 0.5737 129.1980 0.5737 129.3000 0.5754 129.4980 0.5754 129.6000 1.3786 129.7980 1.3786 129.9000 0.5820 130.0980 0.5820 130.2000 1.1272 130.3980 1.1272 130.5000 0.8952 130.6980 0.8952 130.8000 0.7470 130.9980 0.7470 131.1000 0.8368 131.2980 0.8368 131.4000 1.2710 131.5980 1.2710 131.7000 1.4098 131.8980 1.4098 132.0000 1.0574 132.1980 1.0574 132.3000 0.9045 132.4980 0.9045 132.6000 0.5457 132.7980 0.5457 132.9000 1.2497 133.0980 1.2497 133.2000 0.9090 133.3980 0.9090 133.5000 1.2523 133.6980 1.2523 133.8000 0.6574 133.9980 0.6574 134.1000 1.0266 134.2980 1.0266 134.4000 1.5482 134.5980 1.5482 134.7000 0.8369 134.8980 0.8369 135.0000 0.8953 135.1980 0.8953 135.3000 1.1319 135.4980 1.1319 135.6000 1.0691 135.7980 1.0691 135.9000 0.6974 136.0980 0.6974 136.2000 0.8277 136.3980 0.8277 136.5000 0.5462 136.6980 0.5462 136.8000 0.5412 136.9980 0.5412 137.1000 0.5887 137.2980 0.5887 137.4000 0.6782 137.5980 0.6782 137.7000 0.7543 137.8980 0.7543 138.0000 0.5913 138.1980 0.5913 138.3000 0.6190 138.4980 0.6190 138.6000 0.5692 138.7980 0.5692 138.9000 0.5961 139.0980 0.5961 139.2000 0.6150 139.3980 0.6150 139.5000 0.5696 139.6980 0.5696 139.8000 0.6065 139.9980 0.6065 140.1000 0.6194 140.2980 0.6194 140.4000 0.5673 140.5980 0.5673 140.7000 0.6056 140.8980 0.6056 141.0000 0.5477 141.1980 0.5477 141.3000 0.5860 141.4980 0.5860 141.6000 0.5723 141.7980 0.5723 141.9000 0.6247 142.0980 0.6247 142.2000 0.5668 142.3980 0.5668 142.5000 0.6160 142.6980 0.6160 142.8000 0.5790 142.9980 0.5790 143.1000 0.6068 143.2980 0.6068 143.4000 0.5960 143.5980 0.5960 143.7000 0.6236 143.8980 0.6236 144.0000 0.5892 144.1980 0.5892 144.3000 0.6006 144.4980 0.6006 144.6000 0.5466 144.7980 0.5466 144.9000 0.5968 145.0980 0.5968 145.2000 0.5883 145.3980 0.5883 145.5000 0.6004 145.6980 0.6004 145.8000 0.5933 145.9980 0.5933 146.1000 0.8301 146.2980 0.8301 146.4000 0.6131 146.5980 0.6131 146.7000 0.6082 146.8980 0.6082 147.0000 0.5745 147.1980 0.5745 147.3000 0.5786 147.4980 0.5786 147.6000 0.7627 147.7980 0.7627 147.9000 0.6088 148.0980 0.6088 148.2000 0.7124 148.3980 0.7124 148.5000 0.8198 148.6980 0.8198 148.8000 0.9262 148.9980 0.9262 149.1000 0.6409 149.2980 0.6409 149.4000 0.6683 149.5980 0.6683 149.7000 0.6020 149.8980 0.6020 150.0000 0.9248 150.1980 0.9248 150.3000 0.9426 150.4980 0.9426 150.6000 0.5737 150.7980 0.5737 150.9000 0.5754 151.0980 0.5754 151.2000 1.3786 151.3980 1.3786 151.5000 0.5820 151.6980 0.5820 151.8000 1.1272 151.9980 1.1272 152.1000 0.8952 152.2980 0.8952 152.4000 0.7470 152.5980 0.7470 152.7000 0.8368 152.8980 0.8368 153.0000 1.2710 153.1980 1.2710 153.3000 1.4098 153.4980 1.4098 153.6000 1.0574 153.7980 1.0574 153.9000 0.9045 154.0980 0.9045 154.2000 0.5457 154.3980 0.5457 154.5000 1.2497 154.6980 1.2497 154.8000 0.9090 154.9980 0.9090 155.1000 1.2523 155.2980 1.2523 155.4000 0.6574 155.5980 0.6574 155.7000 1.0266 155.8980 1.0266 156.0000 1.5482 156.1980 1.5482 156.3000 0.8369 156.4980 0.8369 156.6000 0.8953 156.7980 0.8953 156.9000 1.1319 157.0980 1.1319 157.2000 1.0691 157.3980 1.0691 157.5000 0.6974 157.6980 0.6974 157.8000 0.8277 157.9980 0.8277 158.1000 0.5462 158.2980 0.5462 158.4000 0.5412 158.5980 0.5412 158.7000 0.5887 158.8980 0.5887 159.0000 0.6782 159.1980 0.6782 159.3000 0.7543 159.4980 0.7543 159.6000 0.5913 159.7980 0.5913 159.9000 0.6190 160.0980 0.6190 160.2000 0.5692 160.3980 0.5692 160.5000 0.5961 160.6980 0.5961 160.8000 0.6150 160.9980 0.6150 161.1000 0.5696 161.2980 0.5696 161.4000 0.6065 161.5980 0.6065 161.7000 0.6194 161.8980 0.6194 162.0000 0.5673 162.1980 0.5673 162.3000 0.6056 162.4980 0.6056 162.6000 0.5477 162.7980 0.5477 162.9000 0.5860 163.0980 0.5860 163.2000 0.5723 163.3980 0.5723 163.5000 0.6247 163.6980 0.6247 163.8000 0.5668 163.9980 0.5668 164.1000 0.6160 164.2980 0.6160 164.4000 0.5790 164.5980 0.5790 164.7000 0.6068 164.8980 0.6068 165.0000 0.5960 165.1980 0.5960 165.3000 0.6236 165.4980 0.6236 165.6000 0.5892 165.7980 0.5892 165.9000 0.6006 166.0980 0.6006 166.2000 0.5466 166.3980 0.5466 166.5000 0.5968 166.6980 0.5968 166.8000 0.5883 166.9980 0.5883 167.1000 0.6004 167.2980 0.6004 167.4000 0.5933 167.5980 0.5933 167.7000 0.8301 167.8980 0.8301 168.0000 0.6131 168.1980 0.6131 168.3000 0.6082 168.4980 0.6082 168.6000 0.5745 168.7980 0.5745 168.9000 0.5786 169.0980 0.5786 169.2000 0.7627 169.3980 0.7627 169.5000 0.6088 169.6980 0.6088 169.8000 0.7124 169.9980 0.7124 170.1000 0.8198 170.2980 0.8198 170.4000 0.9262 170.5980 0.9262 170.7000 0.6409 170.8980 0.6409 171.0000 0.6683 171.1980 0.6683 171.3000 0.6020 171.4980 0.6020 171.6000 0.9248 171.7980 0.9248 171.9000 0.9426 172.0980 0.9426 172.2000 0.5737 172.3980 0.5737 172.5000 0.5754 172.6980 0.5754 172.8000 1.3786 172.9980 1.3786 173.1000 0.5820 173.2980 0.5820 173.4000 1.1272 173.5980 1.1272 173.7000 0.8952 173.8980 0.8952 174.0000 0.7470 174.1980 0.7470 174.3000 0.8368 174.4980 0.8368 174.6000 1.2710 174.7980 1.2710 174.9000 1.4098 175.0980 1.4098 175.2000 1.0574 175.3980 1.0574 175.5000 0.9045 175.6980 0.9045 175.8000 0.5457 175.9980 0.5457 176.1000 1.2497 176.2980 1.2497 176.4000 0.9090 176.5980 0.9090 176.7000 1.2523 176.8980 1.2523 177.0000 0.6574 177.1980 0.6574 177.3000 1.0266 177.4980 1.0266 177.6000 1.5482 177.7980 1.5482 177.9000 0.8369 178.0980 0.8369 178.2000 0.8953 178.3980 0.8953 178.5000 1.1319 178.6980 1.1319 178.8000 1.0691 178.9980 1.0691 179.1000 0.6974 179.2980 0.6974 179.4000 0.8277 179.5980 0.8277 179.7000 0.5462 179.8980 0.5462 180.0000 0.5412 180.1980 0.5412 180.3000 0.5887 180.4980 0.5887 180.6000 0.6782 180.7980 0.6782 180.9000 0.7543 181.0980 0.7543 181.2000 0.5913 181.3980 0.5913 181.5000 0.6190 181.6980 0.6190 181.8000 0.5692 181.9980 0.5692 182.1000 0.5961 182.2980 0.5961 182.4000 0.6150 182.5980 0.6150 182.7000 0.5696 182.8980 0.5696 183.0000 0.6065 183.1980 0.6065 183.3000 0.6194 183.4980 0.6194 183.6000 0.5673 183.7980 0.5673 183.9000 0.6056 184.0980 0.6056 184.2000 0.5477 184.3980 0.5477 184.5000 0.5860 184.6980 0.5860 184.8000 0.5723 184.9980 0.5723 185.1000 0.6247 185.2980 0.6247 185.4000 0.5668 185.5980 0.5668 185.7000 0.6160 185.8980 0.6160 186.0000 0.5790 186.1980 0.5790 186.3000 0.6068 186.4980 0.6068 186.6000 0.5960 186.7980 0.5960 186.9000 0.6236 187.0980 0.6236 187.2000 0.5892 187.3980 0.5892 187.5000 0.6006 187.6980 0.6006 187.8000 0.5466 187.9980 0.5466 188.1000 0.5968 188.2980 0.5968 188.4000 0.5883 188.5980 0.5883 188.7000 0.6004 188.8980 0.6004 189.0000 0.5933 189.1980 0.5933 189.3000 0.8301 189.4980 0.8301 189.6000 0.6131 189.7980 0.6131 189.9000 0.6082 190.0980 0.6082 190.2000 0.5745 190.3980 0.5745 190.5000 0.5786 190.6980 0.5786 190.8000 0.7627 190.9980 0.7627 191.1000 0.6088 191.2980 0.6088 191.4000 0.7124 191.5980 0.7124 191.7000 0.8198 191.8980 0.8198 192.0000 0.9262 192.1980 0.9262 192.3000 0.6409 192.4980 0.6409 192.6000 0.6683 192.7980 0.6683 192.9000 0.6020 193.0980 0.6020 193.2000 0.9248 193.3980 0.9248 193.5000 0.9426 193.6980 0.9426 193.8000 0.5737 193.9980 0.5737 194.1000 0.5754 194.2980 0.5754 194.4000 1.3786 194.5980 1.3786 194.7000 0.5820 194.8980 0.5820 195.0000 1.1272 195.1980 1.1272 195.3000 0.8952 195.4980 0.8952 195.6000 0.7470 195.7980 0.7470 195.9000 0.8368 196.0980 0.8368 196.2000 1.2710 196.3980 1.2710 196.5000 1.4098 196.6980 1.4098 196.8000 1.0574 196.9980 1.0574 197.1000 0.9045 197.2980 0.9045 197.4000 0.5457 197.5980 0.5457 197.7000 1.2497 197.8980 1.2497 198.0000 0.9090 198.1980 0.9090 198.3000 1.2523 198.4980 1.2523 198.6000 0.6574 198.7980 0.6574 198.9000 1.0266 199.0980 1.0266 199.2000 1.5482 199.3980 1.5482 199.5000 0.8369 199.6980 0.8369 199.8000 0.8953 199.9980 0.8953 200.1000 1.1319 200.2980 1.1319 200.4000 1.0691 200.5980 1.0691 200.7000 0.6974 200.8980 0.6974 201.0000 0.8277 201.1980 0.8277 201.3000 0.5462 201.4980 0.5462 201.6000 0.5412 201.7980 0.5412 201.9000 0.5887 202.0980 0.5887 202.2000 0.6782 202.3980 0.6782 202.5000 0.7543 202.6980 0.7543 202.8000 0.5913 202.9980 0.5913 203.1000 0.6190 203.2980 0.6190 203.4000 0.5692 203.5980 0.5692 203.7000 0.5961 203.8980 0.5961 204.0000 0.6150 204.1980 0.6150 204.3000 0.5696 204.4980 0.5696 204.6000 0.6065 204.7980 0.6065 204.9000 0.6194 205.0980 0.6194 205.2000 0.5673 205.3980 0.5673 205.5000 0.6056 205.6980 0.6056 205.8000 0.5477 205.9980 0.5477 206.1000 0.5860 206.2980 0.5860 206.4000 0.5723 206.5980 0.5723 206.7000 0.6247 206.8980 0.6247 207.0000 0.5668 207.1980 0.5668 207.3000 0.6160 207.4980 0.6160 207.6000 0.5790 207.7980 0.5790 207.9000 0.6068 208.0980 0.6068 208.2000 0.5960 208.3980 0.5960 208.5000 0.6236 208.6980 0.6236 208.8000 0.5892 208.9980 0.5892 209.1000 0.6006 209.2980 0.6006 209.4000 0.5466 209.5980 0.5466 209.7000 0.5968 209.8980 0.5968 210.0000 0.5883 210.1980 0.5883 210.3000 0.6004 210.4980 0.6004 210.6000 0.5933 210.7980 0.5933 210.9000 0.8301 211.0980 0.8301 211.2000 0.6131 211.3980 0.6131 211.5000 0.6082 211.6980 0.6082 211.8000 0.5745 211.9980 0.5745 212.1000 0.5786 212.2980 0.5786 212.4000 0.7627 212.5980 0.7627 212.7000 0.6088 212.8980 0.6088 213.0000 0.7124 213.1980 0.7124 213.3000 0.8198 213.4980 0.8198 213.6000 0.9262 213.7980 0.9262 213.9000 0.6409 214.0980 0.6409 214.2000 0.6683 214.3980 0.6683 214.5000 0.6020 214.6980 0.6020 214.8000 0.9248 214.9980 0.9248 215.1000 0.9426 215.2980 0.9426 215.4000 0.5737 215.5980 0.5737 215.7000 0.5754 215.8980 0.5754 216.0000 1.3786 216.1980 1.3786 216.3000 0.5820 216.4980 0.5820 216.6000 1.1272 216.7980 1.1272 216.9000 0.8952 217.0980 0.8952 217.2000 0.7470 217.3980 0.7470 217.5000 0.8368 217.6980 0.8368 217.8000 1.2710 217.9980 1.2710 218.1000 1.4098 218.2980 1.4098 218.4000 1.0574 218.5980 1.0574 218.7000 0.9045 218.8980 0.9045 219.0000 0.5457 219.1980 0.5457 219.3000 1.2497 219.4980 1.2497 219.6000 0.9090 219.7980 0.9090 219.9000 1.2523 220.0980 1.2523 220.2000 0.6574 220.3980 0.6574 220.5000 1.0266 220.6980 1.0266 220.8000 1.5482 220.9980 1.5482 221.1000 0.8369 221.2980 0.8369 221.4000 0.8953 221.5980 0.8953 221.7000 1.1319 221.8980 1.1319 222.0000 1.0691 222.1980 1.0691 222.3000 0.6974 222.4980 0.6974 222.6000 0.8277 222.7980 0.8277 222.9000 0.5462 223.0980 0.5462 223.2000 0.5412 223.3980 0.5412 223.5000 0.5887 223.6980 0.5887 223.8000 0.6782 223.9980 0.6782 224.1000 0.7543 224.2980 0.7543 224.4000 0.5913 224.5980 0.5913 224.7000 0.6190 224.8980 0.6190 225.0000 0.5692 225.1980 0.5692 225.3000 0.5961 225.4980 0.5961 225.6000 0.6150 225.7980 0.6150 225.9000 0.5696 226.0980 0.5696 226.2000 0.6065 226.3980 0.6065 226.5000 0.6194 226.6980 0.6194 226.8000 0.5673 226.9980 0.5673 227.1000 0.6056 227.2980 0.6056 227.4000 0.5477 227.5980 0.5477 227.7000 0.5860 227.8980 0.5860 228.0000 0.5723 228.1980 0.5723 228.3000 0.6247 228.4980 0.6247 228.6000 0.5668 228.7980 0.5668 228.9000 0.6160 229.0980 0.6160 229.2000 0.5790 229.3980 0.5790 229.5000 0.6068 229.6980 0.6068 229.8000 0.5960 229.9980 0.5960 230.1000 0.6236 230.2980 0.6236 230.4000 0.5892 230.5980 0.5892 230.7000 0.6006 230.8980 0.6006 231.0000 0.5466 231.1980 0.5466 231.3000 0.5968 231.4980 0.5968 231.6000 0.5883 231.7980 0.5883 231.9000 0.6004 232.0980 0.6004 232.2000 0.5933 232.3980 0.5933 232.5000 0.8301 232.6980 0.8301 232.8000 0.6131 232.9980 0.6131 233.1000 0.6082 233.2980 0.6082 233.4000 0.5745 233.5980 0.5745 233.7000 0.5786 233.8980 0.5786 234.0000 0.7627 234.1980 0.7627 234.3000 0.6088 234.4980 0.6088 234.6000 0.7124 234.7980 0.7124 234.9000 0.8198 235.0980 0.8198 235.2000 0.9262 235.3980 0.9262 235.5000 0.6409 235.6980 0.6409 235.8000 0.6683 235.9980 0.6683 236.1000 0.6020 236.2980 0.6020 236.4000 0.9248 236.5980 0.9248 236.7000 0.9426 236.8980 0.9426 237.0000 0.5737 237.1980 0.5737 237.3000 0.5754 237.4980 0.5754 237.6000 1.3786 237.7980 1.3786 237.9000 0.5820 238.0980 0.5820 238.2000 1.1272 238.3980 1.1272 238.5000 0.8952 238.6980 0.8952 238.8000 0.7470 238.9980 0.7470 239.1000 0.8368 239.2980 0.8368 239.4000 1.2710 239.5980 1.2710 239.7000 1.4098 239.8980 1.4098 240.0000 1.0574 240.1980 1.0574 240.3000 0.9045 240.4980 0.9045 240.6000 0.5457 240.7980 0.5457 240.9000 1.2497 241.0980 1.2497 241.2000 0.9090 241.3980 0.9090 241.5000 1.2523 241.6980 1.2523 241.8000 0.6574 241.9980 0.6574 242.1000 1.0266 242.2980 1.0266 242.4000 1.5482 242.5980 1.5482 242.7000 0.8369 242.8980 0.8369 243.0000 0.8953 243.1980 0.8953 243.3000 1.1319 243.4980 1.1319 243.6000 1.0691 243.7980 1.0691 243.9000 0.6974 244.0980 0.6974 244.2000 0.8277 244.3980 0.8277 244.5000 0.5462 244.6980 0.5462 244.8000 0.5412 244.9980 0.5412 245.1000 0.5887 245.2980 0.5887 245.4000 0.6782 245.5980 0.6782 245.7000 0.7543 245.8980 0.7543 246.0000 0.5913 246.1980 0.5913 246.3000 0.6190 246.4980 0.6190 246.6000 0.5692 246.7980 0.5692 246.9000 0.5961 247.0980 0.5961 247.2000 0.6150 247.3980 0.6150 247.5000 0.5696 247.6980 0.5696 247.8000 0.6065 247.9980 0.6065 248.1000 0.6194 248.2980 0.6194 248.4000 0.5673 248.5980 0.5673 248.7000 0.6056 248.8980 0.6056 249.0000 0.5477 249.1980 0.5477 249.3000 0.5860 249.4980 0.5860 249.6000 0.5723 249.7980 0.5723 249.9000 0.6247 250.0980 0.6247 250.2000 0.5668 250.3980 0.5668 250.5000 0.6160 250.6980 0.6160 250.8000 0.5790 250.9980 0.5790 251.1000 0.6068 251.2980 0.6068 251.4000 0.5960 251.5980 0.5960 251.7000 0.6236 251.8980 0.6236 252.0000 0.5892 252.1980 0.5892 252.3000 0.6006 252.4980 0.6006 252.6000 0.5466 252.7980 0.5466 252.9000 0.5968 253.0980 0.5968 253.2000 0.5883 253.3980 0.5883 253.5000 0.6004 253.6980 0.6004 253.8000 0.5933 253.9980 0.5933 254.1000 0.8301 254.2980 0.8301 254.4000 0.6131 254.5980 0.6131 254.7000 0.6082 254.8980 0.6082 255.0000 0.5745 255.1980 0.5745 255.3000 0.5786 255.4980 0.5786 255.6000 0.7627 255.7980 0.7627 255.9000 0.6088 256.0980 0.6088 256.2000 0.7124 256.3980 0.7124 256.5000 0.8198 256.6980 0.8198 256.8000 0.9262 256.9980 0.9262 257.1000 0.6409 257.2980 0.6409 257.4000 0.6683 257.5980 0.6683 257.7000 0.6020 257.8980 0.6020 258.0000 0.9248 258.1980 0.9248 258.3000 0.9426 258.4980 0.9426 258.6000 0.5737 258.7980 0.5737 258.9000 0.5754 259.0980 0.5754 259.2000 1.3786 259.3980 1.3786 259.5000 0.5820 259.6980 0.5820 259.8000 1.1272 259.9980 1.1272 260.1000 0.8952 260.2980 0.8952 260.4000 0.7470 260.5980 0.7470 260.7000 0.8368 260.8980 0.8368 261.0000 1.2710 261.1980 1.2710 261.3000 1.4098 261.4980 1.4098 261.6000 1.0574 261.7980 1.0574 261.9000 0.9045 262.0980 0.9045 262.2000 0.5457 262.3980 0.5457 262.5000 1.2497 262.6980 1.2497 262.8000 0.9090 262.9980 0.9090 263.1000 1.2523 263.2980 1.2523 263.4000 0.6574 263.5980 0.6574 263.7000 1.0266 263.8980 1.0266 264.0000 1.5482 264.1980 1.5482 264.3000 0.8369 264.4980 0.8369 264.6000 0.8953 264.7980 0.8953 264.9000 1.1319 265.0980 1.1319 265.2000 1.0691 265.3980 1.0691 265.5000 0.6974 265.6980 0.6974 265.8000 0.8277 265.9980 0.8277 266.1000 0.5462 266.2980 0.5462 266.4000 0.5412 266.5980 0.5412 266.7000 0.5887 266.8980 0.5887 267.0000 0.6782 267.1980 0.6782 267.3000 0.7543 267.4980 0.7543 267.6000 0.5913 267.7980 0.5913 267.9000 0.6190 268.0980 0.6190 268.2000 0.5692 268.3980 0.5692 268.5000 0.5961 268.6980 0.5961 268.8000 0.6150 268.9980 0.6150 269.1000 0.5696 269.2980 0.5696 269.4000 0.6065 269.5980 0.6065 269.7000 0.6194 269.8980 0.6194 270.0000 0.5673 270.1980 0.5673 270.3000 0.6056 270.4980 0.6056 270.6000 0.5477 270.7980 0.5477 270.9000 0.5860 271.0980 0.5860 271.2000 0.5723 271.3980 0.5723 271.5000 0.6247 271.6980 0.6247 271.8000 0.5668 271.9980 0.5668 272.1000 0.6160 272.2980 0.6160 272.4000 0.5790 272.5980 0.5790 272.7000 0.6068 272.8980 0.6068 273.0000 0.5960 273.1980 0.5960 273.3000 0.6236 273.4980 0.6236 273.6000 0.5892 273.7980 0.5892 273.9000 0.6006 274.0980 0.6006 274.2000 0.5466 274.3980 0.5466 274.5000 0.5968 274.6980 0.5968 274.8000 0.5883 274.9980 0.5883 275.1000 0.6004 275.2980 0.6004 275.4000 0.5933 275.5980 0.5933 275.7000 0.8301 275.8980 0.8301 276.0000 0.6131 276.1980 0.6131 276.3000 0.6082 276.4980 0.6082 276.6000 0.5745 276.7980 0.5745 276.9000 0.5786 277.0980 0.5786 277.2000 0.7627 277.3980 0.7627 277.5000 0.6088 277.6980 0.6088 277.8000 0.7124 277.9980 0.7124 278.1000 0.8198 278.2980 0.8198 278.4000 0.9262 278.5980 0.9262 278.7000 0.6409 278.8980 0.6409 279.0000 0.6683 279.1980 0.6683 279.3000 0.6020 279.4980 0.6020 279.6000 0.9248 279.7980 0.9248 279.9000 0.9426 280.0980 0.9426 280.2000 0.5737 280.3980 0.5737 280.5000 0.5754 280.6980 0.5754 280.8000 1.3786 280.9980 1.3786 281.1000 0.5820 281.2980 0.5820 281.4000 1.1272 281.5980 1.1272 281.7000 0.8952 281.8980 0.8952 282.0000 0.7470 282.1980 0.7470 282.3000 0.8368 282.4980 0.8368 282.6000 1.2710 282.7980 1.2710 282.9000 1.4098 283.0980 1.4098 283.2000 1.0574 283.3980 1.0574 283.5000 0.9045 283.6980 0.9045 283.8000 0.5457 283.9980 0.5457 284.1000 1.2497 284.2980 1.2497 284.4000 0.9090 284.5980 0.9090 284.7000 1.2523 284.8980 1.2523 285.0000 0.6574 285.1980 0.6574 285.3000 1.0266 285.4980 1.0266 285.6000 1.5482 285.7980 1.5482 285.9000 0.8369 286.0980 0.8369 286.2000 0.8953 286.3980 0.8953 286.5000 1.1319 286.6980 1.1319 286.8000 1.0691 286.9980 1.0691 287.1000 0.6974 287.2980 0.6974 287.4000 0.8277 287.5980 0.8277 287.7000 0.5462 287.8980 0.5462 288.0000 0.5412 288.1980 0.5412 288.3000 0.5887 288.4980 0.5887 288.6000 0.6782 288.7980 0.6782 288.9000 0.7543 289.0980 0.7543 289.2000 0.5913 289.3980 0.5913 289.5000 0.6190 289.6980 0.6190 289.8000 0.5692 289.9980 0.5692 290.1000 0.5961 290.2980 0.5961 290.4000 0.6150 290.5980 0.6150 290.7000 0.5696 290.8980 0.5696 291.0000 0.6065 291.1980 0.6065 291.3000 0.6194 291.4980 0.6194 291.6000 0.5673 291.7980 0.5673 291.9000 0.6056 292.0980 0.6056 292.2000 0.5477 292.3980 0.5477 292.5000 0.5860 292.6980 0.5860 292.8000 0.5723 292.9980 0.5723 293.1000 0.6247 293.2980 0.6247 293.4000 0.5668 293.5980 0.5668 293.7000 0.6160 293.8980 0.6160 294.0000 0.5790 294.1980 0.5790 294.3000 0.6068 294.4980 0.6068 294.6000 0.5960 294.7980 0.5960 294.9000 0.6236 295.0980 0.6236 295.2000 0.5892 295.3980 0.5892 295.5000 0.6006 295.6980 0.6006 295.8000 0.5466 295.9980 0.5466 296.1000 0.5968 296.2980 0.5968 296.4000 0.5883 296.5980 0.5883 296.7000 0.6004 296.8980 0.6004 297.0000 0.5933 297.1980 0.5933 297.3000 0.8301 297.4980 0.8301 297.6000 0.6131 297.7980 0.6131 297.9000 0.6082 298.0980 0.6082 298.2000 0.5745 298.3980 0.5745 298.5000 0.5786 298.6980 0.5786 298.8000 0.7627 298.9980 0.7627 299.1000 0.6088 299.2980 0.6088 299.4000 0.7124 299.5980 0.7124 299.7000 0.8198 299.8980 0.8198 300.0000 0.9262 300.1980 0.9262 300.3000 0.6409 300.4980 0.6409 300.6000 0.6683 300.7980 0.6683 300.9000 0.6020 301.0980 0.6020 301.2000 0.9248 301.3980 0.9248 301.5000 0.9426 301.6980 0.9426 301.8000 0.5737 301.9980 0.5737 302.1000 0.5754 302.2980 0.5754 302.4000 1.3786 302.5980 1.3786 302.7000 0.5820 302.8980 0.5820 303.0000 1.1272 303.1980 1.1272 303.3000 0.8952 303.4980 0.8952 303.6000 0.7470 303.7980 0.7470 303.9000 0.8368 304.0980 0.8368 304.2000 1.2710 304.3980 1.2710 304.5000 1.4098 304.6980 1.4098 304.8000 1.0574 304.9980 1.0574 305.1000 0.9045 305.2980 0.9045 305.4000 0.5457 305.5980 0.5457 305.7000 1.2497 305.8980 1.2497 306.0000 0.9090 306.1980 0.9090 306.3000 1.2523 306.4980 1.2523 306.6000 0.6574 306.7980 0.6574 306.9000 1.0266 307.0980 1.0266 307.2000 1.5482 307.3980 1.5482 307.5000 0.8369 307.6980 0.8369 307.8000 0.8953 307.9980 0.8953 308.1000 1.1319 308.2980 1.1319 308.4000 1.0691 308.5980 1.0691 308.7000 0.6974 308.8980 0.6974 309.0000 0.8277 309.1980 0.8277 309.3000 0.5462 309.4980 0.5462 309.6000 0.5412 309.7980 0.5412 309.9000 0.5887 310.0980 0.5887 310.2000 0.6782 310.3980 0.6782 310.5000 0.7543 310.6980 0.7543 310.8000 0.5913 310.9980 0.5913 311.1000 0.6190 311.2980 0.6190 311.4000 0.5692 311.5980 0.5692 311.7000 0.5961 311.8980 0.5961 312.0000 0.6150 312.1980 0.6150 312.3000 0.5696 312.4980 0.5696 312.6000 0.6065 312.7980 0.6065 312.9000 0.6194 313.0980 0.6194 313.2000 0.5673 313.3980 0.5673 313.5000 0.6056 313.6980 0.6056 313.8000 0.5477 313.9980 0.5477 314.1000 0.5860 314.2980 0.5860 314.4000 0.5723 314.5980 0.5723 314.7000 0.6247 314.8980 0.6247 315.0000 0.5668 315.1980 0.5668 315.3000 0.6160 315.4980 0.6160 315.6000 0.5790 315.7980 0.5790 315.9000 0.6068 316.0980 0.6068 316.2000 0.5960 316.3980 0.5960 316.5000 0.6236 316.6980 0.6236 316.8000 0.5892 316.9980 0.5892 317.1000 0.6006 317.2980 0.6006 317.4000 0.5466 317.5980 0.5466 317.7000 0.5968 317.8980 0.5968 318.0000 0.5883 318.1980 0.5883 318.3000 0.6004 318.4980 0.6004 318.6000 0.5933 318.7980 0.5933 318.9000 0.8301 319.0980 0.8301 319.2000 0.6131 319.3980 0.6131 319.5000 0.6082 319.6980 0.6082 319.8000 0.5745 319.9980 0.5745 320.1000 0.5786 320.2980 0.5786 320.4000 0.7627 320.5980 0.7627 320.7000 0.6088 320.8980 0.6088 321.0000 0.7124 321.1980 0.7124 321.3000 0.8198 321.4980 0.8198 321.6000 0.9262 321.7980 0.9262 321.9000 0.6409 322.0980 0.6409 322.2000 0.6683 322.3980 0.6683 322.5000 0.6020 322.6980 0.6020 322.8000 0.9248 322.9980 0.9248 323.1000 0.9426 323.2980 0.9426 323.4000 0.5737 323.5980 0.5737 323.7000 0.5754 323.8980 0.5754 324.0000 1.3786 324.1980 1.3786 324.3000 0.5820 324.4980 0.5820 324.6000 1.1272 324.7980 1.1272 324.9000 0.8952 325.0980 0.8952 325.2000 0.7470 325.3980 0.7470 325.5000 0.8368 325.6980 0.8368 325.8000 1.2710 325.9980 1.2710 326.1000 1.4098 326.2980 1.4098 326.4000 1.0574 326.5980 1.0574 326.7000 0.9045 326.8980 0.9045 327.0000 0.5457 327.1980 0.5457 327.3000 1.2497 327.4980 1.2497 327.6000 0.9090 327.7980 0.9090 327.9000 1.2523 328.0980 1.2523 328.2000 0.6574 328.3980 0.6574 328.5000 1.0266 328.6980 1.0266 328.8000 1.5482 328.9980 1.5482 329.1000 0.8369 329.2980 0.8369 329.4000 0.8953 329.5980 0.8953 329.7000 1.1319 329.8980 1.1319 330.0000 1.0691 330.1980 1.0691 330.3000 0.6974 330.4980 0.6974 330.6000 0.8277 330.7980 0.8277 330.9000 0.5462 331.0980 0.5462 331.2000 0.5412 331.3980 0.5412 331.5000 0.5887 331.6980 0.5887 331.8000 0.6782 331.9980 0.6782 332.1000 0.7543 332.2980 0.7543 332.4000 0.5913 332.5980 0.5913 332.7000 0.6190 332.8980 0.6190 333.0000 0.5692 333.1980 0.5692 333.3000 0.5961 333.4980 0.5961 333.6000 0.6150 333.7980 0.6150 333.9000 0.5696 334.0980 0.5696 334.2000 0.6065 334.3980 0.6065 334.5000 0.6194 334.6980 0.6194 334.8000 0.5673 334.9980 0.5673 335.1000 0.6056 335.2980 0.6056 335.4000 0.5477 335.5980 0.5477 335.7000 0.5860 335.8980 0.5860 336.0000 0.5723 336.1980 0.5723 336.3000 0.6247 336.4980 0.6247 336.6000 0.5668 336.7980 0.5668 336.9000 0.6160 337.0980 0.6160 337.2000 0.5790 337.3980 0.5790 337.5000 0.6068 337.6980 0.6068 337.8000 0.5960 337.9980 0.5960 338.1000 0.6236 338.2980 0.6236 338.4000 0.5892 338.5980 0.5892 338.7000 0.6006 338.8980 0.6006 339.0000 0.5466 339.1980 0.5466 339.3000 0.5968 339.4980 0.5968 339.6000 0.5883 339.7980 0.5883 339.9000 0.6004 340.0980 0.6004 340.2000 0.5933 340.3980 0.5933 340.5000 0.8301 340.6980 0.8301 340.8000 0.6131 340.9980 0.6131 341.1000 0.6082 341.2980 0.6082 341.4000 0.5745 341.5980 0.5745 341.7000 0.5786 341.8980 0.5786 342.0000 0.7627 342.1980 0.7627 342.3000 0.6088 342.4980 0.6088 342.6000 0.7124 342.7980 0.7124 342.9000 0.8198 343.0980 0.8198 343.2000 0.9262 343.3980 0.9262 343.5000 0.6409 343.6980 0.6409 343.8000 0.6683 343.9980 0.6683 344.1000 0.6020 344.2980 0.6020 344.4000 0.9248 344.5980 0.9248 344.7000 0.9426 344.8980 0.9426 345.0000 0.5737 345.1980 0.5737 345.3000 0.5754 345.4980 0.5754 345.6000 1.3786 345.7980 1.3786 345.9000 0.5820 346.0980 0.5820 346.2000 1.1272 346.3980 1.1272 346.5000 0.8952 346.6980 0.8952 346.8000 0.7470 346.9980 0.7470 347.1000 0.8368 347.2980 0.8368 347.4000 1.2710 347.5980 1.2710 347.7000 1.4098 347.8980 1.4098 348.0000 1.0574 348.1980 1.0574 348.3000 0.9045 348.4980 0.9045 348.6000 0.5457 348.7980 0.5457 348.9000 1.2497 349.0980 1.2497 349.2000 0.9090 349.3980 0.9090 349.5000 1.2523 349.6980 1.2523 349.8000 0.6574 349.9980 0.6574 350.1000 1.0266 350.2980 1.0266 350.4000 1.5482 350.5980 1.5482 350.7000 0.8369 350.8980 0.8369 351.0000 0.8953 351.1980 0.8953 351.3000 1.1319 351.4980 1.1319 351.6000 1.0691 351.7980 1.0691 351.9000 0.6974 352.0980 0.6974 352.2000 0.8277 352.3980 0.8277 352.5000 0.5462 352.6980 0.5462 352.8000 0.5412 352.9980 0.5412 353.1000 0.5887 353.2980 0.5887 353.4000 0.6782 353.5980 0.6782 353.7000 0.7543 353.8980 0.7543 354.0000 0.5913 354.1980 0.5913 354.3000 0.6190 354.4980 0.6190 354.6000 0.5692 354.7980 0.5692 354.9000 0.5961 355.0980 0.5961 355.2000 0.6150 355.3980 0.6150 355.5000 0.5696 355.6980 0.5696 355.8000 0.6065 355.9980 0.6065 356.1000 0.6194 356.2980 0.6194 356.4000 0.5673 356.5980 0.5673 356.7000 0.6056 356.8980 0.6056 357.0000 0.5477 357.1980 0.5477 357.3000 0.5860 357.4980 0.5860 357.6000 0.5723 357.7980 0.5723 357.9000 0.6247 358.0980 0.6247 358.2000 0.5668 358.3980 0.5668 358.5000 0.6160 358.6980 0.6160 358.8000 0.5790 358.9980 0.5790 359.1000 0.6068 359.2980 0.6068 359.4000 0.5960 359.5980 0.5960 359.7000 0.6236 359.8980 0.6236 360.0000 0.5892 360.1980 0.5892 360.3000 0.6006 360.4980 0.6006 360.6000 0.5466 360.7980 0.5466 360.9000 0.5968 361.0980 0.5968 361.2000 0.5883 361.3980 0.5883 361.5000 0.6004 361.6980 0.6004 361.8000 0.5933 361.9980 0.5933 362.1000 0.8301 362.2980 0.8301 362.4000 0.6131 362.5980 0.6131 362.7000 0.6082 362.8980 0.6082 363.0000 0.5745 363.1980 0.5745 363.3000 0.5786 363.4980 0.5786 363.6000 0.7627 363.7980 0.7627 363.9000 0.6088 364.0980 0.6088 364.2000 0.7124 364.3980 0.7124 364.5000 0.8198 364.6980 0.8198 364.8000 0.9262 364.9980 0.9262 365.1000 0.6409 365.2980 0.6409 365.4000 0.6683 365.5980 0.6683 365.7000 0.6020 365.8980 0.6020 366.0000 0.9248 366.1980 0.9248 366.3000 0.9426 366.4980 0.9426 366.6000 0.5737 366.7980 0.5737 366.9000 0.5754 367.0980 0.5754 367.2000 1.3786 367.3980 1.3786 367.5000 0.5820 367.6980 0.5820 367.8000 1.1272 367.9980 1.1272 368.1000 0.8952 368.2980 0.8952 368.4000 0.7470 368.5980 0.7470 368.7000 0.8368 368.8980 0.8368 369.0000 1.2710 369.1980 1.2710 369.3000 1.4098 369.4980 1.4098 369.6000 1.0574 369.7980 1.0574 369.9000 0.9045 370.0980 0.9045 370.2000 0.5457 370.3980 0.5457 370.5000 1.2497 370.6980 1.2497 370.8000 0.9090 370.9980 0.9090 371.1000 1.2523 371.2980 1.2523 371.4000 0.6574 371.5980 0.6574 371.7000 1.0266 371.8980 1.0266 372.0000 1.5482 372.1980 1.5482 372.3000 0.8369 372.4980 0.8369 372.6000 0.8953 372.7980 0.8953 372.9000 1.1319 373.0980 1.1319 373.2000 1.0691 373.3980 1.0691 373.5000 0.6974 373.6980 0.6974 373.8000 0.8277 373.9980 0.8277 374.1000 0.5462 374.2980 0.5462 374.4000 0.5412 374.5980 0.5412 374.7000 0.5887 374.8980 0.5887 375.0000 0.6782 375.1980 0.6782 375.3000 0.7543 375.4980 0.7543 375.6000 0.5913 375.7980 0.5913 375.9000 0.6190 376.0980 0.6190 376.2000 0.5692 376.3980 0.5692 376.5000 0.5961 376.6980 0.5961 376.8000 0.6150 376.9980 0.6150 377.1000 0.5696 377.2980 0.5696 377.4000 0.6065 377.5980 0.6065 377.7000 0.6194 377.8980 0.6194 378.0000 0.5673 378.1980 0.5673 378.3000 0.6056 378.4980 0.6056 378.6000 0.5477 378.7980 0.5477 378.9000 0.5860 379.0980 0.5860 379.2000 0.5723 379.3980 0.5723 379.5000 0.6247 379.6980 0.6247 379.8000 0.5668 379.9980 0.5668 380.1000 0.6160 380.2980 0.6160 380.4000 0.5790 380.5980 0.5790 380.7000 0.6068 380.8980 0.6068 381.0000 0.5960 381.1980 0.5960 381.3000 0.6236 381.4980 0.6236 381.6000 0.5892 381.7980 0.5892 381.9000 0.6006 382.0980 0.6006 382.2000 0.5466 382.3980 0.5466 382.5000 0.5968 382.6980 0.5968 382.8000 0.5883 382.9980 0.5883 383.1000 0.6004 383.2980 0.6004 383.4000 0.5933 383.5980 0.5933 383.7000 0.8301 383.8980 0.8301 384.0000 0.6131 384.1980 0.6131 384.3000 0.6082 384.4980 0.6082 384.6000 0.5745 384.7980 0.5745 384.9000 0.5786 385.0980 0.5786 385.2000 0.7627 385.3980 0.7627 385.5000 0.6088 385.6980 0.6088 385.8000 0.7124 385.9980 0.7124 386.1000 0.8198 386.2980 0.8198 386.4000 0.9262 386.5980 0.9262 386.7000 0.6409 386.8980 0.6409 387.0000 0.6683 387.1980 0.6683 387.3000 0.6020 387.4980 0.6020 387.6000 0.9248 387.7980 0.9248 387.9000 0.9426 388.0980 0.9426 388.2000 0.5737 388.3980 0.5737 388.5000 0.5754 388.6980 0.5754 388.8000 1.3786 388.9980 1.3786 389.1000 0.5820 389.2980 0.5820 389.4000 1.1272 389.5980 1.1272 389.7000 0.8952 389.8980 0.8952 390.0000 0.7470 390.1980 0.7470 390.3000 0.8368 390.4980 0.8368 390.6000 1.2710 390.7980 1.2710 390.9000 1.4098 391.0980 1.4098 391.2000 1.0574 391.3980 1.0574 391.5000 0.9045 391.6980 0.9045 391.8000 0.5457 391.9980 0.5457 392.1000 1.2497 392.2980 1.2497 392.4000 0.9090 392.5980 0.9090 392.7000 1.2523 392.8980 1.2523 393.0000 0.6574 393.1980 0.6574 393.3000 1.0266 393.4980 1.0266 393.6000 1.5482 393.7980 1.5482 393.9000 0.8369 394.0980 0.8369 394.2000 0.8953 394.3980 0.8953 394.5000 1.1319 394.6980 1.1319 394.8000 1.0691 394.9980 1.0691 395.1000 0.6974 395.2980 0.6974 395.4000 0.8277 395.5980 0.8277 395.7000 0.5462 395.8980 0.5462 396.0000 0.5412 396.1980 0.5412 396.3000 0.5887 396.4980 0.5887 396.6000 0.6782 396.7980 0.6782 396.9000 0.7543 397.0980 0.7543 397.2000 0.5913 397.3980 0.5913 397.5000 0.6190 397.6980 0.6190 397.8000 0.5692 397.9980 0.5692 398.1000 0.5961 398.2980 0.5961 398.4000 0.6150 398.5980 0.6150 398.7000 0.5696 398.8980 0.5696 399.0000 0.6065 399.1980 0.6065 399.3000 0.6194 399.4980 0.6194 399.6000 0.5673 399.7980 0.5673 399.9000 0.6056 400.0980 0.6056 400.2000 0.5477 400.3980 0.5477 400.5000 0.5860 400.6980 0.5860 400.8000 0.5723 400.9980 0.5723 401.1000 0.6247 401.2980 0.6247 401.4000 0.5668 401.5980 0.5668 401.7000 0.6160 401.8980 0.6160 402.0000 0.5790 402.1980 0.5790 402.3000 0.6068 402.4980 0.6068 402.6000 0.5960 402.7980 0.5960 402.9000 0.6236 403.0980 0.6236 403.2000 0.5892 403.3980 0.5892 403.5000 0.6006 403.6980 0.6006 403.8000 0.5466 403.9980 0.5466 404.1000 0.5968 404.2980 0.5968 404.4000 0.5883 404.5980 0.5883 404.7000 0.6004 404.8980 0.6004 405.0000 0.5933 405.1980 0.5933 405.3000 0.8301 405.4980 0.8301 405.6000 0.6131 405.7980 0.6131 405.9000 0.6082 406.0980 0.6082 406.2000 0.5745 406.3980 0.5745 406.5000 0.5786 406.6980 0.5786 406.8000 0.7627 406.9980 0.7627 407.1000 0.6088 407.2980 0.6088 407.4000 0.7124 407.5980 0.7124 407.7000 0.8198 407.8980 0.8198 408.0000 0.9262 408.1980 0.9262 408.3000 0.6409 408.4980 0.6409 408.6000 0.6683 408.7980 0.6683 408.9000 0.6020 409.0980 0.6020 409.2000 0.9248 409.3980 0.9248 409.5000 0.9426 409.6980 0.9426 409.8000 0.5737 409.9980 0.5737 410.1000 0.5754 410.2980 0.5754 410.4000 1.3786 410.5980 1.3786 410.7000 0.5820 410.8980 0.5820 411.0000 1.1272 411.1980 1.1272 411.3000 0.8952 411.4980 0.8952 411.6000 0.7470 411.7980 0.7470 411.9000 0.8368 412.0980 0.8368 412.2000 1.2710 412.3980 1.2710 412.5000 1.4098 412.6980 1.4098 412.8000 1.0574 412.9980 1.0574 413.1000 0.9045 413.2980 0.9045 413.4000 0.5457 413.5980 0.5457 413.7000 1.2497 413.8980 1.2497 414.0000 0.9090 414.1980 0.9090 414.3000 1.2523 414.4980 1.2523 414.6000 0.6574 414.7980 0.6574 414.9000 1.0266 415.0980 1.0266 415.2000 1.5482 415.3980 1.5482 415.5000 0.8369 415.6980 0.8369 415.8000 0.8953 415.9980 0.8953 416.1000 1.1319 416.2980 1.1319 416.4000 1.0691 416.5980 1.0691 416.7000 0.6974 416.8980 0.6974 417.0000 0.8277 417.1980 0.8277 417.3000 0.5462 417.4980 0.5462 417.6000 0.5412 417.7980 0.5412 417.9000 0.5887 418.0980 0.5887 418.2000 0.6782 418.3980 0.6782 418.5000 0.7543 418.6980 0.7543 418.8000 0.5913 418.9980 0.5913 419.1000 0.6190 419.2980 0.6190 419.4000 0.5692 419.5980 0.5692 419.7000 0.5961 419.8980 0.5961 420.0000 0.6150 420.1980 0.6150 420.3000 0.5696 420.4980 0.5696 420.6000 0.6065 420.7980 0.6065 420.9000 0.6194 421.0980 0.6194 421.2000 0.5673 421.3980 0.5673 421.5000 0.6056 421.6980 0.6056 421.8000 0.5477 421.9980 0.5477 422.1000 0.5860 422.2980 0.5860 422.4000 0.5723 422.5980 0.5723 422.7000 0.6247 422.8980 0.6247 423.0000 0.5668 423.1980 0.5668 423.3000 0.6160 423.4980 0.6160 423.6000 0.5790 423.7980 0.5790 423.9000 0.6068 424.0980 0.6068 424.2000 0.5960 424.3980 0.5960 424.5000 0.6236 424.6980 0.6236 424.8000 0.5892 424.9980 0.5892 425.1000 0.6006 425.2980 0.6006 425.4000 0.5466 425.5980 0.5466 425.7000 0.5968 425.8980 0.5968 426.0000 0.5883 426.1980 0.5883 426.3000 0.6004 426.4980 0.6004 426.6000 0.5933 426.7980 0.5933 426.9000 0.8301 427.0980 0.8301 427.2000 0.6131 427.3980 0.6131 427.5000 0.6082 427.6980 0.6082 427.8000 0.5745 427.9980 0.5745 428.1000 0.5786 428.2980 0.5786 428.4000 0.7627 428.5980 0.7627 428.7000 0.6088 428.8980 0.6088 429.0000 0.7124 429.1980 0.7124 429.3000 0.8198 429.4980 0.8198 429.6000 0.9262 429.7980 0.9262 429.9000 0.6409 430.0980 0.6409 430.2000 0.6683 430.3980 0.6683 430.5000 0.6020 430.6980 0.6020 430.8000 0.9248 430.9980 0.9248 431.1000 0.9426 431.2980 0.9426 431.4000 0.5737 431.5980 0.5737 431.7000 0.5754 431.8980 0.5754 432.0000 1.3786 432.1980 1.3786 432.3000 0.5820 432.4980 0.5820 432.6000 1.1272 432.7980 1.1272 432.9000 0.8952 433.0980 0.8952 433.2000 0.7470 433.3980 0.7470 433.5000 0.8368 433.6980 0.8368 433.8000 1.2710 433.9980 1.2710 434.1000 1.4098 434.2980 1.4098 434.4000 1.0574 434.5980 1.0574 434.7000 0.9045 434.8980 0.9045 435.0000 0.5457 435.1980 0.5457 435.3000 1.2497 435.4980 1.2497 435.6000 0.9090 435.7980 0.9090 435.9000 1.2523 436.0980 1.2523 436.2000 0.6574 436.3980 0.6574 436.5000 1.0266 436.6980 1.0266 436.8000 1.5482 436.9980 1.5482 437.1000 0.8369 437.2980 0.8369 437.4000 0.8953 437.5980 0.8953 437.7000 1.1319 437.8980 1.1319 438.0000 1.0691 438.1980 1.0691 438.3000 0.6974 438.4980 0.6974 438.6000 0.8277 438.7980 0.8277 438.9000 0.5462 439.0980 0.5462 439.2000 0.5412 439.3980 0.5412 439.5000 0.5887 439.6980 0.5887 439.8000 0.6782 439.9980 0.6782 440.1000 0.7543 440.2980 0.7543 440.4000 0.5913 440.5980 0.5913 440.7000 0.6190 440.8980 0.6190 441.0000 0.5692 441.1980 0.5692 441.3000 0.5961 441.4980 0.5961 441.6000 0.6150 441.7980 0.6150 441.9000 0.5696 442.0980 0.5696 442.2000 0.6065 442.3980 0.6065 442.5000 0.6194 442.6980 0.6194 442.8000 0.5673 442.9980 0.5673 443.1000 0.6056 443.2980 0.6056 443.4000 0.5477 443.5980 0.5477 443.7000 0.5860 443.8980 0.5860 444.0000 0.5723 444.1980 0.5723 444.3000 0.6247 444.4980 0.6247 444.6000 0.5668 444.7980 0.5668 444.9000 0.6160 445.0980 0.6160 445.2000 0.5790 445.3980 0.5790 445.5000 0.6068 445.6980 0.6068 445.8000 0.5960 445.9980 0.5960 446.1000 0.6236 446.2980 0.6236 446.4000 0.5892 446.5980 0.5892 446.7000 0.6006 446.8980 0.6006 447.0000 0.5466 447.1980 0.5466 447.3000 0.5968 447.4980 0.5968 447.6000 0.5883 447.7980 0.5883 447.9000 0.6004 448.0980 0.6004 448.2000 0.5933 448.3980 0.5933 448.5000 0.8301 448.6980 0.8301 448.8000 0.6131 448.9980 0.6131 449.1000 0.6082 449.2980 0.6082 449.4000 0.5745 449.5980 0.5745 449.7000 0.5786 449.8980 0.5786 450.0000 0.7627 450.1980 0.7627 450.3000 0.6088 450.4980 0.6088 450.6000 0.7124 450.7980 0.7124 450.9000 0.8198 451.0980 0.8198 451.2000 0.9262 451.3980 0.9262 451.5000 0.6409 451.6980 0.6409 451.8000 0.6683 451.9980 0.6683 452.1000 0.6020 452.2980 0.6020 452.4000 0.9248 452.5980 0.9248 452.7000 0.9426 452.8980 0.9426 453.0000 0.5737 453.1980 0.5737 453.3000 0.5754 453.4980 0.5754 453.6000 1.3786 453.7980 1.3786 453.9000 0.5820 454.0980 0.5820 454.2000 1.1272 454.3980 1.1272 454.5000 0.8952 454.6980 0.8952 454.8000 0.7470 454.9980 0.7470 455.1000 0.8368 455.2980 0.8368 455.4000 1.2710 455.5980 1.2710 455.7000 1.4098 455.8980 1.4098 456.0000 1.0574 456.1980 1.0574 456.3000 0.9045 456.4980 0.9045 456.6000 0.5457 456.7980 0.5457 456.9000 1.2497 457.0980 1.2497 457.2000 0.9090 457.3980 0.9090 457.5000 1.2523 457.6980 1.2523 457.8000 0.6574 457.9980 0.6574 458.1000 1.0266 458.2980 1.0266 458.4000 1.5482 458.5980 1.5482 458.7000 0.8369 458.8980 0.8369 459.0000 0.8953 459.1980 0.8953 459.3000 1.1319 459.4980 1.1319 459.6000 1.0691 459.7980 1.0691 459.9000 0.6974 460.0980 0.6974 460.2000 0.8277 460.3980 0.8277 460.5000 0.5462 460.6980 0.5462 460.8000 0.5412 460.9980 0.5412 461.1000 0.5887 461.2980 0.5887 461.4000 0.6782 461.5980 0.6782 461.7000 0.7543 461.8980 0.7543 462.0000 0.5913 462.1980 0.5913 462.3000 0.6190 462.4980 0.6190 462.6000 0.5692 462.7980 0.5692 462.9000 0.5961 463.0980 0.5961 463.2000 0.6150 463.3980 0.6150 463.5000 0.5696 463.6980 0.5696 463.8000 0.6065 463.9980 0.6065 464.1000 0.6194 464.2980 0.6194 464.4000 0.5673 464.5980 0.5673 464.7000 0.6056 464.8980 0.6056 465.0000 0.5477 465.1980 0.5477 465.3000 0.5860 465.4980 0.5860 465.6000 0.5723 465.7980 0.5723 465.9000 0.6247 466.0980 0.6247 466.2000 0.5668 466.3980 0.5668 466.5000 0.6160 466.6980 0.6160 466.8000 0.5790 466.9980 0.5790 467.1000 0.6068 467.2980 0.6068 467.4000 0.5960 467.5980 0.5960 467.7000 0.6236 467.8980 0.6236 468.0000 0.5892 468.1980 0.5892 468.3000 0.6006 468.4980 0.6006 468.6000 0.5466 468.7980 0.5466 468.9000 0.5968 469.0980 0.5968 469.2000 0.5883 469.3980 0.5883 469.5000 0.6004 469.6980 0.6004 469.8000 0.5933 469.9980 0.5933 470.1000 0.8301 470.2980 0.8301 470.4000 0.6131 470.5980 0.6131 470.7000 0.6082 470.8980 0.6082 471.0000 0.5745 471.1980 0.5745 471.3000 0.5786 471.4980 0.5786 471.6000 0.7627 471.7980 0.7627 471.9000 0.6088 472.0980 0.6088 472.2000 0.7124 472.3980 0.7124 472.5000 0.8198 472.6980 0.8198 472.8000 0.9262 472.9980 0.9262 473.1000 0.6409 473.2980 0.6409 473.4000 0.6683 473.5980 0.6683 473.7000 0.6020 473.8980 0.6020 474.0000 0.9248 474.1980 0.9248 474.3000 0.9426 474.4980 0.9426 474.6000 0.5737 474.7980 0.5737 474.9000 0.5754 475.0980 0.5754 475.2000 1.3786 475.3980 1.3786 475.5000 0.5820 475.6980 0.5820 475.8000 1.1272 475.9980 1.1272 476.1000 0.8952 476.2980 0.8952 476.4000 0.7470 476.5980 0.7470 476.7000 0.8368 476.8980 0.8368 477.0000 1.2710 477.1980 1.2710 477.3000 1.4098 477.4980 1.4098 477.6000 1.0574 477.7980 1.0574 477.9000 0.9045 478.0980 0.9045 478.2000 0.5457 478.3980 0.5457 478.5000 1.2497 478.6980 1.2497 478.8000 0.9090 478.9980 0.9090 479.1000 1.2523 479.2980 1.2523 479.4000 0.6574 479.5980 0.6574 479.7000 1.0266 479.8980 1.0266 480.0000 1.5482 480.1980 1.5482 480.3000 0.8369 480.4980 0.8369 480.6000 0.8953 480.7980 0.8953 480.9000 1.1319 481.0980 1.1319 481.2000 1.0691 481.3980 1.0691 481.5000 0.6974 481.6980 0.6974 481.8000 0.8277 481.9980 0.8277 482.1000 0.5462 482.2980 0.5462 482.4000 0.5412 482.5980 0.5412 482.7000 0.5887 482.8980 0.5887 483.0000 0.6782 483.1980 0.6782 483.3000 0.7543 483.4980 0.7543 483.6000 0.5913 483.7980 0.5913 483.9000 0.6190 484.0980 0.6190 484.2000 0.5692 484.3980 0.5692 484.5000 0.5961 484.6980 0.5961 484.8000 0.6150 484.9980 0.6150 485.1000 0.5696 485.2980 0.5696 485.4000 0.6065 485.5980 0.6065 485.7000 0.6194 485.8980 0.6194 486.0000 0.5673 486.1980 0.5673 486.3000 0.6056 486.4980 0.6056 486.6000 0.5477 486.7980 0.5477 486.9000 0.5860 487.0980 0.5860 487.2000 0.5723 487.3980 0.5723 487.5000 0.6247 487.6980 0.6247 487.8000 0.5668 487.9980 0.5668 488.1000 0.6160 488.2980 0.6160 488.4000 0.5790 488.5980 0.5790 488.7000 0.6068 488.8980 0.6068 489.0000 0.5960 489.1980 0.5960 489.3000 0.6236 489.4980 0.6236 489.6000 0.5892 489.7980 0.5892 489.9000 0.6006 490.0980 0.6006 490.2000 0.5466 490.3980 0.5466 490.5000 0.5968 490.6980 0.5968 490.8000 0.5883 490.9980 0.5883 491.1000 0.6004 491.2980 0.6004 491.4000 0.5933 491.5980 0.5933 491.7000 0.8301 491.8980 0.8301 492.0000 0.6131 492.1980 0.6131 492.3000 0.6082 492.4980 0.6082 492.6000 0.5745 492.7980 0.5745 492.9000 0.5786 493.0980 0.5786 493.2000 0.7627 493.3980 0.7627 493.5000 0.6088 493.6980 0.6088 493.8000 0.7124 493.9980 0.7124 494.1000 0.8198 494.2980 0.8198 494.4000 0.9262 494.5980 0.9262 494.7000 0.6409 494.8980 0.6409 495.0000 0.6683 495.1980 0.6683 495.3000 0.6020 495.4980 0.6020 495.6000 0.9248 495.7980 0.9248 495.9000 0.9426 496.0980 0.9426 496.2000 0.5737 496.3980 0.5737 496.5000 0.5754 496.6980 0.5754 496.8000 1.3786 496.9980 1.3786 497.1000 0.5820 497.2980 0.5820 497.4000 1.1272 497.5980 1.1272 497.7000 0.8952 497.8980 0.8952 498.0000 0.7470 498.1980 0.7470 498.3000 0.8368 498.4980 0.8368 498.6000 1.2710 498.7980 1.2710 498.9000 1.4098 499.0980 1.4098 499.2000 1.0574 499.3980 1.0574 499.5000 0.9045 499.6980 0.9045 499.8000 0.5457 499.9980 0.5457 500.1000 1.2497 500.2980 1.2497 500.4000 0.9090 500.5980 0.9090 500.7000 1.2523 500.8980 1.2523 501.0000 0.6574 501.1980 0.6574 501.3000 1.0266 501.4980 1.0266 501.6000 1.5482 501.7980 1.5482 501.9000 0.8369 502.0980 0.8369 502.2000 0.8953 502.3980 0.8953 502.5000 1.1319 502.6980 1.1319 502.8000 1.0691 502.9980 1.0691 503.1000 0.6974 503.2980 0.6974 503.4000 0.8277 503.5980 0.8277 503.7000 0.5462 503.8980 0.5462 504.0000 0.5412 504.1980 0.5412 504.3000 0.5887 504.4980 0.5887 504.6000 0.6782 504.7980 0.6782 504.9000 0.7543 505.0980 0.7543 505.2000 0.5913 505.3980 0.5913 505.5000 0.6190 505.6980 0.6190 505.8000 0.5692 505.9980 0.5692 506.1000 0.5961 506.2980 0.5961 506.4000 0.6150 506.5980 0.6150 506.7000 0.5696 506.8980 0.5696 507.0000 0.6065 507.1980 0.6065 507.3000 0.6194 507.4980 0.6194 507.6000 0.5673 507.7980 0.5673 507.9000 0.6056 508.0980 0.6056 508.2000 0.5477 508.3980 0.5477 508.5000 0.5860 508.6980 0.5860 508.8000 0.5723 508.9980 0.5723 509.1000 0.6247 509.2980 0.6247 509.4000 0.5668 509.5980 0.5668 509.7000 0.6160 509.8980 0.6160 510.0000 0.5790 510.1980 0.5790 510.3000 0.6068 510.4980 0.6068 510.6000 0.5960 510.7980 0.5960 510.9000 0.6236 511.0980 0.6236 511.2000 0.5892 511.3980 0.5892 511.5000 0.6006 511.6980 0.6006 511.8000 0.5466 511.9980 0.5466 512.1000 0.5968 512.2980 0.5968 512.4000 0.5883 512.5980 0.5883 512.7000 0.6004 512.8980 0.6004 513.0000 0.5933 513.1980 0.5933 513.3000 0.8301 513.4980 0.8301 513.6000 0.6131 513.7980 0.6131 513.9000 0.6082 514.0980 0.6082 514.2000 0.5745 514.3980 0.5745 514.5000 0.5786 514.6980 0.5786 514.8000 0.7627 514.9980 0.7627 515.1000 0.6088 515.2980 0.6088 515.4000 0.7124 515.5980 0.7124 515.7000 0.8198 515.8980 0.8198 516.0000 0.9262 516.1980 0.9262 516.3000 0.6409 516.4980 0.6409 516.6000 0.6683 516.7980 0.6683 516.9000 0.6020 517.0980 0.6020 517.2000 0.9248 517.3980 0.9248 517.5000 0.9426 517.6980 0.9426 517.8000 0.5737 517.9980 0.5737 518.1000 0.5754 518.2980 0.5754 518.4000 1.3786 518.5980 1.3786 518.7000 0.5820 518.8980 0.5820 519.0000 1.1272 519.1980 1.1272 519.3000 0.8952 519.4980 0.8952 519.6000 0.7470 519.7980 0.7470 519.9000 0.8368 520.0980 0.8368 520.2000 1.2710 520.3980 1.2710 520.5000 1.4098 520.6980 1.4098 520.8000 1.0574 520.9980 1.0574 521.1000 0.9045 521.2980 0.9045 521.4000 0.5457 521.5980 0.5457 521.7000 1.2497 521.8980 1.2497 522.0000 0.9090 522.1980 0.9090 522.3000 1.2523 522.4980 1.2523 522.6000 0.6574 522.7980 0.6574 522.9000 1.0266 523.0980 1.0266 523.2000 1.5482 523.3980 1.5482 523.5000 0.8369 523.6980 0.8369 523.8000 0.8953 523.9980 0.8953 524.1000 1.1319 524.2980 1.1319 524.4000 1.0691 524.5980 1.0691 524.7000 0.6974 524.8980 0.6974 525.0000 0.8277 525.1980 0.8277 525.3000 0.5462 525.4980 0.5462 525.6000 0.5412 525.7980 0.5412 525.9000 0.5887 526.0980 0.5887 526.2000 0.6782 526.3980 0.6782 526.5000 0.7543 526.6980 0.7543 526.8000 0.5913 526.9980 0.5913 527.1000 0.6190 527.2980 0.6190 527.4000 0.5692 527.5980 0.5692 527.7000 0.5961 527.8980 0.5961 528.0000 0.6150 528.1980 0.6150 528.3000 0.5696 528.4980 0.5696 528.6000 0.6065 528.7980 0.6065 528.9000 0.6194 529.0980 0.6194 529.2000 0.5673 529.3980 0.5673 529.5000 0.6056 529.6980 0.6056 529.8000 0.5477 529.9980 0.5477 530.1000 0.5860 530.2980 0.5860 530.4000 0.5723 530.5980 0.5723 530.7000 0.6247 530.8980 0.6247 531.0000 0.5668 531.1980 0.5668 531.3000 0.6160 531.4980 0.6160 531.6000 0.5790 531.7980 0.5790 531.9000 0.6068 532.0980 0.6068 532.2000 0.5960 532.3980 0.5960 532.5000 0.6236 532.6980 0.6236 532.8000 0.5892 532.9980 0.5892 533.1000 0.6006 533.2980 0.6006 533.4000 0.5466 533.5980 0.5466 533.7000 0.5968 533.8980 0.5968 534.0000 0.5883 534.1980 0.5883 534.3000 0.6004 534.4980 0.6004 534.6000 0.5933 534.7980 0.5933 534.9000 0.8301 535.0980 0.8301 535.2000 0.6131 535.3980 0.6131 535.5000 0.6082 535.6980 0.6082 535.8000 0.5745 535.9980 0.5745 536.1000 0.5786 536.2980 0.5786 536.4000 0.7627 536.5980 0.7627 536.7000 0.6088 536.8980 0.6088 537.0000 0.7124 537.1980 0.7124 537.3000 0.8198 537.4980 0.8198 537.6000 0.9262 537.7980 0.9262 537.9000 0.6409 538.0980 0.6409 538.2000 0.6683 538.3980 0.6683 538.5000 0.6020 538.6980 0.6020 538.8000 0.9248 538.9980 0.9248 539.1000 0.9426 539.2980 0.9426 539.4000 0.5737 539.5980 0.5737 539.7000 0.5754 539.8980 0.5754 540.0000 1.3786 540.1980 1.3786 540.3000 0.5820 540.4980 0.5820 540.6000 1.1272 540.7980 1.1272 540.9000 0.8952 541.0980 0.8952 541.2000 0.7470 541.3980 0.7470 541.5000 0.8368 541.6980 0.8368 541.8000 1.2710 541.9980 1.2710 542.1000 1.4098 542.2980 1.4098 542.4000 1.0574 542.5980 1.0574 542.7000 0.9045 542.8980 0.9045 543.0000 0.5457 543.1980 0.5457 543.3000 1.2497 543.4980 1.2497 543.6000 0.9090 543.7980 0.9090 543.9000 1.2523 544.0980 1.2523 544.2000 0.6574 544.3980 0.6574 544.5000 1.0266 544.6980 1.0266 544.8000 1.5482 544.9980 1.5482 545.1000 0.8369 545.2980 0.8369 545.4000 0.8953 545.5980 0.8953 545.7000 1.1319 545.8980 1.1319 546.0000 1.0691 546.1980 1.0691 546.3000 0.6974 546.4980 0.6974 546.6000 0.8277 546.7980 0.8277 546.9000 0.5462 547.0980 0.5462 547.2000 0.5412 547.3980 0.5412 547.5000 0.5887 547.6980 0.5887 547.8000 0.6782 547.9980 0.6782 548.1000 0.7543 548.2980 0.7543 548.4000 0.5913 548.5980 0.5913 548.7000 0.6190 548.8980 0.6190 549.0000 0.5692 549.1980 0.5692 549.3000 0.5961 549.4980 0.5961 549.6000 0.6150 549.7980 0.6150 549.9000 0.5696 550.0980 0.5696 550.2000 0.6065 550.3980 0.6065 550.5000 0.6194 550.6980 0.6194 550.8000 0.5673 550.9980 0.5673 551.1000 0.6056 551.2980 0.6056 551.4000 0.5477 551.5980 0.5477 551.7000 0.5860 551.8980 0.5860 552.0000 0.5723 552.1980 0.5723 552.3000 0.6247 552.4980 0.6247 552.6000 0.5668 552.7980 0.5668 552.9000 0.6160 553.0980 0.6160 553.2000 0.5790 553.3980 0.5790 553.5000 0.6068 553.6980 0.6068 553.8000 0.5960 553.9980 0.5960 554.1000 0.6236 554.2980 0.6236 554.4000 0.5892 554.5980 0.5892 554.7000 0.6006 554.8980 0.6006 555.0000 0.5466 555.1980 0.5466 555.3000 0.5968 555.4980 0.5968 555.6000 0.5883 555.7980 0.5883 555.9000 0.6004 556.0980 0.6004 556.2000 0.5933 556.3980 0.5933 556.5000 0.8301 556.6980 0.8301 556.8000 0.6131 556.9980 0.6131 557.1000 0.6082 557.2980 0.6082 557.4000 0.5745 557.5980 0.5745 557.7000 0.5786 557.8980 0.5786 558.0000 0.7627 558.1980 0.7627 558.3000 0.6088 558.4980 0.6088 558.6000 0.7124 558.7980 0.7124 558.9000 0.8198 559.0980 0.8198 559.2000 0.9262 559.3980 0.9262 559.5000 0.6409 559.6980 0.6409 559.8000 0.6683 559.9980 0.6683 560.1000 0.6020 560.2980 0.6020 560.4000 0.9248 560.5980 0.9248 560.7000 0.9426 560.8980 0.9426 561.0000 0.5737 561.1980 0.5737 561.3000 0.5754 561.4980 0.5754 561.6000 1.3786 561.7980 1.3786 561.9000 0.5820 562.0980 0.5820 562.2000 1.1272 562.3980 1.1272 562.5000 0.8952 562.6980 0.8952 562.8000 0.7470 562.9980 0.7470 563.1000 0.8368 563.2980 0.8368 563.4000 1.2710 563.5980 1.2710 563.7000 1.4098 563.8980 1.4098 564.0000 1.0574 564.1980 1.0574 564.3000 0.9045 564.4980 0.9045 564.6000 0.5457 564.7980 0.5457 564.9000 1.2497 565.0980 1.2497 565.2000 0.9090 565.3980 0.9090 565.5000 1.2523 565.6980 1.2523 565.8000 0.6574 565.9980 0.6574 566.1000 1.0266 566.2980 1.0266 566.4000 1.5482 566.5980 1.5482 566.7000 0.8369 566.8980 0.8369 567.0000 0.8953 567.1980 0.8953 567.3000 1.1319 567.4980 1.1319 567.6000 1.0691 567.7980 1.0691 567.9000 0.6974 568.0980 0.6974 568.2000 0.8277 568.3980 0.8277 568.5000 0.5462 568.6980 0.5462 568.8000 0.5412 568.9980 0.5412 569.1000 0.5887 569.2980 0.5887 569.4000 0.6782 569.5980 0.6782 569.7000 0.7543 569.8980 0.7543 570.0000 0.5913 570.1980 0.5913 570.3000 0.6190 570.4980 0.6190 570.6000 0.5692 570.7980 0.5692 570.9000 0.5961 571.0980 0.5961 571.2000 0.6150 571.3980 0.6150 571.5000 0.5696 571.6980 0.5696 571.8000 0.6065 571.9980 0.6065 572.1000 0.6194 572.2980 0.6194 572.4000 0.5673 572.5980 0.5673 572.7000 0.6056 572.8980 0.6056 573.0000 0.5477 573.1980 0.5477 573.3000 0.5860 573.4980 0.5860 573.6000 0.5723 573.7980 0.5723 573.9000 0.6247 574.0980 0.6247 574.2000 0.5668 574.3980 0.5668 574.5000 0.6160 574.6980 0.6160 574.8000 0.5790 574.9980 0.5790 575.1000 0.6068 575.2980 0.6068 575.4000 0.5960 575.5980 0.5960 575.7000 0.6236 575.8980 0.6236 576.0000 0.5892 576.1980 0.5892 576.3000 0.6006 576.4980 0.6006 576.6000 0.5466 576.7980 0.5466 576.9000 0.5968 577.0980 0.5968 577.2000 0.5883 577.3980 0.5883 577.5000 0.6004 577.6980 0.6004 577.8000 0.5933 577.9980 0.5933 578.1000 0.8301 578.2980 0.8301 578.4000 0.6131 578.5980 0.6131 578.7000 0.6082 578.8980 0.6082 579.0000 0.5745 579.1980 0.5745 579.3000 0.5786 579.4980 0.5786 579.6000 0.7627 579.7980 0.7627 579.9000 0.6088 580.0980 0.6088 580.2000 0.7124 580.3980 0.7124 580.5000 0.8198 580.6980 0.8198 580.8000 0.9262 580.9980 0.9262 581.1000 0.6409 581.2980 0.6409 581.4000 0.6683 581.5980 0.6683 581.7000 0.6020 581.8980 0.6020 582.0000 0.9248 582.1980 0.9248 582.3000 0.9426 582.4980 0.9426 582.6000 0.5737 582.7980 0.5737 582.9000 0.5754 583.0980 0.5754 583.2000 1.3786 583.3980 1.3786 583.5000 0.5820 583.6980 0.5820 583.8000 1.1272 583.9980 1.1272 584.1000 0.8952 584.2980 0.8952 584.4000 0.7470 584.5980 0.7470 584.7000 0.8368 584.8980 0.8368 585.0000 1.2710 585.1980 1.2710 585.3000 1.4098 585.4980 1.4098 585.6000 1.0574 585.7980 1.0574 585.9000 0.9045 586.0980 0.9045 586.2000 0.5457 586.3980 0.5457 586.5000 1.2497 586.6980 1.2497 586.8000 0.9090 586.9980 0.9090 587.1000 1.2523 587.2980 1.2523 587.4000 0.6574 587.5980 0.6574 587.7000 1.0266 587.8980 1.0266 588.0000 1.5482 588.1980 1.5482 588.3000 0.8369 588.4980 0.8369 588.6000 0.8953 588.7980 0.8953 588.9000 1.1319 589.0980 1.1319 589.2000 1.0691 589.3980 1.0691 589.5000 0.6974 589.6980 0.6974 589.8000 0.8277 589.9980 0.8277 590.1000 0.5462 590.2980 0.5462 590.4000 0.5412 590.5980 0.5412 590.7000 0.5887 590.8980 0.5887 591.0000 0.6782 591.1980 0.6782 591.3000 0.7543 591.4980 0.7543 591.6000 0.5913 591.7980 0.5913 591.9000 0.6190 592.0980 0.6190 592.2000 0.5692 592.3980 0.5692 592.5000 0.5961 592.6980 0.5961 592.8000 0.6150 592.9980 0.6150 593.1000 0.5696 593.2980 0.5696 593.4000 0.6065 593.5980 0.6065 593.7000 0.6194 593.8980 0.6194 594.0000 0.5673 594.1980 0.5673 594.3000 0.6056 594.4980 0.6056 594.6000 0.5477 594.7980 0.5477 594.9000 0.5860 595.0980 0.5860 595.2000 0.5723 595.3980 0.5723 595.5000 0.6247 595.6980 0.6247 595.8000 0.5668 595.9980 0.5668 596.1000 0.6160 596.2980 0.6160 596.4000 0.5790 596.5980 0.5790 596.7000 0.6068 596.8980 0.6068 597.0000 0.5960 597.1980 0.5960 597.3000 0.6236 597.4980 0.6236 597.6000 0.5892 597.7980 0.5892 597.9000 0.6006 598.0980 0.6006 598.2000 0.5466 598.3980 0.5466 598.5000 0.5968 598.6980 0.5968 598.8000 0.5883 598.9980 0.5883 599.1000 0.6004 599.2980 0.6004 599.4000 0.5933 599.5980 0.5933 599.7000 0.8301 599.8980 0.8301 600.0000 0.8301)
Va8 a8 0 PWL(0.0000 0.9970 0.1980 0.9970 0.3000 0.4885 0.4980 0.4885 0.6000 0.8208 0.7980 0.8208 0.9000 0.7362 1.0980 0.7362 1.2000 1.0977 1.3980 1.0977 1.5000 0.6793 1.6980 0.6793 1.8000 1.1737 1.9980 1.1737 2.1000 0.8423 2.2980 0.8423 2.4000 0.4920 2.5980 0.4920 2.7000 1.0349 2.8980 1.0349 3.0000 0.5457 3.1980 0.5457 3.3000 0.7455 3.4980 0.7455 3.6000 0.9785 3.7980 0.9785 3.9000 0.4733 4.0980 0.4733 4.2000 0.4588 4.3980 0.4588 4.5000 0.9206 4.6980 0.9206 4.8000 0.9834 4.9980 0.9834 5.1000 0.5037 5.2980 0.5037 5.4000 0.9488 5.5980 0.9488 5.7000 0.4983 5.8980 0.4983 6.0000 0.6641 6.1980 0.6641 6.3000 0.5256 6.4980 0.5256 6.6000 0.9476 6.7980 0.9476 6.9000 0.4637 7.0980 0.4637 7.2000 0.5412 7.3980 0.5412 7.5000 0.5887 7.6980 0.5887 7.8000 0.5985 7.9980 0.5985 8.1000 0.5033 8.2980 0.5033 8.4000 0.5913 8.5980 0.5913 8.7000 0.6190 8.8980 0.6190 9.0000 0.5692 9.1980 0.5692 9.3000 0.5961 9.4980 0.5961 9.6000 0.6150 9.7980 0.6150 9.9000 0.5696 10.0980 0.5696 10.2000 0.6065 10.3980 0.6065 10.5000 0.6194 10.6980 0.6194 10.8000 0.5673 10.9980 0.5673 11.1000 0.6056 11.2980 0.6056 11.4000 0.5477 11.5980 0.5477 11.7000 0.5860 11.8980 0.5860 12.0000 0.5723 12.1980 0.5723 12.3000 0.6247 12.4980 0.6247 12.6000 0.5668 12.7980 0.5668 12.9000 0.5998 13.0980 0.5998 13.2000 0.5790 13.3980 0.5790 13.5000 0.6068 13.6980 0.6068 13.8000 0.5960 13.9980 0.5960 14.1000 0.6236 14.2980 0.6236 14.4000 0.5892 14.5980 0.5892 14.7000 0.6006 14.8980 0.6006 15.0000 0.5466 15.1980 0.5466 15.3000 0.5968 15.4980 0.5968 15.6000 0.5883 15.7980 0.5883 15.9000 0.6004 16.0980 0.6004 16.2000 0.5933 16.3980 0.5933 16.5000 0.5990 16.6980 0.5990 16.8000 0.6007 16.9980 0.6007 17.1000 0.6082 17.2980 0.6082 17.4000 0.5745 17.5980 0.5745 17.7000 0.5786 17.8980 0.5786 18.0000 0.5559 18.1980 0.5559 18.3000 0.6088 18.4980 0.6088 18.6000 0.5452 18.7980 0.5452 18.9000 0.5821 19.0980 0.5821 19.2000 0.5732 19.3980 0.5732 19.5000 0.6057 19.6980 0.6057 19.8000 0.8662 19.9980 0.8662 20.1000 0.6020 20.2980 0.6020 20.4000 0.5708 20.5980 0.5708 20.7000 0.5164 20.8980 0.5164 21.0000 0.5733 21.1980 0.5733 21.3000 0.5971 21.4980 0.5971 21.6000 0.9970 21.7980 0.9970 21.9000 0.4885 22.0980 0.4885 22.2000 0.8208 22.3980 0.8208 22.5000 0.7362 22.6980 0.7362 22.8000 1.0977 22.9980 1.0977 23.1000 0.6793 23.2980 0.6793 23.4000 1.1737 23.5980 1.1737 23.7000 0.8423 23.8980 0.8423 24.0000 0.4920 24.1980 0.4920 24.3000 1.0349 24.4980 1.0349 24.6000 0.5457 24.7980 0.5457 24.9000 0.7455 25.0980 0.7455 25.2000 0.9785 25.3980 0.9785 25.5000 0.4733 25.6980 0.4733 25.8000 0.4588 25.9980 0.4588 26.1000 0.9206 26.2980 0.9206 26.4000 0.9834 26.5980 0.9834 26.7000 0.5037 26.8980 0.5037 27.0000 0.9488 27.1980 0.9488 27.3000 0.4983 27.4980 0.4983 27.6000 0.6641 27.7980 0.6641 27.9000 0.5256 28.0980 0.5256 28.2000 0.9476 28.3980 0.9476 28.5000 0.4637 28.6980 0.4637 28.8000 0.5412 28.9980 0.5412 29.1000 0.5887 29.2980 0.5887 29.4000 0.5985 29.5980 0.5985 29.7000 0.5033 29.8980 0.5033 30.0000 0.5913 30.1980 0.5913 30.3000 0.6190 30.4980 0.6190 30.6000 0.5692 30.7980 0.5692 30.9000 0.5961 31.0980 0.5961 31.2000 0.6150 31.3980 0.6150 31.5000 0.5696 31.6980 0.5696 31.8000 0.6065 31.9980 0.6065 32.1000 0.6194 32.2980 0.6194 32.4000 0.5673 32.5980 0.5673 32.7000 0.6056 32.8980 0.6056 33.0000 0.5477 33.1980 0.5477 33.3000 0.5860 33.4980 0.5860 33.6000 0.5723 33.7980 0.5723 33.9000 0.6247 34.0980 0.6247 34.2000 0.5668 34.3980 0.5668 34.5000 0.5998 34.6980 0.5998 34.8000 0.5790 34.9980 0.5790 35.1000 0.6068 35.2980 0.6068 35.4000 0.5960 35.5980 0.5960 35.7000 0.6236 35.8980 0.6236 36.0000 0.5892 36.1980 0.5892 36.3000 0.6006 36.4980 0.6006 36.6000 0.5466 36.7980 0.5466 36.9000 0.5968 37.0980 0.5968 37.2000 0.5883 37.3980 0.5883 37.5000 0.6004 37.6980 0.6004 37.8000 0.5933 37.9980 0.5933 38.1000 0.5990 38.2980 0.5990 38.4000 0.6007 38.5980 0.6007 38.7000 0.6082 38.8980 0.6082 39.0000 0.5745 39.1980 0.5745 39.3000 0.5786 39.4980 0.5786 39.6000 0.5559 39.7980 0.5559 39.9000 0.6088 40.0980 0.6088 40.2000 0.5452 40.3980 0.5452 40.5000 0.5821 40.6980 0.5821 40.8000 0.5732 40.9980 0.5732 41.1000 0.6057 41.2980 0.6057 41.4000 0.8662 41.5980 0.8662 41.7000 0.6020 41.8980 0.6020 42.0000 0.5708 42.1980 0.5708 42.3000 0.5164 42.4980 0.5164 42.6000 0.5733 42.7980 0.5733 42.9000 0.5971 43.0980 0.5971 43.2000 0.9970 43.3980 0.9970 43.5000 0.4885 43.6980 0.4885 43.8000 0.8208 43.9980 0.8208 44.1000 0.7362 44.2980 0.7362 44.4000 1.0977 44.5980 1.0977 44.7000 0.6793 44.8980 0.6793 45.0000 1.1737 45.1980 1.1737 45.3000 0.8423 45.4980 0.8423 45.6000 0.4920 45.7980 0.4920 45.9000 1.0349 46.0980 1.0349 46.2000 0.5457 46.3980 0.5457 46.5000 0.7455 46.6980 0.7455 46.8000 0.9785 46.9980 0.9785 47.1000 0.4733 47.2980 0.4733 47.4000 0.4588 47.5980 0.4588 47.7000 0.9206 47.8980 0.9206 48.0000 0.9834 48.1980 0.9834 48.3000 0.5037 48.4980 0.5037 48.6000 0.9488 48.7980 0.9488 48.9000 0.4983 49.0980 0.4983 49.2000 0.6641 49.3980 0.6641 49.5000 0.5256 49.6980 0.5256 49.8000 0.9476 49.9980 0.9476 50.1000 0.4637 50.2980 0.4637 50.4000 0.5412 50.5980 0.5412 50.7000 0.5887 50.8980 0.5887 51.0000 0.5985 51.1980 0.5985 51.3000 0.5033 51.4980 0.5033 51.6000 0.5913 51.7980 0.5913 51.9000 0.6190 52.0980 0.6190 52.2000 0.5692 52.3980 0.5692 52.5000 0.5961 52.6980 0.5961 52.8000 0.6150 52.9980 0.6150 53.1000 0.5696 53.2980 0.5696 53.4000 0.6065 53.5980 0.6065 53.7000 0.6194 53.8980 0.6194 54.0000 0.5673 54.1980 0.5673 54.3000 0.6056 54.4980 0.6056 54.6000 0.5477 54.7980 0.5477 54.9000 0.5860 55.0980 0.5860 55.2000 0.5723 55.3980 0.5723 55.5000 0.6247 55.6980 0.6247 55.8000 0.5668 55.9980 0.5668 56.1000 0.5998 56.2980 0.5998 56.4000 0.5790 56.5980 0.5790 56.7000 0.6068 56.8980 0.6068 57.0000 0.5960 57.1980 0.5960 57.3000 0.6236 57.4980 0.6236 57.6000 0.5892 57.7980 0.5892 57.9000 0.6006 58.0980 0.6006 58.2000 0.5466 58.3980 0.5466 58.5000 0.5968 58.6980 0.5968 58.8000 0.5883 58.9980 0.5883 59.1000 0.6004 59.2980 0.6004 59.4000 0.5933 59.5980 0.5933 59.7000 0.5990 59.8980 0.5990 60.0000 0.6007 60.1980 0.6007 60.3000 0.6082 60.4980 0.6082 60.6000 0.5745 60.7980 0.5745 60.9000 0.5786 61.0980 0.5786 61.2000 0.5559 61.3980 0.5559 61.5000 0.6088 61.6980 0.6088 61.8000 0.5452 61.9980 0.5452 62.1000 0.5821 62.2980 0.5821 62.4000 0.5732 62.5980 0.5732 62.7000 0.6057 62.8980 0.6057 63.0000 0.8662 63.1980 0.8662 63.3000 0.6020 63.4980 0.6020 63.6000 0.5708 63.7980 0.5708 63.9000 0.5164 64.0980 0.5164 64.2000 0.5733 64.3980 0.5733 64.5000 0.5971 64.6980 0.5971 64.8000 0.9970 64.9980 0.9970 65.1000 0.4885 65.2980 0.4885 65.4000 0.8208 65.5980 0.8208 65.7000 0.7362 65.8980 0.7362 66.0000 1.0977 66.1980 1.0977 66.3000 0.6793 66.4980 0.6793 66.6000 1.1737 66.7980 1.1737 66.9000 0.8423 67.0980 0.8423 67.2000 0.4920 67.3980 0.4920 67.5000 1.0349 67.6980 1.0349 67.8000 0.5457 67.9980 0.5457 68.1000 0.7455 68.2980 0.7455 68.4000 0.9785 68.5980 0.9785 68.7000 0.4733 68.8980 0.4733 69.0000 0.4588 69.1980 0.4588 69.3000 0.9206 69.4980 0.9206 69.6000 0.9834 69.7980 0.9834 69.9000 0.5037 70.0980 0.5037 70.2000 0.9488 70.3980 0.9488 70.5000 0.4983 70.6980 0.4983 70.8000 0.6641 70.9980 0.6641 71.1000 0.5256 71.2980 0.5256 71.4000 0.9476 71.5980 0.9476 71.7000 0.4637 71.8980 0.4637 72.0000 0.5412 72.1980 0.5412 72.3000 0.5887 72.4980 0.5887 72.6000 0.5985 72.7980 0.5985 72.9000 0.5033 73.0980 0.5033 73.2000 0.5913 73.3980 0.5913 73.5000 0.6190 73.6980 0.6190 73.8000 0.5692 73.9980 0.5692 74.1000 0.5961 74.2980 0.5961 74.4000 0.6150 74.5980 0.6150 74.7000 0.5696 74.8980 0.5696 75.0000 0.6065 75.1980 0.6065 75.3000 0.6194 75.4980 0.6194 75.6000 0.5673 75.7980 0.5673 75.9000 0.6056 76.0980 0.6056 76.2000 0.5477 76.3980 0.5477 76.5000 0.5860 76.6980 0.5860 76.8000 0.5723 76.9980 0.5723 77.1000 0.6247 77.2980 0.6247 77.4000 0.5668 77.5980 0.5668 77.7000 0.5998 77.8980 0.5998 78.0000 0.5790 78.1980 0.5790 78.3000 0.6068 78.4980 0.6068 78.6000 0.5960 78.7980 0.5960 78.9000 0.6236 79.0980 0.6236 79.2000 0.5892 79.3980 0.5892 79.5000 0.6006 79.6980 0.6006 79.8000 0.5466 79.9980 0.5466 80.1000 0.5968 80.2980 0.5968 80.4000 0.5883 80.5980 0.5883 80.7000 0.6004 80.8980 0.6004 81.0000 0.5933 81.1980 0.5933 81.3000 0.5990 81.4980 0.5990 81.6000 0.6007 81.7980 0.6007 81.9000 0.6082 82.0980 0.6082 82.2000 0.5745 82.3980 0.5745 82.5000 0.5786 82.6980 0.5786 82.8000 0.5559 82.9980 0.5559 83.1000 0.6088 83.2980 0.6088 83.4000 0.5452 83.5980 0.5452 83.7000 0.5821 83.8980 0.5821 84.0000 0.5732 84.1980 0.5732 84.3000 0.6057 84.4980 0.6057 84.6000 0.8662 84.7980 0.8662 84.9000 0.6020 85.0980 0.6020 85.2000 0.5708 85.3980 0.5708 85.5000 0.5164 85.6980 0.5164 85.8000 0.5733 85.9980 0.5733 86.1000 0.5971 86.2980 0.5971 86.4000 0.9970 86.5980 0.9970 86.7000 0.4885 86.8980 0.4885 87.0000 0.8208 87.1980 0.8208 87.3000 0.7362 87.4980 0.7362 87.6000 1.0977 87.7980 1.0977 87.9000 0.6793 88.0980 0.6793 88.2000 1.1737 88.3980 1.1737 88.5000 0.8423 88.6980 0.8423 88.8000 0.4920 88.9980 0.4920 89.1000 1.0349 89.2980 1.0349 89.4000 0.5457 89.5980 0.5457 89.7000 0.7455 89.8980 0.7455 90.0000 0.9785 90.1980 0.9785 90.3000 0.4733 90.4980 0.4733 90.6000 0.4588 90.7980 0.4588 90.9000 0.9206 91.0980 0.9206 91.2000 0.9834 91.3980 0.9834 91.5000 0.5037 91.6980 0.5037 91.8000 0.9488 91.9980 0.9488 92.1000 0.4983 92.2980 0.4983 92.4000 0.6641 92.5980 0.6641 92.7000 0.5256 92.8980 0.5256 93.0000 0.9476 93.1980 0.9476 93.3000 0.4637 93.4980 0.4637 93.6000 0.5412 93.7980 0.5412 93.9000 0.5887 94.0980 0.5887 94.2000 0.5985 94.3980 0.5985 94.5000 0.5033 94.6980 0.5033 94.8000 0.5913 94.9980 0.5913 95.1000 0.6190 95.2980 0.6190 95.4000 0.5692 95.5980 0.5692 95.7000 0.5961 95.8980 0.5961 96.0000 0.6150 96.1980 0.6150 96.3000 0.5696 96.4980 0.5696 96.6000 0.6065 96.7980 0.6065 96.9000 0.6194 97.0980 0.6194 97.2000 0.5673 97.3980 0.5673 97.5000 0.6056 97.6980 0.6056 97.8000 0.5477 97.9980 0.5477 98.1000 0.5860 98.2980 0.5860 98.4000 0.5723 98.5980 0.5723 98.7000 0.6247 98.8980 0.6247 99.0000 0.5668 99.1980 0.5668 99.3000 0.5998 99.4980 0.5998 99.6000 0.5790 99.7980 0.5790 99.9000 0.6068 100.0980 0.6068 100.2000 0.5960 100.3980 0.5960 100.5000 0.6236 100.6980 0.6236 100.8000 0.5892 100.9980 0.5892 101.1000 0.6006 101.2980 0.6006 101.4000 0.5466 101.5980 0.5466 101.7000 0.5968 101.8980 0.5968 102.0000 0.5883 102.1980 0.5883 102.3000 0.6004 102.4980 0.6004 102.6000 0.5933 102.7980 0.5933 102.9000 0.5990 103.0980 0.5990 103.2000 0.6007 103.3980 0.6007 103.5000 0.6082 103.6980 0.6082 103.8000 0.5745 103.9980 0.5745 104.1000 0.5786 104.2980 0.5786 104.4000 0.5559 104.5980 0.5559 104.7000 0.6088 104.8980 0.6088 105.0000 0.5452 105.1980 0.5452 105.3000 0.5821 105.4980 0.5821 105.6000 0.5732 105.7980 0.5732 105.9000 0.6057 106.0980 0.6057 106.2000 0.8662 106.3980 0.8662 106.5000 0.6020 106.6980 0.6020 106.8000 0.5708 106.9980 0.5708 107.1000 0.5164 107.2980 0.5164 107.4000 0.5733 107.5980 0.5733 107.7000 0.5971 107.8980 0.5971 108.0000 0.9970 108.1980 0.9970 108.3000 0.4885 108.4980 0.4885 108.6000 0.8208 108.7980 0.8208 108.9000 0.7362 109.0980 0.7362 109.2000 1.0977 109.3980 1.0977 109.5000 0.6793 109.6980 0.6793 109.8000 1.1737 109.9980 1.1737 110.1000 0.8423 110.2980 0.8423 110.4000 0.4920 110.5980 0.4920 110.7000 1.0349 110.8980 1.0349 111.0000 0.5457 111.1980 0.5457 111.3000 0.7455 111.4980 0.7455 111.6000 0.9785 111.7980 0.9785 111.9000 0.4733 112.0980 0.4733 112.2000 0.4588 112.3980 0.4588 112.5000 0.9206 112.6980 0.9206 112.8000 0.9834 112.9980 0.9834 113.1000 0.5037 113.2980 0.5037 113.4000 0.9488 113.5980 0.9488 113.7000 0.4983 113.8980 0.4983 114.0000 0.6641 114.1980 0.6641 114.3000 0.5256 114.4980 0.5256 114.6000 0.9476 114.7980 0.9476 114.9000 0.4637 115.0980 0.4637 115.2000 0.5412 115.3980 0.5412 115.5000 0.5887 115.6980 0.5887 115.8000 0.5985 115.9980 0.5985 116.1000 0.5033 116.2980 0.5033 116.4000 0.5913 116.5980 0.5913 116.7000 0.6190 116.8980 0.6190 117.0000 0.5692 117.1980 0.5692 117.3000 0.5961 117.4980 0.5961 117.6000 0.6150 117.7980 0.6150 117.9000 0.5696 118.0980 0.5696 118.2000 0.6065 118.3980 0.6065 118.5000 0.6194 118.6980 0.6194 118.8000 0.5673 118.9980 0.5673 119.1000 0.6056 119.2980 0.6056 119.4000 0.5477 119.5980 0.5477 119.7000 0.5860 119.8980 0.5860 120.0000 0.5723 120.1980 0.5723 120.3000 0.6247 120.4980 0.6247 120.6000 0.5668 120.7980 0.5668 120.9000 0.5998 121.0980 0.5998 121.2000 0.5790 121.3980 0.5790 121.5000 0.6068 121.6980 0.6068 121.8000 0.5960 121.9980 0.5960 122.1000 0.6236 122.2980 0.6236 122.4000 0.5892 122.5980 0.5892 122.7000 0.6006 122.8980 0.6006 123.0000 0.5466 123.1980 0.5466 123.3000 0.5968 123.4980 0.5968 123.6000 0.5883 123.7980 0.5883 123.9000 0.6004 124.0980 0.6004 124.2000 0.5933 124.3980 0.5933 124.5000 0.5990 124.6980 0.5990 124.8000 0.6007 124.9980 0.6007 125.1000 0.6082 125.2980 0.6082 125.4000 0.5745 125.5980 0.5745 125.7000 0.5786 125.8980 0.5786 126.0000 0.5559 126.1980 0.5559 126.3000 0.6088 126.4980 0.6088 126.6000 0.5452 126.7980 0.5452 126.9000 0.5821 127.0980 0.5821 127.2000 0.5732 127.3980 0.5732 127.5000 0.6057 127.6980 0.6057 127.8000 0.8662 127.9980 0.8662 128.1000 0.6020 128.2980 0.6020 128.4000 0.5708 128.5980 0.5708 128.7000 0.5164 128.8980 0.5164 129.0000 0.5733 129.1980 0.5733 129.3000 0.5971 129.4980 0.5971 129.6000 0.9970 129.7980 0.9970 129.9000 0.4885 130.0980 0.4885 130.2000 0.8208 130.3980 0.8208 130.5000 0.7362 130.6980 0.7362 130.8000 1.0977 130.9980 1.0977 131.1000 0.6793 131.2980 0.6793 131.4000 1.1737 131.5980 1.1737 131.7000 0.8423 131.8980 0.8423 132.0000 0.4920 132.1980 0.4920 132.3000 1.0349 132.4980 1.0349 132.6000 0.5457 132.7980 0.5457 132.9000 0.7455 133.0980 0.7455 133.2000 0.9785 133.3980 0.9785 133.5000 0.4733 133.6980 0.4733 133.8000 0.4588 133.9980 0.4588 134.1000 0.9206 134.2980 0.9206 134.4000 0.9834 134.5980 0.9834 134.7000 0.5037 134.8980 0.5037 135.0000 0.9488 135.1980 0.9488 135.3000 0.4983 135.4980 0.4983 135.6000 0.6641 135.7980 0.6641 135.9000 0.5256 136.0980 0.5256 136.2000 0.9476 136.3980 0.9476 136.5000 0.4637 136.6980 0.4637 136.8000 0.5412 136.9980 0.5412 137.1000 0.5887 137.2980 0.5887 137.4000 0.5985 137.5980 0.5985 137.7000 0.5033 137.8980 0.5033 138.0000 0.5913 138.1980 0.5913 138.3000 0.6190 138.4980 0.6190 138.6000 0.5692 138.7980 0.5692 138.9000 0.5961 139.0980 0.5961 139.2000 0.6150 139.3980 0.6150 139.5000 0.5696 139.6980 0.5696 139.8000 0.6065 139.9980 0.6065 140.1000 0.6194 140.2980 0.6194 140.4000 0.5673 140.5980 0.5673 140.7000 0.6056 140.8980 0.6056 141.0000 0.5477 141.1980 0.5477 141.3000 0.5860 141.4980 0.5860 141.6000 0.5723 141.7980 0.5723 141.9000 0.6247 142.0980 0.6247 142.2000 0.5668 142.3980 0.5668 142.5000 0.5998 142.6980 0.5998 142.8000 0.5790 142.9980 0.5790 143.1000 0.6068 143.2980 0.6068 143.4000 0.5960 143.5980 0.5960 143.7000 0.6236 143.8980 0.6236 144.0000 0.5892 144.1980 0.5892 144.3000 0.6006 144.4980 0.6006 144.6000 0.5466 144.7980 0.5466 144.9000 0.5968 145.0980 0.5968 145.2000 0.5883 145.3980 0.5883 145.5000 0.6004 145.6980 0.6004 145.8000 0.5933 145.9980 0.5933 146.1000 0.5990 146.2980 0.5990 146.4000 0.6007 146.5980 0.6007 146.7000 0.6082 146.8980 0.6082 147.0000 0.5745 147.1980 0.5745 147.3000 0.5786 147.4980 0.5786 147.6000 0.5559 147.7980 0.5559 147.9000 0.6088 148.0980 0.6088 148.2000 0.5452 148.3980 0.5452 148.5000 0.5821 148.6980 0.5821 148.8000 0.5732 148.9980 0.5732 149.1000 0.6057 149.2980 0.6057 149.4000 0.8662 149.5980 0.8662 149.7000 0.6020 149.8980 0.6020 150.0000 0.5708 150.1980 0.5708 150.3000 0.5164 150.4980 0.5164 150.6000 0.5733 150.7980 0.5733 150.9000 0.5971 151.0980 0.5971 151.2000 0.9970 151.3980 0.9970 151.5000 0.4885 151.6980 0.4885 151.8000 0.8208 151.9980 0.8208 152.1000 0.7362 152.2980 0.7362 152.4000 1.0977 152.5980 1.0977 152.7000 0.6793 152.8980 0.6793 153.0000 1.1737 153.1980 1.1737 153.3000 0.8423 153.4980 0.8423 153.6000 0.4920 153.7980 0.4920 153.9000 1.0349 154.0980 1.0349 154.2000 0.5457 154.3980 0.5457 154.5000 0.7455 154.6980 0.7455 154.8000 0.9785 154.9980 0.9785 155.1000 0.4733 155.2980 0.4733 155.4000 0.4588 155.5980 0.4588 155.7000 0.9206 155.8980 0.9206 156.0000 0.9834 156.1980 0.9834 156.3000 0.5037 156.4980 0.5037 156.6000 0.9488 156.7980 0.9488 156.9000 0.4983 157.0980 0.4983 157.2000 0.6641 157.3980 0.6641 157.5000 0.5256 157.6980 0.5256 157.8000 0.9476 157.9980 0.9476 158.1000 0.4637 158.2980 0.4637 158.4000 0.5412 158.5980 0.5412 158.7000 0.5887 158.8980 0.5887 159.0000 0.5985 159.1980 0.5985 159.3000 0.5033 159.4980 0.5033 159.6000 0.5913 159.7980 0.5913 159.9000 0.6190 160.0980 0.6190 160.2000 0.5692 160.3980 0.5692 160.5000 0.5961 160.6980 0.5961 160.8000 0.6150 160.9980 0.6150 161.1000 0.5696 161.2980 0.5696 161.4000 0.6065 161.5980 0.6065 161.7000 0.6194 161.8980 0.6194 162.0000 0.5673 162.1980 0.5673 162.3000 0.6056 162.4980 0.6056 162.6000 0.5477 162.7980 0.5477 162.9000 0.5860 163.0980 0.5860 163.2000 0.5723 163.3980 0.5723 163.5000 0.6247 163.6980 0.6247 163.8000 0.5668 163.9980 0.5668 164.1000 0.5998 164.2980 0.5998 164.4000 0.5790 164.5980 0.5790 164.7000 0.6068 164.8980 0.6068 165.0000 0.5960 165.1980 0.5960 165.3000 0.6236 165.4980 0.6236 165.6000 0.5892 165.7980 0.5892 165.9000 0.6006 166.0980 0.6006 166.2000 0.5466 166.3980 0.5466 166.5000 0.5968 166.6980 0.5968 166.8000 0.5883 166.9980 0.5883 167.1000 0.6004 167.2980 0.6004 167.4000 0.5933 167.5980 0.5933 167.7000 0.5990 167.8980 0.5990 168.0000 0.6007 168.1980 0.6007 168.3000 0.6082 168.4980 0.6082 168.6000 0.5745 168.7980 0.5745 168.9000 0.5786 169.0980 0.5786 169.2000 0.5559 169.3980 0.5559 169.5000 0.6088 169.6980 0.6088 169.8000 0.5452 169.9980 0.5452 170.1000 0.5821 170.2980 0.5821 170.4000 0.5732 170.5980 0.5732 170.7000 0.6057 170.8980 0.6057 171.0000 0.8662 171.1980 0.8662 171.3000 0.6020 171.4980 0.6020 171.6000 0.5708 171.7980 0.5708 171.9000 0.5164 172.0980 0.5164 172.2000 0.5733 172.3980 0.5733 172.5000 0.5971 172.6980 0.5971 172.8000 0.9970 172.9980 0.9970 173.1000 0.4885 173.2980 0.4885 173.4000 0.8208 173.5980 0.8208 173.7000 0.7362 173.8980 0.7362 174.0000 1.0977 174.1980 1.0977 174.3000 0.6793 174.4980 0.6793 174.6000 1.1737 174.7980 1.1737 174.9000 0.8423 175.0980 0.8423 175.2000 0.4920 175.3980 0.4920 175.5000 1.0349 175.6980 1.0349 175.8000 0.5457 175.9980 0.5457 176.1000 0.7455 176.2980 0.7455 176.4000 0.9785 176.5980 0.9785 176.7000 0.4733 176.8980 0.4733 177.0000 0.4588 177.1980 0.4588 177.3000 0.9206 177.4980 0.9206 177.6000 0.9834 177.7980 0.9834 177.9000 0.5037 178.0980 0.5037 178.2000 0.9488 178.3980 0.9488 178.5000 0.4983 178.6980 0.4983 178.8000 0.6641 178.9980 0.6641 179.1000 0.5256 179.2980 0.5256 179.4000 0.9476 179.5980 0.9476 179.7000 0.4637 179.8980 0.4637 180.0000 0.5412 180.1980 0.5412 180.3000 0.5887 180.4980 0.5887 180.6000 0.5985 180.7980 0.5985 180.9000 0.5033 181.0980 0.5033 181.2000 0.5913 181.3980 0.5913 181.5000 0.6190 181.6980 0.6190 181.8000 0.5692 181.9980 0.5692 182.1000 0.5961 182.2980 0.5961 182.4000 0.6150 182.5980 0.6150 182.7000 0.5696 182.8980 0.5696 183.0000 0.6065 183.1980 0.6065 183.3000 0.6194 183.4980 0.6194 183.6000 0.5673 183.7980 0.5673 183.9000 0.6056 184.0980 0.6056 184.2000 0.5477 184.3980 0.5477 184.5000 0.5860 184.6980 0.5860 184.8000 0.5723 184.9980 0.5723 185.1000 0.6247 185.2980 0.6247 185.4000 0.5668 185.5980 0.5668 185.7000 0.5998 185.8980 0.5998 186.0000 0.5790 186.1980 0.5790 186.3000 0.6068 186.4980 0.6068 186.6000 0.5960 186.7980 0.5960 186.9000 0.6236 187.0980 0.6236 187.2000 0.5892 187.3980 0.5892 187.5000 0.6006 187.6980 0.6006 187.8000 0.5466 187.9980 0.5466 188.1000 0.5968 188.2980 0.5968 188.4000 0.5883 188.5980 0.5883 188.7000 0.6004 188.8980 0.6004 189.0000 0.5933 189.1980 0.5933 189.3000 0.5990 189.4980 0.5990 189.6000 0.6007 189.7980 0.6007 189.9000 0.6082 190.0980 0.6082 190.2000 0.5745 190.3980 0.5745 190.5000 0.5786 190.6980 0.5786 190.8000 0.5559 190.9980 0.5559 191.1000 0.6088 191.2980 0.6088 191.4000 0.5452 191.5980 0.5452 191.7000 0.5821 191.8980 0.5821 192.0000 0.5732 192.1980 0.5732 192.3000 0.6057 192.4980 0.6057 192.6000 0.8662 192.7980 0.8662 192.9000 0.6020 193.0980 0.6020 193.2000 0.5708 193.3980 0.5708 193.5000 0.5164 193.6980 0.5164 193.8000 0.5733 193.9980 0.5733 194.1000 0.5971 194.2980 0.5971 194.4000 0.9970 194.5980 0.9970 194.7000 0.4885 194.8980 0.4885 195.0000 0.8208 195.1980 0.8208 195.3000 0.7362 195.4980 0.7362 195.6000 1.0977 195.7980 1.0977 195.9000 0.6793 196.0980 0.6793 196.2000 1.1737 196.3980 1.1737 196.5000 0.8423 196.6980 0.8423 196.8000 0.4920 196.9980 0.4920 197.1000 1.0349 197.2980 1.0349 197.4000 0.5457 197.5980 0.5457 197.7000 0.7455 197.8980 0.7455 198.0000 0.9785 198.1980 0.9785 198.3000 0.4733 198.4980 0.4733 198.6000 0.4588 198.7980 0.4588 198.9000 0.9206 199.0980 0.9206 199.2000 0.9834 199.3980 0.9834 199.5000 0.5037 199.6980 0.5037 199.8000 0.9488 199.9980 0.9488 200.1000 0.4983 200.2980 0.4983 200.4000 0.6641 200.5980 0.6641 200.7000 0.5256 200.8980 0.5256 201.0000 0.9476 201.1980 0.9476 201.3000 0.4637 201.4980 0.4637 201.6000 0.5412 201.7980 0.5412 201.9000 0.5887 202.0980 0.5887 202.2000 0.5985 202.3980 0.5985 202.5000 0.5033 202.6980 0.5033 202.8000 0.5913 202.9980 0.5913 203.1000 0.6190 203.2980 0.6190 203.4000 0.5692 203.5980 0.5692 203.7000 0.5961 203.8980 0.5961 204.0000 0.6150 204.1980 0.6150 204.3000 0.5696 204.4980 0.5696 204.6000 0.6065 204.7980 0.6065 204.9000 0.6194 205.0980 0.6194 205.2000 0.5673 205.3980 0.5673 205.5000 0.6056 205.6980 0.6056 205.8000 0.5477 205.9980 0.5477 206.1000 0.5860 206.2980 0.5860 206.4000 0.5723 206.5980 0.5723 206.7000 0.6247 206.8980 0.6247 207.0000 0.5668 207.1980 0.5668 207.3000 0.5998 207.4980 0.5998 207.6000 0.5790 207.7980 0.5790 207.9000 0.6068 208.0980 0.6068 208.2000 0.5960 208.3980 0.5960 208.5000 0.6236 208.6980 0.6236 208.8000 0.5892 208.9980 0.5892 209.1000 0.6006 209.2980 0.6006 209.4000 0.5466 209.5980 0.5466 209.7000 0.5968 209.8980 0.5968 210.0000 0.5883 210.1980 0.5883 210.3000 0.6004 210.4980 0.6004 210.6000 0.5933 210.7980 0.5933 210.9000 0.5990 211.0980 0.5990 211.2000 0.6007 211.3980 0.6007 211.5000 0.6082 211.6980 0.6082 211.8000 0.5745 211.9980 0.5745 212.1000 0.5786 212.2980 0.5786 212.4000 0.5559 212.5980 0.5559 212.7000 0.6088 212.8980 0.6088 213.0000 0.5452 213.1980 0.5452 213.3000 0.5821 213.4980 0.5821 213.6000 0.5732 213.7980 0.5732 213.9000 0.6057 214.0980 0.6057 214.2000 0.8662 214.3980 0.8662 214.5000 0.6020 214.6980 0.6020 214.8000 0.5708 214.9980 0.5708 215.1000 0.5164 215.2980 0.5164 215.4000 0.5733 215.5980 0.5733 215.7000 0.5971 215.8980 0.5971 216.0000 0.9970 216.1980 0.9970 216.3000 0.4885 216.4980 0.4885 216.6000 0.8208 216.7980 0.8208 216.9000 0.7362 217.0980 0.7362 217.2000 1.0977 217.3980 1.0977 217.5000 0.6793 217.6980 0.6793 217.8000 1.1737 217.9980 1.1737 218.1000 0.8423 218.2980 0.8423 218.4000 0.4920 218.5980 0.4920 218.7000 1.0349 218.8980 1.0349 219.0000 0.5457 219.1980 0.5457 219.3000 0.7455 219.4980 0.7455 219.6000 0.9785 219.7980 0.9785 219.9000 0.4733 220.0980 0.4733 220.2000 0.4588 220.3980 0.4588 220.5000 0.9206 220.6980 0.9206 220.8000 0.9834 220.9980 0.9834 221.1000 0.5037 221.2980 0.5037 221.4000 0.9488 221.5980 0.9488 221.7000 0.4983 221.8980 0.4983 222.0000 0.6641 222.1980 0.6641 222.3000 0.5256 222.4980 0.5256 222.6000 0.9476 222.7980 0.9476 222.9000 0.4637 223.0980 0.4637 223.2000 0.5412 223.3980 0.5412 223.5000 0.5887 223.6980 0.5887 223.8000 0.5985 223.9980 0.5985 224.1000 0.5033 224.2980 0.5033 224.4000 0.5913 224.5980 0.5913 224.7000 0.6190 224.8980 0.6190 225.0000 0.5692 225.1980 0.5692 225.3000 0.5961 225.4980 0.5961 225.6000 0.6150 225.7980 0.6150 225.9000 0.5696 226.0980 0.5696 226.2000 0.6065 226.3980 0.6065 226.5000 0.6194 226.6980 0.6194 226.8000 0.5673 226.9980 0.5673 227.1000 0.6056 227.2980 0.6056 227.4000 0.5477 227.5980 0.5477 227.7000 0.5860 227.8980 0.5860 228.0000 0.5723 228.1980 0.5723 228.3000 0.6247 228.4980 0.6247 228.6000 0.5668 228.7980 0.5668 228.9000 0.5998 229.0980 0.5998 229.2000 0.5790 229.3980 0.5790 229.5000 0.6068 229.6980 0.6068 229.8000 0.5960 229.9980 0.5960 230.1000 0.6236 230.2980 0.6236 230.4000 0.5892 230.5980 0.5892 230.7000 0.6006 230.8980 0.6006 231.0000 0.5466 231.1980 0.5466 231.3000 0.5968 231.4980 0.5968 231.6000 0.5883 231.7980 0.5883 231.9000 0.6004 232.0980 0.6004 232.2000 0.5933 232.3980 0.5933 232.5000 0.5990 232.6980 0.5990 232.8000 0.6007 232.9980 0.6007 233.1000 0.6082 233.2980 0.6082 233.4000 0.5745 233.5980 0.5745 233.7000 0.5786 233.8980 0.5786 234.0000 0.5559 234.1980 0.5559 234.3000 0.6088 234.4980 0.6088 234.6000 0.5452 234.7980 0.5452 234.9000 0.5821 235.0980 0.5821 235.2000 0.5732 235.3980 0.5732 235.5000 0.6057 235.6980 0.6057 235.8000 0.8662 235.9980 0.8662 236.1000 0.6020 236.2980 0.6020 236.4000 0.5708 236.5980 0.5708 236.7000 0.5164 236.8980 0.5164 237.0000 0.5733 237.1980 0.5733 237.3000 0.5971 237.4980 0.5971 237.6000 0.9970 237.7980 0.9970 237.9000 0.4885 238.0980 0.4885 238.2000 0.8208 238.3980 0.8208 238.5000 0.7362 238.6980 0.7362 238.8000 1.0977 238.9980 1.0977 239.1000 0.6793 239.2980 0.6793 239.4000 1.1737 239.5980 1.1737 239.7000 0.8423 239.8980 0.8423 240.0000 0.4920 240.1980 0.4920 240.3000 1.0349 240.4980 1.0349 240.6000 0.5457 240.7980 0.5457 240.9000 0.7455 241.0980 0.7455 241.2000 0.9785 241.3980 0.9785 241.5000 0.4733 241.6980 0.4733 241.8000 0.4588 241.9980 0.4588 242.1000 0.9206 242.2980 0.9206 242.4000 0.9834 242.5980 0.9834 242.7000 0.5037 242.8980 0.5037 243.0000 0.9488 243.1980 0.9488 243.3000 0.4983 243.4980 0.4983 243.6000 0.6641 243.7980 0.6641 243.9000 0.5256 244.0980 0.5256 244.2000 0.9476 244.3980 0.9476 244.5000 0.4637 244.6980 0.4637 244.8000 0.5412 244.9980 0.5412 245.1000 0.5887 245.2980 0.5887 245.4000 0.5985 245.5980 0.5985 245.7000 0.5033 245.8980 0.5033 246.0000 0.5913 246.1980 0.5913 246.3000 0.6190 246.4980 0.6190 246.6000 0.5692 246.7980 0.5692 246.9000 0.5961 247.0980 0.5961 247.2000 0.6150 247.3980 0.6150 247.5000 0.5696 247.6980 0.5696 247.8000 0.6065 247.9980 0.6065 248.1000 0.6194 248.2980 0.6194 248.4000 0.5673 248.5980 0.5673 248.7000 0.6056 248.8980 0.6056 249.0000 0.5477 249.1980 0.5477 249.3000 0.5860 249.4980 0.5860 249.6000 0.5723 249.7980 0.5723 249.9000 0.6247 250.0980 0.6247 250.2000 0.5668 250.3980 0.5668 250.5000 0.5998 250.6980 0.5998 250.8000 0.5790 250.9980 0.5790 251.1000 0.6068 251.2980 0.6068 251.4000 0.5960 251.5980 0.5960 251.7000 0.6236 251.8980 0.6236 252.0000 0.5892 252.1980 0.5892 252.3000 0.6006 252.4980 0.6006 252.6000 0.5466 252.7980 0.5466 252.9000 0.5968 253.0980 0.5968 253.2000 0.5883 253.3980 0.5883 253.5000 0.6004 253.6980 0.6004 253.8000 0.5933 253.9980 0.5933 254.1000 0.5990 254.2980 0.5990 254.4000 0.6007 254.5980 0.6007 254.7000 0.6082 254.8980 0.6082 255.0000 0.5745 255.1980 0.5745 255.3000 0.5786 255.4980 0.5786 255.6000 0.5559 255.7980 0.5559 255.9000 0.6088 256.0980 0.6088 256.2000 0.5452 256.3980 0.5452 256.5000 0.5821 256.6980 0.5821 256.8000 0.5732 256.9980 0.5732 257.1000 0.6057 257.2980 0.6057 257.4000 0.8662 257.5980 0.8662 257.7000 0.6020 257.8980 0.6020 258.0000 0.5708 258.1980 0.5708 258.3000 0.5164 258.4980 0.5164 258.6000 0.5733 258.7980 0.5733 258.9000 0.5971 259.0980 0.5971 259.2000 0.9970 259.3980 0.9970 259.5000 0.4885 259.6980 0.4885 259.8000 0.8208 259.9980 0.8208 260.1000 0.7362 260.2980 0.7362 260.4000 1.0977 260.5980 1.0977 260.7000 0.6793 260.8980 0.6793 261.0000 1.1737 261.1980 1.1737 261.3000 0.8423 261.4980 0.8423 261.6000 0.4920 261.7980 0.4920 261.9000 1.0349 262.0980 1.0349 262.2000 0.5457 262.3980 0.5457 262.5000 0.7455 262.6980 0.7455 262.8000 0.9785 262.9980 0.9785 263.1000 0.4733 263.2980 0.4733 263.4000 0.4588 263.5980 0.4588 263.7000 0.9206 263.8980 0.9206 264.0000 0.9834 264.1980 0.9834 264.3000 0.5037 264.4980 0.5037 264.6000 0.9488 264.7980 0.9488 264.9000 0.4983 265.0980 0.4983 265.2000 0.6641 265.3980 0.6641 265.5000 0.5256 265.6980 0.5256 265.8000 0.9476 265.9980 0.9476 266.1000 0.4637 266.2980 0.4637 266.4000 0.5412 266.5980 0.5412 266.7000 0.5887 266.8980 0.5887 267.0000 0.5985 267.1980 0.5985 267.3000 0.5033 267.4980 0.5033 267.6000 0.5913 267.7980 0.5913 267.9000 0.6190 268.0980 0.6190 268.2000 0.5692 268.3980 0.5692 268.5000 0.5961 268.6980 0.5961 268.8000 0.6150 268.9980 0.6150 269.1000 0.5696 269.2980 0.5696 269.4000 0.6065 269.5980 0.6065 269.7000 0.6194 269.8980 0.6194 270.0000 0.5673 270.1980 0.5673 270.3000 0.6056 270.4980 0.6056 270.6000 0.5477 270.7980 0.5477 270.9000 0.5860 271.0980 0.5860 271.2000 0.5723 271.3980 0.5723 271.5000 0.6247 271.6980 0.6247 271.8000 0.5668 271.9980 0.5668 272.1000 0.5998 272.2980 0.5998 272.4000 0.5790 272.5980 0.5790 272.7000 0.6068 272.8980 0.6068 273.0000 0.5960 273.1980 0.5960 273.3000 0.6236 273.4980 0.6236 273.6000 0.5892 273.7980 0.5892 273.9000 0.6006 274.0980 0.6006 274.2000 0.5466 274.3980 0.5466 274.5000 0.5968 274.6980 0.5968 274.8000 0.5883 274.9980 0.5883 275.1000 0.6004 275.2980 0.6004 275.4000 0.5933 275.5980 0.5933 275.7000 0.5990 275.8980 0.5990 276.0000 0.6007 276.1980 0.6007 276.3000 0.6082 276.4980 0.6082 276.6000 0.5745 276.7980 0.5745 276.9000 0.5786 277.0980 0.5786 277.2000 0.5559 277.3980 0.5559 277.5000 0.6088 277.6980 0.6088 277.8000 0.5452 277.9980 0.5452 278.1000 0.5821 278.2980 0.5821 278.4000 0.5732 278.5980 0.5732 278.7000 0.6057 278.8980 0.6057 279.0000 0.8662 279.1980 0.8662 279.3000 0.6020 279.4980 0.6020 279.6000 0.5708 279.7980 0.5708 279.9000 0.5164 280.0980 0.5164 280.2000 0.5733 280.3980 0.5733 280.5000 0.5971 280.6980 0.5971 280.8000 0.9970 280.9980 0.9970 281.1000 0.4885 281.2980 0.4885 281.4000 0.8208 281.5980 0.8208 281.7000 0.7362 281.8980 0.7362 282.0000 1.0977 282.1980 1.0977 282.3000 0.6793 282.4980 0.6793 282.6000 1.1737 282.7980 1.1737 282.9000 0.8423 283.0980 0.8423 283.2000 0.4920 283.3980 0.4920 283.5000 1.0349 283.6980 1.0349 283.8000 0.5457 283.9980 0.5457 284.1000 0.7455 284.2980 0.7455 284.4000 0.9785 284.5980 0.9785 284.7000 0.4733 284.8980 0.4733 285.0000 0.4588 285.1980 0.4588 285.3000 0.9206 285.4980 0.9206 285.6000 0.9834 285.7980 0.9834 285.9000 0.5037 286.0980 0.5037 286.2000 0.9488 286.3980 0.9488 286.5000 0.4983 286.6980 0.4983 286.8000 0.6641 286.9980 0.6641 287.1000 0.5256 287.2980 0.5256 287.4000 0.9476 287.5980 0.9476 287.7000 0.4637 287.8980 0.4637 288.0000 0.5412 288.1980 0.5412 288.3000 0.5887 288.4980 0.5887 288.6000 0.5985 288.7980 0.5985 288.9000 0.5033 289.0980 0.5033 289.2000 0.5913 289.3980 0.5913 289.5000 0.6190 289.6980 0.6190 289.8000 0.5692 289.9980 0.5692 290.1000 0.5961 290.2980 0.5961 290.4000 0.6150 290.5980 0.6150 290.7000 0.5696 290.8980 0.5696 291.0000 0.6065 291.1980 0.6065 291.3000 0.6194 291.4980 0.6194 291.6000 0.5673 291.7980 0.5673 291.9000 0.6056 292.0980 0.6056 292.2000 0.5477 292.3980 0.5477 292.5000 0.5860 292.6980 0.5860 292.8000 0.5723 292.9980 0.5723 293.1000 0.6247 293.2980 0.6247 293.4000 0.5668 293.5980 0.5668 293.7000 0.5998 293.8980 0.5998 294.0000 0.5790 294.1980 0.5790 294.3000 0.6068 294.4980 0.6068 294.6000 0.5960 294.7980 0.5960 294.9000 0.6236 295.0980 0.6236 295.2000 0.5892 295.3980 0.5892 295.5000 0.6006 295.6980 0.6006 295.8000 0.5466 295.9980 0.5466 296.1000 0.5968 296.2980 0.5968 296.4000 0.5883 296.5980 0.5883 296.7000 0.6004 296.8980 0.6004 297.0000 0.5933 297.1980 0.5933 297.3000 0.5990 297.4980 0.5990 297.6000 0.6007 297.7980 0.6007 297.9000 0.6082 298.0980 0.6082 298.2000 0.5745 298.3980 0.5745 298.5000 0.5786 298.6980 0.5786 298.8000 0.5559 298.9980 0.5559 299.1000 0.6088 299.2980 0.6088 299.4000 0.5452 299.5980 0.5452 299.7000 0.5821 299.8980 0.5821 300.0000 0.5732 300.1980 0.5732 300.3000 0.6057 300.4980 0.6057 300.6000 0.8662 300.7980 0.8662 300.9000 0.6020 301.0980 0.6020 301.2000 0.5708 301.3980 0.5708 301.5000 0.5164 301.6980 0.5164 301.8000 0.5733 301.9980 0.5733 302.1000 0.5971 302.2980 0.5971 302.4000 0.9970 302.5980 0.9970 302.7000 0.4885 302.8980 0.4885 303.0000 0.8208 303.1980 0.8208 303.3000 0.7362 303.4980 0.7362 303.6000 1.0977 303.7980 1.0977 303.9000 0.6793 304.0980 0.6793 304.2000 1.1737 304.3980 1.1737 304.5000 0.8423 304.6980 0.8423 304.8000 0.4920 304.9980 0.4920 305.1000 1.0349 305.2980 1.0349 305.4000 0.5457 305.5980 0.5457 305.7000 0.7455 305.8980 0.7455 306.0000 0.9785 306.1980 0.9785 306.3000 0.4733 306.4980 0.4733 306.6000 0.4588 306.7980 0.4588 306.9000 0.9206 307.0980 0.9206 307.2000 0.9834 307.3980 0.9834 307.5000 0.5037 307.6980 0.5037 307.8000 0.9488 307.9980 0.9488 308.1000 0.4983 308.2980 0.4983 308.4000 0.6641 308.5980 0.6641 308.7000 0.5256 308.8980 0.5256 309.0000 0.9476 309.1980 0.9476 309.3000 0.4637 309.4980 0.4637 309.6000 0.5412 309.7980 0.5412 309.9000 0.5887 310.0980 0.5887 310.2000 0.5985 310.3980 0.5985 310.5000 0.5033 310.6980 0.5033 310.8000 0.5913 310.9980 0.5913 311.1000 0.6190 311.2980 0.6190 311.4000 0.5692 311.5980 0.5692 311.7000 0.5961 311.8980 0.5961 312.0000 0.6150 312.1980 0.6150 312.3000 0.5696 312.4980 0.5696 312.6000 0.6065 312.7980 0.6065 312.9000 0.6194 313.0980 0.6194 313.2000 0.5673 313.3980 0.5673 313.5000 0.6056 313.6980 0.6056 313.8000 0.5477 313.9980 0.5477 314.1000 0.5860 314.2980 0.5860 314.4000 0.5723 314.5980 0.5723 314.7000 0.6247 314.8980 0.6247 315.0000 0.5668 315.1980 0.5668 315.3000 0.5998 315.4980 0.5998 315.6000 0.5790 315.7980 0.5790 315.9000 0.6068 316.0980 0.6068 316.2000 0.5960 316.3980 0.5960 316.5000 0.6236 316.6980 0.6236 316.8000 0.5892 316.9980 0.5892 317.1000 0.6006 317.2980 0.6006 317.4000 0.5466 317.5980 0.5466 317.7000 0.5968 317.8980 0.5968 318.0000 0.5883 318.1980 0.5883 318.3000 0.6004 318.4980 0.6004 318.6000 0.5933 318.7980 0.5933 318.9000 0.5990 319.0980 0.5990 319.2000 0.6007 319.3980 0.6007 319.5000 0.6082 319.6980 0.6082 319.8000 0.5745 319.9980 0.5745 320.1000 0.5786 320.2980 0.5786 320.4000 0.5559 320.5980 0.5559 320.7000 0.6088 320.8980 0.6088 321.0000 0.5452 321.1980 0.5452 321.3000 0.5821 321.4980 0.5821 321.6000 0.5732 321.7980 0.5732 321.9000 0.6057 322.0980 0.6057 322.2000 0.8662 322.3980 0.8662 322.5000 0.6020 322.6980 0.6020 322.8000 0.5708 322.9980 0.5708 323.1000 0.5164 323.2980 0.5164 323.4000 0.5733 323.5980 0.5733 323.7000 0.5971 323.8980 0.5971 324.0000 0.9970 324.1980 0.9970 324.3000 0.4885 324.4980 0.4885 324.6000 0.8208 324.7980 0.8208 324.9000 0.7362 325.0980 0.7362 325.2000 1.0977 325.3980 1.0977 325.5000 0.6793 325.6980 0.6793 325.8000 1.1737 325.9980 1.1737 326.1000 0.8423 326.2980 0.8423 326.4000 0.4920 326.5980 0.4920 326.7000 1.0349 326.8980 1.0349 327.0000 0.5457 327.1980 0.5457 327.3000 0.7455 327.4980 0.7455 327.6000 0.9785 327.7980 0.9785 327.9000 0.4733 328.0980 0.4733 328.2000 0.4588 328.3980 0.4588 328.5000 0.9206 328.6980 0.9206 328.8000 0.9834 328.9980 0.9834 329.1000 0.5037 329.2980 0.5037 329.4000 0.9488 329.5980 0.9488 329.7000 0.4983 329.8980 0.4983 330.0000 0.6641 330.1980 0.6641 330.3000 0.5256 330.4980 0.5256 330.6000 0.9476 330.7980 0.9476 330.9000 0.4637 331.0980 0.4637 331.2000 0.5412 331.3980 0.5412 331.5000 0.5887 331.6980 0.5887 331.8000 0.5985 331.9980 0.5985 332.1000 0.5033 332.2980 0.5033 332.4000 0.5913 332.5980 0.5913 332.7000 0.6190 332.8980 0.6190 333.0000 0.5692 333.1980 0.5692 333.3000 0.5961 333.4980 0.5961 333.6000 0.6150 333.7980 0.6150 333.9000 0.5696 334.0980 0.5696 334.2000 0.6065 334.3980 0.6065 334.5000 0.6194 334.6980 0.6194 334.8000 0.5673 334.9980 0.5673 335.1000 0.6056 335.2980 0.6056 335.4000 0.5477 335.5980 0.5477 335.7000 0.5860 335.8980 0.5860 336.0000 0.5723 336.1980 0.5723 336.3000 0.6247 336.4980 0.6247 336.6000 0.5668 336.7980 0.5668 336.9000 0.5998 337.0980 0.5998 337.2000 0.5790 337.3980 0.5790 337.5000 0.6068 337.6980 0.6068 337.8000 0.5960 337.9980 0.5960 338.1000 0.6236 338.2980 0.6236 338.4000 0.5892 338.5980 0.5892 338.7000 0.6006 338.8980 0.6006 339.0000 0.5466 339.1980 0.5466 339.3000 0.5968 339.4980 0.5968 339.6000 0.5883 339.7980 0.5883 339.9000 0.6004 340.0980 0.6004 340.2000 0.5933 340.3980 0.5933 340.5000 0.5990 340.6980 0.5990 340.8000 0.6007 340.9980 0.6007 341.1000 0.6082 341.2980 0.6082 341.4000 0.5745 341.5980 0.5745 341.7000 0.5786 341.8980 0.5786 342.0000 0.5559 342.1980 0.5559 342.3000 0.6088 342.4980 0.6088 342.6000 0.5452 342.7980 0.5452 342.9000 0.5821 343.0980 0.5821 343.2000 0.5732 343.3980 0.5732 343.5000 0.6057 343.6980 0.6057 343.8000 0.8662 343.9980 0.8662 344.1000 0.6020 344.2980 0.6020 344.4000 0.5708 344.5980 0.5708 344.7000 0.5164 344.8980 0.5164 345.0000 0.5733 345.1980 0.5733 345.3000 0.5971 345.4980 0.5971 345.6000 0.9970 345.7980 0.9970 345.9000 0.4885 346.0980 0.4885 346.2000 0.8208 346.3980 0.8208 346.5000 0.7362 346.6980 0.7362 346.8000 1.0977 346.9980 1.0977 347.1000 0.6793 347.2980 0.6793 347.4000 1.1737 347.5980 1.1737 347.7000 0.8423 347.8980 0.8423 348.0000 0.4920 348.1980 0.4920 348.3000 1.0349 348.4980 1.0349 348.6000 0.5457 348.7980 0.5457 348.9000 0.7455 349.0980 0.7455 349.2000 0.9785 349.3980 0.9785 349.5000 0.4733 349.6980 0.4733 349.8000 0.4588 349.9980 0.4588 350.1000 0.9206 350.2980 0.9206 350.4000 0.9834 350.5980 0.9834 350.7000 0.5037 350.8980 0.5037 351.0000 0.9488 351.1980 0.9488 351.3000 0.4983 351.4980 0.4983 351.6000 0.6641 351.7980 0.6641 351.9000 0.5256 352.0980 0.5256 352.2000 0.9476 352.3980 0.9476 352.5000 0.4637 352.6980 0.4637 352.8000 0.5412 352.9980 0.5412 353.1000 0.5887 353.2980 0.5887 353.4000 0.5985 353.5980 0.5985 353.7000 0.5033 353.8980 0.5033 354.0000 0.5913 354.1980 0.5913 354.3000 0.6190 354.4980 0.6190 354.6000 0.5692 354.7980 0.5692 354.9000 0.5961 355.0980 0.5961 355.2000 0.6150 355.3980 0.6150 355.5000 0.5696 355.6980 0.5696 355.8000 0.6065 355.9980 0.6065 356.1000 0.6194 356.2980 0.6194 356.4000 0.5673 356.5980 0.5673 356.7000 0.6056 356.8980 0.6056 357.0000 0.5477 357.1980 0.5477 357.3000 0.5860 357.4980 0.5860 357.6000 0.5723 357.7980 0.5723 357.9000 0.6247 358.0980 0.6247 358.2000 0.5668 358.3980 0.5668 358.5000 0.5998 358.6980 0.5998 358.8000 0.5790 358.9980 0.5790 359.1000 0.6068 359.2980 0.6068 359.4000 0.5960 359.5980 0.5960 359.7000 0.6236 359.8980 0.6236 360.0000 0.5892 360.1980 0.5892 360.3000 0.6006 360.4980 0.6006 360.6000 0.5466 360.7980 0.5466 360.9000 0.5968 361.0980 0.5968 361.2000 0.5883 361.3980 0.5883 361.5000 0.6004 361.6980 0.6004 361.8000 0.5933 361.9980 0.5933 362.1000 0.5990 362.2980 0.5990 362.4000 0.6007 362.5980 0.6007 362.7000 0.6082 362.8980 0.6082 363.0000 0.5745 363.1980 0.5745 363.3000 0.5786 363.4980 0.5786 363.6000 0.5559 363.7980 0.5559 363.9000 0.6088 364.0980 0.6088 364.2000 0.5452 364.3980 0.5452 364.5000 0.5821 364.6980 0.5821 364.8000 0.5732 364.9980 0.5732 365.1000 0.6057 365.2980 0.6057 365.4000 0.8662 365.5980 0.8662 365.7000 0.6020 365.8980 0.6020 366.0000 0.5708 366.1980 0.5708 366.3000 0.5164 366.4980 0.5164 366.6000 0.5733 366.7980 0.5733 366.9000 0.5971 367.0980 0.5971 367.2000 0.9970 367.3980 0.9970 367.5000 0.4885 367.6980 0.4885 367.8000 0.8208 367.9980 0.8208 368.1000 0.7362 368.2980 0.7362 368.4000 1.0977 368.5980 1.0977 368.7000 0.6793 368.8980 0.6793 369.0000 1.1737 369.1980 1.1737 369.3000 0.8423 369.4980 0.8423 369.6000 0.4920 369.7980 0.4920 369.9000 1.0349 370.0980 1.0349 370.2000 0.5457 370.3980 0.5457 370.5000 0.7455 370.6980 0.7455 370.8000 0.9785 370.9980 0.9785 371.1000 0.4733 371.2980 0.4733 371.4000 0.4588 371.5980 0.4588 371.7000 0.9206 371.8980 0.9206 372.0000 0.9834 372.1980 0.9834 372.3000 0.5037 372.4980 0.5037 372.6000 0.9488 372.7980 0.9488 372.9000 0.4983 373.0980 0.4983 373.2000 0.6641 373.3980 0.6641 373.5000 0.5256 373.6980 0.5256 373.8000 0.9476 373.9980 0.9476 374.1000 0.4637 374.2980 0.4637 374.4000 0.5412 374.5980 0.5412 374.7000 0.5887 374.8980 0.5887 375.0000 0.5985 375.1980 0.5985 375.3000 0.5033 375.4980 0.5033 375.6000 0.5913 375.7980 0.5913 375.9000 0.6190 376.0980 0.6190 376.2000 0.5692 376.3980 0.5692 376.5000 0.5961 376.6980 0.5961 376.8000 0.6150 376.9980 0.6150 377.1000 0.5696 377.2980 0.5696 377.4000 0.6065 377.5980 0.6065 377.7000 0.6194 377.8980 0.6194 378.0000 0.5673 378.1980 0.5673 378.3000 0.6056 378.4980 0.6056 378.6000 0.5477 378.7980 0.5477 378.9000 0.5860 379.0980 0.5860 379.2000 0.5723 379.3980 0.5723 379.5000 0.6247 379.6980 0.6247 379.8000 0.5668 379.9980 0.5668 380.1000 0.5998 380.2980 0.5998 380.4000 0.5790 380.5980 0.5790 380.7000 0.6068 380.8980 0.6068 381.0000 0.5960 381.1980 0.5960 381.3000 0.6236 381.4980 0.6236 381.6000 0.5892 381.7980 0.5892 381.9000 0.6006 382.0980 0.6006 382.2000 0.5466 382.3980 0.5466 382.5000 0.5968 382.6980 0.5968 382.8000 0.5883 382.9980 0.5883 383.1000 0.6004 383.2980 0.6004 383.4000 0.5933 383.5980 0.5933 383.7000 0.5990 383.8980 0.5990 384.0000 0.6007 384.1980 0.6007 384.3000 0.6082 384.4980 0.6082 384.6000 0.5745 384.7980 0.5745 384.9000 0.5786 385.0980 0.5786 385.2000 0.5559 385.3980 0.5559 385.5000 0.6088 385.6980 0.6088 385.8000 0.5452 385.9980 0.5452 386.1000 0.5821 386.2980 0.5821 386.4000 0.5732 386.5980 0.5732 386.7000 0.6057 386.8980 0.6057 387.0000 0.8662 387.1980 0.8662 387.3000 0.6020 387.4980 0.6020 387.6000 0.5708 387.7980 0.5708 387.9000 0.5164 388.0980 0.5164 388.2000 0.5733 388.3980 0.5733 388.5000 0.5971 388.6980 0.5971 388.8000 0.9970 388.9980 0.9970 389.1000 0.4885 389.2980 0.4885 389.4000 0.8208 389.5980 0.8208 389.7000 0.7362 389.8980 0.7362 390.0000 1.0977 390.1980 1.0977 390.3000 0.6793 390.4980 0.6793 390.6000 1.1737 390.7980 1.1737 390.9000 0.8423 391.0980 0.8423 391.2000 0.4920 391.3980 0.4920 391.5000 1.0349 391.6980 1.0349 391.8000 0.5457 391.9980 0.5457 392.1000 0.7455 392.2980 0.7455 392.4000 0.9785 392.5980 0.9785 392.7000 0.4733 392.8980 0.4733 393.0000 0.4588 393.1980 0.4588 393.3000 0.9206 393.4980 0.9206 393.6000 0.9834 393.7980 0.9834 393.9000 0.5037 394.0980 0.5037 394.2000 0.9488 394.3980 0.9488 394.5000 0.4983 394.6980 0.4983 394.8000 0.6641 394.9980 0.6641 395.1000 0.5256 395.2980 0.5256 395.4000 0.9476 395.5980 0.9476 395.7000 0.4637 395.8980 0.4637 396.0000 0.5412 396.1980 0.5412 396.3000 0.5887 396.4980 0.5887 396.6000 0.5985 396.7980 0.5985 396.9000 0.5033 397.0980 0.5033 397.2000 0.5913 397.3980 0.5913 397.5000 0.6190 397.6980 0.6190 397.8000 0.5692 397.9980 0.5692 398.1000 0.5961 398.2980 0.5961 398.4000 0.6150 398.5980 0.6150 398.7000 0.5696 398.8980 0.5696 399.0000 0.6065 399.1980 0.6065 399.3000 0.6194 399.4980 0.6194 399.6000 0.5673 399.7980 0.5673 399.9000 0.6056 400.0980 0.6056 400.2000 0.5477 400.3980 0.5477 400.5000 0.5860 400.6980 0.5860 400.8000 0.5723 400.9980 0.5723 401.1000 0.6247 401.2980 0.6247 401.4000 0.5668 401.5980 0.5668 401.7000 0.5998 401.8980 0.5998 402.0000 0.5790 402.1980 0.5790 402.3000 0.6068 402.4980 0.6068 402.6000 0.5960 402.7980 0.5960 402.9000 0.6236 403.0980 0.6236 403.2000 0.5892 403.3980 0.5892 403.5000 0.6006 403.6980 0.6006 403.8000 0.5466 403.9980 0.5466 404.1000 0.5968 404.2980 0.5968 404.4000 0.5883 404.5980 0.5883 404.7000 0.6004 404.8980 0.6004 405.0000 0.5933 405.1980 0.5933 405.3000 0.5990 405.4980 0.5990 405.6000 0.6007 405.7980 0.6007 405.9000 0.6082 406.0980 0.6082 406.2000 0.5745 406.3980 0.5745 406.5000 0.5786 406.6980 0.5786 406.8000 0.5559 406.9980 0.5559 407.1000 0.6088 407.2980 0.6088 407.4000 0.5452 407.5980 0.5452 407.7000 0.5821 407.8980 0.5821 408.0000 0.5732 408.1980 0.5732 408.3000 0.6057 408.4980 0.6057 408.6000 0.8662 408.7980 0.8662 408.9000 0.6020 409.0980 0.6020 409.2000 0.5708 409.3980 0.5708 409.5000 0.5164 409.6980 0.5164 409.8000 0.5733 409.9980 0.5733 410.1000 0.5971 410.2980 0.5971 410.4000 0.9970 410.5980 0.9970 410.7000 0.4885 410.8980 0.4885 411.0000 0.8208 411.1980 0.8208 411.3000 0.7362 411.4980 0.7362 411.6000 1.0977 411.7980 1.0977 411.9000 0.6793 412.0980 0.6793 412.2000 1.1737 412.3980 1.1737 412.5000 0.8423 412.6980 0.8423 412.8000 0.4920 412.9980 0.4920 413.1000 1.0349 413.2980 1.0349 413.4000 0.5457 413.5980 0.5457 413.7000 0.7455 413.8980 0.7455 414.0000 0.9785 414.1980 0.9785 414.3000 0.4733 414.4980 0.4733 414.6000 0.4588 414.7980 0.4588 414.9000 0.9206 415.0980 0.9206 415.2000 0.9834 415.3980 0.9834 415.5000 0.5037 415.6980 0.5037 415.8000 0.9488 415.9980 0.9488 416.1000 0.4983 416.2980 0.4983 416.4000 0.6641 416.5980 0.6641 416.7000 0.5256 416.8980 0.5256 417.0000 0.9476 417.1980 0.9476 417.3000 0.4637 417.4980 0.4637 417.6000 0.5412 417.7980 0.5412 417.9000 0.5887 418.0980 0.5887 418.2000 0.5985 418.3980 0.5985 418.5000 0.5033 418.6980 0.5033 418.8000 0.5913 418.9980 0.5913 419.1000 0.6190 419.2980 0.6190 419.4000 0.5692 419.5980 0.5692 419.7000 0.5961 419.8980 0.5961 420.0000 0.6150 420.1980 0.6150 420.3000 0.5696 420.4980 0.5696 420.6000 0.6065 420.7980 0.6065 420.9000 0.6194 421.0980 0.6194 421.2000 0.5673 421.3980 0.5673 421.5000 0.6056 421.6980 0.6056 421.8000 0.5477 421.9980 0.5477 422.1000 0.5860 422.2980 0.5860 422.4000 0.5723 422.5980 0.5723 422.7000 0.6247 422.8980 0.6247 423.0000 0.5668 423.1980 0.5668 423.3000 0.5998 423.4980 0.5998 423.6000 0.5790 423.7980 0.5790 423.9000 0.6068 424.0980 0.6068 424.2000 0.5960 424.3980 0.5960 424.5000 0.6236 424.6980 0.6236 424.8000 0.5892 424.9980 0.5892 425.1000 0.6006 425.2980 0.6006 425.4000 0.5466 425.5980 0.5466 425.7000 0.5968 425.8980 0.5968 426.0000 0.5883 426.1980 0.5883 426.3000 0.6004 426.4980 0.6004 426.6000 0.5933 426.7980 0.5933 426.9000 0.5990 427.0980 0.5990 427.2000 0.6007 427.3980 0.6007 427.5000 0.6082 427.6980 0.6082 427.8000 0.5745 427.9980 0.5745 428.1000 0.5786 428.2980 0.5786 428.4000 0.5559 428.5980 0.5559 428.7000 0.6088 428.8980 0.6088 429.0000 0.5452 429.1980 0.5452 429.3000 0.5821 429.4980 0.5821 429.6000 0.5732 429.7980 0.5732 429.9000 0.6057 430.0980 0.6057 430.2000 0.8662 430.3980 0.8662 430.5000 0.6020 430.6980 0.6020 430.8000 0.5708 430.9980 0.5708 431.1000 0.5164 431.2980 0.5164 431.4000 0.5733 431.5980 0.5733 431.7000 0.5971 431.8980 0.5971 432.0000 0.9970 432.1980 0.9970 432.3000 0.4885 432.4980 0.4885 432.6000 0.8208 432.7980 0.8208 432.9000 0.7362 433.0980 0.7362 433.2000 1.0977 433.3980 1.0977 433.5000 0.6793 433.6980 0.6793 433.8000 1.1737 433.9980 1.1737 434.1000 0.8423 434.2980 0.8423 434.4000 0.4920 434.5980 0.4920 434.7000 1.0349 434.8980 1.0349 435.0000 0.5457 435.1980 0.5457 435.3000 0.7455 435.4980 0.7455 435.6000 0.9785 435.7980 0.9785 435.9000 0.4733 436.0980 0.4733 436.2000 0.4588 436.3980 0.4588 436.5000 0.9206 436.6980 0.9206 436.8000 0.9834 436.9980 0.9834 437.1000 0.5037 437.2980 0.5037 437.4000 0.9488 437.5980 0.9488 437.7000 0.4983 437.8980 0.4983 438.0000 0.6641 438.1980 0.6641 438.3000 0.5256 438.4980 0.5256 438.6000 0.9476 438.7980 0.9476 438.9000 0.4637 439.0980 0.4637 439.2000 0.5412 439.3980 0.5412 439.5000 0.5887 439.6980 0.5887 439.8000 0.5985 439.9980 0.5985 440.1000 0.5033 440.2980 0.5033 440.4000 0.5913 440.5980 0.5913 440.7000 0.6190 440.8980 0.6190 441.0000 0.5692 441.1980 0.5692 441.3000 0.5961 441.4980 0.5961 441.6000 0.6150 441.7980 0.6150 441.9000 0.5696 442.0980 0.5696 442.2000 0.6065 442.3980 0.6065 442.5000 0.6194 442.6980 0.6194 442.8000 0.5673 442.9980 0.5673 443.1000 0.6056 443.2980 0.6056 443.4000 0.5477 443.5980 0.5477 443.7000 0.5860 443.8980 0.5860 444.0000 0.5723 444.1980 0.5723 444.3000 0.6247 444.4980 0.6247 444.6000 0.5668 444.7980 0.5668 444.9000 0.5998 445.0980 0.5998 445.2000 0.5790 445.3980 0.5790 445.5000 0.6068 445.6980 0.6068 445.8000 0.5960 445.9980 0.5960 446.1000 0.6236 446.2980 0.6236 446.4000 0.5892 446.5980 0.5892 446.7000 0.6006 446.8980 0.6006 447.0000 0.5466 447.1980 0.5466 447.3000 0.5968 447.4980 0.5968 447.6000 0.5883 447.7980 0.5883 447.9000 0.6004 448.0980 0.6004 448.2000 0.5933 448.3980 0.5933 448.5000 0.5990 448.6980 0.5990 448.8000 0.6007 448.9980 0.6007 449.1000 0.6082 449.2980 0.6082 449.4000 0.5745 449.5980 0.5745 449.7000 0.5786 449.8980 0.5786 450.0000 0.5559 450.1980 0.5559 450.3000 0.6088 450.4980 0.6088 450.6000 0.5452 450.7980 0.5452 450.9000 0.5821 451.0980 0.5821 451.2000 0.5732 451.3980 0.5732 451.5000 0.6057 451.6980 0.6057 451.8000 0.8662 451.9980 0.8662 452.1000 0.6020 452.2980 0.6020 452.4000 0.5708 452.5980 0.5708 452.7000 0.5164 452.8980 0.5164 453.0000 0.5733 453.1980 0.5733 453.3000 0.5971 453.4980 0.5971 453.6000 0.9970 453.7980 0.9970 453.9000 0.4885 454.0980 0.4885 454.2000 0.8208 454.3980 0.8208 454.5000 0.7362 454.6980 0.7362 454.8000 1.0977 454.9980 1.0977 455.1000 0.6793 455.2980 0.6793 455.4000 1.1737 455.5980 1.1737 455.7000 0.8423 455.8980 0.8423 456.0000 0.4920 456.1980 0.4920 456.3000 1.0349 456.4980 1.0349 456.6000 0.5457 456.7980 0.5457 456.9000 0.7455 457.0980 0.7455 457.2000 0.9785 457.3980 0.9785 457.5000 0.4733 457.6980 0.4733 457.8000 0.4588 457.9980 0.4588 458.1000 0.9206 458.2980 0.9206 458.4000 0.9834 458.5980 0.9834 458.7000 0.5037 458.8980 0.5037 459.0000 0.9488 459.1980 0.9488 459.3000 0.4983 459.4980 0.4983 459.6000 0.6641 459.7980 0.6641 459.9000 0.5256 460.0980 0.5256 460.2000 0.9476 460.3980 0.9476 460.5000 0.4637 460.6980 0.4637 460.8000 0.5412 460.9980 0.5412 461.1000 0.5887 461.2980 0.5887 461.4000 0.5985 461.5980 0.5985 461.7000 0.5033 461.8980 0.5033 462.0000 0.5913 462.1980 0.5913 462.3000 0.6190 462.4980 0.6190 462.6000 0.5692 462.7980 0.5692 462.9000 0.5961 463.0980 0.5961 463.2000 0.6150 463.3980 0.6150 463.5000 0.5696 463.6980 0.5696 463.8000 0.6065 463.9980 0.6065 464.1000 0.6194 464.2980 0.6194 464.4000 0.5673 464.5980 0.5673 464.7000 0.6056 464.8980 0.6056 465.0000 0.5477 465.1980 0.5477 465.3000 0.5860 465.4980 0.5860 465.6000 0.5723 465.7980 0.5723 465.9000 0.6247 466.0980 0.6247 466.2000 0.5668 466.3980 0.5668 466.5000 0.5998 466.6980 0.5998 466.8000 0.5790 466.9980 0.5790 467.1000 0.6068 467.2980 0.6068 467.4000 0.5960 467.5980 0.5960 467.7000 0.6236 467.8980 0.6236 468.0000 0.5892 468.1980 0.5892 468.3000 0.6006 468.4980 0.6006 468.6000 0.5466 468.7980 0.5466 468.9000 0.5968 469.0980 0.5968 469.2000 0.5883 469.3980 0.5883 469.5000 0.6004 469.6980 0.6004 469.8000 0.5933 469.9980 0.5933 470.1000 0.5990 470.2980 0.5990 470.4000 0.6007 470.5980 0.6007 470.7000 0.6082 470.8980 0.6082 471.0000 0.5745 471.1980 0.5745 471.3000 0.5786 471.4980 0.5786 471.6000 0.5559 471.7980 0.5559 471.9000 0.6088 472.0980 0.6088 472.2000 0.5452 472.3980 0.5452 472.5000 0.5821 472.6980 0.5821 472.8000 0.5732 472.9980 0.5732 473.1000 0.6057 473.2980 0.6057 473.4000 0.8662 473.5980 0.8662 473.7000 0.6020 473.8980 0.6020 474.0000 0.5708 474.1980 0.5708 474.3000 0.5164 474.4980 0.5164 474.6000 0.5733 474.7980 0.5733 474.9000 0.5971 475.0980 0.5971 475.2000 0.9970 475.3980 0.9970 475.5000 0.4885 475.6980 0.4885 475.8000 0.8208 475.9980 0.8208 476.1000 0.7362 476.2980 0.7362 476.4000 1.0977 476.5980 1.0977 476.7000 0.6793 476.8980 0.6793 477.0000 1.1737 477.1980 1.1737 477.3000 0.8423 477.4980 0.8423 477.6000 0.4920 477.7980 0.4920 477.9000 1.0349 478.0980 1.0349 478.2000 0.5457 478.3980 0.5457 478.5000 0.7455 478.6980 0.7455 478.8000 0.9785 478.9980 0.9785 479.1000 0.4733 479.2980 0.4733 479.4000 0.4588 479.5980 0.4588 479.7000 0.9206 479.8980 0.9206 480.0000 0.9834 480.1980 0.9834 480.3000 0.5037 480.4980 0.5037 480.6000 0.9488 480.7980 0.9488 480.9000 0.4983 481.0980 0.4983 481.2000 0.6641 481.3980 0.6641 481.5000 0.5256 481.6980 0.5256 481.8000 0.9476 481.9980 0.9476 482.1000 0.4637 482.2980 0.4637 482.4000 0.5412 482.5980 0.5412 482.7000 0.5887 482.8980 0.5887 483.0000 0.5985 483.1980 0.5985 483.3000 0.5033 483.4980 0.5033 483.6000 0.5913 483.7980 0.5913 483.9000 0.6190 484.0980 0.6190 484.2000 0.5692 484.3980 0.5692 484.5000 0.5961 484.6980 0.5961 484.8000 0.6150 484.9980 0.6150 485.1000 0.5696 485.2980 0.5696 485.4000 0.6065 485.5980 0.6065 485.7000 0.6194 485.8980 0.6194 486.0000 0.5673 486.1980 0.5673 486.3000 0.6056 486.4980 0.6056 486.6000 0.5477 486.7980 0.5477 486.9000 0.5860 487.0980 0.5860 487.2000 0.5723 487.3980 0.5723 487.5000 0.6247 487.6980 0.6247 487.8000 0.5668 487.9980 0.5668 488.1000 0.5998 488.2980 0.5998 488.4000 0.5790 488.5980 0.5790 488.7000 0.6068 488.8980 0.6068 489.0000 0.5960 489.1980 0.5960 489.3000 0.6236 489.4980 0.6236 489.6000 0.5892 489.7980 0.5892 489.9000 0.6006 490.0980 0.6006 490.2000 0.5466 490.3980 0.5466 490.5000 0.5968 490.6980 0.5968 490.8000 0.5883 490.9980 0.5883 491.1000 0.6004 491.2980 0.6004 491.4000 0.5933 491.5980 0.5933 491.7000 0.5990 491.8980 0.5990 492.0000 0.6007 492.1980 0.6007 492.3000 0.6082 492.4980 0.6082 492.6000 0.5745 492.7980 0.5745 492.9000 0.5786 493.0980 0.5786 493.2000 0.5559 493.3980 0.5559 493.5000 0.6088 493.6980 0.6088 493.8000 0.5452 493.9980 0.5452 494.1000 0.5821 494.2980 0.5821 494.4000 0.5732 494.5980 0.5732 494.7000 0.6057 494.8980 0.6057 495.0000 0.8662 495.1980 0.8662 495.3000 0.6020 495.4980 0.6020 495.6000 0.5708 495.7980 0.5708 495.9000 0.5164 496.0980 0.5164 496.2000 0.5733 496.3980 0.5733 496.5000 0.5971 496.6980 0.5971 496.8000 0.9970 496.9980 0.9970 497.1000 0.4885 497.2980 0.4885 497.4000 0.8208 497.5980 0.8208 497.7000 0.7362 497.8980 0.7362 498.0000 1.0977 498.1980 1.0977 498.3000 0.6793 498.4980 0.6793 498.6000 1.1737 498.7980 1.1737 498.9000 0.8423 499.0980 0.8423 499.2000 0.4920 499.3980 0.4920 499.5000 1.0349 499.6980 1.0349 499.8000 0.5457 499.9980 0.5457 500.1000 0.7455 500.2980 0.7455 500.4000 0.9785 500.5980 0.9785 500.7000 0.4733 500.8980 0.4733 501.0000 0.4588 501.1980 0.4588 501.3000 0.9206 501.4980 0.9206 501.6000 0.9834 501.7980 0.9834 501.9000 0.5037 502.0980 0.5037 502.2000 0.9488 502.3980 0.9488 502.5000 0.4983 502.6980 0.4983 502.8000 0.6641 502.9980 0.6641 503.1000 0.5256 503.2980 0.5256 503.4000 0.9476 503.5980 0.9476 503.7000 0.4637 503.8980 0.4637 504.0000 0.5412 504.1980 0.5412 504.3000 0.5887 504.4980 0.5887 504.6000 0.5985 504.7980 0.5985 504.9000 0.5033 505.0980 0.5033 505.2000 0.5913 505.3980 0.5913 505.5000 0.6190 505.6980 0.6190 505.8000 0.5692 505.9980 0.5692 506.1000 0.5961 506.2980 0.5961 506.4000 0.6150 506.5980 0.6150 506.7000 0.5696 506.8980 0.5696 507.0000 0.6065 507.1980 0.6065 507.3000 0.6194 507.4980 0.6194 507.6000 0.5673 507.7980 0.5673 507.9000 0.6056 508.0980 0.6056 508.2000 0.5477 508.3980 0.5477 508.5000 0.5860 508.6980 0.5860 508.8000 0.5723 508.9980 0.5723 509.1000 0.6247 509.2980 0.6247 509.4000 0.5668 509.5980 0.5668 509.7000 0.5998 509.8980 0.5998 510.0000 0.5790 510.1980 0.5790 510.3000 0.6068 510.4980 0.6068 510.6000 0.5960 510.7980 0.5960 510.9000 0.6236 511.0980 0.6236 511.2000 0.5892 511.3980 0.5892 511.5000 0.6006 511.6980 0.6006 511.8000 0.5466 511.9980 0.5466 512.1000 0.5968 512.2980 0.5968 512.4000 0.5883 512.5980 0.5883 512.7000 0.6004 512.8980 0.6004 513.0000 0.5933 513.1980 0.5933 513.3000 0.5990 513.4980 0.5990 513.6000 0.6007 513.7980 0.6007 513.9000 0.6082 514.0980 0.6082 514.2000 0.5745 514.3980 0.5745 514.5000 0.5786 514.6980 0.5786 514.8000 0.5559 514.9980 0.5559 515.1000 0.6088 515.2980 0.6088 515.4000 0.5452 515.5980 0.5452 515.7000 0.5821 515.8980 0.5821 516.0000 0.5732 516.1980 0.5732 516.3000 0.6057 516.4980 0.6057 516.6000 0.8662 516.7980 0.8662 516.9000 0.6020 517.0980 0.6020 517.2000 0.5708 517.3980 0.5708 517.5000 0.5164 517.6980 0.5164 517.8000 0.5733 517.9980 0.5733 518.1000 0.5971 518.2980 0.5971 518.4000 0.9970 518.5980 0.9970 518.7000 0.4885 518.8980 0.4885 519.0000 0.8208 519.1980 0.8208 519.3000 0.7362 519.4980 0.7362 519.6000 1.0977 519.7980 1.0977 519.9000 0.6793 520.0980 0.6793 520.2000 1.1737 520.3980 1.1737 520.5000 0.8423 520.6980 0.8423 520.8000 0.4920 520.9980 0.4920 521.1000 1.0349 521.2980 1.0349 521.4000 0.5457 521.5980 0.5457 521.7000 0.7455 521.8980 0.7455 522.0000 0.9785 522.1980 0.9785 522.3000 0.4733 522.4980 0.4733 522.6000 0.4588 522.7980 0.4588 522.9000 0.9206 523.0980 0.9206 523.2000 0.9834 523.3980 0.9834 523.5000 0.5037 523.6980 0.5037 523.8000 0.9488 523.9980 0.9488 524.1000 0.4983 524.2980 0.4983 524.4000 0.6641 524.5980 0.6641 524.7000 0.5256 524.8980 0.5256 525.0000 0.9476 525.1980 0.9476 525.3000 0.4637 525.4980 0.4637 525.6000 0.5412 525.7980 0.5412 525.9000 0.5887 526.0980 0.5887 526.2000 0.5985 526.3980 0.5985 526.5000 0.5033 526.6980 0.5033 526.8000 0.5913 526.9980 0.5913 527.1000 0.6190 527.2980 0.6190 527.4000 0.5692 527.5980 0.5692 527.7000 0.5961 527.8980 0.5961 528.0000 0.6150 528.1980 0.6150 528.3000 0.5696 528.4980 0.5696 528.6000 0.6065 528.7980 0.6065 528.9000 0.6194 529.0980 0.6194 529.2000 0.5673 529.3980 0.5673 529.5000 0.6056 529.6980 0.6056 529.8000 0.5477 529.9980 0.5477 530.1000 0.5860 530.2980 0.5860 530.4000 0.5723 530.5980 0.5723 530.7000 0.6247 530.8980 0.6247 531.0000 0.5668 531.1980 0.5668 531.3000 0.5998 531.4980 0.5998 531.6000 0.5790 531.7980 0.5790 531.9000 0.6068 532.0980 0.6068 532.2000 0.5960 532.3980 0.5960 532.5000 0.6236 532.6980 0.6236 532.8000 0.5892 532.9980 0.5892 533.1000 0.6006 533.2980 0.6006 533.4000 0.5466 533.5980 0.5466 533.7000 0.5968 533.8980 0.5968 534.0000 0.5883 534.1980 0.5883 534.3000 0.6004 534.4980 0.6004 534.6000 0.5933 534.7980 0.5933 534.9000 0.5990 535.0980 0.5990 535.2000 0.6007 535.3980 0.6007 535.5000 0.6082 535.6980 0.6082 535.8000 0.5745 535.9980 0.5745 536.1000 0.5786 536.2980 0.5786 536.4000 0.5559 536.5980 0.5559 536.7000 0.6088 536.8980 0.6088 537.0000 0.5452 537.1980 0.5452 537.3000 0.5821 537.4980 0.5821 537.6000 0.5732 537.7980 0.5732 537.9000 0.6057 538.0980 0.6057 538.2000 0.8662 538.3980 0.8662 538.5000 0.6020 538.6980 0.6020 538.8000 0.5708 538.9980 0.5708 539.1000 0.5164 539.2980 0.5164 539.4000 0.5733 539.5980 0.5733 539.7000 0.5971 539.8980 0.5971 540.0000 0.9970 540.1980 0.9970 540.3000 0.4885 540.4980 0.4885 540.6000 0.8208 540.7980 0.8208 540.9000 0.7362 541.0980 0.7362 541.2000 1.0977 541.3980 1.0977 541.5000 0.6793 541.6980 0.6793 541.8000 1.1737 541.9980 1.1737 542.1000 0.8423 542.2980 0.8423 542.4000 0.4920 542.5980 0.4920 542.7000 1.0349 542.8980 1.0349 543.0000 0.5457 543.1980 0.5457 543.3000 0.7455 543.4980 0.7455 543.6000 0.9785 543.7980 0.9785 543.9000 0.4733 544.0980 0.4733 544.2000 0.4588 544.3980 0.4588 544.5000 0.9206 544.6980 0.9206 544.8000 0.9834 544.9980 0.9834 545.1000 0.5037 545.2980 0.5037 545.4000 0.9488 545.5980 0.9488 545.7000 0.4983 545.8980 0.4983 546.0000 0.6641 546.1980 0.6641 546.3000 0.5256 546.4980 0.5256 546.6000 0.9476 546.7980 0.9476 546.9000 0.4637 547.0980 0.4637 547.2000 0.5412 547.3980 0.5412 547.5000 0.5887 547.6980 0.5887 547.8000 0.5985 547.9980 0.5985 548.1000 0.5033 548.2980 0.5033 548.4000 0.5913 548.5980 0.5913 548.7000 0.6190 548.8980 0.6190 549.0000 0.5692 549.1980 0.5692 549.3000 0.5961 549.4980 0.5961 549.6000 0.6150 549.7980 0.6150 549.9000 0.5696 550.0980 0.5696 550.2000 0.6065 550.3980 0.6065 550.5000 0.6194 550.6980 0.6194 550.8000 0.5673 550.9980 0.5673 551.1000 0.6056 551.2980 0.6056 551.4000 0.5477 551.5980 0.5477 551.7000 0.5860 551.8980 0.5860 552.0000 0.5723 552.1980 0.5723 552.3000 0.6247 552.4980 0.6247 552.6000 0.5668 552.7980 0.5668 552.9000 0.5998 553.0980 0.5998 553.2000 0.5790 553.3980 0.5790 553.5000 0.6068 553.6980 0.6068 553.8000 0.5960 553.9980 0.5960 554.1000 0.6236 554.2980 0.6236 554.4000 0.5892 554.5980 0.5892 554.7000 0.6006 554.8980 0.6006 555.0000 0.5466 555.1980 0.5466 555.3000 0.5968 555.4980 0.5968 555.6000 0.5883 555.7980 0.5883 555.9000 0.6004 556.0980 0.6004 556.2000 0.5933 556.3980 0.5933 556.5000 0.5990 556.6980 0.5990 556.8000 0.6007 556.9980 0.6007 557.1000 0.6082 557.2980 0.6082 557.4000 0.5745 557.5980 0.5745 557.7000 0.5786 557.8980 0.5786 558.0000 0.5559 558.1980 0.5559 558.3000 0.6088 558.4980 0.6088 558.6000 0.5452 558.7980 0.5452 558.9000 0.5821 559.0980 0.5821 559.2000 0.5732 559.3980 0.5732 559.5000 0.6057 559.6980 0.6057 559.8000 0.8662 559.9980 0.8662 560.1000 0.6020 560.2980 0.6020 560.4000 0.5708 560.5980 0.5708 560.7000 0.5164 560.8980 0.5164 561.0000 0.5733 561.1980 0.5733 561.3000 0.5971 561.4980 0.5971 561.6000 0.9970 561.7980 0.9970 561.9000 0.4885 562.0980 0.4885 562.2000 0.8208 562.3980 0.8208 562.5000 0.7362 562.6980 0.7362 562.8000 1.0977 562.9980 1.0977 563.1000 0.6793 563.2980 0.6793 563.4000 1.1737 563.5980 1.1737 563.7000 0.8423 563.8980 0.8423 564.0000 0.4920 564.1980 0.4920 564.3000 1.0349 564.4980 1.0349 564.6000 0.5457 564.7980 0.5457 564.9000 0.7455 565.0980 0.7455 565.2000 0.9785 565.3980 0.9785 565.5000 0.4733 565.6980 0.4733 565.8000 0.4588 565.9980 0.4588 566.1000 0.9206 566.2980 0.9206 566.4000 0.9834 566.5980 0.9834 566.7000 0.5037 566.8980 0.5037 567.0000 0.9488 567.1980 0.9488 567.3000 0.4983 567.4980 0.4983 567.6000 0.6641 567.7980 0.6641 567.9000 0.5256 568.0980 0.5256 568.2000 0.9476 568.3980 0.9476 568.5000 0.4637 568.6980 0.4637 568.8000 0.5412 568.9980 0.5412 569.1000 0.5887 569.2980 0.5887 569.4000 0.5985 569.5980 0.5985 569.7000 0.5033 569.8980 0.5033 570.0000 0.5913 570.1980 0.5913 570.3000 0.6190 570.4980 0.6190 570.6000 0.5692 570.7980 0.5692 570.9000 0.5961 571.0980 0.5961 571.2000 0.6150 571.3980 0.6150 571.5000 0.5696 571.6980 0.5696 571.8000 0.6065 571.9980 0.6065 572.1000 0.6194 572.2980 0.6194 572.4000 0.5673 572.5980 0.5673 572.7000 0.6056 572.8980 0.6056 573.0000 0.5477 573.1980 0.5477 573.3000 0.5860 573.4980 0.5860 573.6000 0.5723 573.7980 0.5723 573.9000 0.6247 574.0980 0.6247 574.2000 0.5668 574.3980 0.5668 574.5000 0.5998 574.6980 0.5998 574.8000 0.5790 574.9980 0.5790 575.1000 0.6068 575.2980 0.6068 575.4000 0.5960 575.5980 0.5960 575.7000 0.6236 575.8980 0.6236 576.0000 0.5892 576.1980 0.5892 576.3000 0.6006 576.4980 0.6006 576.6000 0.5466 576.7980 0.5466 576.9000 0.5968 577.0980 0.5968 577.2000 0.5883 577.3980 0.5883 577.5000 0.6004 577.6980 0.6004 577.8000 0.5933 577.9980 0.5933 578.1000 0.5990 578.2980 0.5990 578.4000 0.6007 578.5980 0.6007 578.7000 0.6082 578.8980 0.6082 579.0000 0.5745 579.1980 0.5745 579.3000 0.5786 579.4980 0.5786 579.6000 0.5559 579.7980 0.5559 579.9000 0.6088 580.0980 0.6088 580.2000 0.5452 580.3980 0.5452 580.5000 0.5821 580.6980 0.5821 580.8000 0.5732 580.9980 0.5732 581.1000 0.6057 581.2980 0.6057 581.4000 0.8662 581.5980 0.8662 581.7000 0.6020 581.8980 0.6020 582.0000 0.5708 582.1980 0.5708 582.3000 0.5164 582.4980 0.5164 582.6000 0.5733 582.7980 0.5733 582.9000 0.5971 583.0980 0.5971 583.2000 0.9970 583.3980 0.9970 583.5000 0.4885 583.6980 0.4885 583.8000 0.8208 583.9980 0.8208 584.1000 0.7362 584.2980 0.7362 584.4000 1.0977 584.5980 1.0977 584.7000 0.6793 584.8980 0.6793 585.0000 1.1737 585.1980 1.1737 585.3000 0.8423 585.4980 0.8423 585.6000 0.4920 585.7980 0.4920 585.9000 1.0349 586.0980 1.0349 586.2000 0.5457 586.3980 0.5457 586.5000 0.7455 586.6980 0.7455 586.8000 0.9785 586.9980 0.9785 587.1000 0.4733 587.2980 0.4733 587.4000 0.4588 587.5980 0.4588 587.7000 0.9206 587.8980 0.9206 588.0000 0.9834 588.1980 0.9834 588.3000 0.5037 588.4980 0.5037 588.6000 0.9488 588.7980 0.9488 588.9000 0.4983 589.0980 0.4983 589.2000 0.6641 589.3980 0.6641 589.5000 0.5256 589.6980 0.5256 589.8000 0.9476 589.9980 0.9476 590.1000 0.4637 590.2980 0.4637 590.4000 0.5412 590.5980 0.5412 590.7000 0.5887 590.8980 0.5887 591.0000 0.5985 591.1980 0.5985 591.3000 0.5033 591.4980 0.5033 591.6000 0.5913 591.7980 0.5913 591.9000 0.6190 592.0980 0.6190 592.2000 0.5692 592.3980 0.5692 592.5000 0.5961 592.6980 0.5961 592.8000 0.6150 592.9980 0.6150 593.1000 0.5696 593.2980 0.5696 593.4000 0.6065 593.5980 0.6065 593.7000 0.6194 593.8980 0.6194 594.0000 0.5673 594.1980 0.5673 594.3000 0.6056 594.4980 0.6056 594.6000 0.5477 594.7980 0.5477 594.9000 0.5860 595.0980 0.5860 595.2000 0.5723 595.3980 0.5723 595.5000 0.6247 595.6980 0.6247 595.8000 0.5668 595.9980 0.5668 596.1000 0.5998 596.2980 0.5998 596.4000 0.5790 596.5980 0.5790 596.7000 0.6068 596.8980 0.6068 597.0000 0.5960 597.1980 0.5960 597.3000 0.6236 597.4980 0.6236 597.6000 0.5892 597.7980 0.5892 597.9000 0.6006 598.0980 0.6006 598.2000 0.5466 598.3980 0.5466 598.5000 0.5968 598.6980 0.5968 598.8000 0.5883 598.9980 0.5883 599.1000 0.6004 599.2980 0.6004 599.4000 0.5933 599.5980 0.5933 599.7000 0.5990 599.8980 0.5990 600.0000 0.5990)
Va9 a9 0 PWL(0.0000 0.8241 0.1980 0.8241 0.3000 1.1436 0.4980 1.1436 0.6000 1.4875 0.7980 1.4875 0.9000 1.6638 1.0980 1.6638 1.2000 1.0669 1.3980 1.0669 1.5000 1.4368 1.6980 1.4368 1.8000 0.8037 1.9980 0.8037 2.1000 1.7000 2.2980 1.7000 2.4000 1.5640 2.5980 1.5640 2.7000 1.1868 2.8980 1.1868 3.0000 1.7000 3.1980 1.7000 3.3000 1.0862 3.4980 1.0862 3.6000 1.0663 3.7980 1.0663 3.9000 1.5503 4.0980 1.5503 4.2000 1.3034 4.3980 1.3034 4.5000 1.4922 4.6980 1.4922 4.8000 1.1058 4.9980 1.1058 5.1000 1.4746 5.2980 1.4746 5.4000 1.3418 5.5980 1.3418 5.7000 1.6668 5.8980 1.6668 6.0000 1.5517 6.1980 1.5517 6.3000 1.3280 6.4980 1.3280 6.6000 0.9032 6.7980 0.9032 6.9000 1.7000 7.0980 1.7000 7.2000 1.6432 7.3980 1.6432 7.5000 0.6755 7.6980 0.6755 7.8000 1.7000 7.9980 1.7000 8.1000 1.6114 8.2980 1.6114 8.4000 1.6980 8.5980 1.6980 8.7000 1.6529 8.8980 1.6529 9.0000 0.8361 9.1980 0.8361 9.3000 1.6490 9.4980 1.6490 9.6000 1.6079 9.7980 1.6079 9.9000 1.7000 10.0980 1.7000 10.2000 0.6065 10.3980 0.6065 10.5000 1.5404 10.6980 1.5404 10.8000 1.0390 10.9980 1.0390 11.1000 1.7000 11.2980 1.7000 11.4000 1.2143 11.5980 1.2143 11.7000 1.7000 11.8980 1.7000 12.0000 1.1185 12.1980 1.1185 12.3000 1.7000 12.4980 1.7000 12.6000 1.7000 12.7980 1.7000 12.9000 1.6451 13.0980 1.6451 13.2000 0.8359 13.3980 0.8359 13.5000 1.6141 13.6980 1.6141 13.8000 0.7458 13.9980 0.7458 14.1000 1.7000 14.2980 1.7000 14.4000 0.6722 14.5980 0.6722 14.7000 1.2888 14.8980 1.2888 15.0000 0.5812 15.1980 0.5812 15.3000 0.7791 15.4980 0.7791 15.6000 0.7355 15.7980 0.7355 15.9000 0.9666 16.0980 0.9666 16.2000 0.5933 16.3980 0.5933 16.5000 0.8885 16.6980 0.8885 16.8000 0.6007 16.9980 0.6007 17.1000 0.6746 17.2980 0.6746 17.4000 0.9802 17.5980 0.9802 17.7000 0.8438 17.8980 0.8438 18.0000 1.3193 18.1980 1.3193 18.3000 0.9385 18.4980 0.9385 18.6000 1.0918 18.7980 1.0918 18.9000 0.9191 19.0980 0.9191 19.2000 1.1563 19.3980 1.1563 19.5000 0.9597 19.6980 0.9597 19.8000 0.8660 19.9980 0.8660 20.1000 0.6020 20.2980 0.6020 20.4000 0.9502 20.5980 0.9502 20.7000 0.5237 20.8980 0.5237 21.0000 0.8244 21.1980 0.8244 21.3000 0.5754 21.4980 0.5754 21.6000 0.8241 21.7980 0.8241 21.9000 1.1436 22.0980 1.1436 22.2000 1.4875 22.3980 1.4875 22.5000 1.6638 22.6980 1.6638 22.8000 1.0669 22.9980 1.0669 23.1000 1.4368 23.2980 1.4368 23.4000 0.8037 23.5980 0.8037 23.7000 1.7000 23.8980 1.7000 24.0000 1.5640 24.1980 1.5640 24.3000 1.1868 24.4980 1.1868 24.6000 1.7000 24.7980 1.7000 24.9000 1.0862 25.0980 1.0862 25.2000 1.0663 25.3980 1.0663 25.5000 1.5503 25.6980 1.5503 25.8000 1.3034 25.9980 1.3034 26.1000 1.4922 26.2980 1.4922 26.4000 1.1058 26.5980 1.1058 26.7000 1.4746 26.8980 1.4746 27.0000 1.3418 27.1980 1.3418 27.3000 1.6668 27.4980 1.6668 27.6000 1.5517 27.7980 1.5517 27.9000 1.3280 28.0980 1.3280 28.2000 0.9032 28.3980 0.9032 28.5000 1.7000 28.6980 1.7000 28.8000 1.6432 28.9980 1.6432 29.1000 0.6755 29.2980 0.6755 29.4000 1.7000 29.5980 1.7000 29.7000 1.6114 29.8980 1.6114 30.0000 1.6980 30.1980 1.6980 30.3000 1.6529 30.4980 1.6529 30.6000 0.8361 30.7980 0.8361 30.9000 1.6490 31.0980 1.6490 31.2000 1.6079 31.3980 1.6079 31.5000 1.7000 31.6980 1.7000 31.8000 0.6065 31.9980 0.6065 32.1000 1.5404 32.2980 1.5404 32.4000 1.0390 32.5980 1.0390 32.7000 1.7000 32.8980 1.7000 33.0000 1.2143 33.1980 1.2143 33.3000 1.7000 33.4980 1.7000 33.6000 1.1185 33.7980 1.1185 33.9000 1.7000 34.0980 1.7000 34.2000 1.7000 34.3980 1.7000 34.5000 1.6451 34.6980 1.6451 34.8000 0.8359 34.9980 0.8359 35.1000 1.6141 35.2980 1.6141 35.4000 0.7458 35.5980 0.7458 35.7000 1.7000 35.8980 1.7000 36.0000 0.6722 36.1980 0.6722 36.3000 1.2888 36.4980 1.2888 36.6000 0.5812 36.7980 0.5812 36.9000 0.7791 37.0980 0.7791 37.2000 0.7355 37.3980 0.7355 37.5000 0.9666 37.6980 0.9666 37.8000 0.5933 37.9980 0.5933 38.1000 0.8885 38.2980 0.8885 38.4000 0.6007 38.5980 0.6007 38.7000 0.6746 38.8980 0.6746 39.0000 0.9802 39.1980 0.9802 39.3000 0.8438 39.4980 0.8438 39.6000 1.3193 39.7980 1.3193 39.9000 0.9385 40.0980 0.9385 40.2000 1.0918 40.3980 1.0918 40.5000 0.9191 40.6980 0.9191 40.8000 1.1563 40.9980 1.1563 41.1000 0.9597 41.2980 0.9597 41.4000 0.8660 41.5980 0.8660 41.7000 0.6020 41.8980 0.6020 42.0000 0.9502 42.1980 0.9502 42.3000 0.5237 42.4980 0.5237 42.6000 0.8244 42.7980 0.8244 42.9000 0.5754 43.0980 0.5754 43.2000 0.8241 43.3980 0.8241 43.5000 1.1436 43.6980 1.1436 43.8000 1.4875 43.9980 1.4875 44.1000 1.6638 44.2980 1.6638 44.4000 1.0669 44.5980 1.0669 44.7000 1.4368 44.8980 1.4368 45.0000 0.8037 45.1980 0.8037 45.3000 1.7000 45.4980 1.7000 45.6000 1.5640 45.7980 1.5640 45.9000 1.1868 46.0980 1.1868 46.2000 1.7000 46.3980 1.7000 46.5000 1.0862 46.6980 1.0862 46.8000 1.0663 46.9980 1.0663 47.1000 1.5503 47.2980 1.5503 47.4000 1.3034 47.5980 1.3034 47.7000 1.4922 47.8980 1.4922 48.0000 1.1058 48.1980 1.1058 48.3000 1.4746 48.4980 1.4746 48.6000 1.3418 48.7980 1.3418 48.9000 1.6668 49.0980 1.6668 49.2000 1.5517 49.3980 1.5517 49.5000 1.3280 49.6980 1.3280 49.8000 0.9032 49.9980 0.9032 50.1000 1.7000 50.2980 1.7000 50.4000 1.6432 50.5980 1.6432 50.7000 0.6755 50.8980 0.6755 51.0000 1.7000 51.1980 1.7000 51.3000 1.6114 51.4980 1.6114 51.6000 1.6980 51.7980 1.6980 51.9000 1.6529 52.0980 1.6529 52.2000 0.8361 52.3980 0.8361 52.5000 1.6490 52.6980 1.6490 52.8000 1.6079 52.9980 1.6079 53.1000 1.7000 53.2980 1.7000 53.4000 0.6065 53.5980 0.6065 53.7000 1.5404 53.8980 1.5404 54.0000 1.0390 54.1980 1.0390 54.3000 1.7000 54.4980 1.7000 54.6000 1.2143 54.7980 1.2143 54.9000 1.7000 55.0980 1.7000 55.2000 1.1185 55.3980 1.1185 55.5000 1.7000 55.6980 1.7000 55.8000 1.7000 55.9980 1.7000 56.1000 1.6451 56.2980 1.6451 56.4000 0.8359 56.5980 0.8359 56.7000 1.6141 56.8980 1.6141 57.0000 0.7458 57.1980 0.7458 57.3000 1.7000 57.4980 1.7000 57.6000 0.6722 57.7980 0.6722 57.9000 1.2888 58.0980 1.2888 58.2000 0.5812 58.3980 0.5812 58.5000 0.7791 58.6980 0.7791 58.8000 0.7355 58.9980 0.7355 59.1000 0.9666 59.2980 0.9666 59.4000 0.5933 59.5980 0.5933 59.7000 0.8885 59.8980 0.8885 60.0000 0.6007 60.1980 0.6007 60.3000 0.6746 60.4980 0.6746 60.6000 0.9802 60.7980 0.9802 60.9000 0.8438 61.0980 0.8438 61.2000 1.3193 61.3980 1.3193 61.5000 0.9385 61.6980 0.9385 61.8000 1.0918 61.9980 1.0918 62.1000 0.9191 62.2980 0.9191 62.4000 1.1563 62.5980 1.1563 62.7000 0.9597 62.8980 0.9597 63.0000 0.8660 63.1980 0.8660 63.3000 0.6020 63.4980 0.6020 63.6000 0.9502 63.7980 0.9502 63.9000 0.5237 64.0980 0.5237 64.2000 0.8244 64.3980 0.8244 64.5000 0.5754 64.6980 0.5754 64.8000 0.8241 64.9980 0.8241 65.1000 1.1436 65.2980 1.1436 65.4000 1.4875 65.5980 1.4875 65.7000 1.6638 65.8980 1.6638 66.0000 1.0669 66.1980 1.0669 66.3000 1.4368 66.4980 1.4368 66.6000 0.8037 66.7980 0.8037 66.9000 1.7000 67.0980 1.7000 67.2000 1.5640 67.3980 1.5640 67.5000 1.1868 67.6980 1.1868 67.8000 1.7000 67.9980 1.7000 68.1000 1.0862 68.2980 1.0862 68.4000 1.0663 68.5980 1.0663 68.7000 1.5503 68.8980 1.5503 69.0000 1.3034 69.1980 1.3034 69.3000 1.4922 69.4980 1.4922 69.6000 1.1058 69.7980 1.1058 69.9000 1.4746 70.0980 1.4746 70.2000 1.3418 70.3980 1.3418 70.5000 1.6668 70.6980 1.6668 70.8000 1.5517 70.9980 1.5517 71.1000 1.3280 71.2980 1.3280 71.4000 0.9032 71.5980 0.9032 71.7000 1.7000 71.8980 1.7000 72.0000 1.6432 72.1980 1.6432 72.3000 0.6755 72.4980 0.6755 72.6000 1.7000 72.7980 1.7000 72.9000 1.6114 73.0980 1.6114 73.2000 1.6980 73.3980 1.6980 73.5000 1.6529 73.6980 1.6529 73.8000 0.8361 73.9980 0.8361 74.1000 1.6490 74.2980 1.6490 74.4000 1.6079 74.5980 1.6079 74.7000 1.7000 74.8980 1.7000 75.0000 0.6065 75.1980 0.6065 75.3000 1.5404 75.4980 1.5404 75.6000 1.0390 75.7980 1.0390 75.9000 1.7000 76.0980 1.7000 76.2000 1.2143 76.3980 1.2143 76.5000 1.7000 76.6980 1.7000 76.8000 1.1185 76.9980 1.1185 77.1000 1.7000 77.2980 1.7000 77.4000 1.7000 77.5980 1.7000 77.7000 1.6451 77.8980 1.6451 78.0000 0.8359 78.1980 0.8359 78.3000 1.6141 78.4980 1.6141 78.6000 0.7458 78.7980 0.7458 78.9000 1.7000 79.0980 1.7000 79.2000 0.6722 79.3980 0.6722 79.5000 1.2888 79.6980 1.2888 79.8000 0.5812 79.9980 0.5812 80.1000 0.7791 80.2980 0.7791 80.4000 0.7355 80.5980 0.7355 80.7000 0.9666 80.8980 0.9666 81.0000 0.5933 81.1980 0.5933 81.3000 0.8885 81.4980 0.8885 81.6000 0.6007 81.7980 0.6007 81.9000 0.6746 82.0980 0.6746 82.2000 0.9802 82.3980 0.9802 82.5000 0.8438 82.6980 0.8438 82.8000 1.3193 82.9980 1.3193 83.1000 0.9385 83.2980 0.9385 83.4000 1.0918 83.5980 1.0918 83.7000 0.9191 83.8980 0.9191 84.0000 1.1563 84.1980 1.1563 84.3000 0.9597 84.4980 0.9597 84.6000 0.8660 84.7980 0.8660 84.9000 0.6020 85.0980 0.6020 85.2000 0.9502 85.3980 0.9502 85.5000 0.5237 85.6980 0.5237 85.8000 0.8244 85.9980 0.8244 86.1000 0.5754 86.2980 0.5754 86.4000 0.8241 86.5980 0.8241 86.7000 1.1436 86.8980 1.1436 87.0000 1.4875 87.1980 1.4875 87.3000 1.6638 87.4980 1.6638 87.6000 1.0669 87.7980 1.0669 87.9000 1.4368 88.0980 1.4368 88.2000 0.8037 88.3980 0.8037 88.5000 1.7000 88.6980 1.7000 88.8000 1.5640 88.9980 1.5640 89.1000 1.1868 89.2980 1.1868 89.4000 1.7000 89.5980 1.7000 89.7000 1.0862 89.8980 1.0862 90.0000 1.0663 90.1980 1.0663 90.3000 1.5503 90.4980 1.5503 90.6000 1.3034 90.7980 1.3034 90.9000 1.4922 91.0980 1.4922 91.2000 1.1058 91.3980 1.1058 91.5000 1.4746 91.6980 1.4746 91.8000 1.3418 91.9980 1.3418 92.1000 1.6668 92.2980 1.6668 92.4000 1.5517 92.5980 1.5517 92.7000 1.3280 92.8980 1.3280 93.0000 0.9032 93.1980 0.9032 93.3000 1.7000 93.4980 1.7000 93.6000 1.6432 93.7980 1.6432 93.9000 0.6755 94.0980 0.6755 94.2000 1.7000 94.3980 1.7000 94.5000 1.6114 94.6980 1.6114 94.8000 1.6980 94.9980 1.6980 95.1000 1.6529 95.2980 1.6529 95.4000 0.8361 95.5980 0.8361 95.7000 1.6490 95.8980 1.6490 96.0000 1.6079 96.1980 1.6079 96.3000 1.7000 96.4980 1.7000 96.6000 0.6065 96.7980 0.6065 96.9000 1.5404 97.0980 1.5404 97.2000 1.0390 97.3980 1.0390 97.5000 1.7000 97.6980 1.7000 97.8000 1.2143 97.9980 1.2143 98.1000 1.7000 98.2980 1.7000 98.4000 1.1185 98.5980 1.1185 98.7000 1.7000 98.8980 1.7000 99.0000 1.7000 99.1980 1.7000 99.3000 1.6451 99.4980 1.6451 99.6000 0.8359 99.7980 0.8359 99.9000 1.6141 100.0980 1.6141 100.2000 0.7458 100.3980 0.7458 100.5000 1.7000 100.6980 1.7000 100.8000 0.6722 100.9980 0.6722 101.1000 1.2888 101.2980 1.2888 101.4000 0.5812 101.5980 0.5812 101.7000 0.7791 101.8980 0.7791 102.0000 0.7355 102.1980 0.7355 102.3000 0.9666 102.4980 0.9666 102.6000 0.5933 102.7980 0.5933 102.9000 0.8885 103.0980 0.8885 103.2000 0.6007 103.3980 0.6007 103.5000 0.6746 103.6980 0.6746 103.8000 0.9802 103.9980 0.9802 104.1000 0.8438 104.2980 0.8438 104.4000 1.3193 104.5980 1.3193 104.7000 0.9385 104.8980 0.9385 105.0000 1.0918 105.1980 1.0918 105.3000 0.9191 105.4980 0.9191 105.6000 1.1563 105.7980 1.1563 105.9000 0.9597 106.0980 0.9597 106.2000 0.8660 106.3980 0.8660 106.5000 0.6020 106.6980 0.6020 106.8000 0.9502 106.9980 0.9502 107.1000 0.5237 107.2980 0.5237 107.4000 0.8244 107.5980 0.8244 107.7000 0.5754 107.8980 0.5754 108.0000 0.8241 108.1980 0.8241 108.3000 1.1436 108.4980 1.1436 108.6000 1.4875 108.7980 1.4875 108.9000 1.6638 109.0980 1.6638 109.2000 1.0669 109.3980 1.0669 109.5000 1.4368 109.6980 1.4368 109.8000 0.8037 109.9980 0.8037 110.1000 1.7000 110.2980 1.7000 110.4000 1.5640 110.5980 1.5640 110.7000 1.1868 110.8980 1.1868 111.0000 1.7000 111.1980 1.7000 111.3000 1.0862 111.4980 1.0862 111.6000 1.0663 111.7980 1.0663 111.9000 1.5503 112.0980 1.5503 112.2000 1.3034 112.3980 1.3034 112.5000 1.4922 112.6980 1.4922 112.8000 1.1058 112.9980 1.1058 113.1000 1.4746 113.2980 1.4746 113.4000 1.3418 113.5980 1.3418 113.7000 1.6668 113.8980 1.6668 114.0000 1.5517 114.1980 1.5517 114.3000 1.3280 114.4980 1.3280 114.6000 0.9032 114.7980 0.9032 114.9000 1.7000 115.0980 1.7000 115.2000 1.6432 115.3980 1.6432 115.5000 0.6755 115.6980 0.6755 115.8000 1.7000 115.9980 1.7000 116.1000 1.6114 116.2980 1.6114 116.4000 1.6980 116.5980 1.6980 116.7000 1.6529 116.8980 1.6529 117.0000 0.8361 117.1980 0.8361 117.3000 1.6490 117.4980 1.6490 117.6000 1.6079 117.7980 1.6079 117.9000 1.7000 118.0980 1.7000 118.2000 0.6065 118.3980 0.6065 118.5000 1.5404 118.6980 1.5404 118.8000 1.0390 118.9980 1.0390 119.1000 1.7000 119.2980 1.7000 119.4000 1.2143 119.5980 1.2143 119.7000 1.7000 119.8980 1.7000 120.0000 1.1185 120.1980 1.1185 120.3000 1.7000 120.4980 1.7000 120.6000 1.7000 120.7980 1.7000 120.9000 1.6451 121.0980 1.6451 121.2000 0.8359 121.3980 0.8359 121.5000 1.6141 121.6980 1.6141 121.8000 0.7458 121.9980 0.7458 122.1000 1.7000 122.2980 1.7000 122.4000 0.6722 122.5980 0.6722 122.7000 1.2888 122.8980 1.2888 123.0000 0.5812 123.1980 0.5812 123.3000 0.7791 123.4980 0.7791 123.6000 0.7355 123.7980 0.7355 123.9000 0.9666 124.0980 0.9666 124.2000 0.5933 124.3980 0.5933 124.5000 0.8885 124.6980 0.8885 124.8000 0.6007 124.9980 0.6007 125.1000 0.6746 125.2980 0.6746 125.4000 0.9802 125.5980 0.9802 125.7000 0.8438 125.8980 0.8438 126.0000 1.3193 126.1980 1.3193 126.3000 0.9385 126.4980 0.9385 126.6000 1.0918 126.7980 1.0918 126.9000 0.9191 127.0980 0.9191 127.2000 1.1563 127.3980 1.1563 127.5000 0.9597 127.6980 0.9597 127.8000 0.8660 127.9980 0.8660 128.1000 0.6020 128.2980 0.6020 128.4000 0.9502 128.5980 0.9502 128.7000 0.5237 128.8980 0.5237 129.0000 0.8244 129.1980 0.8244 129.3000 0.5754 129.4980 0.5754 129.6000 0.8241 129.7980 0.8241 129.9000 1.1436 130.0980 1.1436 130.2000 1.4875 130.3980 1.4875 130.5000 1.6638 130.6980 1.6638 130.8000 1.0669 130.9980 1.0669 131.1000 1.4368 131.2980 1.4368 131.4000 0.8037 131.5980 0.8037 131.7000 1.7000 131.8980 1.7000 132.0000 1.5640 132.1980 1.5640 132.3000 1.1868 132.4980 1.1868 132.6000 1.7000 132.7980 1.7000 132.9000 1.0862 133.0980 1.0862 133.2000 1.0663 133.3980 1.0663 133.5000 1.5503 133.6980 1.5503 133.8000 1.3034 133.9980 1.3034 134.1000 1.4922 134.2980 1.4922 134.4000 1.1058 134.5980 1.1058 134.7000 1.4746 134.8980 1.4746 135.0000 1.3418 135.1980 1.3418 135.3000 1.6668 135.4980 1.6668 135.6000 1.5517 135.7980 1.5517 135.9000 1.3280 136.0980 1.3280 136.2000 0.9032 136.3980 0.9032 136.5000 1.7000 136.6980 1.7000 136.8000 1.6432 136.9980 1.6432 137.1000 0.6755 137.2980 0.6755 137.4000 1.7000 137.5980 1.7000 137.7000 1.6114 137.8980 1.6114 138.0000 1.6980 138.1980 1.6980 138.3000 1.6529 138.4980 1.6529 138.6000 0.8361 138.7980 0.8361 138.9000 1.6490 139.0980 1.6490 139.2000 1.6079 139.3980 1.6079 139.5000 1.7000 139.6980 1.7000 139.8000 0.6065 139.9980 0.6065 140.1000 1.5404 140.2980 1.5404 140.4000 1.0390 140.5980 1.0390 140.7000 1.7000 140.8980 1.7000 141.0000 1.2143 141.1980 1.2143 141.3000 1.7000 141.4980 1.7000 141.6000 1.1185 141.7980 1.1185 141.9000 1.7000 142.0980 1.7000 142.2000 1.7000 142.3980 1.7000 142.5000 1.6451 142.6980 1.6451 142.8000 0.8359 142.9980 0.8359 143.1000 1.6141 143.2980 1.6141 143.4000 0.7458 143.5980 0.7458 143.7000 1.7000 143.8980 1.7000 144.0000 0.6722 144.1980 0.6722 144.3000 1.2888 144.4980 1.2888 144.6000 0.5812 144.7980 0.5812 144.9000 0.7791 145.0980 0.7791 145.2000 0.7355 145.3980 0.7355 145.5000 0.9666 145.6980 0.9666 145.8000 0.5933 145.9980 0.5933 146.1000 0.8885 146.2980 0.8885 146.4000 0.6007 146.5980 0.6007 146.7000 0.6746 146.8980 0.6746 147.0000 0.9802 147.1980 0.9802 147.3000 0.8438 147.4980 0.8438 147.6000 1.3193 147.7980 1.3193 147.9000 0.9385 148.0980 0.9385 148.2000 1.0918 148.3980 1.0918 148.5000 0.9191 148.6980 0.9191 148.8000 1.1563 148.9980 1.1563 149.1000 0.9597 149.2980 0.9597 149.4000 0.8660 149.5980 0.8660 149.7000 0.6020 149.8980 0.6020 150.0000 0.9502 150.1980 0.9502 150.3000 0.5237 150.4980 0.5237 150.6000 0.8244 150.7980 0.8244 150.9000 0.5754 151.0980 0.5754 151.2000 0.8241 151.3980 0.8241 151.5000 1.1436 151.6980 1.1436 151.8000 1.4875 151.9980 1.4875 152.1000 1.6638 152.2980 1.6638 152.4000 1.0669 152.5980 1.0669 152.7000 1.4368 152.8980 1.4368 153.0000 0.8037 153.1980 0.8037 153.3000 1.7000 153.4980 1.7000 153.6000 1.5640 153.7980 1.5640 153.9000 1.1868 154.0980 1.1868 154.2000 1.7000 154.3980 1.7000 154.5000 1.0862 154.6980 1.0862 154.8000 1.0663 154.9980 1.0663 155.1000 1.5503 155.2980 1.5503 155.4000 1.3034 155.5980 1.3034 155.7000 1.4922 155.8980 1.4922 156.0000 1.1058 156.1980 1.1058 156.3000 1.4746 156.4980 1.4746 156.6000 1.3418 156.7980 1.3418 156.9000 1.6668 157.0980 1.6668 157.2000 1.5517 157.3980 1.5517 157.5000 1.3280 157.6980 1.3280 157.8000 0.9032 157.9980 0.9032 158.1000 1.7000 158.2980 1.7000 158.4000 1.6432 158.5980 1.6432 158.7000 0.6755 158.8980 0.6755 159.0000 1.7000 159.1980 1.7000 159.3000 1.6114 159.4980 1.6114 159.6000 1.6980 159.7980 1.6980 159.9000 1.6529 160.0980 1.6529 160.2000 0.8361 160.3980 0.8361 160.5000 1.6490 160.6980 1.6490 160.8000 1.6079 160.9980 1.6079 161.1000 1.7000 161.2980 1.7000 161.4000 0.6065 161.5980 0.6065 161.7000 1.5404 161.8980 1.5404 162.0000 1.0390 162.1980 1.0390 162.3000 1.7000 162.4980 1.7000 162.6000 1.2143 162.7980 1.2143 162.9000 1.7000 163.0980 1.7000 163.2000 1.1185 163.3980 1.1185 163.5000 1.7000 163.6980 1.7000 163.8000 1.7000 163.9980 1.7000 164.1000 1.6451 164.2980 1.6451 164.4000 0.8359 164.5980 0.8359 164.7000 1.6141 164.8980 1.6141 165.0000 0.7458 165.1980 0.7458 165.3000 1.7000 165.4980 1.7000 165.6000 0.6722 165.7980 0.6722 165.9000 1.2888 166.0980 1.2888 166.2000 0.5812 166.3980 0.5812 166.5000 0.7791 166.6980 0.7791 166.8000 0.7355 166.9980 0.7355 167.1000 0.9666 167.2980 0.9666 167.4000 0.5933 167.5980 0.5933 167.7000 0.8885 167.8980 0.8885 168.0000 0.6007 168.1980 0.6007 168.3000 0.6746 168.4980 0.6746 168.6000 0.9802 168.7980 0.9802 168.9000 0.8438 169.0980 0.8438 169.2000 1.3193 169.3980 1.3193 169.5000 0.9385 169.6980 0.9385 169.8000 1.0918 169.9980 1.0918 170.1000 0.9191 170.2980 0.9191 170.4000 1.1563 170.5980 1.1563 170.7000 0.9597 170.8980 0.9597 171.0000 0.8660 171.1980 0.8660 171.3000 0.6020 171.4980 0.6020 171.6000 0.9502 171.7980 0.9502 171.9000 0.5237 172.0980 0.5237 172.2000 0.8244 172.3980 0.8244 172.5000 0.5754 172.6980 0.5754 172.8000 0.8241 172.9980 0.8241 173.1000 1.1436 173.2980 1.1436 173.4000 1.4875 173.5980 1.4875 173.7000 1.6638 173.8980 1.6638 174.0000 1.0669 174.1980 1.0669 174.3000 1.4368 174.4980 1.4368 174.6000 0.8037 174.7980 0.8037 174.9000 1.7000 175.0980 1.7000 175.2000 1.5640 175.3980 1.5640 175.5000 1.1868 175.6980 1.1868 175.8000 1.7000 175.9980 1.7000 176.1000 1.0862 176.2980 1.0862 176.4000 1.0663 176.5980 1.0663 176.7000 1.5503 176.8980 1.5503 177.0000 1.3034 177.1980 1.3034 177.3000 1.4922 177.4980 1.4922 177.6000 1.1058 177.7980 1.1058 177.9000 1.4746 178.0980 1.4746 178.2000 1.3418 178.3980 1.3418 178.5000 1.6668 178.6980 1.6668 178.8000 1.5517 178.9980 1.5517 179.1000 1.3280 179.2980 1.3280 179.4000 0.9032 179.5980 0.9032 179.7000 1.7000 179.8980 1.7000 180.0000 1.6432 180.1980 1.6432 180.3000 0.6755 180.4980 0.6755 180.6000 1.7000 180.7980 1.7000 180.9000 1.6114 181.0980 1.6114 181.2000 1.6980 181.3980 1.6980 181.5000 1.6529 181.6980 1.6529 181.8000 0.8361 181.9980 0.8361 182.1000 1.6490 182.2980 1.6490 182.4000 1.6079 182.5980 1.6079 182.7000 1.7000 182.8980 1.7000 183.0000 0.6065 183.1980 0.6065 183.3000 1.5404 183.4980 1.5404 183.6000 1.0390 183.7980 1.0390 183.9000 1.7000 184.0980 1.7000 184.2000 1.2143 184.3980 1.2143 184.5000 1.7000 184.6980 1.7000 184.8000 1.1185 184.9980 1.1185 185.1000 1.7000 185.2980 1.7000 185.4000 1.7000 185.5980 1.7000 185.7000 1.6451 185.8980 1.6451 186.0000 0.8359 186.1980 0.8359 186.3000 1.6141 186.4980 1.6141 186.6000 0.7458 186.7980 0.7458 186.9000 1.7000 187.0980 1.7000 187.2000 0.6722 187.3980 0.6722 187.5000 1.2888 187.6980 1.2888 187.8000 0.5812 187.9980 0.5812 188.1000 0.7791 188.2980 0.7791 188.4000 0.7355 188.5980 0.7355 188.7000 0.9666 188.8980 0.9666 189.0000 0.5933 189.1980 0.5933 189.3000 0.8885 189.4980 0.8885 189.6000 0.6007 189.7980 0.6007 189.9000 0.6746 190.0980 0.6746 190.2000 0.9802 190.3980 0.9802 190.5000 0.8438 190.6980 0.8438 190.8000 1.3193 190.9980 1.3193 191.1000 0.9385 191.2980 0.9385 191.4000 1.0918 191.5980 1.0918 191.7000 0.9191 191.8980 0.9191 192.0000 1.1563 192.1980 1.1563 192.3000 0.9597 192.4980 0.9597 192.6000 0.8660 192.7980 0.8660 192.9000 0.6020 193.0980 0.6020 193.2000 0.9502 193.3980 0.9502 193.5000 0.5237 193.6980 0.5237 193.8000 0.8244 193.9980 0.8244 194.1000 0.5754 194.2980 0.5754 194.4000 0.8241 194.5980 0.8241 194.7000 1.1436 194.8980 1.1436 195.0000 1.4875 195.1980 1.4875 195.3000 1.6638 195.4980 1.6638 195.6000 1.0669 195.7980 1.0669 195.9000 1.4368 196.0980 1.4368 196.2000 0.8037 196.3980 0.8037 196.5000 1.7000 196.6980 1.7000 196.8000 1.5640 196.9980 1.5640 197.1000 1.1868 197.2980 1.1868 197.4000 1.7000 197.5980 1.7000 197.7000 1.0862 197.8980 1.0862 198.0000 1.0663 198.1980 1.0663 198.3000 1.5503 198.4980 1.5503 198.6000 1.3034 198.7980 1.3034 198.9000 1.4922 199.0980 1.4922 199.2000 1.1058 199.3980 1.1058 199.5000 1.4746 199.6980 1.4746 199.8000 1.3418 199.9980 1.3418 200.1000 1.6668 200.2980 1.6668 200.4000 1.5517 200.5980 1.5517 200.7000 1.3280 200.8980 1.3280 201.0000 0.9032 201.1980 0.9032 201.3000 1.7000 201.4980 1.7000 201.6000 1.6432 201.7980 1.6432 201.9000 0.6755 202.0980 0.6755 202.2000 1.7000 202.3980 1.7000 202.5000 1.6114 202.6980 1.6114 202.8000 1.6980 202.9980 1.6980 203.1000 1.6529 203.2980 1.6529 203.4000 0.8361 203.5980 0.8361 203.7000 1.6490 203.8980 1.6490 204.0000 1.6079 204.1980 1.6079 204.3000 1.7000 204.4980 1.7000 204.6000 0.6065 204.7980 0.6065 204.9000 1.5404 205.0980 1.5404 205.2000 1.0390 205.3980 1.0390 205.5000 1.7000 205.6980 1.7000 205.8000 1.2143 205.9980 1.2143 206.1000 1.7000 206.2980 1.7000 206.4000 1.1185 206.5980 1.1185 206.7000 1.7000 206.8980 1.7000 207.0000 1.7000 207.1980 1.7000 207.3000 1.6451 207.4980 1.6451 207.6000 0.8359 207.7980 0.8359 207.9000 1.6141 208.0980 1.6141 208.2000 0.7458 208.3980 0.7458 208.5000 1.7000 208.6980 1.7000 208.8000 0.6722 208.9980 0.6722 209.1000 1.2888 209.2980 1.2888 209.4000 0.5812 209.5980 0.5812 209.7000 0.7791 209.8980 0.7791 210.0000 0.7355 210.1980 0.7355 210.3000 0.9666 210.4980 0.9666 210.6000 0.5933 210.7980 0.5933 210.9000 0.8885 211.0980 0.8885 211.2000 0.6007 211.3980 0.6007 211.5000 0.6746 211.6980 0.6746 211.8000 0.9802 211.9980 0.9802 212.1000 0.8438 212.2980 0.8438 212.4000 1.3193 212.5980 1.3193 212.7000 0.9385 212.8980 0.9385 213.0000 1.0918 213.1980 1.0918 213.3000 0.9191 213.4980 0.9191 213.6000 1.1563 213.7980 1.1563 213.9000 0.9597 214.0980 0.9597 214.2000 0.8660 214.3980 0.8660 214.5000 0.6020 214.6980 0.6020 214.8000 0.9502 214.9980 0.9502 215.1000 0.5237 215.2980 0.5237 215.4000 0.8244 215.5980 0.8244 215.7000 0.5754 215.8980 0.5754 216.0000 0.8241 216.1980 0.8241 216.3000 1.1436 216.4980 1.1436 216.6000 1.4875 216.7980 1.4875 216.9000 1.6638 217.0980 1.6638 217.2000 1.0669 217.3980 1.0669 217.5000 1.4368 217.6980 1.4368 217.8000 0.8037 217.9980 0.8037 218.1000 1.7000 218.2980 1.7000 218.4000 1.5640 218.5980 1.5640 218.7000 1.1868 218.8980 1.1868 219.0000 1.7000 219.1980 1.7000 219.3000 1.0862 219.4980 1.0862 219.6000 1.0663 219.7980 1.0663 219.9000 1.5503 220.0980 1.5503 220.2000 1.3034 220.3980 1.3034 220.5000 1.4922 220.6980 1.4922 220.8000 1.1058 220.9980 1.1058 221.1000 1.4746 221.2980 1.4746 221.4000 1.3418 221.5980 1.3418 221.7000 1.6668 221.8980 1.6668 222.0000 1.5517 222.1980 1.5517 222.3000 1.3280 222.4980 1.3280 222.6000 0.9032 222.7980 0.9032 222.9000 1.7000 223.0980 1.7000 223.2000 1.6432 223.3980 1.6432 223.5000 0.6755 223.6980 0.6755 223.8000 1.7000 223.9980 1.7000 224.1000 1.6114 224.2980 1.6114 224.4000 1.6980 224.5980 1.6980 224.7000 1.6529 224.8980 1.6529 225.0000 0.8361 225.1980 0.8361 225.3000 1.6490 225.4980 1.6490 225.6000 1.6079 225.7980 1.6079 225.9000 1.7000 226.0980 1.7000 226.2000 0.6065 226.3980 0.6065 226.5000 1.5404 226.6980 1.5404 226.8000 1.0390 226.9980 1.0390 227.1000 1.7000 227.2980 1.7000 227.4000 1.2143 227.5980 1.2143 227.7000 1.7000 227.8980 1.7000 228.0000 1.1185 228.1980 1.1185 228.3000 1.7000 228.4980 1.7000 228.6000 1.7000 228.7980 1.7000 228.9000 1.6451 229.0980 1.6451 229.2000 0.8359 229.3980 0.8359 229.5000 1.6141 229.6980 1.6141 229.8000 0.7458 229.9980 0.7458 230.1000 1.7000 230.2980 1.7000 230.4000 0.6722 230.5980 0.6722 230.7000 1.2888 230.8980 1.2888 231.0000 0.5812 231.1980 0.5812 231.3000 0.7791 231.4980 0.7791 231.6000 0.7355 231.7980 0.7355 231.9000 0.9666 232.0980 0.9666 232.2000 0.5933 232.3980 0.5933 232.5000 0.8885 232.6980 0.8885 232.8000 0.6007 232.9980 0.6007 233.1000 0.6746 233.2980 0.6746 233.4000 0.9802 233.5980 0.9802 233.7000 0.8438 233.8980 0.8438 234.0000 1.3193 234.1980 1.3193 234.3000 0.9385 234.4980 0.9385 234.6000 1.0918 234.7980 1.0918 234.9000 0.9191 235.0980 0.9191 235.2000 1.1563 235.3980 1.1563 235.5000 0.9597 235.6980 0.9597 235.8000 0.8660 235.9980 0.8660 236.1000 0.6020 236.2980 0.6020 236.4000 0.9502 236.5980 0.9502 236.7000 0.5237 236.8980 0.5237 237.0000 0.8244 237.1980 0.8244 237.3000 0.5754 237.4980 0.5754 237.6000 0.8241 237.7980 0.8241 237.9000 1.1436 238.0980 1.1436 238.2000 1.4875 238.3980 1.4875 238.5000 1.6638 238.6980 1.6638 238.8000 1.0669 238.9980 1.0669 239.1000 1.4368 239.2980 1.4368 239.4000 0.8037 239.5980 0.8037 239.7000 1.7000 239.8980 1.7000 240.0000 1.5640 240.1980 1.5640 240.3000 1.1868 240.4980 1.1868 240.6000 1.7000 240.7980 1.7000 240.9000 1.0862 241.0980 1.0862 241.2000 1.0663 241.3980 1.0663 241.5000 1.5503 241.6980 1.5503 241.8000 1.3034 241.9980 1.3034 242.1000 1.4922 242.2980 1.4922 242.4000 1.1058 242.5980 1.1058 242.7000 1.4746 242.8980 1.4746 243.0000 1.3418 243.1980 1.3418 243.3000 1.6668 243.4980 1.6668 243.6000 1.5517 243.7980 1.5517 243.9000 1.3280 244.0980 1.3280 244.2000 0.9032 244.3980 0.9032 244.5000 1.7000 244.6980 1.7000 244.8000 1.6432 244.9980 1.6432 245.1000 0.6755 245.2980 0.6755 245.4000 1.7000 245.5980 1.7000 245.7000 1.6114 245.8980 1.6114 246.0000 1.6980 246.1980 1.6980 246.3000 1.6529 246.4980 1.6529 246.6000 0.8361 246.7980 0.8361 246.9000 1.6490 247.0980 1.6490 247.2000 1.6079 247.3980 1.6079 247.5000 1.7000 247.6980 1.7000 247.8000 0.6065 247.9980 0.6065 248.1000 1.5404 248.2980 1.5404 248.4000 1.0390 248.5980 1.0390 248.7000 1.7000 248.8980 1.7000 249.0000 1.2143 249.1980 1.2143 249.3000 1.7000 249.4980 1.7000 249.6000 1.1185 249.7980 1.1185 249.9000 1.7000 250.0980 1.7000 250.2000 1.7000 250.3980 1.7000 250.5000 1.6451 250.6980 1.6451 250.8000 0.8359 250.9980 0.8359 251.1000 1.6141 251.2980 1.6141 251.4000 0.7458 251.5980 0.7458 251.7000 1.7000 251.8980 1.7000 252.0000 0.6722 252.1980 0.6722 252.3000 1.2888 252.4980 1.2888 252.6000 0.5812 252.7980 0.5812 252.9000 0.7791 253.0980 0.7791 253.2000 0.7355 253.3980 0.7355 253.5000 0.9666 253.6980 0.9666 253.8000 0.5933 253.9980 0.5933 254.1000 0.8885 254.2980 0.8885 254.4000 0.6007 254.5980 0.6007 254.7000 0.6746 254.8980 0.6746 255.0000 0.9802 255.1980 0.9802 255.3000 0.8438 255.4980 0.8438 255.6000 1.3193 255.7980 1.3193 255.9000 0.9385 256.0980 0.9385 256.2000 1.0918 256.3980 1.0918 256.5000 0.9191 256.6980 0.9191 256.8000 1.1563 256.9980 1.1563 257.1000 0.9597 257.2980 0.9597 257.4000 0.8660 257.5980 0.8660 257.7000 0.6020 257.8980 0.6020 258.0000 0.9502 258.1980 0.9502 258.3000 0.5237 258.4980 0.5237 258.6000 0.8244 258.7980 0.8244 258.9000 0.5754 259.0980 0.5754 259.2000 0.8241 259.3980 0.8241 259.5000 1.1436 259.6980 1.1436 259.8000 1.4875 259.9980 1.4875 260.1000 1.6638 260.2980 1.6638 260.4000 1.0669 260.5980 1.0669 260.7000 1.4368 260.8980 1.4368 261.0000 0.8037 261.1980 0.8037 261.3000 1.7000 261.4980 1.7000 261.6000 1.5640 261.7980 1.5640 261.9000 1.1868 262.0980 1.1868 262.2000 1.7000 262.3980 1.7000 262.5000 1.0862 262.6980 1.0862 262.8000 1.0663 262.9980 1.0663 263.1000 1.5503 263.2980 1.5503 263.4000 1.3034 263.5980 1.3034 263.7000 1.4922 263.8980 1.4922 264.0000 1.1058 264.1980 1.1058 264.3000 1.4746 264.4980 1.4746 264.6000 1.3418 264.7980 1.3418 264.9000 1.6668 265.0980 1.6668 265.2000 1.5517 265.3980 1.5517 265.5000 1.3280 265.6980 1.3280 265.8000 0.9032 265.9980 0.9032 266.1000 1.7000 266.2980 1.7000 266.4000 1.6432 266.5980 1.6432 266.7000 0.6755 266.8980 0.6755 267.0000 1.7000 267.1980 1.7000 267.3000 1.6114 267.4980 1.6114 267.6000 1.6980 267.7980 1.6980 267.9000 1.6529 268.0980 1.6529 268.2000 0.8361 268.3980 0.8361 268.5000 1.6490 268.6980 1.6490 268.8000 1.6079 268.9980 1.6079 269.1000 1.7000 269.2980 1.7000 269.4000 0.6065 269.5980 0.6065 269.7000 1.5404 269.8980 1.5404 270.0000 1.0390 270.1980 1.0390 270.3000 1.7000 270.4980 1.7000 270.6000 1.2143 270.7980 1.2143 270.9000 1.7000 271.0980 1.7000 271.2000 1.1185 271.3980 1.1185 271.5000 1.7000 271.6980 1.7000 271.8000 1.7000 271.9980 1.7000 272.1000 1.6451 272.2980 1.6451 272.4000 0.8359 272.5980 0.8359 272.7000 1.6141 272.8980 1.6141 273.0000 0.7458 273.1980 0.7458 273.3000 1.7000 273.4980 1.7000 273.6000 0.6722 273.7980 0.6722 273.9000 1.2888 274.0980 1.2888 274.2000 0.5812 274.3980 0.5812 274.5000 0.7791 274.6980 0.7791 274.8000 0.7355 274.9980 0.7355 275.1000 0.9666 275.2980 0.9666 275.4000 0.5933 275.5980 0.5933 275.7000 0.8885 275.8980 0.8885 276.0000 0.6007 276.1980 0.6007 276.3000 0.6746 276.4980 0.6746 276.6000 0.9802 276.7980 0.9802 276.9000 0.8438 277.0980 0.8438 277.2000 1.3193 277.3980 1.3193 277.5000 0.9385 277.6980 0.9385 277.8000 1.0918 277.9980 1.0918 278.1000 0.9191 278.2980 0.9191 278.4000 1.1563 278.5980 1.1563 278.7000 0.9597 278.8980 0.9597 279.0000 0.8660 279.1980 0.8660 279.3000 0.6020 279.4980 0.6020 279.6000 0.9502 279.7980 0.9502 279.9000 0.5237 280.0980 0.5237 280.2000 0.8244 280.3980 0.8244 280.5000 0.5754 280.6980 0.5754 280.8000 0.8241 280.9980 0.8241 281.1000 1.1436 281.2980 1.1436 281.4000 1.4875 281.5980 1.4875 281.7000 1.6638 281.8980 1.6638 282.0000 1.0669 282.1980 1.0669 282.3000 1.4368 282.4980 1.4368 282.6000 0.8037 282.7980 0.8037 282.9000 1.7000 283.0980 1.7000 283.2000 1.5640 283.3980 1.5640 283.5000 1.1868 283.6980 1.1868 283.8000 1.7000 283.9980 1.7000 284.1000 1.0862 284.2980 1.0862 284.4000 1.0663 284.5980 1.0663 284.7000 1.5503 284.8980 1.5503 285.0000 1.3034 285.1980 1.3034 285.3000 1.4922 285.4980 1.4922 285.6000 1.1058 285.7980 1.1058 285.9000 1.4746 286.0980 1.4746 286.2000 1.3418 286.3980 1.3418 286.5000 1.6668 286.6980 1.6668 286.8000 1.5517 286.9980 1.5517 287.1000 1.3280 287.2980 1.3280 287.4000 0.9032 287.5980 0.9032 287.7000 1.7000 287.8980 1.7000 288.0000 1.6432 288.1980 1.6432 288.3000 0.6755 288.4980 0.6755 288.6000 1.7000 288.7980 1.7000 288.9000 1.6114 289.0980 1.6114 289.2000 1.6980 289.3980 1.6980 289.5000 1.6529 289.6980 1.6529 289.8000 0.8361 289.9980 0.8361 290.1000 1.6490 290.2980 1.6490 290.4000 1.6079 290.5980 1.6079 290.7000 1.7000 290.8980 1.7000 291.0000 0.6065 291.1980 0.6065 291.3000 1.5404 291.4980 1.5404 291.6000 1.0390 291.7980 1.0390 291.9000 1.7000 292.0980 1.7000 292.2000 1.2143 292.3980 1.2143 292.5000 1.7000 292.6980 1.7000 292.8000 1.1185 292.9980 1.1185 293.1000 1.7000 293.2980 1.7000 293.4000 1.7000 293.5980 1.7000 293.7000 1.6451 293.8980 1.6451 294.0000 0.8359 294.1980 0.8359 294.3000 1.6141 294.4980 1.6141 294.6000 0.7458 294.7980 0.7458 294.9000 1.7000 295.0980 1.7000 295.2000 0.6722 295.3980 0.6722 295.5000 1.2888 295.6980 1.2888 295.8000 0.5812 295.9980 0.5812 296.1000 0.7791 296.2980 0.7791 296.4000 0.7355 296.5980 0.7355 296.7000 0.9666 296.8980 0.9666 297.0000 0.5933 297.1980 0.5933 297.3000 0.8885 297.4980 0.8885 297.6000 0.6007 297.7980 0.6007 297.9000 0.6746 298.0980 0.6746 298.2000 0.9802 298.3980 0.9802 298.5000 0.8438 298.6980 0.8438 298.8000 1.3193 298.9980 1.3193 299.1000 0.9385 299.2980 0.9385 299.4000 1.0918 299.5980 1.0918 299.7000 0.9191 299.8980 0.9191 300.0000 1.1563 300.1980 1.1563 300.3000 0.9597 300.4980 0.9597 300.6000 0.8660 300.7980 0.8660 300.9000 0.6020 301.0980 0.6020 301.2000 0.9502 301.3980 0.9502 301.5000 0.5237 301.6980 0.5237 301.8000 0.8244 301.9980 0.8244 302.1000 0.5754 302.2980 0.5754 302.4000 0.8241 302.5980 0.8241 302.7000 1.1436 302.8980 1.1436 303.0000 1.4875 303.1980 1.4875 303.3000 1.6638 303.4980 1.6638 303.6000 1.0669 303.7980 1.0669 303.9000 1.4368 304.0980 1.4368 304.2000 0.8037 304.3980 0.8037 304.5000 1.7000 304.6980 1.7000 304.8000 1.5640 304.9980 1.5640 305.1000 1.1868 305.2980 1.1868 305.4000 1.7000 305.5980 1.7000 305.7000 1.0862 305.8980 1.0862 306.0000 1.0663 306.1980 1.0663 306.3000 1.5503 306.4980 1.5503 306.6000 1.3034 306.7980 1.3034 306.9000 1.4922 307.0980 1.4922 307.2000 1.1058 307.3980 1.1058 307.5000 1.4746 307.6980 1.4746 307.8000 1.3418 307.9980 1.3418 308.1000 1.6668 308.2980 1.6668 308.4000 1.5517 308.5980 1.5517 308.7000 1.3280 308.8980 1.3280 309.0000 0.9032 309.1980 0.9032 309.3000 1.7000 309.4980 1.7000 309.6000 1.6432 309.7980 1.6432 309.9000 0.6755 310.0980 0.6755 310.2000 1.7000 310.3980 1.7000 310.5000 1.6114 310.6980 1.6114 310.8000 1.6980 310.9980 1.6980 311.1000 1.6529 311.2980 1.6529 311.4000 0.8361 311.5980 0.8361 311.7000 1.6490 311.8980 1.6490 312.0000 1.6079 312.1980 1.6079 312.3000 1.7000 312.4980 1.7000 312.6000 0.6065 312.7980 0.6065 312.9000 1.5404 313.0980 1.5404 313.2000 1.0390 313.3980 1.0390 313.5000 1.7000 313.6980 1.7000 313.8000 1.2143 313.9980 1.2143 314.1000 1.7000 314.2980 1.7000 314.4000 1.1185 314.5980 1.1185 314.7000 1.7000 314.8980 1.7000 315.0000 1.7000 315.1980 1.7000 315.3000 1.6451 315.4980 1.6451 315.6000 0.8359 315.7980 0.8359 315.9000 1.6141 316.0980 1.6141 316.2000 0.7458 316.3980 0.7458 316.5000 1.7000 316.6980 1.7000 316.8000 0.6722 316.9980 0.6722 317.1000 1.2888 317.2980 1.2888 317.4000 0.5812 317.5980 0.5812 317.7000 0.7791 317.8980 0.7791 318.0000 0.7355 318.1980 0.7355 318.3000 0.9666 318.4980 0.9666 318.6000 0.5933 318.7980 0.5933 318.9000 0.8885 319.0980 0.8885 319.2000 0.6007 319.3980 0.6007 319.5000 0.6746 319.6980 0.6746 319.8000 0.9802 319.9980 0.9802 320.1000 0.8438 320.2980 0.8438 320.4000 1.3193 320.5980 1.3193 320.7000 0.9385 320.8980 0.9385 321.0000 1.0918 321.1980 1.0918 321.3000 0.9191 321.4980 0.9191 321.6000 1.1563 321.7980 1.1563 321.9000 0.9597 322.0980 0.9597 322.2000 0.8660 322.3980 0.8660 322.5000 0.6020 322.6980 0.6020 322.8000 0.9502 322.9980 0.9502 323.1000 0.5237 323.2980 0.5237 323.4000 0.8244 323.5980 0.8244 323.7000 0.5754 323.8980 0.5754 324.0000 0.8241 324.1980 0.8241 324.3000 1.1436 324.4980 1.1436 324.6000 1.4875 324.7980 1.4875 324.9000 1.6638 325.0980 1.6638 325.2000 1.0669 325.3980 1.0669 325.5000 1.4368 325.6980 1.4368 325.8000 0.8037 325.9980 0.8037 326.1000 1.7000 326.2980 1.7000 326.4000 1.5640 326.5980 1.5640 326.7000 1.1868 326.8980 1.1868 327.0000 1.7000 327.1980 1.7000 327.3000 1.0862 327.4980 1.0862 327.6000 1.0663 327.7980 1.0663 327.9000 1.5503 328.0980 1.5503 328.2000 1.3034 328.3980 1.3034 328.5000 1.4922 328.6980 1.4922 328.8000 1.1058 328.9980 1.1058 329.1000 1.4746 329.2980 1.4746 329.4000 1.3418 329.5980 1.3418 329.7000 1.6668 329.8980 1.6668 330.0000 1.5517 330.1980 1.5517 330.3000 1.3280 330.4980 1.3280 330.6000 0.9032 330.7980 0.9032 330.9000 1.7000 331.0980 1.7000 331.2000 1.6432 331.3980 1.6432 331.5000 0.6755 331.6980 0.6755 331.8000 1.7000 331.9980 1.7000 332.1000 1.6114 332.2980 1.6114 332.4000 1.6980 332.5980 1.6980 332.7000 1.6529 332.8980 1.6529 333.0000 0.8361 333.1980 0.8361 333.3000 1.6490 333.4980 1.6490 333.6000 1.6079 333.7980 1.6079 333.9000 1.7000 334.0980 1.7000 334.2000 0.6065 334.3980 0.6065 334.5000 1.5404 334.6980 1.5404 334.8000 1.0390 334.9980 1.0390 335.1000 1.7000 335.2980 1.7000 335.4000 1.2143 335.5980 1.2143 335.7000 1.7000 335.8980 1.7000 336.0000 1.1185 336.1980 1.1185 336.3000 1.7000 336.4980 1.7000 336.6000 1.7000 336.7980 1.7000 336.9000 1.6451 337.0980 1.6451 337.2000 0.8359 337.3980 0.8359 337.5000 1.6141 337.6980 1.6141 337.8000 0.7458 337.9980 0.7458 338.1000 1.7000 338.2980 1.7000 338.4000 0.6722 338.5980 0.6722 338.7000 1.2888 338.8980 1.2888 339.0000 0.5812 339.1980 0.5812 339.3000 0.7791 339.4980 0.7791 339.6000 0.7355 339.7980 0.7355 339.9000 0.9666 340.0980 0.9666 340.2000 0.5933 340.3980 0.5933 340.5000 0.8885 340.6980 0.8885 340.8000 0.6007 340.9980 0.6007 341.1000 0.6746 341.2980 0.6746 341.4000 0.9802 341.5980 0.9802 341.7000 0.8438 341.8980 0.8438 342.0000 1.3193 342.1980 1.3193 342.3000 0.9385 342.4980 0.9385 342.6000 1.0918 342.7980 1.0918 342.9000 0.9191 343.0980 0.9191 343.2000 1.1563 343.3980 1.1563 343.5000 0.9597 343.6980 0.9597 343.8000 0.8660 343.9980 0.8660 344.1000 0.6020 344.2980 0.6020 344.4000 0.9502 344.5980 0.9502 344.7000 0.5237 344.8980 0.5237 345.0000 0.8244 345.1980 0.8244 345.3000 0.5754 345.4980 0.5754 345.6000 0.8241 345.7980 0.8241 345.9000 1.1436 346.0980 1.1436 346.2000 1.4875 346.3980 1.4875 346.5000 1.6638 346.6980 1.6638 346.8000 1.0669 346.9980 1.0669 347.1000 1.4368 347.2980 1.4368 347.4000 0.8037 347.5980 0.8037 347.7000 1.7000 347.8980 1.7000 348.0000 1.5640 348.1980 1.5640 348.3000 1.1868 348.4980 1.1868 348.6000 1.7000 348.7980 1.7000 348.9000 1.0862 349.0980 1.0862 349.2000 1.0663 349.3980 1.0663 349.5000 1.5503 349.6980 1.5503 349.8000 1.3034 349.9980 1.3034 350.1000 1.4922 350.2980 1.4922 350.4000 1.1058 350.5980 1.1058 350.7000 1.4746 350.8980 1.4746 351.0000 1.3418 351.1980 1.3418 351.3000 1.6668 351.4980 1.6668 351.6000 1.5517 351.7980 1.5517 351.9000 1.3280 352.0980 1.3280 352.2000 0.9032 352.3980 0.9032 352.5000 1.7000 352.6980 1.7000 352.8000 1.6432 352.9980 1.6432 353.1000 0.6755 353.2980 0.6755 353.4000 1.7000 353.5980 1.7000 353.7000 1.6114 353.8980 1.6114 354.0000 1.6980 354.1980 1.6980 354.3000 1.6529 354.4980 1.6529 354.6000 0.8361 354.7980 0.8361 354.9000 1.6490 355.0980 1.6490 355.2000 1.6079 355.3980 1.6079 355.5000 1.7000 355.6980 1.7000 355.8000 0.6065 355.9980 0.6065 356.1000 1.5404 356.2980 1.5404 356.4000 1.0390 356.5980 1.0390 356.7000 1.7000 356.8980 1.7000 357.0000 1.2143 357.1980 1.2143 357.3000 1.7000 357.4980 1.7000 357.6000 1.1185 357.7980 1.1185 357.9000 1.7000 358.0980 1.7000 358.2000 1.7000 358.3980 1.7000 358.5000 1.6451 358.6980 1.6451 358.8000 0.8359 358.9980 0.8359 359.1000 1.6141 359.2980 1.6141 359.4000 0.7458 359.5980 0.7458 359.7000 1.7000 359.8980 1.7000 360.0000 0.6722 360.1980 0.6722 360.3000 1.2888 360.4980 1.2888 360.6000 0.5812 360.7980 0.5812 360.9000 0.7791 361.0980 0.7791 361.2000 0.7355 361.3980 0.7355 361.5000 0.9666 361.6980 0.9666 361.8000 0.5933 361.9980 0.5933 362.1000 0.8885 362.2980 0.8885 362.4000 0.6007 362.5980 0.6007 362.7000 0.6746 362.8980 0.6746 363.0000 0.9802 363.1980 0.9802 363.3000 0.8438 363.4980 0.8438 363.6000 1.3193 363.7980 1.3193 363.9000 0.9385 364.0980 0.9385 364.2000 1.0918 364.3980 1.0918 364.5000 0.9191 364.6980 0.9191 364.8000 1.1563 364.9980 1.1563 365.1000 0.9597 365.2980 0.9597 365.4000 0.8660 365.5980 0.8660 365.7000 0.6020 365.8980 0.6020 366.0000 0.9502 366.1980 0.9502 366.3000 0.5237 366.4980 0.5237 366.6000 0.8244 366.7980 0.8244 366.9000 0.5754 367.0980 0.5754 367.2000 0.8241 367.3980 0.8241 367.5000 1.1436 367.6980 1.1436 367.8000 1.4875 367.9980 1.4875 368.1000 1.6638 368.2980 1.6638 368.4000 1.0669 368.5980 1.0669 368.7000 1.4368 368.8980 1.4368 369.0000 0.8037 369.1980 0.8037 369.3000 1.7000 369.4980 1.7000 369.6000 1.5640 369.7980 1.5640 369.9000 1.1868 370.0980 1.1868 370.2000 1.7000 370.3980 1.7000 370.5000 1.0862 370.6980 1.0862 370.8000 1.0663 370.9980 1.0663 371.1000 1.5503 371.2980 1.5503 371.4000 1.3034 371.5980 1.3034 371.7000 1.4922 371.8980 1.4922 372.0000 1.1058 372.1980 1.1058 372.3000 1.4746 372.4980 1.4746 372.6000 1.3418 372.7980 1.3418 372.9000 1.6668 373.0980 1.6668 373.2000 1.5517 373.3980 1.5517 373.5000 1.3280 373.6980 1.3280 373.8000 0.9032 373.9980 0.9032 374.1000 1.7000 374.2980 1.7000 374.4000 1.6432 374.5980 1.6432 374.7000 0.6755 374.8980 0.6755 375.0000 1.7000 375.1980 1.7000 375.3000 1.6114 375.4980 1.6114 375.6000 1.6980 375.7980 1.6980 375.9000 1.6529 376.0980 1.6529 376.2000 0.8361 376.3980 0.8361 376.5000 1.6490 376.6980 1.6490 376.8000 1.6079 376.9980 1.6079 377.1000 1.7000 377.2980 1.7000 377.4000 0.6065 377.5980 0.6065 377.7000 1.5404 377.8980 1.5404 378.0000 1.0390 378.1980 1.0390 378.3000 1.7000 378.4980 1.7000 378.6000 1.2143 378.7980 1.2143 378.9000 1.7000 379.0980 1.7000 379.2000 1.1185 379.3980 1.1185 379.5000 1.7000 379.6980 1.7000 379.8000 1.7000 379.9980 1.7000 380.1000 1.6451 380.2980 1.6451 380.4000 0.8359 380.5980 0.8359 380.7000 1.6141 380.8980 1.6141 381.0000 0.7458 381.1980 0.7458 381.3000 1.7000 381.4980 1.7000 381.6000 0.6722 381.7980 0.6722 381.9000 1.2888 382.0980 1.2888 382.2000 0.5812 382.3980 0.5812 382.5000 0.7791 382.6980 0.7791 382.8000 0.7355 382.9980 0.7355 383.1000 0.9666 383.2980 0.9666 383.4000 0.5933 383.5980 0.5933 383.7000 0.8885 383.8980 0.8885 384.0000 0.6007 384.1980 0.6007 384.3000 0.6746 384.4980 0.6746 384.6000 0.9802 384.7980 0.9802 384.9000 0.8438 385.0980 0.8438 385.2000 1.3193 385.3980 1.3193 385.5000 0.9385 385.6980 0.9385 385.8000 1.0918 385.9980 1.0918 386.1000 0.9191 386.2980 0.9191 386.4000 1.1563 386.5980 1.1563 386.7000 0.9597 386.8980 0.9597 387.0000 0.8660 387.1980 0.8660 387.3000 0.6020 387.4980 0.6020 387.6000 0.9502 387.7980 0.9502 387.9000 0.5237 388.0980 0.5237 388.2000 0.8244 388.3980 0.8244 388.5000 0.5754 388.6980 0.5754 388.8000 0.8241 388.9980 0.8241 389.1000 1.1436 389.2980 1.1436 389.4000 1.4875 389.5980 1.4875 389.7000 1.6638 389.8980 1.6638 390.0000 1.0669 390.1980 1.0669 390.3000 1.4368 390.4980 1.4368 390.6000 0.8037 390.7980 0.8037 390.9000 1.7000 391.0980 1.7000 391.2000 1.5640 391.3980 1.5640 391.5000 1.1868 391.6980 1.1868 391.8000 1.7000 391.9980 1.7000 392.1000 1.0862 392.2980 1.0862 392.4000 1.0663 392.5980 1.0663 392.7000 1.5503 392.8980 1.5503 393.0000 1.3034 393.1980 1.3034 393.3000 1.4922 393.4980 1.4922 393.6000 1.1058 393.7980 1.1058 393.9000 1.4746 394.0980 1.4746 394.2000 1.3418 394.3980 1.3418 394.5000 1.6668 394.6980 1.6668 394.8000 1.5517 394.9980 1.5517 395.1000 1.3280 395.2980 1.3280 395.4000 0.9032 395.5980 0.9032 395.7000 1.7000 395.8980 1.7000 396.0000 1.6432 396.1980 1.6432 396.3000 0.6755 396.4980 0.6755 396.6000 1.7000 396.7980 1.7000 396.9000 1.6114 397.0980 1.6114 397.2000 1.6980 397.3980 1.6980 397.5000 1.6529 397.6980 1.6529 397.8000 0.8361 397.9980 0.8361 398.1000 1.6490 398.2980 1.6490 398.4000 1.6079 398.5980 1.6079 398.7000 1.7000 398.8980 1.7000 399.0000 0.6065 399.1980 0.6065 399.3000 1.5404 399.4980 1.5404 399.6000 1.0390 399.7980 1.0390 399.9000 1.7000 400.0980 1.7000 400.2000 1.2143 400.3980 1.2143 400.5000 1.7000 400.6980 1.7000 400.8000 1.1185 400.9980 1.1185 401.1000 1.7000 401.2980 1.7000 401.4000 1.7000 401.5980 1.7000 401.7000 1.6451 401.8980 1.6451 402.0000 0.8359 402.1980 0.8359 402.3000 1.6141 402.4980 1.6141 402.6000 0.7458 402.7980 0.7458 402.9000 1.7000 403.0980 1.7000 403.2000 0.6722 403.3980 0.6722 403.5000 1.2888 403.6980 1.2888 403.8000 0.5812 403.9980 0.5812 404.1000 0.7791 404.2980 0.7791 404.4000 0.7355 404.5980 0.7355 404.7000 0.9666 404.8980 0.9666 405.0000 0.5933 405.1980 0.5933 405.3000 0.8885 405.4980 0.8885 405.6000 0.6007 405.7980 0.6007 405.9000 0.6746 406.0980 0.6746 406.2000 0.9802 406.3980 0.9802 406.5000 0.8438 406.6980 0.8438 406.8000 1.3193 406.9980 1.3193 407.1000 0.9385 407.2980 0.9385 407.4000 1.0918 407.5980 1.0918 407.7000 0.9191 407.8980 0.9191 408.0000 1.1563 408.1980 1.1563 408.3000 0.9597 408.4980 0.9597 408.6000 0.8660 408.7980 0.8660 408.9000 0.6020 409.0980 0.6020 409.2000 0.9502 409.3980 0.9502 409.5000 0.5237 409.6980 0.5237 409.8000 0.8244 409.9980 0.8244 410.1000 0.5754 410.2980 0.5754 410.4000 0.8241 410.5980 0.8241 410.7000 1.1436 410.8980 1.1436 411.0000 1.4875 411.1980 1.4875 411.3000 1.6638 411.4980 1.6638 411.6000 1.0669 411.7980 1.0669 411.9000 1.4368 412.0980 1.4368 412.2000 0.8037 412.3980 0.8037 412.5000 1.7000 412.6980 1.7000 412.8000 1.5640 412.9980 1.5640 413.1000 1.1868 413.2980 1.1868 413.4000 1.7000 413.5980 1.7000 413.7000 1.0862 413.8980 1.0862 414.0000 1.0663 414.1980 1.0663 414.3000 1.5503 414.4980 1.5503 414.6000 1.3034 414.7980 1.3034 414.9000 1.4922 415.0980 1.4922 415.2000 1.1058 415.3980 1.1058 415.5000 1.4746 415.6980 1.4746 415.8000 1.3418 415.9980 1.3418 416.1000 1.6668 416.2980 1.6668 416.4000 1.5517 416.5980 1.5517 416.7000 1.3280 416.8980 1.3280 417.0000 0.9032 417.1980 0.9032 417.3000 1.7000 417.4980 1.7000 417.6000 1.6432 417.7980 1.6432 417.9000 0.6755 418.0980 0.6755 418.2000 1.7000 418.3980 1.7000 418.5000 1.6114 418.6980 1.6114 418.8000 1.6980 418.9980 1.6980 419.1000 1.6529 419.2980 1.6529 419.4000 0.8361 419.5980 0.8361 419.7000 1.6490 419.8980 1.6490 420.0000 1.6079 420.1980 1.6079 420.3000 1.7000 420.4980 1.7000 420.6000 0.6065 420.7980 0.6065 420.9000 1.5404 421.0980 1.5404 421.2000 1.0390 421.3980 1.0390 421.5000 1.7000 421.6980 1.7000 421.8000 1.2143 421.9980 1.2143 422.1000 1.7000 422.2980 1.7000 422.4000 1.1185 422.5980 1.1185 422.7000 1.7000 422.8980 1.7000 423.0000 1.7000 423.1980 1.7000 423.3000 1.6451 423.4980 1.6451 423.6000 0.8359 423.7980 0.8359 423.9000 1.6141 424.0980 1.6141 424.2000 0.7458 424.3980 0.7458 424.5000 1.7000 424.6980 1.7000 424.8000 0.6722 424.9980 0.6722 425.1000 1.2888 425.2980 1.2888 425.4000 0.5812 425.5980 0.5812 425.7000 0.7791 425.8980 0.7791 426.0000 0.7355 426.1980 0.7355 426.3000 0.9666 426.4980 0.9666 426.6000 0.5933 426.7980 0.5933 426.9000 0.8885 427.0980 0.8885 427.2000 0.6007 427.3980 0.6007 427.5000 0.6746 427.6980 0.6746 427.8000 0.9802 427.9980 0.9802 428.1000 0.8438 428.2980 0.8438 428.4000 1.3193 428.5980 1.3193 428.7000 0.9385 428.8980 0.9385 429.0000 1.0918 429.1980 1.0918 429.3000 0.9191 429.4980 0.9191 429.6000 1.1563 429.7980 1.1563 429.9000 0.9597 430.0980 0.9597 430.2000 0.8660 430.3980 0.8660 430.5000 0.6020 430.6980 0.6020 430.8000 0.9502 430.9980 0.9502 431.1000 0.5237 431.2980 0.5237 431.4000 0.8244 431.5980 0.8244 431.7000 0.5754 431.8980 0.5754 432.0000 0.8241 432.1980 0.8241 432.3000 1.1436 432.4980 1.1436 432.6000 1.4875 432.7980 1.4875 432.9000 1.6638 433.0980 1.6638 433.2000 1.0669 433.3980 1.0669 433.5000 1.4368 433.6980 1.4368 433.8000 0.8037 433.9980 0.8037 434.1000 1.7000 434.2980 1.7000 434.4000 1.5640 434.5980 1.5640 434.7000 1.1868 434.8980 1.1868 435.0000 1.7000 435.1980 1.7000 435.3000 1.0862 435.4980 1.0862 435.6000 1.0663 435.7980 1.0663 435.9000 1.5503 436.0980 1.5503 436.2000 1.3034 436.3980 1.3034 436.5000 1.4922 436.6980 1.4922 436.8000 1.1058 436.9980 1.1058 437.1000 1.4746 437.2980 1.4746 437.4000 1.3418 437.5980 1.3418 437.7000 1.6668 437.8980 1.6668 438.0000 1.5517 438.1980 1.5517 438.3000 1.3280 438.4980 1.3280 438.6000 0.9032 438.7980 0.9032 438.9000 1.7000 439.0980 1.7000 439.2000 1.6432 439.3980 1.6432 439.5000 0.6755 439.6980 0.6755 439.8000 1.7000 439.9980 1.7000 440.1000 1.6114 440.2980 1.6114 440.4000 1.6980 440.5980 1.6980 440.7000 1.6529 440.8980 1.6529 441.0000 0.8361 441.1980 0.8361 441.3000 1.6490 441.4980 1.6490 441.6000 1.6079 441.7980 1.6079 441.9000 1.7000 442.0980 1.7000 442.2000 0.6065 442.3980 0.6065 442.5000 1.5404 442.6980 1.5404 442.8000 1.0390 442.9980 1.0390 443.1000 1.7000 443.2980 1.7000 443.4000 1.2143 443.5980 1.2143 443.7000 1.7000 443.8980 1.7000 444.0000 1.1185 444.1980 1.1185 444.3000 1.7000 444.4980 1.7000 444.6000 1.7000 444.7980 1.7000 444.9000 1.6451 445.0980 1.6451 445.2000 0.8359 445.3980 0.8359 445.5000 1.6141 445.6980 1.6141 445.8000 0.7458 445.9980 0.7458 446.1000 1.7000 446.2980 1.7000 446.4000 0.6722 446.5980 0.6722 446.7000 1.2888 446.8980 1.2888 447.0000 0.5812 447.1980 0.5812 447.3000 0.7791 447.4980 0.7791 447.6000 0.7355 447.7980 0.7355 447.9000 0.9666 448.0980 0.9666 448.2000 0.5933 448.3980 0.5933 448.5000 0.8885 448.6980 0.8885 448.8000 0.6007 448.9980 0.6007 449.1000 0.6746 449.2980 0.6746 449.4000 0.9802 449.5980 0.9802 449.7000 0.8438 449.8980 0.8438 450.0000 1.3193 450.1980 1.3193 450.3000 0.9385 450.4980 0.9385 450.6000 1.0918 450.7980 1.0918 450.9000 0.9191 451.0980 0.9191 451.2000 1.1563 451.3980 1.1563 451.5000 0.9597 451.6980 0.9597 451.8000 0.8660 451.9980 0.8660 452.1000 0.6020 452.2980 0.6020 452.4000 0.9502 452.5980 0.9502 452.7000 0.5237 452.8980 0.5237 453.0000 0.8244 453.1980 0.8244 453.3000 0.5754 453.4980 0.5754 453.6000 0.8241 453.7980 0.8241 453.9000 1.1436 454.0980 1.1436 454.2000 1.4875 454.3980 1.4875 454.5000 1.6638 454.6980 1.6638 454.8000 1.0669 454.9980 1.0669 455.1000 1.4368 455.2980 1.4368 455.4000 0.8037 455.5980 0.8037 455.7000 1.7000 455.8980 1.7000 456.0000 1.5640 456.1980 1.5640 456.3000 1.1868 456.4980 1.1868 456.6000 1.7000 456.7980 1.7000 456.9000 1.0862 457.0980 1.0862 457.2000 1.0663 457.3980 1.0663 457.5000 1.5503 457.6980 1.5503 457.8000 1.3034 457.9980 1.3034 458.1000 1.4922 458.2980 1.4922 458.4000 1.1058 458.5980 1.1058 458.7000 1.4746 458.8980 1.4746 459.0000 1.3418 459.1980 1.3418 459.3000 1.6668 459.4980 1.6668 459.6000 1.5517 459.7980 1.5517 459.9000 1.3280 460.0980 1.3280 460.2000 0.9032 460.3980 0.9032 460.5000 1.7000 460.6980 1.7000 460.8000 1.6432 460.9980 1.6432 461.1000 0.6755 461.2980 0.6755 461.4000 1.7000 461.5980 1.7000 461.7000 1.6114 461.8980 1.6114 462.0000 1.6980 462.1980 1.6980 462.3000 1.6529 462.4980 1.6529 462.6000 0.8361 462.7980 0.8361 462.9000 1.6490 463.0980 1.6490 463.2000 1.6079 463.3980 1.6079 463.5000 1.7000 463.6980 1.7000 463.8000 0.6065 463.9980 0.6065 464.1000 1.5404 464.2980 1.5404 464.4000 1.0390 464.5980 1.0390 464.7000 1.7000 464.8980 1.7000 465.0000 1.2143 465.1980 1.2143 465.3000 1.7000 465.4980 1.7000 465.6000 1.1185 465.7980 1.1185 465.9000 1.7000 466.0980 1.7000 466.2000 1.7000 466.3980 1.7000 466.5000 1.6451 466.6980 1.6451 466.8000 0.8359 466.9980 0.8359 467.1000 1.6141 467.2980 1.6141 467.4000 0.7458 467.5980 0.7458 467.7000 1.7000 467.8980 1.7000 468.0000 0.6722 468.1980 0.6722 468.3000 1.2888 468.4980 1.2888 468.6000 0.5812 468.7980 0.5812 468.9000 0.7791 469.0980 0.7791 469.2000 0.7355 469.3980 0.7355 469.5000 0.9666 469.6980 0.9666 469.8000 0.5933 469.9980 0.5933 470.1000 0.8885 470.2980 0.8885 470.4000 0.6007 470.5980 0.6007 470.7000 0.6746 470.8980 0.6746 471.0000 0.9802 471.1980 0.9802 471.3000 0.8438 471.4980 0.8438 471.6000 1.3193 471.7980 1.3193 471.9000 0.9385 472.0980 0.9385 472.2000 1.0918 472.3980 1.0918 472.5000 0.9191 472.6980 0.9191 472.8000 1.1563 472.9980 1.1563 473.1000 0.9597 473.2980 0.9597 473.4000 0.8660 473.5980 0.8660 473.7000 0.6020 473.8980 0.6020 474.0000 0.9502 474.1980 0.9502 474.3000 0.5237 474.4980 0.5237 474.6000 0.8244 474.7980 0.8244 474.9000 0.5754 475.0980 0.5754 475.2000 0.8241 475.3980 0.8241 475.5000 1.1436 475.6980 1.1436 475.8000 1.4875 475.9980 1.4875 476.1000 1.6638 476.2980 1.6638 476.4000 1.0669 476.5980 1.0669 476.7000 1.4368 476.8980 1.4368 477.0000 0.8037 477.1980 0.8037 477.3000 1.7000 477.4980 1.7000 477.6000 1.5640 477.7980 1.5640 477.9000 1.1868 478.0980 1.1868 478.2000 1.7000 478.3980 1.7000 478.5000 1.0862 478.6980 1.0862 478.8000 1.0663 478.9980 1.0663 479.1000 1.5503 479.2980 1.5503 479.4000 1.3034 479.5980 1.3034 479.7000 1.4922 479.8980 1.4922 480.0000 1.1058 480.1980 1.1058 480.3000 1.4746 480.4980 1.4746 480.6000 1.3418 480.7980 1.3418 480.9000 1.6668 481.0980 1.6668 481.2000 1.5517 481.3980 1.5517 481.5000 1.3280 481.6980 1.3280 481.8000 0.9032 481.9980 0.9032 482.1000 1.7000 482.2980 1.7000 482.4000 1.6432 482.5980 1.6432 482.7000 0.6755 482.8980 0.6755 483.0000 1.7000 483.1980 1.7000 483.3000 1.6114 483.4980 1.6114 483.6000 1.6980 483.7980 1.6980 483.9000 1.6529 484.0980 1.6529 484.2000 0.8361 484.3980 0.8361 484.5000 1.6490 484.6980 1.6490 484.8000 1.6079 484.9980 1.6079 485.1000 1.7000 485.2980 1.7000 485.4000 0.6065 485.5980 0.6065 485.7000 1.5404 485.8980 1.5404 486.0000 1.0390 486.1980 1.0390 486.3000 1.7000 486.4980 1.7000 486.6000 1.2143 486.7980 1.2143 486.9000 1.7000 487.0980 1.7000 487.2000 1.1185 487.3980 1.1185 487.5000 1.7000 487.6980 1.7000 487.8000 1.7000 487.9980 1.7000 488.1000 1.6451 488.2980 1.6451 488.4000 0.8359 488.5980 0.8359 488.7000 1.6141 488.8980 1.6141 489.0000 0.7458 489.1980 0.7458 489.3000 1.7000 489.4980 1.7000 489.6000 0.6722 489.7980 0.6722 489.9000 1.2888 490.0980 1.2888 490.2000 0.5812 490.3980 0.5812 490.5000 0.7791 490.6980 0.7791 490.8000 0.7355 490.9980 0.7355 491.1000 0.9666 491.2980 0.9666 491.4000 0.5933 491.5980 0.5933 491.7000 0.8885 491.8980 0.8885 492.0000 0.6007 492.1980 0.6007 492.3000 0.6746 492.4980 0.6746 492.6000 0.9802 492.7980 0.9802 492.9000 0.8438 493.0980 0.8438 493.2000 1.3193 493.3980 1.3193 493.5000 0.9385 493.6980 0.9385 493.8000 1.0918 493.9980 1.0918 494.1000 0.9191 494.2980 0.9191 494.4000 1.1563 494.5980 1.1563 494.7000 0.9597 494.8980 0.9597 495.0000 0.8660 495.1980 0.8660 495.3000 0.6020 495.4980 0.6020 495.6000 0.9502 495.7980 0.9502 495.9000 0.5237 496.0980 0.5237 496.2000 0.8244 496.3980 0.8244 496.5000 0.5754 496.6980 0.5754 496.8000 0.8241 496.9980 0.8241 497.1000 1.1436 497.2980 1.1436 497.4000 1.4875 497.5980 1.4875 497.7000 1.6638 497.8980 1.6638 498.0000 1.0669 498.1980 1.0669 498.3000 1.4368 498.4980 1.4368 498.6000 0.8037 498.7980 0.8037 498.9000 1.7000 499.0980 1.7000 499.2000 1.5640 499.3980 1.5640 499.5000 1.1868 499.6980 1.1868 499.8000 1.7000 499.9980 1.7000 500.1000 1.0862 500.2980 1.0862 500.4000 1.0663 500.5980 1.0663 500.7000 1.5503 500.8980 1.5503 501.0000 1.3034 501.1980 1.3034 501.3000 1.4922 501.4980 1.4922 501.6000 1.1058 501.7980 1.1058 501.9000 1.4746 502.0980 1.4746 502.2000 1.3418 502.3980 1.3418 502.5000 1.6668 502.6980 1.6668 502.8000 1.5517 502.9980 1.5517 503.1000 1.3280 503.2980 1.3280 503.4000 0.9032 503.5980 0.9032 503.7000 1.7000 503.8980 1.7000 504.0000 1.6432 504.1980 1.6432 504.3000 0.6755 504.4980 0.6755 504.6000 1.7000 504.7980 1.7000 504.9000 1.6114 505.0980 1.6114 505.2000 1.6980 505.3980 1.6980 505.5000 1.6529 505.6980 1.6529 505.8000 0.8361 505.9980 0.8361 506.1000 1.6490 506.2980 1.6490 506.4000 1.6079 506.5980 1.6079 506.7000 1.7000 506.8980 1.7000 507.0000 0.6065 507.1980 0.6065 507.3000 1.5404 507.4980 1.5404 507.6000 1.0390 507.7980 1.0390 507.9000 1.7000 508.0980 1.7000 508.2000 1.2143 508.3980 1.2143 508.5000 1.7000 508.6980 1.7000 508.8000 1.1185 508.9980 1.1185 509.1000 1.7000 509.2980 1.7000 509.4000 1.7000 509.5980 1.7000 509.7000 1.6451 509.8980 1.6451 510.0000 0.8359 510.1980 0.8359 510.3000 1.6141 510.4980 1.6141 510.6000 0.7458 510.7980 0.7458 510.9000 1.7000 511.0980 1.7000 511.2000 0.6722 511.3980 0.6722 511.5000 1.2888 511.6980 1.2888 511.8000 0.5812 511.9980 0.5812 512.1000 0.7791 512.2980 0.7791 512.4000 0.7355 512.5980 0.7355 512.7000 0.9666 512.8980 0.9666 513.0000 0.5933 513.1980 0.5933 513.3000 0.8885 513.4980 0.8885 513.6000 0.6007 513.7980 0.6007 513.9000 0.6746 514.0980 0.6746 514.2000 0.9802 514.3980 0.9802 514.5000 0.8438 514.6980 0.8438 514.8000 1.3193 514.9980 1.3193 515.1000 0.9385 515.2980 0.9385 515.4000 1.0918 515.5980 1.0918 515.7000 0.9191 515.8980 0.9191 516.0000 1.1563 516.1980 1.1563 516.3000 0.9597 516.4980 0.9597 516.6000 0.8660 516.7980 0.8660 516.9000 0.6020 517.0980 0.6020 517.2000 0.9502 517.3980 0.9502 517.5000 0.5237 517.6980 0.5237 517.8000 0.8244 517.9980 0.8244 518.1000 0.5754 518.2980 0.5754 518.4000 0.8241 518.5980 0.8241 518.7000 1.1436 518.8980 1.1436 519.0000 1.4875 519.1980 1.4875 519.3000 1.6638 519.4980 1.6638 519.6000 1.0669 519.7980 1.0669 519.9000 1.4368 520.0980 1.4368 520.2000 0.8037 520.3980 0.8037 520.5000 1.7000 520.6980 1.7000 520.8000 1.5640 520.9980 1.5640 521.1000 1.1868 521.2980 1.1868 521.4000 1.7000 521.5980 1.7000 521.7000 1.0862 521.8980 1.0862 522.0000 1.0663 522.1980 1.0663 522.3000 1.5503 522.4980 1.5503 522.6000 1.3034 522.7980 1.3034 522.9000 1.4922 523.0980 1.4922 523.2000 1.1058 523.3980 1.1058 523.5000 1.4746 523.6980 1.4746 523.8000 1.3418 523.9980 1.3418 524.1000 1.6668 524.2980 1.6668 524.4000 1.5517 524.5980 1.5517 524.7000 1.3280 524.8980 1.3280 525.0000 0.9032 525.1980 0.9032 525.3000 1.7000 525.4980 1.7000 525.6000 1.6432 525.7980 1.6432 525.9000 0.6755 526.0980 0.6755 526.2000 1.7000 526.3980 1.7000 526.5000 1.6114 526.6980 1.6114 526.8000 1.6980 526.9980 1.6980 527.1000 1.6529 527.2980 1.6529 527.4000 0.8361 527.5980 0.8361 527.7000 1.6490 527.8980 1.6490 528.0000 1.6079 528.1980 1.6079 528.3000 1.7000 528.4980 1.7000 528.6000 0.6065 528.7980 0.6065 528.9000 1.5404 529.0980 1.5404 529.2000 1.0390 529.3980 1.0390 529.5000 1.7000 529.6980 1.7000 529.8000 1.2143 529.9980 1.2143 530.1000 1.7000 530.2980 1.7000 530.4000 1.1185 530.5980 1.1185 530.7000 1.7000 530.8980 1.7000 531.0000 1.7000 531.1980 1.7000 531.3000 1.6451 531.4980 1.6451 531.6000 0.8359 531.7980 0.8359 531.9000 1.6141 532.0980 1.6141 532.2000 0.7458 532.3980 0.7458 532.5000 1.7000 532.6980 1.7000 532.8000 0.6722 532.9980 0.6722 533.1000 1.2888 533.2980 1.2888 533.4000 0.5812 533.5980 0.5812 533.7000 0.7791 533.8980 0.7791 534.0000 0.7355 534.1980 0.7355 534.3000 0.9666 534.4980 0.9666 534.6000 0.5933 534.7980 0.5933 534.9000 0.8885 535.0980 0.8885 535.2000 0.6007 535.3980 0.6007 535.5000 0.6746 535.6980 0.6746 535.8000 0.9802 535.9980 0.9802 536.1000 0.8438 536.2980 0.8438 536.4000 1.3193 536.5980 1.3193 536.7000 0.9385 536.8980 0.9385 537.0000 1.0918 537.1980 1.0918 537.3000 0.9191 537.4980 0.9191 537.6000 1.1563 537.7980 1.1563 537.9000 0.9597 538.0980 0.9597 538.2000 0.8660 538.3980 0.8660 538.5000 0.6020 538.6980 0.6020 538.8000 0.9502 538.9980 0.9502 539.1000 0.5237 539.2980 0.5237 539.4000 0.8244 539.5980 0.8244 539.7000 0.5754 539.8980 0.5754 540.0000 0.8241 540.1980 0.8241 540.3000 1.1436 540.4980 1.1436 540.6000 1.4875 540.7980 1.4875 540.9000 1.6638 541.0980 1.6638 541.2000 1.0669 541.3980 1.0669 541.5000 1.4368 541.6980 1.4368 541.8000 0.8037 541.9980 0.8037 542.1000 1.7000 542.2980 1.7000 542.4000 1.5640 542.5980 1.5640 542.7000 1.1868 542.8980 1.1868 543.0000 1.7000 543.1980 1.7000 543.3000 1.0862 543.4980 1.0862 543.6000 1.0663 543.7980 1.0663 543.9000 1.5503 544.0980 1.5503 544.2000 1.3034 544.3980 1.3034 544.5000 1.4922 544.6980 1.4922 544.8000 1.1058 544.9980 1.1058 545.1000 1.4746 545.2980 1.4746 545.4000 1.3418 545.5980 1.3418 545.7000 1.6668 545.8980 1.6668 546.0000 1.5517 546.1980 1.5517 546.3000 1.3280 546.4980 1.3280 546.6000 0.9032 546.7980 0.9032 546.9000 1.7000 547.0980 1.7000 547.2000 1.6432 547.3980 1.6432 547.5000 0.6755 547.6980 0.6755 547.8000 1.7000 547.9980 1.7000 548.1000 1.6114 548.2980 1.6114 548.4000 1.6980 548.5980 1.6980 548.7000 1.6529 548.8980 1.6529 549.0000 0.8361 549.1980 0.8361 549.3000 1.6490 549.4980 1.6490 549.6000 1.6079 549.7980 1.6079 549.9000 1.7000 550.0980 1.7000 550.2000 0.6065 550.3980 0.6065 550.5000 1.5404 550.6980 1.5404 550.8000 1.0390 550.9980 1.0390 551.1000 1.7000 551.2980 1.7000 551.4000 1.2143 551.5980 1.2143 551.7000 1.7000 551.8980 1.7000 552.0000 1.1185 552.1980 1.1185 552.3000 1.7000 552.4980 1.7000 552.6000 1.7000 552.7980 1.7000 552.9000 1.6451 553.0980 1.6451 553.2000 0.8359 553.3980 0.8359 553.5000 1.6141 553.6980 1.6141 553.8000 0.7458 553.9980 0.7458 554.1000 1.7000 554.2980 1.7000 554.4000 0.6722 554.5980 0.6722 554.7000 1.2888 554.8980 1.2888 555.0000 0.5812 555.1980 0.5812 555.3000 0.7791 555.4980 0.7791 555.6000 0.7355 555.7980 0.7355 555.9000 0.9666 556.0980 0.9666 556.2000 0.5933 556.3980 0.5933 556.5000 0.8885 556.6980 0.8885 556.8000 0.6007 556.9980 0.6007 557.1000 0.6746 557.2980 0.6746 557.4000 0.9802 557.5980 0.9802 557.7000 0.8438 557.8980 0.8438 558.0000 1.3193 558.1980 1.3193 558.3000 0.9385 558.4980 0.9385 558.6000 1.0918 558.7980 1.0918 558.9000 0.9191 559.0980 0.9191 559.2000 1.1563 559.3980 1.1563 559.5000 0.9597 559.6980 0.9597 559.8000 0.8660 559.9980 0.8660 560.1000 0.6020 560.2980 0.6020 560.4000 0.9502 560.5980 0.9502 560.7000 0.5237 560.8980 0.5237 561.0000 0.8244 561.1980 0.8244 561.3000 0.5754 561.4980 0.5754 561.6000 0.8241 561.7980 0.8241 561.9000 1.1436 562.0980 1.1436 562.2000 1.4875 562.3980 1.4875 562.5000 1.6638 562.6980 1.6638 562.8000 1.0669 562.9980 1.0669 563.1000 1.4368 563.2980 1.4368 563.4000 0.8037 563.5980 0.8037 563.7000 1.7000 563.8980 1.7000 564.0000 1.5640 564.1980 1.5640 564.3000 1.1868 564.4980 1.1868 564.6000 1.7000 564.7980 1.7000 564.9000 1.0862 565.0980 1.0862 565.2000 1.0663 565.3980 1.0663 565.5000 1.5503 565.6980 1.5503 565.8000 1.3034 565.9980 1.3034 566.1000 1.4922 566.2980 1.4922 566.4000 1.1058 566.5980 1.1058 566.7000 1.4746 566.8980 1.4746 567.0000 1.3418 567.1980 1.3418 567.3000 1.6668 567.4980 1.6668 567.6000 1.5517 567.7980 1.5517 567.9000 1.3280 568.0980 1.3280 568.2000 0.9032 568.3980 0.9032 568.5000 1.7000 568.6980 1.7000 568.8000 1.6432 568.9980 1.6432 569.1000 0.6755 569.2980 0.6755 569.4000 1.7000 569.5980 1.7000 569.7000 1.6114 569.8980 1.6114 570.0000 1.6980 570.1980 1.6980 570.3000 1.6529 570.4980 1.6529 570.6000 0.8361 570.7980 0.8361 570.9000 1.6490 571.0980 1.6490 571.2000 1.6079 571.3980 1.6079 571.5000 1.7000 571.6980 1.7000 571.8000 0.6065 571.9980 0.6065 572.1000 1.5404 572.2980 1.5404 572.4000 1.0390 572.5980 1.0390 572.7000 1.7000 572.8980 1.7000 573.0000 1.2143 573.1980 1.2143 573.3000 1.7000 573.4980 1.7000 573.6000 1.1185 573.7980 1.1185 573.9000 1.7000 574.0980 1.7000 574.2000 1.7000 574.3980 1.7000 574.5000 1.6451 574.6980 1.6451 574.8000 0.8359 574.9980 0.8359 575.1000 1.6141 575.2980 1.6141 575.4000 0.7458 575.5980 0.7458 575.7000 1.7000 575.8980 1.7000 576.0000 0.6722 576.1980 0.6722 576.3000 1.2888 576.4980 1.2888 576.6000 0.5812 576.7980 0.5812 576.9000 0.7791 577.0980 0.7791 577.2000 0.7355 577.3980 0.7355 577.5000 0.9666 577.6980 0.9666 577.8000 0.5933 577.9980 0.5933 578.1000 0.8885 578.2980 0.8885 578.4000 0.6007 578.5980 0.6007 578.7000 0.6746 578.8980 0.6746 579.0000 0.9802 579.1980 0.9802 579.3000 0.8438 579.4980 0.8438 579.6000 1.3193 579.7980 1.3193 579.9000 0.9385 580.0980 0.9385 580.2000 1.0918 580.3980 1.0918 580.5000 0.9191 580.6980 0.9191 580.8000 1.1563 580.9980 1.1563 581.1000 0.9597 581.2980 0.9597 581.4000 0.8660 581.5980 0.8660 581.7000 0.6020 581.8980 0.6020 582.0000 0.9502 582.1980 0.9502 582.3000 0.5237 582.4980 0.5237 582.6000 0.8244 582.7980 0.8244 582.9000 0.5754 583.0980 0.5754 583.2000 0.8241 583.3980 0.8241 583.5000 1.1436 583.6980 1.1436 583.8000 1.4875 583.9980 1.4875 584.1000 1.6638 584.2980 1.6638 584.4000 1.0669 584.5980 1.0669 584.7000 1.4368 584.8980 1.4368 585.0000 0.8037 585.1980 0.8037 585.3000 1.7000 585.4980 1.7000 585.6000 1.5640 585.7980 1.5640 585.9000 1.1868 586.0980 1.1868 586.2000 1.7000 586.3980 1.7000 586.5000 1.0862 586.6980 1.0862 586.8000 1.0663 586.9980 1.0663 587.1000 1.5503 587.2980 1.5503 587.4000 1.3034 587.5980 1.3034 587.7000 1.4922 587.8980 1.4922 588.0000 1.1058 588.1980 1.1058 588.3000 1.4746 588.4980 1.4746 588.6000 1.3418 588.7980 1.3418 588.9000 1.6668 589.0980 1.6668 589.2000 1.5517 589.3980 1.5517 589.5000 1.3280 589.6980 1.3280 589.8000 0.9032 589.9980 0.9032 590.1000 1.7000 590.2980 1.7000 590.4000 1.6432 590.5980 1.6432 590.7000 0.6755 590.8980 0.6755 591.0000 1.7000 591.1980 1.7000 591.3000 1.6114 591.4980 1.6114 591.6000 1.6980 591.7980 1.6980 591.9000 1.6529 592.0980 1.6529 592.2000 0.8361 592.3980 0.8361 592.5000 1.6490 592.6980 1.6490 592.8000 1.6079 592.9980 1.6079 593.1000 1.7000 593.2980 1.7000 593.4000 0.6065 593.5980 0.6065 593.7000 1.5404 593.8980 1.5404 594.0000 1.0390 594.1980 1.0390 594.3000 1.7000 594.4980 1.7000 594.6000 1.2143 594.7980 1.2143 594.9000 1.7000 595.0980 1.7000 595.2000 1.1185 595.3980 1.1185 595.5000 1.7000 595.6980 1.7000 595.8000 1.7000 595.9980 1.7000 596.1000 1.6451 596.2980 1.6451 596.4000 0.8359 596.5980 0.8359 596.7000 1.6141 596.8980 1.6141 597.0000 0.7458 597.1980 0.7458 597.3000 1.7000 597.4980 1.7000 597.6000 0.6722 597.7980 0.6722 597.9000 1.2888 598.0980 1.2888 598.2000 0.5812 598.3980 0.5812 598.5000 0.7791 598.6980 0.7791 598.8000 0.7355 598.9980 0.7355 599.1000 0.9666 599.2980 0.9666 599.4000 0.5933 599.5980 0.5933 599.7000 0.8885 599.8980 0.8885 600.0000 0.8885)
Va10 a10 0 PWL(0.0000 1.3890 0.1980 1.3890 0.3000 1.0167 0.4980 1.0167 0.6000 1.6680 0.7980 1.6680 0.9000 1.2853 1.0980 1.2853 1.2000 1.5178 1.3980 1.5178 1.5000 1.3289 1.6980 1.3289 1.8000 1.4717 1.9980 1.4717 2.1000 1.3485 2.2980 1.3485 2.4000 0.7654 2.5980 0.7654 2.7000 1.3865 2.8980 1.3865 3.0000 1.6290 3.1980 1.6290 3.3000 0.8489 3.4980 0.8489 3.6000 1.5180 3.7980 1.5180 3.9000 1.0014 4.0980 1.0014 4.2000 1.0727 4.3980 1.0727 4.5000 1.5365 4.6980 1.5365 4.8000 1.2242 4.9980 1.2242 5.1000 0.8932 5.2980 0.8932 5.4000 1.1560 5.5980 1.1560 5.7000 1.4669 5.8980 1.4669 6.0000 1.4599 6.1980 1.4599 6.3000 1.5164 6.4980 1.5164 6.6000 0.4370 6.7980 0.4370 6.9000 1.3328 7.0980 1.3328 7.2000 1.4404 7.3980 1.4404 7.5000 1.7000 7.6980 1.7000 7.8000 0.9742 7.9980 0.9742 8.1000 1.3125 8.2980 1.3125 8.4000 1.0458 8.5980 1.0458 8.7000 0.9826 8.8980 0.9826 9.0000 1.7000 9.1980 1.7000 9.3000 1.2201 9.4980 1.2201 9.6000 0.9923 9.7980 0.9923 9.9000 1.1317 10.0980 1.1317 10.2000 1.7000 10.3980 1.7000 10.5000 1.1677 10.6980 1.1677 10.8000 1.6994 10.9980 1.6994 11.1000 0.9488 11.2980 0.9488 11.4000 1.7000 11.5980 1.7000 11.7000 1.1912 11.8980 1.1912 12.0000 1.7000 12.1980 1.7000 12.3000 0.8032 12.4980 0.8032 12.6000 0.8656 12.7980 0.8656 12.9000 1.0673 13.0980 1.0673 13.2000 1.7000 13.3980 1.7000 13.5000 1.1240 13.6980 1.1240 13.8000 1.7000 13.9980 1.7000 14.1000 0.7099 14.2980 0.7099 14.4000 1.5949 14.5980 1.5949 14.7000 1.1241 14.8980 1.1241 15.0000 1.6695 15.1980 1.6695 15.3000 1.4415 15.4980 1.4415 15.6000 1.4239 15.7980 1.4239 15.9000 1.3686 16.0980 1.3686 16.2000 1.4932 16.3980 1.4932 16.5000 1.3527 16.6980 1.3527 16.8000 1.6149 16.9980 1.6149 17.1000 1.6066 17.2980 1.6066 17.4000 1.7000 17.5980 1.7000 17.7000 1.5284 17.8980 1.5284 18.0000 1.1273 18.1980 1.1273 18.3000 1.5936 18.4980 1.5936 18.6000 1.7000 18.7980 1.7000 18.9000 1.3411 19.0980 1.3411 19.2000 1.0636 19.3980 1.0636 19.5000 1.2662 19.6980 1.2662 19.8000 1.3557 19.9980 1.3557 20.1000 1.4687 20.2980 1.4687 20.4000 1.3298 20.5980 1.3298 20.7000 1.4403 20.8980 1.4403 21.0000 1.7000 21.1980 1.7000 21.3000 1.6215 21.4980 1.6215 21.6000 1.3890 21.7980 1.3890 21.9000 1.0167 22.0980 1.0167 22.2000 1.6680 22.3980 1.6680 22.5000 1.2853 22.6980 1.2853 22.8000 1.5178 22.9980 1.5178 23.1000 1.3289 23.2980 1.3289 23.4000 1.4717 23.5980 1.4717 23.7000 1.3485 23.8980 1.3485 24.0000 0.7654 24.1980 0.7654 24.3000 1.3865 24.4980 1.3865 24.6000 1.6290 24.7980 1.6290 24.9000 0.8489 25.0980 0.8489 25.2000 1.5180 25.3980 1.5180 25.5000 1.0014 25.6980 1.0014 25.8000 1.0727 25.9980 1.0727 26.1000 1.5365 26.2980 1.5365 26.4000 1.2242 26.5980 1.2242 26.7000 0.8932 26.8980 0.8932 27.0000 1.1560 27.1980 1.1560 27.3000 1.4669 27.4980 1.4669 27.6000 1.4599 27.7980 1.4599 27.9000 1.5164 28.0980 1.5164 28.2000 0.4370 28.3980 0.4370 28.5000 1.3328 28.6980 1.3328 28.8000 1.4404 28.9980 1.4404 29.1000 1.7000 29.2980 1.7000 29.4000 0.9742 29.5980 0.9742 29.7000 1.3125 29.8980 1.3125 30.0000 1.0458 30.1980 1.0458 30.3000 0.9826 30.4980 0.9826 30.6000 1.7000 30.7980 1.7000 30.9000 1.2201 31.0980 1.2201 31.2000 0.9923 31.3980 0.9923 31.5000 1.1317 31.6980 1.1317 31.8000 1.7000 31.9980 1.7000 32.1000 1.1677 32.2980 1.1677 32.4000 1.6994 32.5980 1.6994 32.7000 0.9488 32.8980 0.9488 33.0000 1.7000 33.1980 1.7000 33.3000 1.1912 33.4980 1.1912 33.6000 1.7000 33.7980 1.7000 33.9000 0.8032 34.0980 0.8032 34.2000 0.8656 34.3980 0.8656 34.5000 1.0673 34.6980 1.0673 34.8000 1.7000 34.9980 1.7000 35.1000 1.1240 35.2980 1.1240 35.4000 1.7000 35.5980 1.7000 35.7000 0.7099 35.8980 0.7099 36.0000 1.5949 36.1980 1.5949 36.3000 1.1241 36.4980 1.1241 36.6000 1.6695 36.7980 1.6695 36.9000 1.4415 37.0980 1.4415 37.2000 1.4239 37.3980 1.4239 37.5000 1.3686 37.6980 1.3686 37.8000 1.4932 37.9980 1.4932 38.1000 1.3527 38.2980 1.3527 38.4000 1.6149 38.5980 1.6149 38.7000 1.6066 38.8980 1.6066 39.0000 1.7000 39.1980 1.7000 39.3000 1.5284 39.4980 1.5284 39.6000 1.1273 39.7980 1.1273 39.9000 1.5936 40.0980 1.5936 40.2000 1.7000 40.3980 1.7000 40.5000 1.3411 40.6980 1.3411 40.8000 1.0636 40.9980 1.0636 41.1000 1.2662 41.2980 1.2662 41.4000 1.3557 41.5980 1.3557 41.7000 1.4687 41.8980 1.4687 42.0000 1.3298 42.1980 1.3298 42.3000 1.4403 42.4980 1.4403 42.6000 1.7000 42.7980 1.7000 42.9000 1.6215 43.0980 1.6215 43.2000 1.3890 43.3980 1.3890 43.5000 1.0167 43.6980 1.0167 43.8000 1.6680 43.9980 1.6680 44.1000 1.2853 44.2980 1.2853 44.4000 1.5178 44.5980 1.5178 44.7000 1.3289 44.8980 1.3289 45.0000 1.4717 45.1980 1.4717 45.3000 1.3485 45.4980 1.3485 45.6000 0.7654 45.7980 0.7654 45.9000 1.3865 46.0980 1.3865 46.2000 1.6290 46.3980 1.6290 46.5000 0.8489 46.6980 0.8489 46.8000 1.5180 46.9980 1.5180 47.1000 1.0014 47.2980 1.0014 47.4000 1.0727 47.5980 1.0727 47.7000 1.5365 47.8980 1.5365 48.0000 1.2242 48.1980 1.2242 48.3000 0.8932 48.4980 0.8932 48.6000 1.1560 48.7980 1.1560 48.9000 1.4669 49.0980 1.4669 49.2000 1.4599 49.3980 1.4599 49.5000 1.5164 49.6980 1.5164 49.8000 0.4370 49.9980 0.4370 50.1000 1.3328 50.2980 1.3328 50.4000 1.4404 50.5980 1.4404 50.7000 1.7000 50.8980 1.7000 51.0000 0.9742 51.1980 0.9742 51.3000 1.3125 51.4980 1.3125 51.6000 1.0458 51.7980 1.0458 51.9000 0.9826 52.0980 0.9826 52.2000 1.7000 52.3980 1.7000 52.5000 1.2201 52.6980 1.2201 52.8000 0.9923 52.9980 0.9923 53.1000 1.1317 53.2980 1.1317 53.4000 1.7000 53.5980 1.7000 53.7000 1.1677 53.8980 1.1677 54.0000 1.6994 54.1980 1.6994 54.3000 0.9488 54.4980 0.9488 54.6000 1.7000 54.7980 1.7000 54.9000 1.1912 55.0980 1.1912 55.2000 1.7000 55.3980 1.7000 55.5000 0.8032 55.6980 0.8032 55.8000 0.8656 55.9980 0.8656 56.1000 1.0673 56.2980 1.0673 56.4000 1.7000 56.5980 1.7000 56.7000 1.1240 56.8980 1.1240 57.0000 1.7000 57.1980 1.7000 57.3000 0.7099 57.4980 0.7099 57.6000 1.5949 57.7980 1.5949 57.9000 1.1241 58.0980 1.1241 58.2000 1.6695 58.3980 1.6695 58.5000 1.4415 58.6980 1.4415 58.8000 1.4239 58.9980 1.4239 59.1000 1.3686 59.2980 1.3686 59.4000 1.4932 59.5980 1.4932 59.7000 1.3527 59.8980 1.3527 60.0000 1.6149 60.1980 1.6149 60.3000 1.6066 60.4980 1.6066 60.6000 1.7000 60.7980 1.7000 60.9000 1.5284 61.0980 1.5284 61.2000 1.1273 61.3980 1.1273 61.5000 1.5936 61.6980 1.5936 61.8000 1.7000 61.9980 1.7000 62.1000 1.3411 62.2980 1.3411 62.4000 1.0636 62.5980 1.0636 62.7000 1.2662 62.8980 1.2662 63.0000 1.3557 63.1980 1.3557 63.3000 1.4687 63.4980 1.4687 63.6000 1.3298 63.7980 1.3298 63.9000 1.4403 64.0980 1.4403 64.2000 1.7000 64.3980 1.7000 64.5000 1.6215 64.6980 1.6215 64.8000 1.3890 64.9980 1.3890 65.1000 1.0167 65.2980 1.0167 65.4000 1.6680 65.5980 1.6680 65.7000 1.2853 65.8980 1.2853 66.0000 1.5178 66.1980 1.5178 66.3000 1.3289 66.4980 1.3289 66.6000 1.4717 66.7980 1.4717 66.9000 1.3485 67.0980 1.3485 67.2000 0.7654 67.3980 0.7654 67.5000 1.3865 67.6980 1.3865 67.8000 1.6290 67.9980 1.6290 68.1000 0.8489 68.2980 0.8489 68.4000 1.5180 68.5980 1.5180 68.7000 1.0014 68.8980 1.0014 69.0000 1.0727 69.1980 1.0727 69.3000 1.5365 69.4980 1.5365 69.6000 1.2242 69.7980 1.2242 69.9000 0.8932 70.0980 0.8932 70.2000 1.1560 70.3980 1.1560 70.5000 1.4669 70.6980 1.4669 70.8000 1.4599 70.9980 1.4599 71.1000 1.5164 71.2980 1.5164 71.4000 0.4370 71.5980 0.4370 71.7000 1.3328 71.8980 1.3328 72.0000 1.4404 72.1980 1.4404 72.3000 1.7000 72.4980 1.7000 72.6000 0.9742 72.7980 0.9742 72.9000 1.3125 73.0980 1.3125 73.2000 1.0458 73.3980 1.0458 73.5000 0.9826 73.6980 0.9826 73.8000 1.7000 73.9980 1.7000 74.1000 1.2201 74.2980 1.2201 74.4000 0.9923 74.5980 0.9923 74.7000 1.1317 74.8980 1.1317 75.0000 1.7000 75.1980 1.7000 75.3000 1.1677 75.4980 1.1677 75.6000 1.6994 75.7980 1.6994 75.9000 0.9488 76.0980 0.9488 76.2000 1.7000 76.3980 1.7000 76.5000 1.1912 76.6980 1.1912 76.8000 1.7000 76.9980 1.7000 77.1000 0.8032 77.2980 0.8032 77.4000 0.8656 77.5980 0.8656 77.7000 1.0673 77.8980 1.0673 78.0000 1.7000 78.1980 1.7000 78.3000 1.1240 78.4980 1.1240 78.6000 1.7000 78.7980 1.7000 78.9000 0.7099 79.0980 0.7099 79.2000 1.5949 79.3980 1.5949 79.5000 1.1241 79.6980 1.1241 79.8000 1.6695 79.9980 1.6695 80.1000 1.4415 80.2980 1.4415 80.4000 1.4239 80.5980 1.4239 80.7000 1.3686 80.8980 1.3686 81.0000 1.4932 81.1980 1.4932 81.3000 1.3527 81.4980 1.3527 81.6000 1.6149 81.7980 1.6149 81.9000 1.6066 82.0980 1.6066 82.2000 1.7000 82.3980 1.7000 82.5000 1.5284 82.6980 1.5284 82.8000 1.1273 82.9980 1.1273 83.1000 1.5936 83.2980 1.5936 83.4000 1.7000 83.5980 1.7000 83.7000 1.3411 83.8980 1.3411 84.0000 1.0636 84.1980 1.0636 84.3000 1.2662 84.4980 1.2662 84.6000 1.3557 84.7980 1.3557 84.9000 1.4687 85.0980 1.4687 85.2000 1.3298 85.3980 1.3298 85.5000 1.4403 85.6980 1.4403 85.8000 1.7000 85.9980 1.7000 86.1000 1.6215 86.2980 1.6215 86.4000 1.3890 86.5980 1.3890 86.7000 1.0167 86.8980 1.0167 87.0000 1.6680 87.1980 1.6680 87.3000 1.2853 87.4980 1.2853 87.6000 1.5178 87.7980 1.5178 87.9000 1.3289 88.0980 1.3289 88.2000 1.4717 88.3980 1.4717 88.5000 1.3485 88.6980 1.3485 88.8000 0.7654 88.9980 0.7654 89.1000 1.3865 89.2980 1.3865 89.4000 1.6290 89.5980 1.6290 89.7000 0.8489 89.8980 0.8489 90.0000 1.5180 90.1980 1.5180 90.3000 1.0014 90.4980 1.0014 90.6000 1.0727 90.7980 1.0727 90.9000 1.5365 91.0980 1.5365 91.2000 1.2242 91.3980 1.2242 91.5000 0.8932 91.6980 0.8932 91.8000 1.1560 91.9980 1.1560 92.1000 1.4669 92.2980 1.4669 92.4000 1.4599 92.5980 1.4599 92.7000 1.5164 92.8980 1.5164 93.0000 0.4370 93.1980 0.4370 93.3000 1.3328 93.4980 1.3328 93.6000 1.4404 93.7980 1.4404 93.9000 1.7000 94.0980 1.7000 94.2000 0.9742 94.3980 0.9742 94.5000 1.3125 94.6980 1.3125 94.8000 1.0458 94.9980 1.0458 95.1000 0.9826 95.2980 0.9826 95.4000 1.7000 95.5980 1.7000 95.7000 1.2201 95.8980 1.2201 96.0000 0.9923 96.1980 0.9923 96.3000 1.1317 96.4980 1.1317 96.6000 1.7000 96.7980 1.7000 96.9000 1.1677 97.0980 1.1677 97.2000 1.6994 97.3980 1.6994 97.5000 0.9488 97.6980 0.9488 97.8000 1.7000 97.9980 1.7000 98.1000 1.1912 98.2980 1.1912 98.4000 1.7000 98.5980 1.7000 98.7000 0.8032 98.8980 0.8032 99.0000 0.8656 99.1980 0.8656 99.3000 1.0673 99.4980 1.0673 99.6000 1.7000 99.7980 1.7000 99.9000 1.1240 100.0980 1.1240 100.2000 1.7000 100.3980 1.7000 100.5000 0.7099 100.6980 0.7099 100.8000 1.5949 100.9980 1.5949 101.1000 1.1241 101.2980 1.1241 101.4000 1.6695 101.5980 1.6695 101.7000 1.4415 101.8980 1.4415 102.0000 1.4239 102.1980 1.4239 102.3000 1.3686 102.4980 1.3686 102.6000 1.4932 102.7980 1.4932 102.9000 1.3527 103.0980 1.3527 103.2000 1.6149 103.3980 1.6149 103.5000 1.6066 103.6980 1.6066 103.8000 1.7000 103.9980 1.7000 104.1000 1.5284 104.2980 1.5284 104.4000 1.1273 104.5980 1.1273 104.7000 1.5936 104.8980 1.5936 105.0000 1.7000 105.1980 1.7000 105.3000 1.3411 105.4980 1.3411 105.6000 1.0636 105.7980 1.0636 105.9000 1.2662 106.0980 1.2662 106.2000 1.3557 106.3980 1.3557 106.5000 1.4687 106.6980 1.4687 106.8000 1.3298 106.9980 1.3298 107.1000 1.4403 107.2980 1.4403 107.4000 1.7000 107.5980 1.7000 107.7000 1.6215 107.8980 1.6215 108.0000 1.3890 108.1980 1.3890 108.3000 1.0167 108.4980 1.0167 108.6000 1.6680 108.7980 1.6680 108.9000 1.2853 109.0980 1.2853 109.2000 1.5178 109.3980 1.5178 109.5000 1.3289 109.6980 1.3289 109.8000 1.4717 109.9980 1.4717 110.1000 1.3485 110.2980 1.3485 110.4000 0.7654 110.5980 0.7654 110.7000 1.3865 110.8980 1.3865 111.0000 1.6290 111.1980 1.6290 111.3000 0.8489 111.4980 0.8489 111.6000 1.5180 111.7980 1.5180 111.9000 1.0014 112.0980 1.0014 112.2000 1.0727 112.3980 1.0727 112.5000 1.5365 112.6980 1.5365 112.8000 1.2242 112.9980 1.2242 113.1000 0.8932 113.2980 0.8932 113.4000 1.1560 113.5980 1.1560 113.7000 1.4669 113.8980 1.4669 114.0000 1.4599 114.1980 1.4599 114.3000 1.5164 114.4980 1.5164 114.6000 0.4370 114.7980 0.4370 114.9000 1.3328 115.0980 1.3328 115.2000 1.4404 115.3980 1.4404 115.5000 1.7000 115.6980 1.7000 115.8000 0.9742 115.9980 0.9742 116.1000 1.3125 116.2980 1.3125 116.4000 1.0458 116.5980 1.0458 116.7000 0.9826 116.8980 0.9826 117.0000 1.7000 117.1980 1.7000 117.3000 1.2201 117.4980 1.2201 117.6000 0.9923 117.7980 0.9923 117.9000 1.1317 118.0980 1.1317 118.2000 1.7000 118.3980 1.7000 118.5000 1.1677 118.6980 1.1677 118.8000 1.6994 118.9980 1.6994 119.1000 0.9488 119.2980 0.9488 119.4000 1.7000 119.5980 1.7000 119.7000 1.1912 119.8980 1.1912 120.0000 1.7000 120.1980 1.7000 120.3000 0.8032 120.4980 0.8032 120.6000 0.8656 120.7980 0.8656 120.9000 1.0673 121.0980 1.0673 121.2000 1.7000 121.3980 1.7000 121.5000 1.1240 121.6980 1.1240 121.8000 1.7000 121.9980 1.7000 122.1000 0.7099 122.2980 0.7099 122.4000 1.5949 122.5980 1.5949 122.7000 1.1241 122.8980 1.1241 123.0000 1.6695 123.1980 1.6695 123.3000 1.4415 123.4980 1.4415 123.6000 1.4239 123.7980 1.4239 123.9000 1.3686 124.0980 1.3686 124.2000 1.4932 124.3980 1.4932 124.5000 1.3527 124.6980 1.3527 124.8000 1.6149 124.9980 1.6149 125.1000 1.6066 125.2980 1.6066 125.4000 1.7000 125.5980 1.7000 125.7000 1.5284 125.8980 1.5284 126.0000 1.1273 126.1980 1.1273 126.3000 1.5936 126.4980 1.5936 126.6000 1.7000 126.7980 1.7000 126.9000 1.3411 127.0980 1.3411 127.2000 1.0636 127.3980 1.0636 127.5000 1.2662 127.6980 1.2662 127.8000 1.3557 127.9980 1.3557 128.1000 1.4687 128.2980 1.4687 128.4000 1.3298 128.5980 1.3298 128.7000 1.4403 128.8980 1.4403 129.0000 1.7000 129.1980 1.7000 129.3000 1.6215 129.4980 1.6215 129.6000 1.3890 129.7980 1.3890 129.9000 1.0167 130.0980 1.0167 130.2000 1.6680 130.3980 1.6680 130.5000 1.2853 130.6980 1.2853 130.8000 1.5178 130.9980 1.5178 131.1000 1.3289 131.2980 1.3289 131.4000 1.4717 131.5980 1.4717 131.7000 1.3485 131.8980 1.3485 132.0000 0.7654 132.1980 0.7654 132.3000 1.3865 132.4980 1.3865 132.6000 1.6290 132.7980 1.6290 132.9000 0.8489 133.0980 0.8489 133.2000 1.5180 133.3980 1.5180 133.5000 1.0014 133.6980 1.0014 133.8000 1.0727 133.9980 1.0727 134.1000 1.5365 134.2980 1.5365 134.4000 1.2242 134.5980 1.2242 134.7000 0.8932 134.8980 0.8932 135.0000 1.1560 135.1980 1.1560 135.3000 1.4669 135.4980 1.4669 135.6000 1.4599 135.7980 1.4599 135.9000 1.5164 136.0980 1.5164 136.2000 0.4370 136.3980 0.4370 136.5000 1.3328 136.6980 1.3328 136.8000 1.4404 136.9980 1.4404 137.1000 1.7000 137.2980 1.7000 137.4000 0.9742 137.5980 0.9742 137.7000 1.3125 137.8980 1.3125 138.0000 1.0458 138.1980 1.0458 138.3000 0.9826 138.4980 0.9826 138.6000 1.7000 138.7980 1.7000 138.9000 1.2201 139.0980 1.2201 139.2000 0.9923 139.3980 0.9923 139.5000 1.1317 139.6980 1.1317 139.8000 1.7000 139.9980 1.7000 140.1000 1.1677 140.2980 1.1677 140.4000 1.6994 140.5980 1.6994 140.7000 0.9488 140.8980 0.9488 141.0000 1.7000 141.1980 1.7000 141.3000 1.1912 141.4980 1.1912 141.6000 1.7000 141.7980 1.7000 141.9000 0.8032 142.0980 0.8032 142.2000 0.8656 142.3980 0.8656 142.5000 1.0673 142.6980 1.0673 142.8000 1.7000 142.9980 1.7000 143.1000 1.1240 143.2980 1.1240 143.4000 1.7000 143.5980 1.7000 143.7000 0.7099 143.8980 0.7099 144.0000 1.5949 144.1980 1.5949 144.3000 1.1241 144.4980 1.1241 144.6000 1.6695 144.7980 1.6695 144.9000 1.4415 145.0980 1.4415 145.2000 1.4239 145.3980 1.4239 145.5000 1.3686 145.6980 1.3686 145.8000 1.4932 145.9980 1.4932 146.1000 1.3527 146.2980 1.3527 146.4000 1.6149 146.5980 1.6149 146.7000 1.6066 146.8980 1.6066 147.0000 1.7000 147.1980 1.7000 147.3000 1.5284 147.4980 1.5284 147.6000 1.1273 147.7980 1.1273 147.9000 1.5936 148.0980 1.5936 148.2000 1.7000 148.3980 1.7000 148.5000 1.3411 148.6980 1.3411 148.8000 1.0636 148.9980 1.0636 149.1000 1.2662 149.2980 1.2662 149.4000 1.3557 149.5980 1.3557 149.7000 1.4687 149.8980 1.4687 150.0000 1.3298 150.1980 1.3298 150.3000 1.4403 150.4980 1.4403 150.6000 1.7000 150.7980 1.7000 150.9000 1.6215 151.0980 1.6215 151.2000 1.3890 151.3980 1.3890 151.5000 1.0167 151.6980 1.0167 151.8000 1.6680 151.9980 1.6680 152.1000 1.2853 152.2980 1.2853 152.4000 1.5178 152.5980 1.5178 152.7000 1.3289 152.8980 1.3289 153.0000 1.4717 153.1980 1.4717 153.3000 1.3485 153.4980 1.3485 153.6000 0.7654 153.7980 0.7654 153.9000 1.3865 154.0980 1.3865 154.2000 1.6290 154.3980 1.6290 154.5000 0.8489 154.6980 0.8489 154.8000 1.5180 154.9980 1.5180 155.1000 1.0014 155.2980 1.0014 155.4000 1.0727 155.5980 1.0727 155.7000 1.5365 155.8980 1.5365 156.0000 1.2242 156.1980 1.2242 156.3000 0.8932 156.4980 0.8932 156.6000 1.1560 156.7980 1.1560 156.9000 1.4669 157.0980 1.4669 157.2000 1.4599 157.3980 1.4599 157.5000 1.5164 157.6980 1.5164 157.8000 0.4370 157.9980 0.4370 158.1000 1.3328 158.2980 1.3328 158.4000 1.4404 158.5980 1.4404 158.7000 1.7000 158.8980 1.7000 159.0000 0.9742 159.1980 0.9742 159.3000 1.3125 159.4980 1.3125 159.6000 1.0458 159.7980 1.0458 159.9000 0.9826 160.0980 0.9826 160.2000 1.7000 160.3980 1.7000 160.5000 1.2201 160.6980 1.2201 160.8000 0.9923 160.9980 0.9923 161.1000 1.1317 161.2980 1.1317 161.4000 1.7000 161.5980 1.7000 161.7000 1.1677 161.8980 1.1677 162.0000 1.6994 162.1980 1.6994 162.3000 0.9488 162.4980 0.9488 162.6000 1.7000 162.7980 1.7000 162.9000 1.1912 163.0980 1.1912 163.2000 1.7000 163.3980 1.7000 163.5000 0.8032 163.6980 0.8032 163.8000 0.8656 163.9980 0.8656 164.1000 1.0673 164.2980 1.0673 164.4000 1.7000 164.5980 1.7000 164.7000 1.1240 164.8980 1.1240 165.0000 1.7000 165.1980 1.7000 165.3000 0.7099 165.4980 0.7099 165.6000 1.5949 165.7980 1.5949 165.9000 1.1241 166.0980 1.1241 166.2000 1.6695 166.3980 1.6695 166.5000 1.4415 166.6980 1.4415 166.8000 1.4239 166.9980 1.4239 167.1000 1.3686 167.2980 1.3686 167.4000 1.4932 167.5980 1.4932 167.7000 1.3527 167.8980 1.3527 168.0000 1.6149 168.1980 1.6149 168.3000 1.6066 168.4980 1.6066 168.6000 1.7000 168.7980 1.7000 168.9000 1.5284 169.0980 1.5284 169.2000 1.1273 169.3980 1.1273 169.5000 1.5936 169.6980 1.5936 169.8000 1.7000 169.9980 1.7000 170.1000 1.3411 170.2980 1.3411 170.4000 1.0636 170.5980 1.0636 170.7000 1.2662 170.8980 1.2662 171.0000 1.3557 171.1980 1.3557 171.3000 1.4687 171.4980 1.4687 171.6000 1.3298 171.7980 1.3298 171.9000 1.4403 172.0980 1.4403 172.2000 1.7000 172.3980 1.7000 172.5000 1.6215 172.6980 1.6215 172.8000 1.3890 172.9980 1.3890 173.1000 1.0167 173.2980 1.0167 173.4000 1.6680 173.5980 1.6680 173.7000 1.2853 173.8980 1.2853 174.0000 1.5178 174.1980 1.5178 174.3000 1.3289 174.4980 1.3289 174.6000 1.4717 174.7980 1.4717 174.9000 1.3485 175.0980 1.3485 175.2000 0.7654 175.3980 0.7654 175.5000 1.3865 175.6980 1.3865 175.8000 1.6290 175.9980 1.6290 176.1000 0.8489 176.2980 0.8489 176.4000 1.5180 176.5980 1.5180 176.7000 1.0014 176.8980 1.0014 177.0000 1.0727 177.1980 1.0727 177.3000 1.5365 177.4980 1.5365 177.6000 1.2242 177.7980 1.2242 177.9000 0.8932 178.0980 0.8932 178.2000 1.1560 178.3980 1.1560 178.5000 1.4669 178.6980 1.4669 178.8000 1.4599 178.9980 1.4599 179.1000 1.5164 179.2980 1.5164 179.4000 0.4370 179.5980 0.4370 179.7000 1.3328 179.8980 1.3328 180.0000 1.4404 180.1980 1.4404 180.3000 1.7000 180.4980 1.7000 180.6000 0.9742 180.7980 0.9742 180.9000 1.3125 181.0980 1.3125 181.2000 1.0458 181.3980 1.0458 181.5000 0.9826 181.6980 0.9826 181.8000 1.7000 181.9980 1.7000 182.1000 1.2201 182.2980 1.2201 182.4000 0.9923 182.5980 0.9923 182.7000 1.1317 182.8980 1.1317 183.0000 1.7000 183.1980 1.7000 183.3000 1.1677 183.4980 1.1677 183.6000 1.6994 183.7980 1.6994 183.9000 0.9488 184.0980 0.9488 184.2000 1.7000 184.3980 1.7000 184.5000 1.1912 184.6980 1.1912 184.8000 1.7000 184.9980 1.7000 185.1000 0.8032 185.2980 0.8032 185.4000 0.8656 185.5980 0.8656 185.7000 1.0673 185.8980 1.0673 186.0000 1.7000 186.1980 1.7000 186.3000 1.1240 186.4980 1.1240 186.6000 1.7000 186.7980 1.7000 186.9000 0.7099 187.0980 0.7099 187.2000 1.5949 187.3980 1.5949 187.5000 1.1241 187.6980 1.1241 187.8000 1.6695 187.9980 1.6695 188.1000 1.4415 188.2980 1.4415 188.4000 1.4239 188.5980 1.4239 188.7000 1.3686 188.8980 1.3686 189.0000 1.4932 189.1980 1.4932 189.3000 1.3527 189.4980 1.3527 189.6000 1.6149 189.7980 1.6149 189.9000 1.6066 190.0980 1.6066 190.2000 1.7000 190.3980 1.7000 190.5000 1.5284 190.6980 1.5284 190.8000 1.1273 190.9980 1.1273 191.1000 1.5936 191.2980 1.5936 191.4000 1.7000 191.5980 1.7000 191.7000 1.3411 191.8980 1.3411 192.0000 1.0636 192.1980 1.0636 192.3000 1.2662 192.4980 1.2662 192.6000 1.3557 192.7980 1.3557 192.9000 1.4687 193.0980 1.4687 193.2000 1.3298 193.3980 1.3298 193.5000 1.4403 193.6980 1.4403 193.8000 1.7000 193.9980 1.7000 194.1000 1.6215 194.2980 1.6215 194.4000 1.3890 194.5980 1.3890 194.7000 1.0167 194.8980 1.0167 195.0000 1.6680 195.1980 1.6680 195.3000 1.2853 195.4980 1.2853 195.6000 1.5178 195.7980 1.5178 195.9000 1.3289 196.0980 1.3289 196.2000 1.4717 196.3980 1.4717 196.5000 1.3485 196.6980 1.3485 196.8000 0.7654 196.9980 0.7654 197.1000 1.3865 197.2980 1.3865 197.4000 1.6290 197.5980 1.6290 197.7000 0.8489 197.8980 0.8489 198.0000 1.5180 198.1980 1.5180 198.3000 1.0014 198.4980 1.0014 198.6000 1.0727 198.7980 1.0727 198.9000 1.5365 199.0980 1.5365 199.2000 1.2242 199.3980 1.2242 199.5000 0.8932 199.6980 0.8932 199.8000 1.1560 199.9980 1.1560 200.1000 1.4669 200.2980 1.4669 200.4000 1.4599 200.5980 1.4599 200.7000 1.5164 200.8980 1.5164 201.0000 0.4370 201.1980 0.4370 201.3000 1.3328 201.4980 1.3328 201.6000 1.4404 201.7980 1.4404 201.9000 1.7000 202.0980 1.7000 202.2000 0.9742 202.3980 0.9742 202.5000 1.3125 202.6980 1.3125 202.8000 1.0458 202.9980 1.0458 203.1000 0.9826 203.2980 0.9826 203.4000 1.7000 203.5980 1.7000 203.7000 1.2201 203.8980 1.2201 204.0000 0.9923 204.1980 0.9923 204.3000 1.1317 204.4980 1.1317 204.6000 1.7000 204.7980 1.7000 204.9000 1.1677 205.0980 1.1677 205.2000 1.6994 205.3980 1.6994 205.5000 0.9488 205.6980 0.9488 205.8000 1.7000 205.9980 1.7000 206.1000 1.1912 206.2980 1.1912 206.4000 1.7000 206.5980 1.7000 206.7000 0.8032 206.8980 0.8032 207.0000 0.8656 207.1980 0.8656 207.3000 1.0673 207.4980 1.0673 207.6000 1.7000 207.7980 1.7000 207.9000 1.1240 208.0980 1.1240 208.2000 1.7000 208.3980 1.7000 208.5000 0.7099 208.6980 0.7099 208.8000 1.5949 208.9980 1.5949 209.1000 1.1241 209.2980 1.1241 209.4000 1.6695 209.5980 1.6695 209.7000 1.4415 209.8980 1.4415 210.0000 1.4239 210.1980 1.4239 210.3000 1.3686 210.4980 1.3686 210.6000 1.4932 210.7980 1.4932 210.9000 1.3527 211.0980 1.3527 211.2000 1.6149 211.3980 1.6149 211.5000 1.6066 211.6980 1.6066 211.8000 1.7000 211.9980 1.7000 212.1000 1.5284 212.2980 1.5284 212.4000 1.1273 212.5980 1.1273 212.7000 1.5936 212.8980 1.5936 213.0000 1.7000 213.1980 1.7000 213.3000 1.3411 213.4980 1.3411 213.6000 1.0636 213.7980 1.0636 213.9000 1.2662 214.0980 1.2662 214.2000 1.3557 214.3980 1.3557 214.5000 1.4687 214.6980 1.4687 214.8000 1.3298 214.9980 1.3298 215.1000 1.4403 215.2980 1.4403 215.4000 1.7000 215.5980 1.7000 215.7000 1.6215 215.8980 1.6215 216.0000 1.3890 216.1980 1.3890 216.3000 1.0167 216.4980 1.0167 216.6000 1.6680 216.7980 1.6680 216.9000 1.2853 217.0980 1.2853 217.2000 1.5178 217.3980 1.5178 217.5000 1.3289 217.6980 1.3289 217.8000 1.4717 217.9980 1.4717 218.1000 1.3485 218.2980 1.3485 218.4000 0.7654 218.5980 0.7654 218.7000 1.3865 218.8980 1.3865 219.0000 1.6290 219.1980 1.6290 219.3000 0.8489 219.4980 0.8489 219.6000 1.5180 219.7980 1.5180 219.9000 1.0014 220.0980 1.0014 220.2000 1.0727 220.3980 1.0727 220.5000 1.5365 220.6980 1.5365 220.8000 1.2242 220.9980 1.2242 221.1000 0.8932 221.2980 0.8932 221.4000 1.1560 221.5980 1.1560 221.7000 1.4669 221.8980 1.4669 222.0000 1.4599 222.1980 1.4599 222.3000 1.5164 222.4980 1.5164 222.6000 0.4370 222.7980 0.4370 222.9000 1.3328 223.0980 1.3328 223.2000 1.4404 223.3980 1.4404 223.5000 1.7000 223.6980 1.7000 223.8000 0.9742 223.9980 0.9742 224.1000 1.3125 224.2980 1.3125 224.4000 1.0458 224.5980 1.0458 224.7000 0.9826 224.8980 0.9826 225.0000 1.7000 225.1980 1.7000 225.3000 1.2201 225.4980 1.2201 225.6000 0.9923 225.7980 0.9923 225.9000 1.1317 226.0980 1.1317 226.2000 1.7000 226.3980 1.7000 226.5000 1.1677 226.6980 1.1677 226.8000 1.6994 226.9980 1.6994 227.1000 0.9488 227.2980 0.9488 227.4000 1.7000 227.5980 1.7000 227.7000 1.1912 227.8980 1.1912 228.0000 1.7000 228.1980 1.7000 228.3000 0.8032 228.4980 0.8032 228.6000 0.8656 228.7980 0.8656 228.9000 1.0673 229.0980 1.0673 229.2000 1.7000 229.3980 1.7000 229.5000 1.1240 229.6980 1.1240 229.8000 1.7000 229.9980 1.7000 230.1000 0.7099 230.2980 0.7099 230.4000 1.5949 230.5980 1.5949 230.7000 1.1241 230.8980 1.1241 231.0000 1.6695 231.1980 1.6695 231.3000 1.4415 231.4980 1.4415 231.6000 1.4239 231.7980 1.4239 231.9000 1.3686 232.0980 1.3686 232.2000 1.4932 232.3980 1.4932 232.5000 1.3527 232.6980 1.3527 232.8000 1.6149 232.9980 1.6149 233.1000 1.6066 233.2980 1.6066 233.4000 1.7000 233.5980 1.7000 233.7000 1.5284 233.8980 1.5284 234.0000 1.1273 234.1980 1.1273 234.3000 1.5936 234.4980 1.5936 234.6000 1.7000 234.7980 1.7000 234.9000 1.3411 235.0980 1.3411 235.2000 1.0636 235.3980 1.0636 235.5000 1.2662 235.6980 1.2662 235.8000 1.3557 235.9980 1.3557 236.1000 1.4687 236.2980 1.4687 236.4000 1.3298 236.5980 1.3298 236.7000 1.4403 236.8980 1.4403 237.0000 1.7000 237.1980 1.7000 237.3000 1.6215 237.4980 1.6215 237.6000 1.3890 237.7980 1.3890 237.9000 1.0167 238.0980 1.0167 238.2000 1.6680 238.3980 1.6680 238.5000 1.2853 238.6980 1.2853 238.8000 1.5178 238.9980 1.5178 239.1000 1.3289 239.2980 1.3289 239.4000 1.4717 239.5980 1.4717 239.7000 1.3485 239.8980 1.3485 240.0000 0.7654 240.1980 0.7654 240.3000 1.3865 240.4980 1.3865 240.6000 1.6290 240.7980 1.6290 240.9000 0.8489 241.0980 0.8489 241.2000 1.5180 241.3980 1.5180 241.5000 1.0014 241.6980 1.0014 241.8000 1.0727 241.9980 1.0727 242.1000 1.5365 242.2980 1.5365 242.4000 1.2242 242.5980 1.2242 242.7000 0.8932 242.8980 0.8932 243.0000 1.1560 243.1980 1.1560 243.3000 1.4669 243.4980 1.4669 243.6000 1.4599 243.7980 1.4599 243.9000 1.5164 244.0980 1.5164 244.2000 0.4370 244.3980 0.4370 244.5000 1.3328 244.6980 1.3328 244.8000 1.4404 244.9980 1.4404 245.1000 1.7000 245.2980 1.7000 245.4000 0.9742 245.5980 0.9742 245.7000 1.3125 245.8980 1.3125 246.0000 1.0458 246.1980 1.0458 246.3000 0.9826 246.4980 0.9826 246.6000 1.7000 246.7980 1.7000 246.9000 1.2201 247.0980 1.2201 247.2000 0.9923 247.3980 0.9923 247.5000 1.1317 247.6980 1.1317 247.8000 1.7000 247.9980 1.7000 248.1000 1.1677 248.2980 1.1677 248.4000 1.6994 248.5980 1.6994 248.7000 0.9488 248.8980 0.9488 249.0000 1.7000 249.1980 1.7000 249.3000 1.1912 249.4980 1.1912 249.6000 1.7000 249.7980 1.7000 249.9000 0.8032 250.0980 0.8032 250.2000 0.8656 250.3980 0.8656 250.5000 1.0673 250.6980 1.0673 250.8000 1.7000 250.9980 1.7000 251.1000 1.1240 251.2980 1.1240 251.4000 1.7000 251.5980 1.7000 251.7000 0.7099 251.8980 0.7099 252.0000 1.5949 252.1980 1.5949 252.3000 1.1241 252.4980 1.1241 252.6000 1.6695 252.7980 1.6695 252.9000 1.4415 253.0980 1.4415 253.2000 1.4239 253.3980 1.4239 253.5000 1.3686 253.6980 1.3686 253.8000 1.4932 253.9980 1.4932 254.1000 1.3527 254.2980 1.3527 254.4000 1.6149 254.5980 1.6149 254.7000 1.6066 254.8980 1.6066 255.0000 1.7000 255.1980 1.7000 255.3000 1.5284 255.4980 1.5284 255.6000 1.1273 255.7980 1.1273 255.9000 1.5936 256.0980 1.5936 256.2000 1.7000 256.3980 1.7000 256.5000 1.3411 256.6980 1.3411 256.8000 1.0636 256.9980 1.0636 257.1000 1.2662 257.2980 1.2662 257.4000 1.3557 257.5980 1.3557 257.7000 1.4687 257.8980 1.4687 258.0000 1.3298 258.1980 1.3298 258.3000 1.4403 258.4980 1.4403 258.6000 1.7000 258.7980 1.7000 258.9000 1.6215 259.0980 1.6215 259.2000 1.3890 259.3980 1.3890 259.5000 1.0167 259.6980 1.0167 259.8000 1.6680 259.9980 1.6680 260.1000 1.2853 260.2980 1.2853 260.4000 1.5178 260.5980 1.5178 260.7000 1.3289 260.8980 1.3289 261.0000 1.4717 261.1980 1.4717 261.3000 1.3485 261.4980 1.3485 261.6000 0.7654 261.7980 0.7654 261.9000 1.3865 262.0980 1.3865 262.2000 1.6290 262.3980 1.6290 262.5000 0.8489 262.6980 0.8489 262.8000 1.5180 262.9980 1.5180 263.1000 1.0014 263.2980 1.0014 263.4000 1.0727 263.5980 1.0727 263.7000 1.5365 263.8980 1.5365 264.0000 1.2242 264.1980 1.2242 264.3000 0.8932 264.4980 0.8932 264.6000 1.1560 264.7980 1.1560 264.9000 1.4669 265.0980 1.4669 265.2000 1.4599 265.3980 1.4599 265.5000 1.5164 265.6980 1.5164 265.8000 0.4370 265.9980 0.4370 266.1000 1.3328 266.2980 1.3328 266.4000 1.4404 266.5980 1.4404 266.7000 1.7000 266.8980 1.7000 267.0000 0.9742 267.1980 0.9742 267.3000 1.3125 267.4980 1.3125 267.6000 1.0458 267.7980 1.0458 267.9000 0.9826 268.0980 0.9826 268.2000 1.7000 268.3980 1.7000 268.5000 1.2201 268.6980 1.2201 268.8000 0.9923 268.9980 0.9923 269.1000 1.1317 269.2980 1.1317 269.4000 1.7000 269.5980 1.7000 269.7000 1.1677 269.8980 1.1677 270.0000 1.6994 270.1980 1.6994 270.3000 0.9488 270.4980 0.9488 270.6000 1.7000 270.7980 1.7000 270.9000 1.1912 271.0980 1.1912 271.2000 1.7000 271.3980 1.7000 271.5000 0.8032 271.6980 0.8032 271.8000 0.8656 271.9980 0.8656 272.1000 1.0673 272.2980 1.0673 272.4000 1.7000 272.5980 1.7000 272.7000 1.1240 272.8980 1.1240 273.0000 1.7000 273.1980 1.7000 273.3000 0.7099 273.4980 0.7099 273.6000 1.5949 273.7980 1.5949 273.9000 1.1241 274.0980 1.1241 274.2000 1.6695 274.3980 1.6695 274.5000 1.4415 274.6980 1.4415 274.8000 1.4239 274.9980 1.4239 275.1000 1.3686 275.2980 1.3686 275.4000 1.4932 275.5980 1.4932 275.7000 1.3527 275.8980 1.3527 276.0000 1.6149 276.1980 1.6149 276.3000 1.6066 276.4980 1.6066 276.6000 1.7000 276.7980 1.7000 276.9000 1.5284 277.0980 1.5284 277.2000 1.1273 277.3980 1.1273 277.5000 1.5936 277.6980 1.5936 277.8000 1.7000 277.9980 1.7000 278.1000 1.3411 278.2980 1.3411 278.4000 1.0636 278.5980 1.0636 278.7000 1.2662 278.8980 1.2662 279.0000 1.3557 279.1980 1.3557 279.3000 1.4687 279.4980 1.4687 279.6000 1.3298 279.7980 1.3298 279.9000 1.4403 280.0980 1.4403 280.2000 1.7000 280.3980 1.7000 280.5000 1.6215 280.6980 1.6215 280.8000 1.3890 280.9980 1.3890 281.1000 1.0167 281.2980 1.0167 281.4000 1.6680 281.5980 1.6680 281.7000 1.2853 281.8980 1.2853 282.0000 1.5178 282.1980 1.5178 282.3000 1.3289 282.4980 1.3289 282.6000 1.4717 282.7980 1.4717 282.9000 1.3485 283.0980 1.3485 283.2000 0.7654 283.3980 0.7654 283.5000 1.3865 283.6980 1.3865 283.8000 1.6290 283.9980 1.6290 284.1000 0.8489 284.2980 0.8489 284.4000 1.5180 284.5980 1.5180 284.7000 1.0014 284.8980 1.0014 285.0000 1.0727 285.1980 1.0727 285.3000 1.5365 285.4980 1.5365 285.6000 1.2242 285.7980 1.2242 285.9000 0.8932 286.0980 0.8932 286.2000 1.1560 286.3980 1.1560 286.5000 1.4669 286.6980 1.4669 286.8000 1.4599 286.9980 1.4599 287.1000 1.5164 287.2980 1.5164 287.4000 0.4370 287.5980 0.4370 287.7000 1.3328 287.8980 1.3328 288.0000 1.4404 288.1980 1.4404 288.3000 1.7000 288.4980 1.7000 288.6000 0.9742 288.7980 0.9742 288.9000 1.3125 289.0980 1.3125 289.2000 1.0458 289.3980 1.0458 289.5000 0.9826 289.6980 0.9826 289.8000 1.7000 289.9980 1.7000 290.1000 1.2201 290.2980 1.2201 290.4000 0.9923 290.5980 0.9923 290.7000 1.1317 290.8980 1.1317 291.0000 1.7000 291.1980 1.7000 291.3000 1.1677 291.4980 1.1677 291.6000 1.6994 291.7980 1.6994 291.9000 0.9488 292.0980 0.9488 292.2000 1.7000 292.3980 1.7000 292.5000 1.1912 292.6980 1.1912 292.8000 1.7000 292.9980 1.7000 293.1000 0.8032 293.2980 0.8032 293.4000 0.8656 293.5980 0.8656 293.7000 1.0673 293.8980 1.0673 294.0000 1.7000 294.1980 1.7000 294.3000 1.1240 294.4980 1.1240 294.6000 1.7000 294.7980 1.7000 294.9000 0.7099 295.0980 0.7099 295.2000 1.5949 295.3980 1.5949 295.5000 1.1241 295.6980 1.1241 295.8000 1.6695 295.9980 1.6695 296.1000 1.4415 296.2980 1.4415 296.4000 1.4239 296.5980 1.4239 296.7000 1.3686 296.8980 1.3686 297.0000 1.4932 297.1980 1.4932 297.3000 1.3527 297.4980 1.3527 297.6000 1.6149 297.7980 1.6149 297.9000 1.6066 298.0980 1.6066 298.2000 1.7000 298.3980 1.7000 298.5000 1.5284 298.6980 1.5284 298.8000 1.1273 298.9980 1.1273 299.1000 1.5936 299.2980 1.5936 299.4000 1.7000 299.5980 1.7000 299.7000 1.3411 299.8980 1.3411 300.0000 1.0636 300.1980 1.0636 300.3000 1.2662 300.4980 1.2662 300.6000 1.3557 300.7980 1.3557 300.9000 1.4687 301.0980 1.4687 301.2000 1.3298 301.3980 1.3298 301.5000 1.4403 301.6980 1.4403 301.8000 1.7000 301.9980 1.7000 302.1000 1.6215 302.2980 1.6215 302.4000 1.3890 302.5980 1.3890 302.7000 1.0167 302.8980 1.0167 303.0000 1.6680 303.1980 1.6680 303.3000 1.2853 303.4980 1.2853 303.6000 1.5178 303.7980 1.5178 303.9000 1.3289 304.0980 1.3289 304.2000 1.4717 304.3980 1.4717 304.5000 1.3485 304.6980 1.3485 304.8000 0.7654 304.9980 0.7654 305.1000 1.3865 305.2980 1.3865 305.4000 1.6290 305.5980 1.6290 305.7000 0.8489 305.8980 0.8489 306.0000 1.5180 306.1980 1.5180 306.3000 1.0014 306.4980 1.0014 306.6000 1.0727 306.7980 1.0727 306.9000 1.5365 307.0980 1.5365 307.2000 1.2242 307.3980 1.2242 307.5000 0.8932 307.6980 0.8932 307.8000 1.1560 307.9980 1.1560 308.1000 1.4669 308.2980 1.4669 308.4000 1.4599 308.5980 1.4599 308.7000 1.5164 308.8980 1.5164 309.0000 0.4370 309.1980 0.4370 309.3000 1.3328 309.4980 1.3328 309.6000 1.4404 309.7980 1.4404 309.9000 1.7000 310.0980 1.7000 310.2000 0.9742 310.3980 0.9742 310.5000 1.3125 310.6980 1.3125 310.8000 1.0458 310.9980 1.0458 311.1000 0.9826 311.2980 0.9826 311.4000 1.7000 311.5980 1.7000 311.7000 1.2201 311.8980 1.2201 312.0000 0.9923 312.1980 0.9923 312.3000 1.1317 312.4980 1.1317 312.6000 1.7000 312.7980 1.7000 312.9000 1.1677 313.0980 1.1677 313.2000 1.6994 313.3980 1.6994 313.5000 0.9488 313.6980 0.9488 313.8000 1.7000 313.9980 1.7000 314.1000 1.1912 314.2980 1.1912 314.4000 1.7000 314.5980 1.7000 314.7000 0.8032 314.8980 0.8032 315.0000 0.8656 315.1980 0.8656 315.3000 1.0673 315.4980 1.0673 315.6000 1.7000 315.7980 1.7000 315.9000 1.1240 316.0980 1.1240 316.2000 1.7000 316.3980 1.7000 316.5000 0.7099 316.6980 0.7099 316.8000 1.5949 316.9980 1.5949 317.1000 1.1241 317.2980 1.1241 317.4000 1.6695 317.5980 1.6695 317.7000 1.4415 317.8980 1.4415 318.0000 1.4239 318.1980 1.4239 318.3000 1.3686 318.4980 1.3686 318.6000 1.4932 318.7980 1.4932 318.9000 1.3527 319.0980 1.3527 319.2000 1.6149 319.3980 1.6149 319.5000 1.6066 319.6980 1.6066 319.8000 1.7000 319.9980 1.7000 320.1000 1.5284 320.2980 1.5284 320.4000 1.1273 320.5980 1.1273 320.7000 1.5936 320.8980 1.5936 321.0000 1.7000 321.1980 1.7000 321.3000 1.3411 321.4980 1.3411 321.6000 1.0636 321.7980 1.0636 321.9000 1.2662 322.0980 1.2662 322.2000 1.3557 322.3980 1.3557 322.5000 1.4687 322.6980 1.4687 322.8000 1.3298 322.9980 1.3298 323.1000 1.4403 323.2980 1.4403 323.4000 1.7000 323.5980 1.7000 323.7000 1.6215 323.8980 1.6215 324.0000 1.3890 324.1980 1.3890 324.3000 1.0167 324.4980 1.0167 324.6000 1.6680 324.7980 1.6680 324.9000 1.2853 325.0980 1.2853 325.2000 1.5178 325.3980 1.5178 325.5000 1.3289 325.6980 1.3289 325.8000 1.4717 325.9980 1.4717 326.1000 1.3485 326.2980 1.3485 326.4000 0.7654 326.5980 0.7654 326.7000 1.3865 326.8980 1.3865 327.0000 1.6290 327.1980 1.6290 327.3000 0.8489 327.4980 0.8489 327.6000 1.5180 327.7980 1.5180 327.9000 1.0014 328.0980 1.0014 328.2000 1.0727 328.3980 1.0727 328.5000 1.5365 328.6980 1.5365 328.8000 1.2242 328.9980 1.2242 329.1000 0.8932 329.2980 0.8932 329.4000 1.1560 329.5980 1.1560 329.7000 1.4669 329.8980 1.4669 330.0000 1.4599 330.1980 1.4599 330.3000 1.5164 330.4980 1.5164 330.6000 0.4370 330.7980 0.4370 330.9000 1.3328 331.0980 1.3328 331.2000 1.4404 331.3980 1.4404 331.5000 1.7000 331.6980 1.7000 331.8000 0.9742 331.9980 0.9742 332.1000 1.3125 332.2980 1.3125 332.4000 1.0458 332.5980 1.0458 332.7000 0.9826 332.8980 0.9826 333.0000 1.7000 333.1980 1.7000 333.3000 1.2201 333.4980 1.2201 333.6000 0.9923 333.7980 0.9923 333.9000 1.1317 334.0980 1.1317 334.2000 1.7000 334.3980 1.7000 334.5000 1.1677 334.6980 1.1677 334.8000 1.6994 334.9980 1.6994 335.1000 0.9488 335.2980 0.9488 335.4000 1.7000 335.5980 1.7000 335.7000 1.1912 335.8980 1.1912 336.0000 1.7000 336.1980 1.7000 336.3000 0.8032 336.4980 0.8032 336.6000 0.8656 336.7980 0.8656 336.9000 1.0673 337.0980 1.0673 337.2000 1.7000 337.3980 1.7000 337.5000 1.1240 337.6980 1.1240 337.8000 1.7000 337.9980 1.7000 338.1000 0.7099 338.2980 0.7099 338.4000 1.5949 338.5980 1.5949 338.7000 1.1241 338.8980 1.1241 339.0000 1.6695 339.1980 1.6695 339.3000 1.4415 339.4980 1.4415 339.6000 1.4239 339.7980 1.4239 339.9000 1.3686 340.0980 1.3686 340.2000 1.4932 340.3980 1.4932 340.5000 1.3527 340.6980 1.3527 340.8000 1.6149 340.9980 1.6149 341.1000 1.6066 341.2980 1.6066 341.4000 1.7000 341.5980 1.7000 341.7000 1.5284 341.8980 1.5284 342.0000 1.1273 342.1980 1.1273 342.3000 1.5936 342.4980 1.5936 342.6000 1.7000 342.7980 1.7000 342.9000 1.3411 343.0980 1.3411 343.2000 1.0636 343.3980 1.0636 343.5000 1.2662 343.6980 1.2662 343.8000 1.3557 343.9980 1.3557 344.1000 1.4687 344.2980 1.4687 344.4000 1.3298 344.5980 1.3298 344.7000 1.4403 344.8980 1.4403 345.0000 1.7000 345.1980 1.7000 345.3000 1.6215 345.4980 1.6215 345.6000 1.3890 345.7980 1.3890 345.9000 1.0167 346.0980 1.0167 346.2000 1.6680 346.3980 1.6680 346.5000 1.2853 346.6980 1.2853 346.8000 1.5178 346.9980 1.5178 347.1000 1.3289 347.2980 1.3289 347.4000 1.4717 347.5980 1.4717 347.7000 1.3485 347.8980 1.3485 348.0000 0.7654 348.1980 0.7654 348.3000 1.3865 348.4980 1.3865 348.6000 1.6290 348.7980 1.6290 348.9000 0.8489 349.0980 0.8489 349.2000 1.5180 349.3980 1.5180 349.5000 1.0014 349.6980 1.0014 349.8000 1.0727 349.9980 1.0727 350.1000 1.5365 350.2980 1.5365 350.4000 1.2242 350.5980 1.2242 350.7000 0.8932 350.8980 0.8932 351.0000 1.1560 351.1980 1.1560 351.3000 1.4669 351.4980 1.4669 351.6000 1.4599 351.7980 1.4599 351.9000 1.5164 352.0980 1.5164 352.2000 0.4370 352.3980 0.4370 352.5000 1.3328 352.6980 1.3328 352.8000 1.4404 352.9980 1.4404 353.1000 1.7000 353.2980 1.7000 353.4000 0.9742 353.5980 0.9742 353.7000 1.3125 353.8980 1.3125 354.0000 1.0458 354.1980 1.0458 354.3000 0.9826 354.4980 0.9826 354.6000 1.7000 354.7980 1.7000 354.9000 1.2201 355.0980 1.2201 355.2000 0.9923 355.3980 0.9923 355.5000 1.1317 355.6980 1.1317 355.8000 1.7000 355.9980 1.7000 356.1000 1.1677 356.2980 1.1677 356.4000 1.6994 356.5980 1.6994 356.7000 0.9488 356.8980 0.9488 357.0000 1.7000 357.1980 1.7000 357.3000 1.1912 357.4980 1.1912 357.6000 1.7000 357.7980 1.7000 357.9000 0.8032 358.0980 0.8032 358.2000 0.8656 358.3980 0.8656 358.5000 1.0673 358.6980 1.0673 358.8000 1.7000 358.9980 1.7000 359.1000 1.1240 359.2980 1.1240 359.4000 1.7000 359.5980 1.7000 359.7000 0.7099 359.8980 0.7099 360.0000 1.5949 360.1980 1.5949 360.3000 1.1241 360.4980 1.1241 360.6000 1.6695 360.7980 1.6695 360.9000 1.4415 361.0980 1.4415 361.2000 1.4239 361.3980 1.4239 361.5000 1.3686 361.6980 1.3686 361.8000 1.4932 361.9980 1.4932 362.1000 1.3527 362.2980 1.3527 362.4000 1.6149 362.5980 1.6149 362.7000 1.6066 362.8980 1.6066 363.0000 1.7000 363.1980 1.7000 363.3000 1.5284 363.4980 1.5284 363.6000 1.1273 363.7980 1.1273 363.9000 1.5936 364.0980 1.5936 364.2000 1.7000 364.3980 1.7000 364.5000 1.3411 364.6980 1.3411 364.8000 1.0636 364.9980 1.0636 365.1000 1.2662 365.2980 1.2662 365.4000 1.3557 365.5980 1.3557 365.7000 1.4687 365.8980 1.4687 366.0000 1.3298 366.1980 1.3298 366.3000 1.4403 366.4980 1.4403 366.6000 1.7000 366.7980 1.7000 366.9000 1.6215 367.0980 1.6215 367.2000 1.3890 367.3980 1.3890 367.5000 1.0167 367.6980 1.0167 367.8000 1.6680 367.9980 1.6680 368.1000 1.2853 368.2980 1.2853 368.4000 1.5178 368.5980 1.5178 368.7000 1.3289 368.8980 1.3289 369.0000 1.4717 369.1980 1.4717 369.3000 1.3485 369.4980 1.3485 369.6000 0.7654 369.7980 0.7654 369.9000 1.3865 370.0980 1.3865 370.2000 1.6290 370.3980 1.6290 370.5000 0.8489 370.6980 0.8489 370.8000 1.5180 370.9980 1.5180 371.1000 1.0014 371.2980 1.0014 371.4000 1.0727 371.5980 1.0727 371.7000 1.5365 371.8980 1.5365 372.0000 1.2242 372.1980 1.2242 372.3000 0.8932 372.4980 0.8932 372.6000 1.1560 372.7980 1.1560 372.9000 1.4669 373.0980 1.4669 373.2000 1.4599 373.3980 1.4599 373.5000 1.5164 373.6980 1.5164 373.8000 0.4370 373.9980 0.4370 374.1000 1.3328 374.2980 1.3328 374.4000 1.4404 374.5980 1.4404 374.7000 1.7000 374.8980 1.7000 375.0000 0.9742 375.1980 0.9742 375.3000 1.3125 375.4980 1.3125 375.6000 1.0458 375.7980 1.0458 375.9000 0.9826 376.0980 0.9826 376.2000 1.7000 376.3980 1.7000 376.5000 1.2201 376.6980 1.2201 376.8000 0.9923 376.9980 0.9923 377.1000 1.1317 377.2980 1.1317 377.4000 1.7000 377.5980 1.7000 377.7000 1.1677 377.8980 1.1677 378.0000 1.6994 378.1980 1.6994 378.3000 0.9488 378.4980 0.9488 378.6000 1.7000 378.7980 1.7000 378.9000 1.1912 379.0980 1.1912 379.2000 1.7000 379.3980 1.7000 379.5000 0.8032 379.6980 0.8032 379.8000 0.8656 379.9980 0.8656 380.1000 1.0673 380.2980 1.0673 380.4000 1.7000 380.5980 1.7000 380.7000 1.1240 380.8980 1.1240 381.0000 1.7000 381.1980 1.7000 381.3000 0.7099 381.4980 0.7099 381.6000 1.5949 381.7980 1.5949 381.9000 1.1241 382.0980 1.1241 382.2000 1.6695 382.3980 1.6695 382.5000 1.4415 382.6980 1.4415 382.8000 1.4239 382.9980 1.4239 383.1000 1.3686 383.2980 1.3686 383.4000 1.4932 383.5980 1.4932 383.7000 1.3527 383.8980 1.3527 384.0000 1.6149 384.1980 1.6149 384.3000 1.6066 384.4980 1.6066 384.6000 1.7000 384.7980 1.7000 384.9000 1.5284 385.0980 1.5284 385.2000 1.1273 385.3980 1.1273 385.5000 1.5936 385.6980 1.5936 385.8000 1.7000 385.9980 1.7000 386.1000 1.3411 386.2980 1.3411 386.4000 1.0636 386.5980 1.0636 386.7000 1.2662 386.8980 1.2662 387.0000 1.3557 387.1980 1.3557 387.3000 1.4687 387.4980 1.4687 387.6000 1.3298 387.7980 1.3298 387.9000 1.4403 388.0980 1.4403 388.2000 1.7000 388.3980 1.7000 388.5000 1.6215 388.6980 1.6215 388.8000 1.3890 388.9980 1.3890 389.1000 1.0167 389.2980 1.0167 389.4000 1.6680 389.5980 1.6680 389.7000 1.2853 389.8980 1.2853 390.0000 1.5178 390.1980 1.5178 390.3000 1.3289 390.4980 1.3289 390.6000 1.4717 390.7980 1.4717 390.9000 1.3485 391.0980 1.3485 391.2000 0.7654 391.3980 0.7654 391.5000 1.3865 391.6980 1.3865 391.8000 1.6290 391.9980 1.6290 392.1000 0.8489 392.2980 0.8489 392.4000 1.5180 392.5980 1.5180 392.7000 1.0014 392.8980 1.0014 393.0000 1.0727 393.1980 1.0727 393.3000 1.5365 393.4980 1.5365 393.6000 1.2242 393.7980 1.2242 393.9000 0.8932 394.0980 0.8932 394.2000 1.1560 394.3980 1.1560 394.5000 1.4669 394.6980 1.4669 394.8000 1.4599 394.9980 1.4599 395.1000 1.5164 395.2980 1.5164 395.4000 0.4370 395.5980 0.4370 395.7000 1.3328 395.8980 1.3328 396.0000 1.4404 396.1980 1.4404 396.3000 1.7000 396.4980 1.7000 396.6000 0.9742 396.7980 0.9742 396.9000 1.3125 397.0980 1.3125 397.2000 1.0458 397.3980 1.0458 397.5000 0.9826 397.6980 0.9826 397.8000 1.7000 397.9980 1.7000 398.1000 1.2201 398.2980 1.2201 398.4000 0.9923 398.5980 0.9923 398.7000 1.1317 398.8980 1.1317 399.0000 1.7000 399.1980 1.7000 399.3000 1.1677 399.4980 1.1677 399.6000 1.6994 399.7980 1.6994 399.9000 0.9488 400.0980 0.9488 400.2000 1.7000 400.3980 1.7000 400.5000 1.1912 400.6980 1.1912 400.8000 1.7000 400.9980 1.7000 401.1000 0.8032 401.2980 0.8032 401.4000 0.8656 401.5980 0.8656 401.7000 1.0673 401.8980 1.0673 402.0000 1.7000 402.1980 1.7000 402.3000 1.1240 402.4980 1.1240 402.6000 1.7000 402.7980 1.7000 402.9000 0.7099 403.0980 0.7099 403.2000 1.5949 403.3980 1.5949 403.5000 1.1241 403.6980 1.1241 403.8000 1.6695 403.9980 1.6695 404.1000 1.4415 404.2980 1.4415 404.4000 1.4239 404.5980 1.4239 404.7000 1.3686 404.8980 1.3686 405.0000 1.4932 405.1980 1.4932 405.3000 1.3527 405.4980 1.3527 405.6000 1.6149 405.7980 1.6149 405.9000 1.6066 406.0980 1.6066 406.2000 1.7000 406.3980 1.7000 406.5000 1.5284 406.6980 1.5284 406.8000 1.1273 406.9980 1.1273 407.1000 1.5936 407.2980 1.5936 407.4000 1.7000 407.5980 1.7000 407.7000 1.3411 407.8980 1.3411 408.0000 1.0636 408.1980 1.0636 408.3000 1.2662 408.4980 1.2662 408.6000 1.3557 408.7980 1.3557 408.9000 1.4687 409.0980 1.4687 409.2000 1.3298 409.3980 1.3298 409.5000 1.4403 409.6980 1.4403 409.8000 1.7000 409.9980 1.7000 410.1000 1.6215 410.2980 1.6215 410.4000 1.3890 410.5980 1.3890 410.7000 1.0167 410.8980 1.0167 411.0000 1.6680 411.1980 1.6680 411.3000 1.2853 411.4980 1.2853 411.6000 1.5178 411.7980 1.5178 411.9000 1.3289 412.0980 1.3289 412.2000 1.4717 412.3980 1.4717 412.5000 1.3485 412.6980 1.3485 412.8000 0.7654 412.9980 0.7654 413.1000 1.3865 413.2980 1.3865 413.4000 1.6290 413.5980 1.6290 413.7000 0.8489 413.8980 0.8489 414.0000 1.5180 414.1980 1.5180 414.3000 1.0014 414.4980 1.0014 414.6000 1.0727 414.7980 1.0727 414.9000 1.5365 415.0980 1.5365 415.2000 1.2242 415.3980 1.2242 415.5000 0.8932 415.6980 0.8932 415.8000 1.1560 415.9980 1.1560 416.1000 1.4669 416.2980 1.4669 416.4000 1.4599 416.5980 1.4599 416.7000 1.5164 416.8980 1.5164 417.0000 0.4370 417.1980 0.4370 417.3000 1.3328 417.4980 1.3328 417.6000 1.4404 417.7980 1.4404 417.9000 1.7000 418.0980 1.7000 418.2000 0.9742 418.3980 0.9742 418.5000 1.3125 418.6980 1.3125 418.8000 1.0458 418.9980 1.0458 419.1000 0.9826 419.2980 0.9826 419.4000 1.7000 419.5980 1.7000 419.7000 1.2201 419.8980 1.2201 420.0000 0.9923 420.1980 0.9923 420.3000 1.1317 420.4980 1.1317 420.6000 1.7000 420.7980 1.7000 420.9000 1.1677 421.0980 1.1677 421.2000 1.6994 421.3980 1.6994 421.5000 0.9488 421.6980 0.9488 421.8000 1.7000 421.9980 1.7000 422.1000 1.1912 422.2980 1.1912 422.4000 1.7000 422.5980 1.7000 422.7000 0.8032 422.8980 0.8032 423.0000 0.8656 423.1980 0.8656 423.3000 1.0673 423.4980 1.0673 423.6000 1.7000 423.7980 1.7000 423.9000 1.1240 424.0980 1.1240 424.2000 1.7000 424.3980 1.7000 424.5000 0.7099 424.6980 0.7099 424.8000 1.5949 424.9980 1.5949 425.1000 1.1241 425.2980 1.1241 425.4000 1.6695 425.5980 1.6695 425.7000 1.4415 425.8980 1.4415 426.0000 1.4239 426.1980 1.4239 426.3000 1.3686 426.4980 1.3686 426.6000 1.4932 426.7980 1.4932 426.9000 1.3527 427.0980 1.3527 427.2000 1.6149 427.3980 1.6149 427.5000 1.6066 427.6980 1.6066 427.8000 1.7000 427.9980 1.7000 428.1000 1.5284 428.2980 1.5284 428.4000 1.1273 428.5980 1.1273 428.7000 1.5936 428.8980 1.5936 429.0000 1.7000 429.1980 1.7000 429.3000 1.3411 429.4980 1.3411 429.6000 1.0636 429.7980 1.0636 429.9000 1.2662 430.0980 1.2662 430.2000 1.3557 430.3980 1.3557 430.5000 1.4687 430.6980 1.4687 430.8000 1.3298 430.9980 1.3298 431.1000 1.4403 431.2980 1.4403 431.4000 1.7000 431.5980 1.7000 431.7000 1.6215 431.8980 1.6215 432.0000 1.3890 432.1980 1.3890 432.3000 1.0167 432.4980 1.0167 432.6000 1.6680 432.7980 1.6680 432.9000 1.2853 433.0980 1.2853 433.2000 1.5178 433.3980 1.5178 433.5000 1.3289 433.6980 1.3289 433.8000 1.4717 433.9980 1.4717 434.1000 1.3485 434.2980 1.3485 434.4000 0.7654 434.5980 0.7654 434.7000 1.3865 434.8980 1.3865 435.0000 1.6290 435.1980 1.6290 435.3000 0.8489 435.4980 0.8489 435.6000 1.5180 435.7980 1.5180 435.9000 1.0014 436.0980 1.0014 436.2000 1.0727 436.3980 1.0727 436.5000 1.5365 436.6980 1.5365 436.8000 1.2242 436.9980 1.2242 437.1000 0.8932 437.2980 0.8932 437.4000 1.1560 437.5980 1.1560 437.7000 1.4669 437.8980 1.4669 438.0000 1.4599 438.1980 1.4599 438.3000 1.5164 438.4980 1.5164 438.6000 0.4370 438.7980 0.4370 438.9000 1.3328 439.0980 1.3328 439.2000 1.4404 439.3980 1.4404 439.5000 1.7000 439.6980 1.7000 439.8000 0.9742 439.9980 0.9742 440.1000 1.3125 440.2980 1.3125 440.4000 1.0458 440.5980 1.0458 440.7000 0.9826 440.8980 0.9826 441.0000 1.7000 441.1980 1.7000 441.3000 1.2201 441.4980 1.2201 441.6000 0.9923 441.7980 0.9923 441.9000 1.1317 442.0980 1.1317 442.2000 1.7000 442.3980 1.7000 442.5000 1.1677 442.6980 1.1677 442.8000 1.6994 442.9980 1.6994 443.1000 0.9488 443.2980 0.9488 443.4000 1.7000 443.5980 1.7000 443.7000 1.1912 443.8980 1.1912 444.0000 1.7000 444.1980 1.7000 444.3000 0.8032 444.4980 0.8032 444.6000 0.8656 444.7980 0.8656 444.9000 1.0673 445.0980 1.0673 445.2000 1.7000 445.3980 1.7000 445.5000 1.1240 445.6980 1.1240 445.8000 1.7000 445.9980 1.7000 446.1000 0.7099 446.2980 0.7099 446.4000 1.5949 446.5980 1.5949 446.7000 1.1241 446.8980 1.1241 447.0000 1.6695 447.1980 1.6695 447.3000 1.4415 447.4980 1.4415 447.6000 1.4239 447.7980 1.4239 447.9000 1.3686 448.0980 1.3686 448.2000 1.4932 448.3980 1.4932 448.5000 1.3527 448.6980 1.3527 448.8000 1.6149 448.9980 1.6149 449.1000 1.6066 449.2980 1.6066 449.4000 1.7000 449.5980 1.7000 449.7000 1.5284 449.8980 1.5284 450.0000 1.1273 450.1980 1.1273 450.3000 1.5936 450.4980 1.5936 450.6000 1.7000 450.7980 1.7000 450.9000 1.3411 451.0980 1.3411 451.2000 1.0636 451.3980 1.0636 451.5000 1.2662 451.6980 1.2662 451.8000 1.3557 451.9980 1.3557 452.1000 1.4687 452.2980 1.4687 452.4000 1.3298 452.5980 1.3298 452.7000 1.4403 452.8980 1.4403 453.0000 1.7000 453.1980 1.7000 453.3000 1.6215 453.4980 1.6215 453.6000 1.3890 453.7980 1.3890 453.9000 1.0167 454.0980 1.0167 454.2000 1.6680 454.3980 1.6680 454.5000 1.2853 454.6980 1.2853 454.8000 1.5178 454.9980 1.5178 455.1000 1.3289 455.2980 1.3289 455.4000 1.4717 455.5980 1.4717 455.7000 1.3485 455.8980 1.3485 456.0000 0.7654 456.1980 0.7654 456.3000 1.3865 456.4980 1.3865 456.6000 1.6290 456.7980 1.6290 456.9000 0.8489 457.0980 0.8489 457.2000 1.5180 457.3980 1.5180 457.5000 1.0014 457.6980 1.0014 457.8000 1.0727 457.9980 1.0727 458.1000 1.5365 458.2980 1.5365 458.4000 1.2242 458.5980 1.2242 458.7000 0.8932 458.8980 0.8932 459.0000 1.1560 459.1980 1.1560 459.3000 1.4669 459.4980 1.4669 459.6000 1.4599 459.7980 1.4599 459.9000 1.5164 460.0980 1.5164 460.2000 0.4370 460.3980 0.4370 460.5000 1.3328 460.6980 1.3328 460.8000 1.4404 460.9980 1.4404 461.1000 1.7000 461.2980 1.7000 461.4000 0.9742 461.5980 0.9742 461.7000 1.3125 461.8980 1.3125 462.0000 1.0458 462.1980 1.0458 462.3000 0.9826 462.4980 0.9826 462.6000 1.7000 462.7980 1.7000 462.9000 1.2201 463.0980 1.2201 463.2000 0.9923 463.3980 0.9923 463.5000 1.1317 463.6980 1.1317 463.8000 1.7000 463.9980 1.7000 464.1000 1.1677 464.2980 1.1677 464.4000 1.6994 464.5980 1.6994 464.7000 0.9488 464.8980 0.9488 465.0000 1.7000 465.1980 1.7000 465.3000 1.1912 465.4980 1.1912 465.6000 1.7000 465.7980 1.7000 465.9000 0.8032 466.0980 0.8032 466.2000 0.8656 466.3980 0.8656 466.5000 1.0673 466.6980 1.0673 466.8000 1.7000 466.9980 1.7000 467.1000 1.1240 467.2980 1.1240 467.4000 1.7000 467.5980 1.7000 467.7000 0.7099 467.8980 0.7099 468.0000 1.5949 468.1980 1.5949 468.3000 1.1241 468.4980 1.1241 468.6000 1.6695 468.7980 1.6695 468.9000 1.4415 469.0980 1.4415 469.2000 1.4239 469.3980 1.4239 469.5000 1.3686 469.6980 1.3686 469.8000 1.4932 469.9980 1.4932 470.1000 1.3527 470.2980 1.3527 470.4000 1.6149 470.5980 1.6149 470.7000 1.6066 470.8980 1.6066 471.0000 1.7000 471.1980 1.7000 471.3000 1.5284 471.4980 1.5284 471.6000 1.1273 471.7980 1.1273 471.9000 1.5936 472.0980 1.5936 472.2000 1.7000 472.3980 1.7000 472.5000 1.3411 472.6980 1.3411 472.8000 1.0636 472.9980 1.0636 473.1000 1.2662 473.2980 1.2662 473.4000 1.3557 473.5980 1.3557 473.7000 1.4687 473.8980 1.4687 474.0000 1.3298 474.1980 1.3298 474.3000 1.4403 474.4980 1.4403 474.6000 1.7000 474.7980 1.7000 474.9000 1.6215 475.0980 1.6215 475.2000 1.3890 475.3980 1.3890 475.5000 1.0167 475.6980 1.0167 475.8000 1.6680 475.9980 1.6680 476.1000 1.2853 476.2980 1.2853 476.4000 1.5178 476.5980 1.5178 476.7000 1.3289 476.8980 1.3289 477.0000 1.4717 477.1980 1.4717 477.3000 1.3485 477.4980 1.3485 477.6000 0.7654 477.7980 0.7654 477.9000 1.3865 478.0980 1.3865 478.2000 1.6290 478.3980 1.6290 478.5000 0.8489 478.6980 0.8489 478.8000 1.5180 478.9980 1.5180 479.1000 1.0014 479.2980 1.0014 479.4000 1.0727 479.5980 1.0727 479.7000 1.5365 479.8980 1.5365 480.0000 1.2242 480.1980 1.2242 480.3000 0.8932 480.4980 0.8932 480.6000 1.1560 480.7980 1.1560 480.9000 1.4669 481.0980 1.4669 481.2000 1.4599 481.3980 1.4599 481.5000 1.5164 481.6980 1.5164 481.8000 0.4370 481.9980 0.4370 482.1000 1.3328 482.2980 1.3328 482.4000 1.4404 482.5980 1.4404 482.7000 1.7000 482.8980 1.7000 483.0000 0.9742 483.1980 0.9742 483.3000 1.3125 483.4980 1.3125 483.6000 1.0458 483.7980 1.0458 483.9000 0.9826 484.0980 0.9826 484.2000 1.7000 484.3980 1.7000 484.5000 1.2201 484.6980 1.2201 484.8000 0.9923 484.9980 0.9923 485.1000 1.1317 485.2980 1.1317 485.4000 1.7000 485.5980 1.7000 485.7000 1.1677 485.8980 1.1677 486.0000 1.6994 486.1980 1.6994 486.3000 0.9488 486.4980 0.9488 486.6000 1.7000 486.7980 1.7000 486.9000 1.1912 487.0980 1.1912 487.2000 1.7000 487.3980 1.7000 487.5000 0.8032 487.6980 0.8032 487.8000 0.8656 487.9980 0.8656 488.1000 1.0673 488.2980 1.0673 488.4000 1.7000 488.5980 1.7000 488.7000 1.1240 488.8980 1.1240 489.0000 1.7000 489.1980 1.7000 489.3000 0.7099 489.4980 0.7099 489.6000 1.5949 489.7980 1.5949 489.9000 1.1241 490.0980 1.1241 490.2000 1.6695 490.3980 1.6695 490.5000 1.4415 490.6980 1.4415 490.8000 1.4239 490.9980 1.4239 491.1000 1.3686 491.2980 1.3686 491.4000 1.4932 491.5980 1.4932 491.7000 1.3527 491.8980 1.3527 492.0000 1.6149 492.1980 1.6149 492.3000 1.6066 492.4980 1.6066 492.6000 1.7000 492.7980 1.7000 492.9000 1.5284 493.0980 1.5284 493.2000 1.1273 493.3980 1.1273 493.5000 1.5936 493.6980 1.5936 493.8000 1.7000 493.9980 1.7000 494.1000 1.3411 494.2980 1.3411 494.4000 1.0636 494.5980 1.0636 494.7000 1.2662 494.8980 1.2662 495.0000 1.3557 495.1980 1.3557 495.3000 1.4687 495.4980 1.4687 495.6000 1.3298 495.7980 1.3298 495.9000 1.4403 496.0980 1.4403 496.2000 1.7000 496.3980 1.7000 496.5000 1.6215 496.6980 1.6215 496.8000 1.3890 496.9980 1.3890 497.1000 1.0167 497.2980 1.0167 497.4000 1.6680 497.5980 1.6680 497.7000 1.2853 497.8980 1.2853 498.0000 1.5178 498.1980 1.5178 498.3000 1.3289 498.4980 1.3289 498.6000 1.4717 498.7980 1.4717 498.9000 1.3485 499.0980 1.3485 499.2000 0.7654 499.3980 0.7654 499.5000 1.3865 499.6980 1.3865 499.8000 1.6290 499.9980 1.6290 500.1000 0.8489 500.2980 0.8489 500.4000 1.5180 500.5980 1.5180 500.7000 1.0014 500.8980 1.0014 501.0000 1.0727 501.1980 1.0727 501.3000 1.5365 501.4980 1.5365 501.6000 1.2242 501.7980 1.2242 501.9000 0.8932 502.0980 0.8932 502.2000 1.1560 502.3980 1.1560 502.5000 1.4669 502.6980 1.4669 502.8000 1.4599 502.9980 1.4599 503.1000 1.5164 503.2980 1.5164 503.4000 0.4370 503.5980 0.4370 503.7000 1.3328 503.8980 1.3328 504.0000 1.4404 504.1980 1.4404 504.3000 1.7000 504.4980 1.7000 504.6000 0.9742 504.7980 0.9742 504.9000 1.3125 505.0980 1.3125 505.2000 1.0458 505.3980 1.0458 505.5000 0.9826 505.6980 0.9826 505.8000 1.7000 505.9980 1.7000 506.1000 1.2201 506.2980 1.2201 506.4000 0.9923 506.5980 0.9923 506.7000 1.1317 506.8980 1.1317 507.0000 1.7000 507.1980 1.7000 507.3000 1.1677 507.4980 1.1677 507.6000 1.6994 507.7980 1.6994 507.9000 0.9488 508.0980 0.9488 508.2000 1.7000 508.3980 1.7000 508.5000 1.1912 508.6980 1.1912 508.8000 1.7000 508.9980 1.7000 509.1000 0.8032 509.2980 0.8032 509.4000 0.8656 509.5980 0.8656 509.7000 1.0673 509.8980 1.0673 510.0000 1.7000 510.1980 1.7000 510.3000 1.1240 510.4980 1.1240 510.6000 1.7000 510.7980 1.7000 510.9000 0.7099 511.0980 0.7099 511.2000 1.5949 511.3980 1.5949 511.5000 1.1241 511.6980 1.1241 511.8000 1.6695 511.9980 1.6695 512.1000 1.4415 512.2980 1.4415 512.4000 1.4239 512.5980 1.4239 512.7000 1.3686 512.8980 1.3686 513.0000 1.4932 513.1980 1.4932 513.3000 1.3527 513.4980 1.3527 513.6000 1.6149 513.7980 1.6149 513.9000 1.6066 514.0980 1.6066 514.2000 1.7000 514.3980 1.7000 514.5000 1.5284 514.6980 1.5284 514.8000 1.1273 514.9980 1.1273 515.1000 1.5936 515.2980 1.5936 515.4000 1.7000 515.5980 1.7000 515.7000 1.3411 515.8980 1.3411 516.0000 1.0636 516.1980 1.0636 516.3000 1.2662 516.4980 1.2662 516.6000 1.3557 516.7980 1.3557 516.9000 1.4687 517.0980 1.4687 517.2000 1.3298 517.3980 1.3298 517.5000 1.4403 517.6980 1.4403 517.8000 1.7000 517.9980 1.7000 518.1000 1.6215 518.2980 1.6215 518.4000 1.3890 518.5980 1.3890 518.7000 1.0167 518.8980 1.0167 519.0000 1.6680 519.1980 1.6680 519.3000 1.2853 519.4980 1.2853 519.6000 1.5178 519.7980 1.5178 519.9000 1.3289 520.0980 1.3289 520.2000 1.4717 520.3980 1.4717 520.5000 1.3485 520.6980 1.3485 520.8000 0.7654 520.9980 0.7654 521.1000 1.3865 521.2980 1.3865 521.4000 1.6290 521.5980 1.6290 521.7000 0.8489 521.8980 0.8489 522.0000 1.5180 522.1980 1.5180 522.3000 1.0014 522.4980 1.0014 522.6000 1.0727 522.7980 1.0727 522.9000 1.5365 523.0980 1.5365 523.2000 1.2242 523.3980 1.2242 523.5000 0.8932 523.6980 0.8932 523.8000 1.1560 523.9980 1.1560 524.1000 1.4669 524.2980 1.4669 524.4000 1.4599 524.5980 1.4599 524.7000 1.5164 524.8980 1.5164 525.0000 0.4370 525.1980 0.4370 525.3000 1.3328 525.4980 1.3328 525.6000 1.4404 525.7980 1.4404 525.9000 1.7000 526.0980 1.7000 526.2000 0.9742 526.3980 0.9742 526.5000 1.3125 526.6980 1.3125 526.8000 1.0458 526.9980 1.0458 527.1000 0.9826 527.2980 0.9826 527.4000 1.7000 527.5980 1.7000 527.7000 1.2201 527.8980 1.2201 528.0000 0.9923 528.1980 0.9923 528.3000 1.1317 528.4980 1.1317 528.6000 1.7000 528.7980 1.7000 528.9000 1.1677 529.0980 1.1677 529.2000 1.6994 529.3980 1.6994 529.5000 0.9488 529.6980 0.9488 529.8000 1.7000 529.9980 1.7000 530.1000 1.1912 530.2980 1.1912 530.4000 1.7000 530.5980 1.7000 530.7000 0.8032 530.8980 0.8032 531.0000 0.8656 531.1980 0.8656 531.3000 1.0673 531.4980 1.0673 531.6000 1.7000 531.7980 1.7000 531.9000 1.1240 532.0980 1.1240 532.2000 1.7000 532.3980 1.7000 532.5000 0.7099 532.6980 0.7099 532.8000 1.5949 532.9980 1.5949 533.1000 1.1241 533.2980 1.1241 533.4000 1.6695 533.5980 1.6695 533.7000 1.4415 533.8980 1.4415 534.0000 1.4239 534.1980 1.4239 534.3000 1.3686 534.4980 1.3686 534.6000 1.4932 534.7980 1.4932 534.9000 1.3527 535.0980 1.3527 535.2000 1.6149 535.3980 1.6149 535.5000 1.6066 535.6980 1.6066 535.8000 1.7000 535.9980 1.7000 536.1000 1.5284 536.2980 1.5284 536.4000 1.1273 536.5980 1.1273 536.7000 1.5936 536.8980 1.5936 537.0000 1.7000 537.1980 1.7000 537.3000 1.3411 537.4980 1.3411 537.6000 1.0636 537.7980 1.0636 537.9000 1.2662 538.0980 1.2662 538.2000 1.3557 538.3980 1.3557 538.5000 1.4687 538.6980 1.4687 538.8000 1.3298 538.9980 1.3298 539.1000 1.4403 539.2980 1.4403 539.4000 1.7000 539.5980 1.7000 539.7000 1.6215 539.8980 1.6215 540.0000 1.3890 540.1980 1.3890 540.3000 1.0167 540.4980 1.0167 540.6000 1.6680 540.7980 1.6680 540.9000 1.2853 541.0980 1.2853 541.2000 1.5178 541.3980 1.5178 541.5000 1.3289 541.6980 1.3289 541.8000 1.4717 541.9980 1.4717 542.1000 1.3485 542.2980 1.3485 542.4000 0.7654 542.5980 0.7654 542.7000 1.3865 542.8980 1.3865 543.0000 1.6290 543.1980 1.6290 543.3000 0.8489 543.4980 0.8489 543.6000 1.5180 543.7980 1.5180 543.9000 1.0014 544.0980 1.0014 544.2000 1.0727 544.3980 1.0727 544.5000 1.5365 544.6980 1.5365 544.8000 1.2242 544.9980 1.2242 545.1000 0.8932 545.2980 0.8932 545.4000 1.1560 545.5980 1.1560 545.7000 1.4669 545.8980 1.4669 546.0000 1.4599 546.1980 1.4599 546.3000 1.5164 546.4980 1.5164 546.6000 0.4370 546.7980 0.4370 546.9000 1.3328 547.0980 1.3328 547.2000 1.4404 547.3980 1.4404 547.5000 1.7000 547.6980 1.7000 547.8000 0.9742 547.9980 0.9742 548.1000 1.3125 548.2980 1.3125 548.4000 1.0458 548.5980 1.0458 548.7000 0.9826 548.8980 0.9826 549.0000 1.7000 549.1980 1.7000 549.3000 1.2201 549.4980 1.2201 549.6000 0.9923 549.7980 0.9923 549.9000 1.1317 550.0980 1.1317 550.2000 1.7000 550.3980 1.7000 550.5000 1.1677 550.6980 1.1677 550.8000 1.6994 550.9980 1.6994 551.1000 0.9488 551.2980 0.9488 551.4000 1.7000 551.5980 1.7000 551.7000 1.1912 551.8980 1.1912 552.0000 1.7000 552.1980 1.7000 552.3000 0.8032 552.4980 0.8032 552.6000 0.8656 552.7980 0.8656 552.9000 1.0673 553.0980 1.0673 553.2000 1.7000 553.3980 1.7000 553.5000 1.1240 553.6980 1.1240 553.8000 1.7000 553.9980 1.7000 554.1000 0.7099 554.2980 0.7099 554.4000 1.5949 554.5980 1.5949 554.7000 1.1241 554.8980 1.1241 555.0000 1.6695 555.1980 1.6695 555.3000 1.4415 555.4980 1.4415 555.6000 1.4239 555.7980 1.4239 555.9000 1.3686 556.0980 1.3686 556.2000 1.4932 556.3980 1.4932 556.5000 1.3527 556.6980 1.3527 556.8000 1.6149 556.9980 1.6149 557.1000 1.6066 557.2980 1.6066 557.4000 1.7000 557.5980 1.7000 557.7000 1.5284 557.8980 1.5284 558.0000 1.1273 558.1980 1.1273 558.3000 1.5936 558.4980 1.5936 558.6000 1.7000 558.7980 1.7000 558.9000 1.3411 559.0980 1.3411 559.2000 1.0636 559.3980 1.0636 559.5000 1.2662 559.6980 1.2662 559.8000 1.3557 559.9980 1.3557 560.1000 1.4687 560.2980 1.4687 560.4000 1.3298 560.5980 1.3298 560.7000 1.4403 560.8980 1.4403 561.0000 1.7000 561.1980 1.7000 561.3000 1.6215 561.4980 1.6215 561.6000 1.3890 561.7980 1.3890 561.9000 1.0167 562.0980 1.0167 562.2000 1.6680 562.3980 1.6680 562.5000 1.2853 562.6980 1.2853 562.8000 1.5178 562.9980 1.5178 563.1000 1.3289 563.2980 1.3289 563.4000 1.4717 563.5980 1.4717 563.7000 1.3485 563.8980 1.3485 564.0000 0.7654 564.1980 0.7654 564.3000 1.3865 564.4980 1.3865 564.6000 1.6290 564.7980 1.6290 564.9000 0.8489 565.0980 0.8489 565.2000 1.5180 565.3980 1.5180 565.5000 1.0014 565.6980 1.0014 565.8000 1.0727 565.9980 1.0727 566.1000 1.5365 566.2980 1.5365 566.4000 1.2242 566.5980 1.2242 566.7000 0.8932 566.8980 0.8932 567.0000 1.1560 567.1980 1.1560 567.3000 1.4669 567.4980 1.4669 567.6000 1.4599 567.7980 1.4599 567.9000 1.5164 568.0980 1.5164 568.2000 0.4370 568.3980 0.4370 568.5000 1.3328 568.6980 1.3328 568.8000 1.4404 568.9980 1.4404 569.1000 1.7000 569.2980 1.7000 569.4000 0.9742 569.5980 0.9742 569.7000 1.3125 569.8980 1.3125 570.0000 1.0458 570.1980 1.0458 570.3000 0.9826 570.4980 0.9826 570.6000 1.7000 570.7980 1.7000 570.9000 1.2201 571.0980 1.2201 571.2000 0.9923 571.3980 0.9923 571.5000 1.1317 571.6980 1.1317 571.8000 1.7000 571.9980 1.7000 572.1000 1.1677 572.2980 1.1677 572.4000 1.6994 572.5980 1.6994 572.7000 0.9488 572.8980 0.9488 573.0000 1.7000 573.1980 1.7000 573.3000 1.1912 573.4980 1.1912 573.6000 1.7000 573.7980 1.7000 573.9000 0.8032 574.0980 0.8032 574.2000 0.8656 574.3980 0.8656 574.5000 1.0673 574.6980 1.0673 574.8000 1.7000 574.9980 1.7000 575.1000 1.1240 575.2980 1.1240 575.4000 1.7000 575.5980 1.7000 575.7000 0.7099 575.8980 0.7099 576.0000 1.5949 576.1980 1.5949 576.3000 1.1241 576.4980 1.1241 576.6000 1.6695 576.7980 1.6695 576.9000 1.4415 577.0980 1.4415 577.2000 1.4239 577.3980 1.4239 577.5000 1.3686 577.6980 1.3686 577.8000 1.4932 577.9980 1.4932 578.1000 1.3527 578.2980 1.3527 578.4000 1.6149 578.5980 1.6149 578.7000 1.6066 578.8980 1.6066 579.0000 1.7000 579.1980 1.7000 579.3000 1.5284 579.4980 1.5284 579.6000 1.1273 579.7980 1.1273 579.9000 1.5936 580.0980 1.5936 580.2000 1.7000 580.3980 1.7000 580.5000 1.3411 580.6980 1.3411 580.8000 1.0636 580.9980 1.0636 581.1000 1.2662 581.2980 1.2662 581.4000 1.3557 581.5980 1.3557 581.7000 1.4687 581.8980 1.4687 582.0000 1.3298 582.1980 1.3298 582.3000 1.4403 582.4980 1.4403 582.6000 1.7000 582.7980 1.7000 582.9000 1.6215 583.0980 1.6215 583.2000 1.3890 583.3980 1.3890 583.5000 1.0167 583.6980 1.0167 583.8000 1.6680 583.9980 1.6680 584.1000 1.2853 584.2980 1.2853 584.4000 1.5178 584.5980 1.5178 584.7000 1.3289 584.8980 1.3289 585.0000 1.4717 585.1980 1.4717 585.3000 1.3485 585.4980 1.3485 585.6000 0.7654 585.7980 0.7654 585.9000 1.3865 586.0980 1.3865 586.2000 1.6290 586.3980 1.6290 586.5000 0.8489 586.6980 0.8489 586.8000 1.5180 586.9980 1.5180 587.1000 1.0014 587.2980 1.0014 587.4000 1.0727 587.5980 1.0727 587.7000 1.5365 587.8980 1.5365 588.0000 1.2242 588.1980 1.2242 588.3000 0.8932 588.4980 0.8932 588.6000 1.1560 588.7980 1.1560 588.9000 1.4669 589.0980 1.4669 589.2000 1.4599 589.3980 1.4599 589.5000 1.5164 589.6980 1.5164 589.8000 0.4370 589.9980 0.4370 590.1000 1.3328 590.2980 1.3328 590.4000 1.4404 590.5980 1.4404 590.7000 1.7000 590.8980 1.7000 591.0000 0.9742 591.1980 0.9742 591.3000 1.3125 591.4980 1.3125 591.6000 1.0458 591.7980 1.0458 591.9000 0.9826 592.0980 0.9826 592.2000 1.7000 592.3980 1.7000 592.5000 1.2201 592.6980 1.2201 592.8000 0.9923 592.9980 0.9923 593.1000 1.1317 593.2980 1.1317 593.4000 1.7000 593.5980 1.7000 593.7000 1.1677 593.8980 1.1677 594.0000 1.6994 594.1980 1.6994 594.3000 0.9488 594.4980 0.9488 594.6000 1.7000 594.7980 1.7000 594.9000 1.1912 595.0980 1.1912 595.2000 1.7000 595.3980 1.7000 595.5000 0.8032 595.6980 0.8032 595.8000 0.8656 595.9980 0.8656 596.1000 1.0673 596.2980 1.0673 596.4000 1.7000 596.5980 1.7000 596.7000 1.1240 596.8980 1.1240 597.0000 1.7000 597.1980 1.7000 597.3000 0.7099 597.4980 0.7099 597.6000 1.5949 597.7980 1.5949 597.9000 1.1241 598.0980 1.1241 598.2000 1.6695 598.3980 1.6695 598.5000 1.4415 598.6980 1.4415 598.8000 1.4239 598.9980 1.4239 599.1000 1.3686 599.2980 1.3686 599.4000 1.4932 599.5980 1.4932 599.7000 1.3527 599.8980 1.3527 600.0000 1.3527)
Va11 a11 0 PWL(0.0000 0.9315 0.1980 0.9315 0.3000 0.9004 0.4980 0.9004 0.6000 0.8485 0.7980 0.8485 0.9000 1.1370 1.0980 1.1370 1.2000 0.5775 1.3980 0.5775 1.5000 0.6685 1.6980 0.6685 1.8000 0.6541 1.9980 0.6541 2.1000 0.5959 2.2980 0.5959 2.4000 0.9662 2.5980 0.9662 2.7000 0.8137 2.8980 0.8137 3.0000 0.5457 3.1980 0.5457 3.3000 0.9488 3.4980 0.9488 3.6000 0.6484 3.7980 0.6484 3.9000 0.9633 4.0980 0.9633 4.2000 0.8336 4.3980 0.8336 4.5000 0.5562 4.6980 0.5562 4.8000 0.7680 4.9980 0.7680 5.1000 0.9813 5.2980 0.9813 5.4000 0.9239 5.5980 0.9239 5.7000 0.5635 5.8980 0.5635 6.0000 0.6502 6.1980 0.6502 6.3000 0.5981 6.4980 0.5981 6.6000 1.3567 6.7980 1.3567 6.9000 0.8142 7.0980 0.8142 7.2000 0.5412 7.3980 0.5412 7.5000 0.5887 7.6980 0.5887 7.8000 0.5985 7.9980 0.5985 8.1000 0.7333 8.2980 0.7333 8.4000 0.5913 8.5980 0.5913 8.7000 0.6190 8.8980 0.6190 9.0000 0.5692 9.1980 0.5692 9.3000 0.5961 9.4980 0.5961 9.6000 0.6150 9.7980 0.6150 9.9000 0.5696 10.0980 0.5696 10.2000 0.6065 10.3980 0.6065 10.5000 0.6194 10.6980 0.6194 10.8000 0.5673 10.9980 0.5673 11.1000 0.6056 11.2980 0.6056 11.4000 0.5477 11.5980 0.5477 11.7000 0.5860 11.8980 0.5860 12.0000 0.5723 12.1980 0.5723 12.3000 0.6247 12.4980 0.6247 12.6000 0.5668 12.7980 0.5668 12.9000 0.5998 13.0980 0.5998 13.2000 0.5790 13.3980 0.5790 13.5000 0.6068 13.6980 0.6068 13.8000 0.5960 13.9980 0.5960 14.1000 0.6236 14.2980 0.6236 14.4000 0.5892 14.5980 0.5892 14.7000 0.6006 14.8980 0.6006 15.0000 0.5466 15.1980 0.5466 15.3000 0.5968 15.4980 0.5968 15.6000 0.5971 15.7980 0.5971 15.9000 0.6004 16.0980 0.6004 16.2000 0.5933 16.3980 0.5933 16.5000 0.5768 16.6980 0.5768 16.8000 0.6007 16.9980 0.6007 17.1000 0.6082 17.2980 0.6082 17.4000 0.5745 17.5980 0.5745 17.7000 0.5786 17.8980 0.5786 18.0000 0.5559 18.1980 0.5559 18.3000 0.6088 18.4980 0.6088 18.6000 0.8045 18.7980 0.8045 18.9000 0.5821 19.0980 0.5821 19.2000 0.5732 19.3980 0.5732 19.5000 0.6057 19.6980 0.6057 19.8000 0.5458 19.9980 0.5458 20.1000 0.6020 20.2980 0.6020 20.4000 0.5708 20.5980 0.5708 20.7000 0.7692 20.8980 0.7692 21.0000 0.5724 21.1980 0.5724 21.3000 0.5754 21.4980 0.5754 21.6000 0.9315 21.7980 0.9315 21.9000 0.9004 22.0980 0.9004 22.2000 0.8485 22.3980 0.8485 22.5000 1.1370 22.6980 1.1370 22.8000 0.5775 22.9980 0.5775 23.1000 0.6685 23.2980 0.6685 23.4000 0.6541 23.5980 0.6541 23.7000 0.5959 23.8980 0.5959 24.0000 0.9662 24.1980 0.9662 24.3000 0.8137 24.4980 0.8137 24.6000 0.5457 24.7980 0.5457 24.9000 0.9488 25.0980 0.9488 25.2000 0.6484 25.3980 0.6484 25.5000 0.9633 25.6980 0.9633 25.8000 0.8336 25.9980 0.8336 26.1000 0.5562 26.2980 0.5562 26.4000 0.7680 26.5980 0.7680 26.7000 0.9813 26.8980 0.9813 27.0000 0.9239 27.1980 0.9239 27.3000 0.5635 27.4980 0.5635 27.6000 0.6502 27.7980 0.6502 27.9000 0.5981 28.0980 0.5981 28.2000 1.3567 28.3980 1.3567 28.5000 0.8142 28.6980 0.8142 28.8000 0.5412 28.9980 0.5412 29.1000 0.5887 29.2980 0.5887 29.4000 0.5985 29.5980 0.5985 29.7000 0.7333 29.8980 0.7333 30.0000 0.5913 30.1980 0.5913 30.3000 0.6190 30.4980 0.6190 30.6000 0.5692 30.7980 0.5692 30.9000 0.5961 31.0980 0.5961 31.2000 0.6150 31.3980 0.6150 31.5000 0.5696 31.6980 0.5696 31.8000 0.6065 31.9980 0.6065 32.1000 0.6194 32.2980 0.6194 32.4000 0.5673 32.5980 0.5673 32.7000 0.6056 32.8980 0.6056 33.0000 0.5477 33.1980 0.5477 33.3000 0.5860 33.4980 0.5860 33.6000 0.5723 33.7980 0.5723 33.9000 0.6247 34.0980 0.6247 34.2000 0.5668 34.3980 0.5668 34.5000 0.5998 34.6980 0.5998 34.8000 0.5790 34.9980 0.5790 35.1000 0.6068 35.2980 0.6068 35.4000 0.5960 35.5980 0.5960 35.7000 0.6236 35.8980 0.6236 36.0000 0.5892 36.1980 0.5892 36.3000 0.6006 36.4980 0.6006 36.6000 0.5466 36.7980 0.5466 36.9000 0.5968 37.0980 0.5968 37.2000 0.5971 37.3980 0.5971 37.5000 0.6004 37.6980 0.6004 37.8000 0.5933 37.9980 0.5933 38.1000 0.5768 38.2980 0.5768 38.4000 0.6007 38.5980 0.6007 38.7000 0.6082 38.8980 0.6082 39.0000 0.5745 39.1980 0.5745 39.3000 0.5786 39.4980 0.5786 39.6000 0.5559 39.7980 0.5559 39.9000 0.6088 40.0980 0.6088 40.2000 0.8045 40.3980 0.8045 40.5000 0.5821 40.6980 0.5821 40.8000 0.5732 40.9980 0.5732 41.1000 0.6057 41.2980 0.6057 41.4000 0.5458 41.5980 0.5458 41.7000 0.6020 41.8980 0.6020 42.0000 0.5708 42.1980 0.5708 42.3000 0.7692 42.4980 0.7692 42.6000 0.5724 42.7980 0.5724 42.9000 0.5754 43.0980 0.5754 43.2000 0.9315 43.3980 0.9315 43.5000 0.9004 43.6980 0.9004 43.8000 0.8485 43.9980 0.8485 44.1000 1.1370 44.2980 1.1370 44.4000 0.5775 44.5980 0.5775 44.7000 0.6685 44.8980 0.6685 45.0000 0.6541 45.1980 0.6541 45.3000 0.5959 45.4980 0.5959 45.6000 0.9662 45.7980 0.9662 45.9000 0.8137 46.0980 0.8137 46.2000 0.5457 46.3980 0.5457 46.5000 0.9488 46.6980 0.9488 46.8000 0.6484 46.9980 0.6484 47.1000 0.9633 47.2980 0.9633 47.4000 0.8336 47.5980 0.8336 47.7000 0.5562 47.8980 0.5562 48.0000 0.7680 48.1980 0.7680 48.3000 0.9813 48.4980 0.9813 48.6000 0.9239 48.7980 0.9239 48.9000 0.5635 49.0980 0.5635 49.2000 0.6502 49.3980 0.6502 49.5000 0.5981 49.6980 0.5981 49.8000 1.3567 49.9980 1.3567 50.1000 0.8142 50.2980 0.8142 50.4000 0.5412 50.5980 0.5412 50.7000 0.5887 50.8980 0.5887 51.0000 0.5985 51.1980 0.5985 51.3000 0.7333 51.4980 0.7333 51.6000 0.5913 51.7980 0.5913 51.9000 0.6190 52.0980 0.6190 52.2000 0.5692 52.3980 0.5692 52.5000 0.5961 52.6980 0.5961 52.8000 0.6150 52.9980 0.6150 53.1000 0.5696 53.2980 0.5696 53.4000 0.6065 53.5980 0.6065 53.7000 0.6194 53.8980 0.6194 54.0000 0.5673 54.1980 0.5673 54.3000 0.6056 54.4980 0.6056 54.6000 0.5477 54.7980 0.5477 54.9000 0.5860 55.0980 0.5860 55.2000 0.5723 55.3980 0.5723 55.5000 0.6247 55.6980 0.6247 55.8000 0.5668 55.9980 0.5668 56.1000 0.5998 56.2980 0.5998 56.4000 0.5790 56.5980 0.5790 56.7000 0.6068 56.8980 0.6068 57.0000 0.5960 57.1980 0.5960 57.3000 0.6236 57.4980 0.6236 57.6000 0.5892 57.7980 0.5892 57.9000 0.6006 58.0980 0.6006 58.2000 0.5466 58.3980 0.5466 58.5000 0.5968 58.6980 0.5968 58.8000 0.5971 58.9980 0.5971 59.1000 0.6004 59.2980 0.6004 59.4000 0.5933 59.5980 0.5933 59.7000 0.5768 59.8980 0.5768 60.0000 0.6007 60.1980 0.6007 60.3000 0.6082 60.4980 0.6082 60.6000 0.5745 60.7980 0.5745 60.9000 0.5786 61.0980 0.5786 61.2000 0.5559 61.3980 0.5559 61.5000 0.6088 61.6980 0.6088 61.8000 0.8045 61.9980 0.8045 62.1000 0.5821 62.2980 0.5821 62.4000 0.5732 62.5980 0.5732 62.7000 0.6057 62.8980 0.6057 63.0000 0.5458 63.1980 0.5458 63.3000 0.6020 63.4980 0.6020 63.6000 0.5708 63.7980 0.5708 63.9000 0.7692 64.0980 0.7692 64.2000 0.5724 64.3980 0.5724 64.5000 0.5754 64.6980 0.5754 64.8000 0.9315 64.9980 0.9315 65.1000 0.9004 65.2980 0.9004 65.4000 0.8485 65.5980 0.8485 65.7000 1.1370 65.8980 1.1370 66.0000 0.5775 66.1980 0.5775 66.3000 0.6685 66.4980 0.6685 66.6000 0.6541 66.7980 0.6541 66.9000 0.5959 67.0980 0.5959 67.2000 0.9662 67.3980 0.9662 67.5000 0.8137 67.6980 0.8137 67.8000 0.5457 67.9980 0.5457 68.1000 0.9488 68.2980 0.9488 68.4000 0.6484 68.5980 0.6484 68.7000 0.9633 68.8980 0.9633 69.0000 0.8336 69.1980 0.8336 69.3000 0.5562 69.4980 0.5562 69.6000 0.7680 69.7980 0.7680 69.9000 0.9813 70.0980 0.9813 70.2000 0.9239 70.3980 0.9239 70.5000 0.5635 70.6980 0.5635 70.8000 0.6502 70.9980 0.6502 71.1000 0.5981 71.2980 0.5981 71.4000 1.3567 71.5980 1.3567 71.7000 0.8142 71.8980 0.8142 72.0000 0.5412 72.1980 0.5412 72.3000 0.5887 72.4980 0.5887 72.6000 0.5985 72.7980 0.5985 72.9000 0.7333 73.0980 0.7333 73.2000 0.5913 73.3980 0.5913 73.5000 0.6190 73.6980 0.6190 73.8000 0.5692 73.9980 0.5692 74.1000 0.5961 74.2980 0.5961 74.4000 0.6150 74.5980 0.6150 74.7000 0.5696 74.8980 0.5696 75.0000 0.6065 75.1980 0.6065 75.3000 0.6194 75.4980 0.6194 75.6000 0.5673 75.7980 0.5673 75.9000 0.6056 76.0980 0.6056 76.2000 0.5477 76.3980 0.5477 76.5000 0.5860 76.6980 0.5860 76.8000 0.5723 76.9980 0.5723 77.1000 0.6247 77.2980 0.6247 77.4000 0.5668 77.5980 0.5668 77.7000 0.5998 77.8980 0.5998 78.0000 0.5790 78.1980 0.5790 78.3000 0.6068 78.4980 0.6068 78.6000 0.5960 78.7980 0.5960 78.9000 0.6236 79.0980 0.6236 79.2000 0.5892 79.3980 0.5892 79.5000 0.6006 79.6980 0.6006 79.8000 0.5466 79.9980 0.5466 80.1000 0.5968 80.2980 0.5968 80.4000 0.5971 80.5980 0.5971 80.7000 0.6004 80.8980 0.6004 81.0000 0.5933 81.1980 0.5933 81.3000 0.5768 81.4980 0.5768 81.6000 0.6007 81.7980 0.6007 81.9000 0.6082 82.0980 0.6082 82.2000 0.5745 82.3980 0.5745 82.5000 0.5786 82.6980 0.5786 82.8000 0.5559 82.9980 0.5559 83.1000 0.6088 83.2980 0.6088 83.4000 0.8045 83.5980 0.8045 83.7000 0.5821 83.8980 0.5821 84.0000 0.5732 84.1980 0.5732 84.3000 0.6057 84.4980 0.6057 84.6000 0.5458 84.7980 0.5458 84.9000 0.6020 85.0980 0.6020 85.2000 0.5708 85.3980 0.5708 85.5000 0.7692 85.6980 0.7692 85.8000 0.5724 85.9980 0.5724 86.1000 0.5754 86.2980 0.5754 86.4000 0.9315 86.5980 0.9315 86.7000 0.9004 86.8980 0.9004 87.0000 0.8485 87.1980 0.8485 87.3000 1.1370 87.4980 1.1370 87.6000 0.5775 87.7980 0.5775 87.9000 0.6685 88.0980 0.6685 88.2000 0.6541 88.3980 0.6541 88.5000 0.5959 88.6980 0.5959 88.8000 0.9662 88.9980 0.9662 89.1000 0.8137 89.2980 0.8137 89.4000 0.5457 89.5980 0.5457 89.7000 0.9488 89.8980 0.9488 90.0000 0.6484 90.1980 0.6484 90.3000 0.9633 90.4980 0.9633 90.6000 0.8336 90.7980 0.8336 90.9000 0.5562 91.0980 0.5562 91.2000 0.7680 91.3980 0.7680 91.5000 0.9813 91.6980 0.9813 91.8000 0.9239 91.9980 0.9239 92.1000 0.5635 92.2980 0.5635 92.4000 0.6502 92.5980 0.6502 92.7000 0.5981 92.8980 0.5981 93.0000 1.3567 93.1980 1.3567 93.3000 0.8142 93.4980 0.8142 93.6000 0.5412 93.7980 0.5412 93.9000 0.5887 94.0980 0.5887 94.2000 0.5985 94.3980 0.5985 94.5000 0.7333 94.6980 0.7333 94.8000 0.5913 94.9980 0.5913 95.1000 0.6190 95.2980 0.6190 95.4000 0.5692 95.5980 0.5692 95.7000 0.5961 95.8980 0.5961 96.0000 0.6150 96.1980 0.6150 96.3000 0.5696 96.4980 0.5696 96.6000 0.6065 96.7980 0.6065 96.9000 0.6194 97.0980 0.6194 97.2000 0.5673 97.3980 0.5673 97.5000 0.6056 97.6980 0.6056 97.8000 0.5477 97.9980 0.5477 98.1000 0.5860 98.2980 0.5860 98.4000 0.5723 98.5980 0.5723 98.7000 0.6247 98.8980 0.6247 99.0000 0.5668 99.1980 0.5668 99.3000 0.5998 99.4980 0.5998 99.6000 0.5790 99.7980 0.5790 99.9000 0.6068 100.0980 0.6068 100.2000 0.5960 100.3980 0.5960 100.5000 0.6236 100.6980 0.6236 100.8000 0.5892 100.9980 0.5892 101.1000 0.6006 101.2980 0.6006 101.4000 0.5466 101.5980 0.5466 101.7000 0.5968 101.8980 0.5968 102.0000 0.5971 102.1980 0.5971 102.3000 0.6004 102.4980 0.6004 102.6000 0.5933 102.7980 0.5933 102.9000 0.5768 103.0980 0.5768 103.2000 0.6007 103.3980 0.6007 103.5000 0.6082 103.6980 0.6082 103.8000 0.5745 103.9980 0.5745 104.1000 0.5786 104.2980 0.5786 104.4000 0.5559 104.5980 0.5559 104.7000 0.6088 104.8980 0.6088 105.0000 0.8045 105.1980 0.8045 105.3000 0.5821 105.4980 0.5821 105.6000 0.5732 105.7980 0.5732 105.9000 0.6057 106.0980 0.6057 106.2000 0.5458 106.3980 0.5458 106.5000 0.6020 106.6980 0.6020 106.8000 0.5708 106.9980 0.5708 107.1000 0.7692 107.2980 0.7692 107.4000 0.5724 107.5980 0.5724 107.7000 0.5754 107.8980 0.5754 108.0000 0.9315 108.1980 0.9315 108.3000 0.9004 108.4980 0.9004 108.6000 0.8485 108.7980 0.8485 108.9000 1.1370 109.0980 1.1370 109.2000 0.5775 109.3980 0.5775 109.5000 0.6685 109.6980 0.6685 109.8000 0.6541 109.9980 0.6541 110.1000 0.5959 110.2980 0.5959 110.4000 0.9662 110.5980 0.9662 110.7000 0.8137 110.8980 0.8137 111.0000 0.5457 111.1980 0.5457 111.3000 0.9488 111.4980 0.9488 111.6000 0.6484 111.7980 0.6484 111.9000 0.9633 112.0980 0.9633 112.2000 0.8336 112.3980 0.8336 112.5000 0.5562 112.6980 0.5562 112.8000 0.7680 112.9980 0.7680 113.1000 0.9813 113.2980 0.9813 113.4000 0.9239 113.5980 0.9239 113.7000 0.5635 113.8980 0.5635 114.0000 0.6502 114.1980 0.6502 114.3000 0.5981 114.4980 0.5981 114.6000 1.3567 114.7980 1.3567 114.9000 0.8142 115.0980 0.8142 115.2000 0.5412 115.3980 0.5412 115.5000 0.5887 115.6980 0.5887 115.8000 0.5985 115.9980 0.5985 116.1000 0.7333 116.2980 0.7333 116.4000 0.5913 116.5980 0.5913 116.7000 0.6190 116.8980 0.6190 117.0000 0.5692 117.1980 0.5692 117.3000 0.5961 117.4980 0.5961 117.6000 0.6150 117.7980 0.6150 117.9000 0.5696 118.0980 0.5696 118.2000 0.6065 118.3980 0.6065 118.5000 0.6194 118.6980 0.6194 118.8000 0.5673 118.9980 0.5673 119.1000 0.6056 119.2980 0.6056 119.4000 0.5477 119.5980 0.5477 119.7000 0.5860 119.8980 0.5860 120.0000 0.5723 120.1980 0.5723 120.3000 0.6247 120.4980 0.6247 120.6000 0.5668 120.7980 0.5668 120.9000 0.5998 121.0980 0.5998 121.2000 0.5790 121.3980 0.5790 121.5000 0.6068 121.6980 0.6068 121.8000 0.5960 121.9980 0.5960 122.1000 0.6236 122.2980 0.6236 122.4000 0.5892 122.5980 0.5892 122.7000 0.6006 122.8980 0.6006 123.0000 0.5466 123.1980 0.5466 123.3000 0.5968 123.4980 0.5968 123.6000 0.5971 123.7980 0.5971 123.9000 0.6004 124.0980 0.6004 124.2000 0.5933 124.3980 0.5933 124.5000 0.5768 124.6980 0.5768 124.8000 0.6007 124.9980 0.6007 125.1000 0.6082 125.2980 0.6082 125.4000 0.5745 125.5980 0.5745 125.7000 0.5786 125.8980 0.5786 126.0000 0.5559 126.1980 0.5559 126.3000 0.6088 126.4980 0.6088 126.6000 0.8045 126.7980 0.8045 126.9000 0.5821 127.0980 0.5821 127.2000 0.5732 127.3980 0.5732 127.5000 0.6057 127.6980 0.6057 127.8000 0.5458 127.9980 0.5458 128.1000 0.6020 128.2980 0.6020 128.4000 0.5708 128.5980 0.5708 128.7000 0.7692 128.8980 0.7692 129.0000 0.5724 129.1980 0.5724 129.3000 0.5754 129.4980 0.5754 129.6000 0.9315 129.7980 0.9315 129.9000 0.9004 130.0980 0.9004 130.2000 0.8485 130.3980 0.8485 130.5000 1.1370 130.6980 1.1370 130.8000 0.5775 130.9980 0.5775 131.1000 0.6685 131.2980 0.6685 131.4000 0.6541 131.5980 0.6541 131.7000 0.5959 131.8980 0.5959 132.0000 0.9662 132.1980 0.9662 132.3000 0.8137 132.4980 0.8137 132.6000 0.5457 132.7980 0.5457 132.9000 0.9488 133.0980 0.9488 133.2000 0.6484 133.3980 0.6484 133.5000 0.9633 133.6980 0.9633 133.8000 0.8336 133.9980 0.8336 134.1000 0.5562 134.2980 0.5562 134.4000 0.7680 134.5980 0.7680 134.7000 0.9813 134.8980 0.9813 135.0000 0.9239 135.1980 0.9239 135.3000 0.5635 135.4980 0.5635 135.6000 0.6502 135.7980 0.6502 135.9000 0.5981 136.0980 0.5981 136.2000 1.3567 136.3980 1.3567 136.5000 0.8142 136.6980 0.8142 136.8000 0.5412 136.9980 0.5412 137.1000 0.5887 137.2980 0.5887 137.4000 0.5985 137.5980 0.5985 137.7000 0.7333 137.8980 0.7333 138.0000 0.5913 138.1980 0.5913 138.3000 0.6190 138.4980 0.6190 138.6000 0.5692 138.7980 0.5692 138.9000 0.5961 139.0980 0.5961 139.2000 0.6150 139.3980 0.6150 139.5000 0.5696 139.6980 0.5696 139.8000 0.6065 139.9980 0.6065 140.1000 0.6194 140.2980 0.6194 140.4000 0.5673 140.5980 0.5673 140.7000 0.6056 140.8980 0.6056 141.0000 0.5477 141.1980 0.5477 141.3000 0.5860 141.4980 0.5860 141.6000 0.5723 141.7980 0.5723 141.9000 0.6247 142.0980 0.6247 142.2000 0.5668 142.3980 0.5668 142.5000 0.5998 142.6980 0.5998 142.8000 0.5790 142.9980 0.5790 143.1000 0.6068 143.2980 0.6068 143.4000 0.5960 143.5980 0.5960 143.7000 0.6236 143.8980 0.6236 144.0000 0.5892 144.1980 0.5892 144.3000 0.6006 144.4980 0.6006 144.6000 0.5466 144.7980 0.5466 144.9000 0.5968 145.0980 0.5968 145.2000 0.5971 145.3980 0.5971 145.5000 0.6004 145.6980 0.6004 145.8000 0.5933 145.9980 0.5933 146.1000 0.5768 146.2980 0.5768 146.4000 0.6007 146.5980 0.6007 146.7000 0.6082 146.8980 0.6082 147.0000 0.5745 147.1980 0.5745 147.3000 0.5786 147.4980 0.5786 147.6000 0.5559 147.7980 0.5559 147.9000 0.6088 148.0980 0.6088 148.2000 0.8045 148.3980 0.8045 148.5000 0.5821 148.6980 0.5821 148.8000 0.5732 148.9980 0.5732 149.1000 0.6057 149.2980 0.6057 149.4000 0.5458 149.5980 0.5458 149.7000 0.6020 149.8980 0.6020 150.0000 0.5708 150.1980 0.5708 150.3000 0.7692 150.4980 0.7692 150.6000 0.5724 150.7980 0.5724 150.9000 0.5754 151.0980 0.5754 151.2000 0.9315 151.3980 0.9315 151.5000 0.9004 151.6980 0.9004 151.8000 0.8485 151.9980 0.8485 152.1000 1.1370 152.2980 1.1370 152.4000 0.5775 152.5980 0.5775 152.7000 0.6685 152.8980 0.6685 153.0000 0.6541 153.1980 0.6541 153.3000 0.5959 153.4980 0.5959 153.6000 0.9662 153.7980 0.9662 153.9000 0.8137 154.0980 0.8137 154.2000 0.5457 154.3980 0.5457 154.5000 0.9488 154.6980 0.9488 154.8000 0.6484 154.9980 0.6484 155.1000 0.9633 155.2980 0.9633 155.4000 0.8336 155.5980 0.8336 155.7000 0.5562 155.8980 0.5562 156.0000 0.7680 156.1980 0.7680 156.3000 0.9813 156.4980 0.9813 156.6000 0.9239 156.7980 0.9239 156.9000 0.5635 157.0980 0.5635 157.2000 0.6502 157.3980 0.6502 157.5000 0.5981 157.6980 0.5981 157.8000 1.3567 157.9980 1.3567 158.1000 0.8142 158.2980 0.8142 158.4000 0.5412 158.5980 0.5412 158.7000 0.5887 158.8980 0.5887 159.0000 0.5985 159.1980 0.5985 159.3000 0.7333 159.4980 0.7333 159.6000 0.5913 159.7980 0.5913 159.9000 0.6190 160.0980 0.6190 160.2000 0.5692 160.3980 0.5692 160.5000 0.5961 160.6980 0.5961 160.8000 0.6150 160.9980 0.6150 161.1000 0.5696 161.2980 0.5696 161.4000 0.6065 161.5980 0.6065 161.7000 0.6194 161.8980 0.6194 162.0000 0.5673 162.1980 0.5673 162.3000 0.6056 162.4980 0.6056 162.6000 0.5477 162.7980 0.5477 162.9000 0.5860 163.0980 0.5860 163.2000 0.5723 163.3980 0.5723 163.5000 0.6247 163.6980 0.6247 163.8000 0.5668 163.9980 0.5668 164.1000 0.5998 164.2980 0.5998 164.4000 0.5790 164.5980 0.5790 164.7000 0.6068 164.8980 0.6068 165.0000 0.5960 165.1980 0.5960 165.3000 0.6236 165.4980 0.6236 165.6000 0.5892 165.7980 0.5892 165.9000 0.6006 166.0980 0.6006 166.2000 0.5466 166.3980 0.5466 166.5000 0.5968 166.6980 0.5968 166.8000 0.5971 166.9980 0.5971 167.1000 0.6004 167.2980 0.6004 167.4000 0.5933 167.5980 0.5933 167.7000 0.5768 167.8980 0.5768 168.0000 0.6007 168.1980 0.6007 168.3000 0.6082 168.4980 0.6082 168.6000 0.5745 168.7980 0.5745 168.9000 0.5786 169.0980 0.5786 169.2000 0.5559 169.3980 0.5559 169.5000 0.6088 169.6980 0.6088 169.8000 0.8045 169.9980 0.8045 170.1000 0.5821 170.2980 0.5821 170.4000 0.5732 170.5980 0.5732 170.7000 0.6057 170.8980 0.6057 171.0000 0.5458 171.1980 0.5458 171.3000 0.6020 171.4980 0.6020 171.6000 0.5708 171.7980 0.5708 171.9000 0.7692 172.0980 0.7692 172.2000 0.5724 172.3980 0.5724 172.5000 0.5754 172.6980 0.5754 172.8000 0.9315 172.9980 0.9315 173.1000 0.9004 173.2980 0.9004 173.4000 0.8485 173.5980 0.8485 173.7000 1.1370 173.8980 1.1370 174.0000 0.5775 174.1980 0.5775 174.3000 0.6685 174.4980 0.6685 174.6000 0.6541 174.7980 0.6541 174.9000 0.5959 175.0980 0.5959 175.2000 0.9662 175.3980 0.9662 175.5000 0.8137 175.6980 0.8137 175.8000 0.5457 175.9980 0.5457 176.1000 0.9488 176.2980 0.9488 176.4000 0.6484 176.5980 0.6484 176.7000 0.9633 176.8980 0.9633 177.0000 0.8336 177.1980 0.8336 177.3000 0.5562 177.4980 0.5562 177.6000 0.7680 177.7980 0.7680 177.9000 0.9813 178.0980 0.9813 178.2000 0.9239 178.3980 0.9239 178.5000 0.5635 178.6980 0.5635 178.8000 0.6502 178.9980 0.6502 179.1000 0.5981 179.2980 0.5981 179.4000 1.3567 179.5980 1.3567 179.7000 0.8142 179.8980 0.8142 180.0000 0.5412 180.1980 0.5412 180.3000 0.5887 180.4980 0.5887 180.6000 0.5985 180.7980 0.5985 180.9000 0.7333 181.0980 0.7333 181.2000 0.5913 181.3980 0.5913 181.5000 0.6190 181.6980 0.6190 181.8000 0.5692 181.9980 0.5692 182.1000 0.5961 182.2980 0.5961 182.4000 0.6150 182.5980 0.6150 182.7000 0.5696 182.8980 0.5696 183.0000 0.6065 183.1980 0.6065 183.3000 0.6194 183.4980 0.6194 183.6000 0.5673 183.7980 0.5673 183.9000 0.6056 184.0980 0.6056 184.2000 0.5477 184.3980 0.5477 184.5000 0.5860 184.6980 0.5860 184.8000 0.5723 184.9980 0.5723 185.1000 0.6247 185.2980 0.6247 185.4000 0.5668 185.5980 0.5668 185.7000 0.5998 185.8980 0.5998 186.0000 0.5790 186.1980 0.5790 186.3000 0.6068 186.4980 0.6068 186.6000 0.5960 186.7980 0.5960 186.9000 0.6236 187.0980 0.6236 187.2000 0.5892 187.3980 0.5892 187.5000 0.6006 187.6980 0.6006 187.8000 0.5466 187.9980 0.5466 188.1000 0.5968 188.2980 0.5968 188.4000 0.5971 188.5980 0.5971 188.7000 0.6004 188.8980 0.6004 189.0000 0.5933 189.1980 0.5933 189.3000 0.5768 189.4980 0.5768 189.6000 0.6007 189.7980 0.6007 189.9000 0.6082 190.0980 0.6082 190.2000 0.5745 190.3980 0.5745 190.5000 0.5786 190.6980 0.5786 190.8000 0.5559 190.9980 0.5559 191.1000 0.6088 191.2980 0.6088 191.4000 0.8045 191.5980 0.8045 191.7000 0.5821 191.8980 0.5821 192.0000 0.5732 192.1980 0.5732 192.3000 0.6057 192.4980 0.6057 192.6000 0.5458 192.7980 0.5458 192.9000 0.6020 193.0980 0.6020 193.2000 0.5708 193.3980 0.5708 193.5000 0.7692 193.6980 0.7692 193.8000 0.5724 193.9980 0.5724 194.1000 0.5754 194.2980 0.5754 194.4000 0.9315 194.5980 0.9315 194.7000 0.9004 194.8980 0.9004 195.0000 0.8485 195.1980 0.8485 195.3000 1.1370 195.4980 1.1370 195.6000 0.5775 195.7980 0.5775 195.9000 0.6685 196.0980 0.6685 196.2000 0.6541 196.3980 0.6541 196.5000 0.5959 196.6980 0.5959 196.8000 0.9662 196.9980 0.9662 197.1000 0.8137 197.2980 0.8137 197.4000 0.5457 197.5980 0.5457 197.7000 0.9488 197.8980 0.9488 198.0000 0.6484 198.1980 0.6484 198.3000 0.9633 198.4980 0.9633 198.6000 0.8336 198.7980 0.8336 198.9000 0.5562 199.0980 0.5562 199.2000 0.7680 199.3980 0.7680 199.5000 0.9813 199.6980 0.9813 199.8000 0.9239 199.9980 0.9239 200.1000 0.5635 200.2980 0.5635 200.4000 0.6502 200.5980 0.6502 200.7000 0.5981 200.8980 0.5981 201.0000 1.3567 201.1980 1.3567 201.3000 0.8142 201.4980 0.8142 201.6000 0.5412 201.7980 0.5412 201.9000 0.5887 202.0980 0.5887 202.2000 0.5985 202.3980 0.5985 202.5000 0.7333 202.6980 0.7333 202.8000 0.5913 202.9980 0.5913 203.1000 0.6190 203.2980 0.6190 203.4000 0.5692 203.5980 0.5692 203.7000 0.5961 203.8980 0.5961 204.0000 0.6150 204.1980 0.6150 204.3000 0.5696 204.4980 0.5696 204.6000 0.6065 204.7980 0.6065 204.9000 0.6194 205.0980 0.6194 205.2000 0.5673 205.3980 0.5673 205.5000 0.6056 205.6980 0.6056 205.8000 0.5477 205.9980 0.5477 206.1000 0.5860 206.2980 0.5860 206.4000 0.5723 206.5980 0.5723 206.7000 0.6247 206.8980 0.6247 207.0000 0.5668 207.1980 0.5668 207.3000 0.5998 207.4980 0.5998 207.6000 0.5790 207.7980 0.5790 207.9000 0.6068 208.0980 0.6068 208.2000 0.5960 208.3980 0.5960 208.5000 0.6236 208.6980 0.6236 208.8000 0.5892 208.9980 0.5892 209.1000 0.6006 209.2980 0.6006 209.4000 0.5466 209.5980 0.5466 209.7000 0.5968 209.8980 0.5968 210.0000 0.5971 210.1980 0.5971 210.3000 0.6004 210.4980 0.6004 210.6000 0.5933 210.7980 0.5933 210.9000 0.5768 211.0980 0.5768 211.2000 0.6007 211.3980 0.6007 211.5000 0.6082 211.6980 0.6082 211.8000 0.5745 211.9980 0.5745 212.1000 0.5786 212.2980 0.5786 212.4000 0.5559 212.5980 0.5559 212.7000 0.6088 212.8980 0.6088 213.0000 0.8045 213.1980 0.8045 213.3000 0.5821 213.4980 0.5821 213.6000 0.5732 213.7980 0.5732 213.9000 0.6057 214.0980 0.6057 214.2000 0.5458 214.3980 0.5458 214.5000 0.6020 214.6980 0.6020 214.8000 0.5708 214.9980 0.5708 215.1000 0.7692 215.2980 0.7692 215.4000 0.5724 215.5980 0.5724 215.7000 0.5754 215.8980 0.5754 216.0000 0.9315 216.1980 0.9315 216.3000 0.9004 216.4980 0.9004 216.6000 0.8485 216.7980 0.8485 216.9000 1.1370 217.0980 1.1370 217.2000 0.5775 217.3980 0.5775 217.5000 0.6685 217.6980 0.6685 217.8000 0.6541 217.9980 0.6541 218.1000 0.5959 218.2980 0.5959 218.4000 0.9662 218.5980 0.9662 218.7000 0.8137 218.8980 0.8137 219.0000 0.5457 219.1980 0.5457 219.3000 0.9488 219.4980 0.9488 219.6000 0.6484 219.7980 0.6484 219.9000 0.9633 220.0980 0.9633 220.2000 0.8336 220.3980 0.8336 220.5000 0.5562 220.6980 0.5562 220.8000 0.7680 220.9980 0.7680 221.1000 0.9813 221.2980 0.9813 221.4000 0.9239 221.5980 0.9239 221.7000 0.5635 221.8980 0.5635 222.0000 0.6502 222.1980 0.6502 222.3000 0.5981 222.4980 0.5981 222.6000 1.3567 222.7980 1.3567 222.9000 0.8142 223.0980 0.8142 223.2000 0.5412 223.3980 0.5412 223.5000 0.5887 223.6980 0.5887 223.8000 0.5985 223.9980 0.5985 224.1000 0.7333 224.2980 0.7333 224.4000 0.5913 224.5980 0.5913 224.7000 0.6190 224.8980 0.6190 225.0000 0.5692 225.1980 0.5692 225.3000 0.5961 225.4980 0.5961 225.6000 0.6150 225.7980 0.6150 225.9000 0.5696 226.0980 0.5696 226.2000 0.6065 226.3980 0.6065 226.5000 0.6194 226.6980 0.6194 226.8000 0.5673 226.9980 0.5673 227.1000 0.6056 227.2980 0.6056 227.4000 0.5477 227.5980 0.5477 227.7000 0.5860 227.8980 0.5860 228.0000 0.5723 228.1980 0.5723 228.3000 0.6247 228.4980 0.6247 228.6000 0.5668 228.7980 0.5668 228.9000 0.5998 229.0980 0.5998 229.2000 0.5790 229.3980 0.5790 229.5000 0.6068 229.6980 0.6068 229.8000 0.5960 229.9980 0.5960 230.1000 0.6236 230.2980 0.6236 230.4000 0.5892 230.5980 0.5892 230.7000 0.6006 230.8980 0.6006 231.0000 0.5466 231.1980 0.5466 231.3000 0.5968 231.4980 0.5968 231.6000 0.5971 231.7980 0.5971 231.9000 0.6004 232.0980 0.6004 232.2000 0.5933 232.3980 0.5933 232.5000 0.5768 232.6980 0.5768 232.8000 0.6007 232.9980 0.6007 233.1000 0.6082 233.2980 0.6082 233.4000 0.5745 233.5980 0.5745 233.7000 0.5786 233.8980 0.5786 234.0000 0.5559 234.1980 0.5559 234.3000 0.6088 234.4980 0.6088 234.6000 0.8045 234.7980 0.8045 234.9000 0.5821 235.0980 0.5821 235.2000 0.5732 235.3980 0.5732 235.5000 0.6057 235.6980 0.6057 235.8000 0.5458 235.9980 0.5458 236.1000 0.6020 236.2980 0.6020 236.4000 0.5708 236.5980 0.5708 236.7000 0.7692 236.8980 0.7692 237.0000 0.5724 237.1980 0.5724 237.3000 0.5754 237.4980 0.5754 237.6000 0.9315 237.7980 0.9315 237.9000 0.9004 238.0980 0.9004 238.2000 0.8485 238.3980 0.8485 238.5000 1.1370 238.6980 1.1370 238.8000 0.5775 238.9980 0.5775 239.1000 0.6685 239.2980 0.6685 239.4000 0.6541 239.5980 0.6541 239.7000 0.5959 239.8980 0.5959 240.0000 0.9662 240.1980 0.9662 240.3000 0.8137 240.4980 0.8137 240.6000 0.5457 240.7980 0.5457 240.9000 0.9488 241.0980 0.9488 241.2000 0.6484 241.3980 0.6484 241.5000 0.9633 241.6980 0.9633 241.8000 0.8336 241.9980 0.8336 242.1000 0.5562 242.2980 0.5562 242.4000 0.7680 242.5980 0.7680 242.7000 0.9813 242.8980 0.9813 243.0000 0.9239 243.1980 0.9239 243.3000 0.5635 243.4980 0.5635 243.6000 0.6502 243.7980 0.6502 243.9000 0.5981 244.0980 0.5981 244.2000 1.3567 244.3980 1.3567 244.5000 0.8142 244.6980 0.8142 244.8000 0.5412 244.9980 0.5412 245.1000 0.5887 245.2980 0.5887 245.4000 0.5985 245.5980 0.5985 245.7000 0.7333 245.8980 0.7333 246.0000 0.5913 246.1980 0.5913 246.3000 0.6190 246.4980 0.6190 246.6000 0.5692 246.7980 0.5692 246.9000 0.5961 247.0980 0.5961 247.2000 0.6150 247.3980 0.6150 247.5000 0.5696 247.6980 0.5696 247.8000 0.6065 247.9980 0.6065 248.1000 0.6194 248.2980 0.6194 248.4000 0.5673 248.5980 0.5673 248.7000 0.6056 248.8980 0.6056 249.0000 0.5477 249.1980 0.5477 249.3000 0.5860 249.4980 0.5860 249.6000 0.5723 249.7980 0.5723 249.9000 0.6247 250.0980 0.6247 250.2000 0.5668 250.3980 0.5668 250.5000 0.5998 250.6980 0.5998 250.8000 0.5790 250.9980 0.5790 251.1000 0.6068 251.2980 0.6068 251.4000 0.5960 251.5980 0.5960 251.7000 0.6236 251.8980 0.6236 252.0000 0.5892 252.1980 0.5892 252.3000 0.6006 252.4980 0.6006 252.6000 0.5466 252.7980 0.5466 252.9000 0.5968 253.0980 0.5968 253.2000 0.5971 253.3980 0.5971 253.5000 0.6004 253.6980 0.6004 253.8000 0.5933 253.9980 0.5933 254.1000 0.5768 254.2980 0.5768 254.4000 0.6007 254.5980 0.6007 254.7000 0.6082 254.8980 0.6082 255.0000 0.5745 255.1980 0.5745 255.3000 0.5786 255.4980 0.5786 255.6000 0.5559 255.7980 0.5559 255.9000 0.6088 256.0980 0.6088 256.2000 0.8045 256.3980 0.8045 256.5000 0.5821 256.6980 0.5821 256.8000 0.5732 256.9980 0.5732 257.1000 0.6057 257.2980 0.6057 257.4000 0.5458 257.5980 0.5458 257.7000 0.6020 257.8980 0.6020 258.0000 0.5708 258.1980 0.5708 258.3000 0.7692 258.4980 0.7692 258.6000 0.5724 258.7980 0.5724 258.9000 0.5754 259.0980 0.5754 259.2000 0.9315 259.3980 0.9315 259.5000 0.9004 259.6980 0.9004 259.8000 0.8485 259.9980 0.8485 260.1000 1.1370 260.2980 1.1370 260.4000 0.5775 260.5980 0.5775 260.7000 0.6685 260.8980 0.6685 261.0000 0.6541 261.1980 0.6541 261.3000 0.5959 261.4980 0.5959 261.6000 0.9662 261.7980 0.9662 261.9000 0.8137 262.0980 0.8137 262.2000 0.5457 262.3980 0.5457 262.5000 0.9488 262.6980 0.9488 262.8000 0.6484 262.9980 0.6484 263.1000 0.9633 263.2980 0.9633 263.4000 0.8336 263.5980 0.8336 263.7000 0.5562 263.8980 0.5562 264.0000 0.7680 264.1980 0.7680 264.3000 0.9813 264.4980 0.9813 264.6000 0.9239 264.7980 0.9239 264.9000 0.5635 265.0980 0.5635 265.2000 0.6502 265.3980 0.6502 265.5000 0.5981 265.6980 0.5981 265.8000 1.3567 265.9980 1.3567 266.1000 0.8142 266.2980 0.8142 266.4000 0.5412 266.5980 0.5412 266.7000 0.5887 266.8980 0.5887 267.0000 0.5985 267.1980 0.5985 267.3000 0.7333 267.4980 0.7333 267.6000 0.5913 267.7980 0.5913 267.9000 0.6190 268.0980 0.6190 268.2000 0.5692 268.3980 0.5692 268.5000 0.5961 268.6980 0.5961 268.8000 0.6150 268.9980 0.6150 269.1000 0.5696 269.2980 0.5696 269.4000 0.6065 269.5980 0.6065 269.7000 0.6194 269.8980 0.6194 270.0000 0.5673 270.1980 0.5673 270.3000 0.6056 270.4980 0.6056 270.6000 0.5477 270.7980 0.5477 270.9000 0.5860 271.0980 0.5860 271.2000 0.5723 271.3980 0.5723 271.5000 0.6247 271.6980 0.6247 271.8000 0.5668 271.9980 0.5668 272.1000 0.5998 272.2980 0.5998 272.4000 0.5790 272.5980 0.5790 272.7000 0.6068 272.8980 0.6068 273.0000 0.5960 273.1980 0.5960 273.3000 0.6236 273.4980 0.6236 273.6000 0.5892 273.7980 0.5892 273.9000 0.6006 274.0980 0.6006 274.2000 0.5466 274.3980 0.5466 274.5000 0.5968 274.6980 0.5968 274.8000 0.5971 274.9980 0.5971 275.1000 0.6004 275.2980 0.6004 275.4000 0.5933 275.5980 0.5933 275.7000 0.5768 275.8980 0.5768 276.0000 0.6007 276.1980 0.6007 276.3000 0.6082 276.4980 0.6082 276.6000 0.5745 276.7980 0.5745 276.9000 0.5786 277.0980 0.5786 277.2000 0.5559 277.3980 0.5559 277.5000 0.6088 277.6980 0.6088 277.8000 0.8045 277.9980 0.8045 278.1000 0.5821 278.2980 0.5821 278.4000 0.5732 278.5980 0.5732 278.7000 0.6057 278.8980 0.6057 279.0000 0.5458 279.1980 0.5458 279.3000 0.6020 279.4980 0.6020 279.6000 0.5708 279.7980 0.5708 279.9000 0.7692 280.0980 0.7692 280.2000 0.5724 280.3980 0.5724 280.5000 0.5754 280.6980 0.5754 280.8000 0.9315 280.9980 0.9315 281.1000 0.9004 281.2980 0.9004 281.4000 0.8485 281.5980 0.8485 281.7000 1.1370 281.8980 1.1370 282.0000 0.5775 282.1980 0.5775 282.3000 0.6685 282.4980 0.6685 282.6000 0.6541 282.7980 0.6541 282.9000 0.5959 283.0980 0.5959 283.2000 0.9662 283.3980 0.9662 283.5000 0.8137 283.6980 0.8137 283.8000 0.5457 283.9980 0.5457 284.1000 0.9488 284.2980 0.9488 284.4000 0.6484 284.5980 0.6484 284.7000 0.9633 284.8980 0.9633 285.0000 0.8336 285.1980 0.8336 285.3000 0.5562 285.4980 0.5562 285.6000 0.7680 285.7980 0.7680 285.9000 0.9813 286.0980 0.9813 286.2000 0.9239 286.3980 0.9239 286.5000 0.5635 286.6980 0.5635 286.8000 0.6502 286.9980 0.6502 287.1000 0.5981 287.2980 0.5981 287.4000 1.3567 287.5980 1.3567 287.7000 0.8142 287.8980 0.8142 288.0000 0.5412 288.1980 0.5412 288.3000 0.5887 288.4980 0.5887 288.6000 0.5985 288.7980 0.5985 288.9000 0.7333 289.0980 0.7333 289.2000 0.5913 289.3980 0.5913 289.5000 0.6190 289.6980 0.6190 289.8000 0.5692 289.9980 0.5692 290.1000 0.5961 290.2980 0.5961 290.4000 0.6150 290.5980 0.6150 290.7000 0.5696 290.8980 0.5696 291.0000 0.6065 291.1980 0.6065 291.3000 0.6194 291.4980 0.6194 291.6000 0.5673 291.7980 0.5673 291.9000 0.6056 292.0980 0.6056 292.2000 0.5477 292.3980 0.5477 292.5000 0.5860 292.6980 0.5860 292.8000 0.5723 292.9980 0.5723 293.1000 0.6247 293.2980 0.6247 293.4000 0.5668 293.5980 0.5668 293.7000 0.5998 293.8980 0.5998 294.0000 0.5790 294.1980 0.5790 294.3000 0.6068 294.4980 0.6068 294.6000 0.5960 294.7980 0.5960 294.9000 0.6236 295.0980 0.6236 295.2000 0.5892 295.3980 0.5892 295.5000 0.6006 295.6980 0.6006 295.8000 0.5466 295.9980 0.5466 296.1000 0.5968 296.2980 0.5968 296.4000 0.5971 296.5980 0.5971 296.7000 0.6004 296.8980 0.6004 297.0000 0.5933 297.1980 0.5933 297.3000 0.5768 297.4980 0.5768 297.6000 0.6007 297.7980 0.6007 297.9000 0.6082 298.0980 0.6082 298.2000 0.5745 298.3980 0.5745 298.5000 0.5786 298.6980 0.5786 298.8000 0.5559 298.9980 0.5559 299.1000 0.6088 299.2980 0.6088 299.4000 0.8045 299.5980 0.8045 299.7000 0.5821 299.8980 0.5821 300.0000 0.5732 300.1980 0.5732 300.3000 0.6057 300.4980 0.6057 300.6000 0.5458 300.7980 0.5458 300.9000 0.6020 301.0980 0.6020 301.2000 0.5708 301.3980 0.5708 301.5000 0.7692 301.6980 0.7692 301.8000 0.5724 301.9980 0.5724 302.1000 0.5754 302.2980 0.5754 302.4000 0.9315 302.5980 0.9315 302.7000 0.9004 302.8980 0.9004 303.0000 0.8485 303.1980 0.8485 303.3000 1.1370 303.4980 1.1370 303.6000 0.5775 303.7980 0.5775 303.9000 0.6685 304.0980 0.6685 304.2000 0.6541 304.3980 0.6541 304.5000 0.5959 304.6980 0.5959 304.8000 0.9662 304.9980 0.9662 305.1000 0.8137 305.2980 0.8137 305.4000 0.5457 305.5980 0.5457 305.7000 0.9488 305.8980 0.9488 306.0000 0.6484 306.1980 0.6484 306.3000 0.9633 306.4980 0.9633 306.6000 0.8336 306.7980 0.8336 306.9000 0.5562 307.0980 0.5562 307.2000 0.7680 307.3980 0.7680 307.5000 0.9813 307.6980 0.9813 307.8000 0.9239 307.9980 0.9239 308.1000 0.5635 308.2980 0.5635 308.4000 0.6502 308.5980 0.6502 308.7000 0.5981 308.8980 0.5981 309.0000 1.3567 309.1980 1.3567 309.3000 0.8142 309.4980 0.8142 309.6000 0.5412 309.7980 0.5412 309.9000 0.5887 310.0980 0.5887 310.2000 0.5985 310.3980 0.5985 310.5000 0.7333 310.6980 0.7333 310.8000 0.5913 310.9980 0.5913 311.1000 0.6190 311.2980 0.6190 311.4000 0.5692 311.5980 0.5692 311.7000 0.5961 311.8980 0.5961 312.0000 0.6150 312.1980 0.6150 312.3000 0.5696 312.4980 0.5696 312.6000 0.6065 312.7980 0.6065 312.9000 0.6194 313.0980 0.6194 313.2000 0.5673 313.3980 0.5673 313.5000 0.6056 313.6980 0.6056 313.8000 0.5477 313.9980 0.5477 314.1000 0.5860 314.2980 0.5860 314.4000 0.5723 314.5980 0.5723 314.7000 0.6247 314.8980 0.6247 315.0000 0.5668 315.1980 0.5668 315.3000 0.5998 315.4980 0.5998 315.6000 0.5790 315.7980 0.5790 315.9000 0.6068 316.0980 0.6068 316.2000 0.5960 316.3980 0.5960 316.5000 0.6236 316.6980 0.6236 316.8000 0.5892 316.9980 0.5892 317.1000 0.6006 317.2980 0.6006 317.4000 0.5466 317.5980 0.5466 317.7000 0.5968 317.8980 0.5968 318.0000 0.5971 318.1980 0.5971 318.3000 0.6004 318.4980 0.6004 318.6000 0.5933 318.7980 0.5933 318.9000 0.5768 319.0980 0.5768 319.2000 0.6007 319.3980 0.6007 319.5000 0.6082 319.6980 0.6082 319.8000 0.5745 319.9980 0.5745 320.1000 0.5786 320.2980 0.5786 320.4000 0.5559 320.5980 0.5559 320.7000 0.6088 320.8980 0.6088 321.0000 0.8045 321.1980 0.8045 321.3000 0.5821 321.4980 0.5821 321.6000 0.5732 321.7980 0.5732 321.9000 0.6057 322.0980 0.6057 322.2000 0.5458 322.3980 0.5458 322.5000 0.6020 322.6980 0.6020 322.8000 0.5708 322.9980 0.5708 323.1000 0.7692 323.2980 0.7692 323.4000 0.5724 323.5980 0.5724 323.7000 0.5754 323.8980 0.5754 324.0000 0.9315 324.1980 0.9315 324.3000 0.9004 324.4980 0.9004 324.6000 0.8485 324.7980 0.8485 324.9000 1.1370 325.0980 1.1370 325.2000 0.5775 325.3980 0.5775 325.5000 0.6685 325.6980 0.6685 325.8000 0.6541 325.9980 0.6541 326.1000 0.5959 326.2980 0.5959 326.4000 0.9662 326.5980 0.9662 326.7000 0.8137 326.8980 0.8137 327.0000 0.5457 327.1980 0.5457 327.3000 0.9488 327.4980 0.9488 327.6000 0.6484 327.7980 0.6484 327.9000 0.9633 328.0980 0.9633 328.2000 0.8336 328.3980 0.8336 328.5000 0.5562 328.6980 0.5562 328.8000 0.7680 328.9980 0.7680 329.1000 0.9813 329.2980 0.9813 329.4000 0.9239 329.5980 0.9239 329.7000 0.5635 329.8980 0.5635 330.0000 0.6502 330.1980 0.6502 330.3000 0.5981 330.4980 0.5981 330.6000 1.3567 330.7980 1.3567 330.9000 0.8142 331.0980 0.8142 331.2000 0.5412 331.3980 0.5412 331.5000 0.5887 331.6980 0.5887 331.8000 0.5985 331.9980 0.5985 332.1000 0.7333 332.2980 0.7333 332.4000 0.5913 332.5980 0.5913 332.7000 0.6190 332.8980 0.6190 333.0000 0.5692 333.1980 0.5692 333.3000 0.5961 333.4980 0.5961 333.6000 0.6150 333.7980 0.6150 333.9000 0.5696 334.0980 0.5696 334.2000 0.6065 334.3980 0.6065 334.5000 0.6194 334.6980 0.6194 334.8000 0.5673 334.9980 0.5673 335.1000 0.6056 335.2980 0.6056 335.4000 0.5477 335.5980 0.5477 335.7000 0.5860 335.8980 0.5860 336.0000 0.5723 336.1980 0.5723 336.3000 0.6247 336.4980 0.6247 336.6000 0.5668 336.7980 0.5668 336.9000 0.5998 337.0980 0.5998 337.2000 0.5790 337.3980 0.5790 337.5000 0.6068 337.6980 0.6068 337.8000 0.5960 337.9980 0.5960 338.1000 0.6236 338.2980 0.6236 338.4000 0.5892 338.5980 0.5892 338.7000 0.6006 338.8980 0.6006 339.0000 0.5466 339.1980 0.5466 339.3000 0.5968 339.4980 0.5968 339.6000 0.5971 339.7980 0.5971 339.9000 0.6004 340.0980 0.6004 340.2000 0.5933 340.3980 0.5933 340.5000 0.5768 340.6980 0.5768 340.8000 0.6007 340.9980 0.6007 341.1000 0.6082 341.2980 0.6082 341.4000 0.5745 341.5980 0.5745 341.7000 0.5786 341.8980 0.5786 342.0000 0.5559 342.1980 0.5559 342.3000 0.6088 342.4980 0.6088 342.6000 0.8045 342.7980 0.8045 342.9000 0.5821 343.0980 0.5821 343.2000 0.5732 343.3980 0.5732 343.5000 0.6057 343.6980 0.6057 343.8000 0.5458 343.9980 0.5458 344.1000 0.6020 344.2980 0.6020 344.4000 0.5708 344.5980 0.5708 344.7000 0.7692 344.8980 0.7692 345.0000 0.5724 345.1980 0.5724 345.3000 0.5754 345.4980 0.5754 345.6000 0.9315 345.7980 0.9315 345.9000 0.9004 346.0980 0.9004 346.2000 0.8485 346.3980 0.8485 346.5000 1.1370 346.6980 1.1370 346.8000 0.5775 346.9980 0.5775 347.1000 0.6685 347.2980 0.6685 347.4000 0.6541 347.5980 0.6541 347.7000 0.5959 347.8980 0.5959 348.0000 0.9662 348.1980 0.9662 348.3000 0.8137 348.4980 0.8137 348.6000 0.5457 348.7980 0.5457 348.9000 0.9488 349.0980 0.9488 349.2000 0.6484 349.3980 0.6484 349.5000 0.9633 349.6980 0.9633 349.8000 0.8336 349.9980 0.8336 350.1000 0.5562 350.2980 0.5562 350.4000 0.7680 350.5980 0.7680 350.7000 0.9813 350.8980 0.9813 351.0000 0.9239 351.1980 0.9239 351.3000 0.5635 351.4980 0.5635 351.6000 0.6502 351.7980 0.6502 351.9000 0.5981 352.0980 0.5981 352.2000 1.3567 352.3980 1.3567 352.5000 0.8142 352.6980 0.8142 352.8000 0.5412 352.9980 0.5412 353.1000 0.5887 353.2980 0.5887 353.4000 0.5985 353.5980 0.5985 353.7000 0.7333 353.8980 0.7333 354.0000 0.5913 354.1980 0.5913 354.3000 0.6190 354.4980 0.6190 354.6000 0.5692 354.7980 0.5692 354.9000 0.5961 355.0980 0.5961 355.2000 0.6150 355.3980 0.6150 355.5000 0.5696 355.6980 0.5696 355.8000 0.6065 355.9980 0.6065 356.1000 0.6194 356.2980 0.6194 356.4000 0.5673 356.5980 0.5673 356.7000 0.6056 356.8980 0.6056 357.0000 0.5477 357.1980 0.5477 357.3000 0.5860 357.4980 0.5860 357.6000 0.5723 357.7980 0.5723 357.9000 0.6247 358.0980 0.6247 358.2000 0.5668 358.3980 0.5668 358.5000 0.5998 358.6980 0.5998 358.8000 0.5790 358.9980 0.5790 359.1000 0.6068 359.2980 0.6068 359.4000 0.5960 359.5980 0.5960 359.7000 0.6236 359.8980 0.6236 360.0000 0.5892 360.1980 0.5892 360.3000 0.6006 360.4980 0.6006 360.6000 0.5466 360.7980 0.5466 360.9000 0.5968 361.0980 0.5968 361.2000 0.5971 361.3980 0.5971 361.5000 0.6004 361.6980 0.6004 361.8000 0.5933 361.9980 0.5933 362.1000 0.5768 362.2980 0.5768 362.4000 0.6007 362.5980 0.6007 362.7000 0.6082 362.8980 0.6082 363.0000 0.5745 363.1980 0.5745 363.3000 0.5786 363.4980 0.5786 363.6000 0.5559 363.7980 0.5559 363.9000 0.6088 364.0980 0.6088 364.2000 0.8045 364.3980 0.8045 364.5000 0.5821 364.6980 0.5821 364.8000 0.5732 364.9980 0.5732 365.1000 0.6057 365.2980 0.6057 365.4000 0.5458 365.5980 0.5458 365.7000 0.6020 365.8980 0.6020 366.0000 0.5708 366.1980 0.5708 366.3000 0.7692 366.4980 0.7692 366.6000 0.5724 366.7980 0.5724 366.9000 0.5754 367.0980 0.5754 367.2000 0.9315 367.3980 0.9315 367.5000 0.9004 367.6980 0.9004 367.8000 0.8485 367.9980 0.8485 368.1000 1.1370 368.2980 1.1370 368.4000 0.5775 368.5980 0.5775 368.7000 0.6685 368.8980 0.6685 369.0000 0.6541 369.1980 0.6541 369.3000 0.5959 369.4980 0.5959 369.6000 0.9662 369.7980 0.9662 369.9000 0.8137 370.0980 0.8137 370.2000 0.5457 370.3980 0.5457 370.5000 0.9488 370.6980 0.9488 370.8000 0.6484 370.9980 0.6484 371.1000 0.9633 371.2980 0.9633 371.4000 0.8336 371.5980 0.8336 371.7000 0.5562 371.8980 0.5562 372.0000 0.7680 372.1980 0.7680 372.3000 0.9813 372.4980 0.9813 372.6000 0.9239 372.7980 0.9239 372.9000 0.5635 373.0980 0.5635 373.2000 0.6502 373.3980 0.6502 373.5000 0.5981 373.6980 0.5981 373.8000 1.3567 373.9980 1.3567 374.1000 0.8142 374.2980 0.8142 374.4000 0.5412 374.5980 0.5412 374.7000 0.5887 374.8980 0.5887 375.0000 0.5985 375.1980 0.5985 375.3000 0.7333 375.4980 0.7333 375.6000 0.5913 375.7980 0.5913 375.9000 0.6190 376.0980 0.6190 376.2000 0.5692 376.3980 0.5692 376.5000 0.5961 376.6980 0.5961 376.8000 0.6150 376.9980 0.6150 377.1000 0.5696 377.2980 0.5696 377.4000 0.6065 377.5980 0.6065 377.7000 0.6194 377.8980 0.6194 378.0000 0.5673 378.1980 0.5673 378.3000 0.6056 378.4980 0.6056 378.6000 0.5477 378.7980 0.5477 378.9000 0.5860 379.0980 0.5860 379.2000 0.5723 379.3980 0.5723 379.5000 0.6247 379.6980 0.6247 379.8000 0.5668 379.9980 0.5668 380.1000 0.5998 380.2980 0.5998 380.4000 0.5790 380.5980 0.5790 380.7000 0.6068 380.8980 0.6068 381.0000 0.5960 381.1980 0.5960 381.3000 0.6236 381.4980 0.6236 381.6000 0.5892 381.7980 0.5892 381.9000 0.6006 382.0980 0.6006 382.2000 0.5466 382.3980 0.5466 382.5000 0.5968 382.6980 0.5968 382.8000 0.5971 382.9980 0.5971 383.1000 0.6004 383.2980 0.6004 383.4000 0.5933 383.5980 0.5933 383.7000 0.5768 383.8980 0.5768 384.0000 0.6007 384.1980 0.6007 384.3000 0.6082 384.4980 0.6082 384.6000 0.5745 384.7980 0.5745 384.9000 0.5786 385.0980 0.5786 385.2000 0.5559 385.3980 0.5559 385.5000 0.6088 385.6980 0.6088 385.8000 0.8045 385.9980 0.8045 386.1000 0.5821 386.2980 0.5821 386.4000 0.5732 386.5980 0.5732 386.7000 0.6057 386.8980 0.6057 387.0000 0.5458 387.1980 0.5458 387.3000 0.6020 387.4980 0.6020 387.6000 0.5708 387.7980 0.5708 387.9000 0.7692 388.0980 0.7692 388.2000 0.5724 388.3980 0.5724 388.5000 0.5754 388.6980 0.5754 388.8000 0.9315 388.9980 0.9315 389.1000 0.9004 389.2980 0.9004 389.4000 0.8485 389.5980 0.8485 389.7000 1.1370 389.8980 1.1370 390.0000 0.5775 390.1980 0.5775 390.3000 0.6685 390.4980 0.6685 390.6000 0.6541 390.7980 0.6541 390.9000 0.5959 391.0980 0.5959 391.2000 0.9662 391.3980 0.9662 391.5000 0.8137 391.6980 0.8137 391.8000 0.5457 391.9980 0.5457 392.1000 0.9488 392.2980 0.9488 392.4000 0.6484 392.5980 0.6484 392.7000 0.9633 392.8980 0.9633 393.0000 0.8336 393.1980 0.8336 393.3000 0.5562 393.4980 0.5562 393.6000 0.7680 393.7980 0.7680 393.9000 0.9813 394.0980 0.9813 394.2000 0.9239 394.3980 0.9239 394.5000 0.5635 394.6980 0.5635 394.8000 0.6502 394.9980 0.6502 395.1000 0.5981 395.2980 0.5981 395.4000 1.3567 395.5980 1.3567 395.7000 0.8142 395.8980 0.8142 396.0000 0.5412 396.1980 0.5412 396.3000 0.5887 396.4980 0.5887 396.6000 0.5985 396.7980 0.5985 396.9000 0.7333 397.0980 0.7333 397.2000 0.5913 397.3980 0.5913 397.5000 0.6190 397.6980 0.6190 397.8000 0.5692 397.9980 0.5692 398.1000 0.5961 398.2980 0.5961 398.4000 0.6150 398.5980 0.6150 398.7000 0.5696 398.8980 0.5696 399.0000 0.6065 399.1980 0.6065 399.3000 0.6194 399.4980 0.6194 399.6000 0.5673 399.7980 0.5673 399.9000 0.6056 400.0980 0.6056 400.2000 0.5477 400.3980 0.5477 400.5000 0.5860 400.6980 0.5860 400.8000 0.5723 400.9980 0.5723 401.1000 0.6247 401.2980 0.6247 401.4000 0.5668 401.5980 0.5668 401.7000 0.5998 401.8980 0.5998 402.0000 0.5790 402.1980 0.5790 402.3000 0.6068 402.4980 0.6068 402.6000 0.5960 402.7980 0.5960 402.9000 0.6236 403.0980 0.6236 403.2000 0.5892 403.3980 0.5892 403.5000 0.6006 403.6980 0.6006 403.8000 0.5466 403.9980 0.5466 404.1000 0.5968 404.2980 0.5968 404.4000 0.5971 404.5980 0.5971 404.7000 0.6004 404.8980 0.6004 405.0000 0.5933 405.1980 0.5933 405.3000 0.5768 405.4980 0.5768 405.6000 0.6007 405.7980 0.6007 405.9000 0.6082 406.0980 0.6082 406.2000 0.5745 406.3980 0.5745 406.5000 0.5786 406.6980 0.5786 406.8000 0.5559 406.9980 0.5559 407.1000 0.6088 407.2980 0.6088 407.4000 0.8045 407.5980 0.8045 407.7000 0.5821 407.8980 0.5821 408.0000 0.5732 408.1980 0.5732 408.3000 0.6057 408.4980 0.6057 408.6000 0.5458 408.7980 0.5458 408.9000 0.6020 409.0980 0.6020 409.2000 0.5708 409.3980 0.5708 409.5000 0.7692 409.6980 0.7692 409.8000 0.5724 409.9980 0.5724 410.1000 0.5754 410.2980 0.5754 410.4000 0.9315 410.5980 0.9315 410.7000 0.9004 410.8980 0.9004 411.0000 0.8485 411.1980 0.8485 411.3000 1.1370 411.4980 1.1370 411.6000 0.5775 411.7980 0.5775 411.9000 0.6685 412.0980 0.6685 412.2000 0.6541 412.3980 0.6541 412.5000 0.5959 412.6980 0.5959 412.8000 0.9662 412.9980 0.9662 413.1000 0.8137 413.2980 0.8137 413.4000 0.5457 413.5980 0.5457 413.7000 0.9488 413.8980 0.9488 414.0000 0.6484 414.1980 0.6484 414.3000 0.9633 414.4980 0.9633 414.6000 0.8336 414.7980 0.8336 414.9000 0.5562 415.0980 0.5562 415.2000 0.7680 415.3980 0.7680 415.5000 0.9813 415.6980 0.9813 415.8000 0.9239 415.9980 0.9239 416.1000 0.5635 416.2980 0.5635 416.4000 0.6502 416.5980 0.6502 416.7000 0.5981 416.8980 0.5981 417.0000 1.3567 417.1980 1.3567 417.3000 0.8142 417.4980 0.8142 417.6000 0.5412 417.7980 0.5412 417.9000 0.5887 418.0980 0.5887 418.2000 0.5985 418.3980 0.5985 418.5000 0.7333 418.6980 0.7333 418.8000 0.5913 418.9980 0.5913 419.1000 0.6190 419.2980 0.6190 419.4000 0.5692 419.5980 0.5692 419.7000 0.5961 419.8980 0.5961 420.0000 0.6150 420.1980 0.6150 420.3000 0.5696 420.4980 0.5696 420.6000 0.6065 420.7980 0.6065 420.9000 0.6194 421.0980 0.6194 421.2000 0.5673 421.3980 0.5673 421.5000 0.6056 421.6980 0.6056 421.8000 0.5477 421.9980 0.5477 422.1000 0.5860 422.2980 0.5860 422.4000 0.5723 422.5980 0.5723 422.7000 0.6247 422.8980 0.6247 423.0000 0.5668 423.1980 0.5668 423.3000 0.5998 423.4980 0.5998 423.6000 0.5790 423.7980 0.5790 423.9000 0.6068 424.0980 0.6068 424.2000 0.5960 424.3980 0.5960 424.5000 0.6236 424.6980 0.6236 424.8000 0.5892 424.9980 0.5892 425.1000 0.6006 425.2980 0.6006 425.4000 0.5466 425.5980 0.5466 425.7000 0.5968 425.8980 0.5968 426.0000 0.5971 426.1980 0.5971 426.3000 0.6004 426.4980 0.6004 426.6000 0.5933 426.7980 0.5933 426.9000 0.5768 427.0980 0.5768 427.2000 0.6007 427.3980 0.6007 427.5000 0.6082 427.6980 0.6082 427.8000 0.5745 427.9980 0.5745 428.1000 0.5786 428.2980 0.5786 428.4000 0.5559 428.5980 0.5559 428.7000 0.6088 428.8980 0.6088 429.0000 0.8045 429.1980 0.8045 429.3000 0.5821 429.4980 0.5821 429.6000 0.5732 429.7980 0.5732 429.9000 0.6057 430.0980 0.6057 430.2000 0.5458 430.3980 0.5458 430.5000 0.6020 430.6980 0.6020 430.8000 0.5708 430.9980 0.5708 431.1000 0.7692 431.2980 0.7692 431.4000 0.5724 431.5980 0.5724 431.7000 0.5754 431.8980 0.5754 432.0000 0.9315 432.1980 0.9315 432.3000 0.9004 432.4980 0.9004 432.6000 0.8485 432.7980 0.8485 432.9000 1.1370 433.0980 1.1370 433.2000 0.5775 433.3980 0.5775 433.5000 0.6685 433.6980 0.6685 433.8000 0.6541 433.9980 0.6541 434.1000 0.5959 434.2980 0.5959 434.4000 0.9662 434.5980 0.9662 434.7000 0.8137 434.8980 0.8137 435.0000 0.5457 435.1980 0.5457 435.3000 0.9488 435.4980 0.9488 435.6000 0.6484 435.7980 0.6484 435.9000 0.9633 436.0980 0.9633 436.2000 0.8336 436.3980 0.8336 436.5000 0.5562 436.6980 0.5562 436.8000 0.7680 436.9980 0.7680 437.1000 0.9813 437.2980 0.9813 437.4000 0.9239 437.5980 0.9239 437.7000 0.5635 437.8980 0.5635 438.0000 0.6502 438.1980 0.6502 438.3000 0.5981 438.4980 0.5981 438.6000 1.3567 438.7980 1.3567 438.9000 0.8142 439.0980 0.8142 439.2000 0.5412 439.3980 0.5412 439.5000 0.5887 439.6980 0.5887 439.8000 0.5985 439.9980 0.5985 440.1000 0.7333 440.2980 0.7333 440.4000 0.5913 440.5980 0.5913 440.7000 0.6190 440.8980 0.6190 441.0000 0.5692 441.1980 0.5692 441.3000 0.5961 441.4980 0.5961 441.6000 0.6150 441.7980 0.6150 441.9000 0.5696 442.0980 0.5696 442.2000 0.6065 442.3980 0.6065 442.5000 0.6194 442.6980 0.6194 442.8000 0.5673 442.9980 0.5673 443.1000 0.6056 443.2980 0.6056 443.4000 0.5477 443.5980 0.5477 443.7000 0.5860 443.8980 0.5860 444.0000 0.5723 444.1980 0.5723 444.3000 0.6247 444.4980 0.6247 444.6000 0.5668 444.7980 0.5668 444.9000 0.5998 445.0980 0.5998 445.2000 0.5790 445.3980 0.5790 445.5000 0.6068 445.6980 0.6068 445.8000 0.5960 445.9980 0.5960 446.1000 0.6236 446.2980 0.6236 446.4000 0.5892 446.5980 0.5892 446.7000 0.6006 446.8980 0.6006 447.0000 0.5466 447.1980 0.5466 447.3000 0.5968 447.4980 0.5968 447.6000 0.5971 447.7980 0.5971 447.9000 0.6004 448.0980 0.6004 448.2000 0.5933 448.3980 0.5933 448.5000 0.5768 448.6980 0.5768 448.8000 0.6007 448.9980 0.6007 449.1000 0.6082 449.2980 0.6082 449.4000 0.5745 449.5980 0.5745 449.7000 0.5786 449.8980 0.5786 450.0000 0.5559 450.1980 0.5559 450.3000 0.6088 450.4980 0.6088 450.6000 0.8045 450.7980 0.8045 450.9000 0.5821 451.0980 0.5821 451.2000 0.5732 451.3980 0.5732 451.5000 0.6057 451.6980 0.6057 451.8000 0.5458 451.9980 0.5458 452.1000 0.6020 452.2980 0.6020 452.4000 0.5708 452.5980 0.5708 452.7000 0.7692 452.8980 0.7692 453.0000 0.5724 453.1980 0.5724 453.3000 0.5754 453.4980 0.5754 453.6000 0.9315 453.7980 0.9315 453.9000 0.9004 454.0980 0.9004 454.2000 0.8485 454.3980 0.8485 454.5000 1.1370 454.6980 1.1370 454.8000 0.5775 454.9980 0.5775 455.1000 0.6685 455.2980 0.6685 455.4000 0.6541 455.5980 0.6541 455.7000 0.5959 455.8980 0.5959 456.0000 0.9662 456.1980 0.9662 456.3000 0.8137 456.4980 0.8137 456.6000 0.5457 456.7980 0.5457 456.9000 0.9488 457.0980 0.9488 457.2000 0.6484 457.3980 0.6484 457.5000 0.9633 457.6980 0.9633 457.8000 0.8336 457.9980 0.8336 458.1000 0.5562 458.2980 0.5562 458.4000 0.7680 458.5980 0.7680 458.7000 0.9813 458.8980 0.9813 459.0000 0.9239 459.1980 0.9239 459.3000 0.5635 459.4980 0.5635 459.6000 0.6502 459.7980 0.6502 459.9000 0.5981 460.0980 0.5981 460.2000 1.3567 460.3980 1.3567 460.5000 0.8142 460.6980 0.8142 460.8000 0.5412 460.9980 0.5412 461.1000 0.5887 461.2980 0.5887 461.4000 0.5985 461.5980 0.5985 461.7000 0.7333 461.8980 0.7333 462.0000 0.5913 462.1980 0.5913 462.3000 0.6190 462.4980 0.6190 462.6000 0.5692 462.7980 0.5692 462.9000 0.5961 463.0980 0.5961 463.2000 0.6150 463.3980 0.6150 463.5000 0.5696 463.6980 0.5696 463.8000 0.6065 463.9980 0.6065 464.1000 0.6194 464.2980 0.6194 464.4000 0.5673 464.5980 0.5673 464.7000 0.6056 464.8980 0.6056 465.0000 0.5477 465.1980 0.5477 465.3000 0.5860 465.4980 0.5860 465.6000 0.5723 465.7980 0.5723 465.9000 0.6247 466.0980 0.6247 466.2000 0.5668 466.3980 0.5668 466.5000 0.5998 466.6980 0.5998 466.8000 0.5790 466.9980 0.5790 467.1000 0.6068 467.2980 0.6068 467.4000 0.5960 467.5980 0.5960 467.7000 0.6236 467.8980 0.6236 468.0000 0.5892 468.1980 0.5892 468.3000 0.6006 468.4980 0.6006 468.6000 0.5466 468.7980 0.5466 468.9000 0.5968 469.0980 0.5968 469.2000 0.5971 469.3980 0.5971 469.5000 0.6004 469.6980 0.6004 469.8000 0.5933 469.9980 0.5933 470.1000 0.5768 470.2980 0.5768 470.4000 0.6007 470.5980 0.6007 470.7000 0.6082 470.8980 0.6082 471.0000 0.5745 471.1980 0.5745 471.3000 0.5786 471.4980 0.5786 471.6000 0.5559 471.7980 0.5559 471.9000 0.6088 472.0980 0.6088 472.2000 0.8045 472.3980 0.8045 472.5000 0.5821 472.6980 0.5821 472.8000 0.5732 472.9980 0.5732 473.1000 0.6057 473.2980 0.6057 473.4000 0.5458 473.5980 0.5458 473.7000 0.6020 473.8980 0.6020 474.0000 0.5708 474.1980 0.5708 474.3000 0.7692 474.4980 0.7692 474.6000 0.5724 474.7980 0.5724 474.9000 0.5754 475.0980 0.5754 475.2000 0.9315 475.3980 0.9315 475.5000 0.9004 475.6980 0.9004 475.8000 0.8485 475.9980 0.8485 476.1000 1.1370 476.2980 1.1370 476.4000 0.5775 476.5980 0.5775 476.7000 0.6685 476.8980 0.6685 477.0000 0.6541 477.1980 0.6541 477.3000 0.5959 477.4980 0.5959 477.6000 0.9662 477.7980 0.9662 477.9000 0.8137 478.0980 0.8137 478.2000 0.5457 478.3980 0.5457 478.5000 0.9488 478.6980 0.9488 478.8000 0.6484 478.9980 0.6484 479.1000 0.9633 479.2980 0.9633 479.4000 0.8336 479.5980 0.8336 479.7000 0.5562 479.8980 0.5562 480.0000 0.7680 480.1980 0.7680 480.3000 0.9813 480.4980 0.9813 480.6000 0.9239 480.7980 0.9239 480.9000 0.5635 481.0980 0.5635 481.2000 0.6502 481.3980 0.6502 481.5000 0.5981 481.6980 0.5981 481.8000 1.3567 481.9980 1.3567 482.1000 0.8142 482.2980 0.8142 482.4000 0.5412 482.5980 0.5412 482.7000 0.5887 482.8980 0.5887 483.0000 0.5985 483.1980 0.5985 483.3000 0.7333 483.4980 0.7333 483.6000 0.5913 483.7980 0.5913 483.9000 0.6190 484.0980 0.6190 484.2000 0.5692 484.3980 0.5692 484.5000 0.5961 484.6980 0.5961 484.8000 0.6150 484.9980 0.6150 485.1000 0.5696 485.2980 0.5696 485.4000 0.6065 485.5980 0.6065 485.7000 0.6194 485.8980 0.6194 486.0000 0.5673 486.1980 0.5673 486.3000 0.6056 486.4980 0.6056 486.6000 0.5477 486.7980 0.5477 486.9000 0.5860 487.0980 0.5860 487.2000 0.5723 487.3980 0.5723 487.5000 0.6247 487.6980 0.6247 487.8000 0.5668 487.9980 0.5668 488.1000 0.5998 488.2980 0.5998 488.4000 0.5790 488.5980 0.5790 488.7000 0.6068 488.8980 0.6068 489.0000 0.5960 489.1980 0.5960 489.3000 0.6236 489.4980 0.6236 489.6000 0.5892 489.7980 0.5892 489.9000 0.6006 490.0980 0.6006 490.2000 0.5466 490.3980 0.5466 490.5000 0.5968 490.6980 0.5968 490.8000 0.5971 490.9980 0.5971 491.1000 0.6004 491.2980 0.6004 491.4000 0.5933 491.5980 0.5933 491.7000 0.5768 491.8980 0.5768 492.0000 0.6007 492.1980 0.6007 492.3000 0.6082 492.4980 0.6082 492.6000 0.5745 492.7980 0.5745 492.9000 0.5786 493.0980 0.5786 493.2000 0.5559 493.3980 0.5559 493.5000 0.6088 493.6980 0.6088 493.8000 0.8045 493.9980 0.8045 494.1000 0.5821 494.2980 0.5821 494.4000 0.5732 494.5980 0.5732 494.7000 0.6057 494.8980 0.6057 495.0000 0.5458 495.1980 0.5458 495.3000 0.6020 495.4980 0.6020 495.6000 0.5708 495.7980 0.5708 495.9000 0.7692 496.0980 0.7692 496.2000 0.5724 496.3980 0.5724 496.5000 0.5754 496.6980 0.5754 496.8000 0.9315 496.9980 0.9315 497.1000 0.9004 497.2980 0.9004 497.4000 0.8485 497.5980 0.8485 497.7000 1.1370 497.8980 1.1370 498.0000 0.5775 498.1980 0.5775 498.3000 0.6685 498.4980 0.6685 498.6000 0.6541 498.7980 0.6541 498.9000 0.5959 499.0980 0.5959 499.2000 0.9662 499.3980 0.9662 499.5000 0.8137 499.6980 0.8137 499.8000 0.5457 499.9980 0.5457 500.1000 0.9488 500.2980 0.9488 500.4000 0.6484 500.5980 0.6484 500.7000 0.9633 500.8980 0.9633 501.0000 0.8336 501.1980 0.8336 501.3000 0.5562 501.4980 0.5562 501.6000 0.7680 501.7980 0.7680 501.9000 0.9813 502.0980 0.9813 502.2000 0.9239 502.3980 0.9239 502.5000 0.5635 502.6980 0.5635 502.8000 0.6502 502.9980 0.6502 503.1000 0.5981 503.2980 0.5981 503.4000 1.3567 503.5980 1.3567 503.7000 0.8142 503.8980 0.8142 504.0000 0.5412 504.1980 0.5412 504.3000 0.5887 504.4980 0.5887 504.6000 0.5985 504.7980 0.5985 504.9000 0.7333 505.0980 0.7333 505.2000 0.5913 505.3980 0.5913 505.5000 0.6190 505.6980 0.6190 505.8000 0.5692 505.9980 0.5692 506.1000 0.5961 506.2980 0.5961 506.4000 0.6150 506.5980 0.6150 506.7000 0.5696 506.8980 0.5696 507.0000 0.6065 507.1980 0.6065 507.3000 0.6194 507.4980 0.6194 507.6000 0.5673 507.7980 0.5673 507.9000 0.6056 508.0980 0.6056 508.2000 0.5477 508.3980 0.5477 508.5000 0.5860 508.6980 0.5860 508.8000 0.5723 508.9980 0.5723 509.1000 0.6247 509.2980 0.6247 509.4000 0.5668 509.5980 0.5668 509.7000 0.5998 509.8980 0.5998 510.0000 0.5790 510.1980 0.5790 510.3000 0.6068 510.4980 0.6068 510.6000 0.5960 510.7980 0.5960 510.9000 0.6236 511.0980 0.6236 511.2000 0.5892 511.3980 0.5892 511.5000 0.6006 511.6980 0.6006 511.8000 0.5466 511.9980 0.5466 512.1000 0.5968 512.2980 0.5968 512.4000 0.5971 512.5980 0.5971 512.7000 0.6004 512.8980 0.6004 513.0000 0.5933 513.1980 0.5933 513.3000 0.5768 513.4980 0.5768 513.6000 0.6007 513.7980 0.6007 513.9000 0.6082 514.0980 0.6082 514.2000 0.5745 514.3980 0.5745 514.5000 0.5786 514.6980 0.5786 514.8000 0.5559 514.9980 0.5559 515.1000 0.6088 515.2980 0.6088 515.4000 0.8045 515.5980 0.8045 515.7000 0.5821 515.8980 0.5821 516.0000 0.5732 516.1980 0.5732 516.3000 0.6057 516.4980 0.6057 516.6000 0.5458 516.7980 0.5458 516.9000 0.6020 517.0980 0.6020 517.2000 0.5708 517.3980 0.5708 517.5000 0.7692 517.6980 0.7692 517.8000 0.5724 517.9980 0.5724 518.1000 0.5754 518.2980 0.5754 518.4000 0.9315 518.5980 0.9315 518.7000 0.9004 518.8980 0.9004 519.0000 0.8485 519.1980 0.8485 519.3000 1.1370 519.4980 1.1370 519.6000 0.5775 519.7980 0.5775 519.9000 0.6685 520.0980 0.6685 520.2000 0.6541 520.3980 0.6541 520.5000 0.5959 520.6980 0.5959 520.8000 0.9662 520.9980 0.9662 521.1000 0.8137 521.2980 0.8137 521.4000 0.5457 521.5980 0.5457 521.7000 0.9488 521.8980 0.9488 522.0000 0.6484 522.1980 0.6484 522.3000 0.9633 522.4980 0.9633 522.6000 0.8336 522.7980 0.8336 522.9000 0.5562 523.0980 0.5562 523.2000 0.7680 523.3980 0.7680 523.5000 0.9813 523.6980 0.9813 523.8000 0.9239 523.9980 0.9239 524.1000 0.5635 524.2980 0.5635 524.4000 0.6502 524.5980 0.6502 524.7000 0.5981 524.8980 0.5981 525.0000 1.3567 525.1980 1.3567 525.3000 0.8142 525.4980 0.8142 525.6000 0.5412 525.7980 0.5412 525.9000 0.5887 526.0980 0.5887 526.2000 0.5985 526.3980 0.5985 526.5000 0.7333 526.6980 0.7333 526.8000 0.5913 526.9980 0.5913 527.1000 0.6190 527.2980 0.6190 527.4000 0.5692 527.5980 0.5692 527.7000 0.5961 527.8980 0.5961 528.0000 0.6150 528.1980 0.6150 528.3000 0.5696 528.4980 0.5696 528.6000 0.6065 528.7980 0.6065 528.9000 0.6194 529.0980 0.6194 529.2000 0.5673 529.3980 0.5673 529.5000 0.6056 529.6980 0.6056 529.8000 0.5477 529.9980 0.5477 530.1000 0.5860 530.2980 0.5860 530.4000 0.5723 530.5980 0.5723 530.7000 0.6247 530.8980 0.6247 531.0000 0.5668 531.1980 0.5668 531.3000 0.5998 531.4980 0.5998 531.6000 0.5790 531.7980 0.5790 531.9000 0.6068 532.0980 0.6068 532.2000 0.5960 532.3980 0.5960 532.5000 0.6236 532.6980 0.6236 532.8000 0.5892 532.9980 0.5892 533.1000 0.6006 533.2980 0.6006 533.4000 0.5466 533.5980 0.5466 533.7000 0.5968 533.8980 0.5968 534.0000 0.5971 534.1980 0.5971 534.3000 0.6004 534.4980 0.6004 534.6000 0.5933 534.7980 0.5933 534.9000 0.5768 535.0980 0.5768 535.2000 0.6007 535.3980 0.6007 535.5000 0.6082 535.6980 0.6082 535.8000 0.5745 535.9980 0.5745 536.1000 0.5786 536.2980 0.5786 536.4000 0.5559 536.5980 0.5559 536.7000 0.6088 536.8980 0.6088 537.0000 0.8045 537.1980 0.8045 537.3000 0.5821 537.4980 0.5821 537.6000 0.5732 537.7980 0.5732 537.9000 0.6057 538.0980 0.6057 538.2000 0.5458 538.3980 0.5458 538.5000 0.6020 538.6980 0.6020 538.8000 0.5708 538.9980 0.5708 539.1000 0.7692 539.2980 0.7692 539.4000 0.5724 539.5980 0.5724 539.7000 0.5754 539.8980 0.5754 540.0000 0.9315 540.1980 0.9315 540.3000 0.9004 540.4980 0.9004 540.6000 0.8485 540.7980 0.8485 540.9000 1.1370 541.0980 1.1370 541.2000 0.5775 541.3980 0.5775 541.5000 0.6685 541.6980 0.6685 541.8000 0.6541 541.9980 0.6541 542.1000 0.5959 542.2980 0.5959 542.4000 0.9662 542.5980 0.9662 542.7000 0.8137 542.8980 0.8137 543.0000 0.5457 543.1980 0.5457 543.3000 0.9488 543.4980 0.9488 543.6000 0.6484 543.7980 0.6484 543.9000 0.9633 544.0980 0.9633 544.2000 0.8336 544.3980 0.8336 544.5000 0.5562 544.6980 0.5562 544.8000 0.7680 544.9980 0.7680 545.1000 0.9813 545.2980 0.9813 545.4000 0.9239 545.5980 0.9239 545.7000 0.5635 545.8980 0.5635 546.0000 0.6502 546.1980 0.6502 546.3000 0.5981 546.4980 0.5981 546.6000 1.3567 546.7980 1.3567 546.9000 0.8142 547.0980 0.8142 547.2000 0.5412 547.3980 0.5412 547.5000 0.5887 547.6980 0.5887 547.8000 0.5985 547.9980 0.5985 548.1000 0.7333 548.2980 0.7333 548.4000 0.5913 548.5980 0.5913 548.7000 0.6190 548.8980 0.6190 549.0000 0.5692 549.1980 0.5692 549.3000 0.5961 549.4980 0.5961 549.6000 0.6150 549.7980 0.6150 549.9000 0.5696 550.0980 0.5696 550.2000 0.6065 550.3980 0.6065 550.5000 0.6194 550.6980 0.6194 550.8000 0.5673 550.9980 0.5673 551.1000 0.6056 551.2980 0.6056 551.4000 0.5477 551.5980 0.5477 551.7000 0.5860 551.8980 0.5860 552.0000 0.5723 552.1980 0.5723 552.3000 0.6247 552.4980 0.6247 552.6000 0.5668 552.7980 0.5668 552.9000 0.5998 553.0980 0.5998 553.2000 0.5790 553.3980 0.5790 553.5000 0.6068 553.6980 0.6068 553.8000 0.5960 553.9980 0.5960 554.1000 0.6236 554.2980 0.6236 554.4000 0.5892 554.5980 0.5892 554.7000 0.6006 554.8980 0.6006 555.0000 0.5466 555.1980 0.5466 555.3000 0.5968 555.4980 0.5968 555.6000 0.5971 555.7980 0.5971 555.9000 0.6004 556.0980 0.6004 556.2000 0.5933 556.3980 0.5933 556.5000 0.5768 556.6980 0.5768 556.8000 0.6007 556.9980 0.6007 557.1000 0.6082 557.2980 0.6082 557.4000 0.5745 557.5980 0.5745 557.7000 0.5786 557.8980 0.5786 558.0000 0.5559 558.1980 0.5559 558.3000 0.6088 558.4980 0.6088 558.6000 0.8045 558.7980 0.8045 558.9000 0.5821 559.0980 0.5821 559.2000 0.5732 559.3980 0.5732 559.5000 0.6057 559.6980 0.6057 559.8000 0.5458 559.9980 0.5458 560.1000 0.6020 560.2980 0.6020 560.4000 0.5708 560.5980 0.5708 560.7000 0.7692 560.8980 0.7692 561.0000 0.5724 561.1980 0.5724 561.3000 0.5754 561.4980 0.5754 561.6000 0.9315 561.7980 0.9315 561.9000 0.9004 562.0980 0.9004 562.2000 0.8485 562.3980 0.8485 562.5000 1.1370 562.6980 1.1370 562.8000 0.5775 562.9980 0.5775 563.1000 0.6685 563.2980 0.6685 563.4000 0.6541 563.5980 0.6541 563.7000 0.5959 563.8980 0.5959 564.0000 0.9662 564.1980 0.9662 564.3000 0.8137 564.4980 0.8137 564.6000 0.5457 564.7980 0.5457 564.9000 0.9488 565.0980 0.9488 565.2000 0.6484 565.3980 0.6484 565.5000 0.9633 565.6980 0.9633 565.8000 0.8336 565.9980 0.8336 566.1000 0.5562 566.2980 0.5562 566.4000 0.7680 566.5980 0.7680 566.7000 0.9813 566.8980 0.9813 567.0000 0.9239 567.1980 0.9239 567.3000 0.5635 567.4980 0.5635 567.6000 0.6502 567.7980 0.6502 567.9000 0.5981 568.0980 0.5981 568.2000 1.3567 568.3980 1.3567 568.5000 0.8142 568.6980 0.8142 568.8000 0.5412 568.9980 0.5412 569.1000 0.5887 569.2980 0.5887 569.4000 0.5985 569.5980 0.5985 569.7000 0.7333 569.8980 0.7333 570.0000 0.5913 570.1980 0.5913 570.3000 0.6190 570.4980 0.6190 570.6000 0.5692 570.7980 0.5692 570.9000 0.5961 571.0980 0.5961 571.2000 0.6150 571.3980 0.6150 571.5000 0.5696 571.6980 0.5696 571.8000 0.6065 571.9980 0.6065 572.1000 0.6194 572.2980 0.6194 572.4000 0.5673 572.5980 0.5673 572.7000 0.6056 572.8980 0.6056 573.0000 0.5477 573.1980 0.5477 573.3000 0.5860 573.4980 0.5860 573.6000 0.5723 573.7980 0.5723 573.9000 0.6247 574.0980 0.6247 574.2000 0.5668 574.3980 0.5668 574.5000 0.5998 574.6980 0.5998 574.8000 0.5790 574.9980 0.5790 575.1000 0.6068 575.2980 0.6068 575.4000 0.5960 575.5980 0.5960 575.7000 0.6236 575.8980 0.6236 576.0000 0.5892 576.1980 0.5892 576.3000 0.6006 576.4980 0.6006 576.6000 0.5466 576.7980 0.5466 576.9000 0.5968 577.0980 0.5968 577.2000 0.5971 577.3980 0.5971 577.5000 0.6004 577.6980 0.6004 577.8000 0.5933 577.9980 0.5933 578.1000 0.5768 578.2980 0.5768 578.4000 0.6007 578.5980 0.6007 578.7000 0.6082 578.8980 0.6082 579.0000 0.5745 579.1980 0.5745 579.3000 0.5786 579.4980 0.5786 579.6000 0.5559 579.7980 0.5559 579.9000 0.6088 580.0980 0.6088 580.2000 0.8045 580.3980 0.8045 580.5000 0.5821 580.6980 0.5821 580.8000 0.5732 580.9980 0.5732 581.1000 0.6057 581.2980 0.6057 581.4000 0.5458 581.5980 0.5458 581.7000 0.6020 581.8980 0.6020 582.0000 0.5708 582.1980 0.5708 582.3000 0.7692 582.4980 0.7692 582.6000 0.5724 582.7980 0.5724 582.9000 0.5754 583.0980 0.5754 583.2000 0.9315 583.3980 0.9315 583.5000 0.9004 583.6980 0.9004 583.8000 0.8485 583.9980 0.8485 584.1000 1.1370 584.2980 1.1370 584.4000 0.5775 584.5980 0.5775 584.7000 0.6685 584.8980 0.6685 585.0000 0.6541 585.1980 0.6541 585.3000 0.5959 585.4980 0.5959 585.6000 0.9662 585.7980 0.9662 585.9000 0.8137 586.0980 0.8137 586.2000 0.5457 586.3980 0.5457 586.5000 0.9488 586.6980 0.9488 586.8000 0.6484 586.9980 0.6484 587.1000 0.9633 587.2980 0.9633 587.4000 0.8336 587.5980 0.8336 587.7000 0.5562 587.8980 0.5562 588.0000 0.7680 588.1980 0.7680 588.3000 0.9813 588.4980 0.9813 588.6000 0.9239 588.7980 0.9239 588.9000 0.5635 589.0980 0.5635 589.2000 0.6502 589.3980 0.6502 589.5000 0.5981 589.6980 0.5981 589.8000 1.3567 589.9980 1.3567 590.1000 0.8142 590.2980 0.8142 590.4000 0.5412 590.5980 0.5412 590.7000 0.5887 590.8980 0.5887 591.0000 0.5985 591.1980 0.5985 591.3000 0.7333 591.4980 0.7333 591.6000 0.5913 591.7980 0.5913 591.9000 0.6190 592.0980 0.6190 592.2000 0.5692 592.3980 0.5692 592.5000 0.5961 592.6980 0.5961 592.8000 0.6150 592.9980 0.6150 593.1000 0.5696 593.2980 0.5696 593.4000 0.6065 593.5980 0.6065 593.7000 0.6194 593.8980 0.6194 594.0000 0.5673 594.1980 0.5673 594.3000 0.6056 594.4980 0.6056 594.6000 0.5477 594.7980 0.5477 594.9000 0.5860 595.0980 0.5860 595.2000 0.5723 595.3980 0.5723 595.5000 0.6247 595.6980 0.6247 595.8000 0.5668 595.9980 0.5668 596.1000 0.5998 596.2980 0.5998 596.4000 0.5790 596.5980 0.5790 596.7000 0.6068 596.8980 0.6068 597.0000 0.5960 597.1980 0.5960 597.3000 0.6236 597.4980 0.6236 597.6000 0.5892 597.7980 0.5892 597.9000 0.6006 598.0980 0.6006 598.2000 0.5466 598.3980 0.5466 598.5000 0.5968 598.6980 0.5968 598.8000 0.5971 598.9980 0.5971 599.1000 0.6004 599.2980 0.6004 599.4000 0.5933 599.5980 0.5933 599.7000 0.5768 599.8980 0.5768 600.0000 0.5768)
Va12 a12 0 PWL(0.0000 0.4335 0.1980 0.4335 0.3000 0.4885 0.4980 0.4885 0.6000 0.4856 0.7980 0.4856 0.9000 0.4180 1.0980 0.4180 1.2000 0.5773 1.3980 0.5773 1.5000 0.3323 1.6980 0.3323 1.8000 0.7012 1.9980 0.7012 2.1000 0.6574 2.2980 0.6574 2.4000 0.3615 2.5980 0.3615 2.7000 0.4251 2.8980 0.4251 3.0000 0.5457 3.1980 0.5457 3.3000 0.5207 3.4980 0.5207 3.6000 0.5663 3.7980 0.5663 3.9000 0.4060 4.0980 0.4060 4.2000 0.4588 4.3980 0.4588 4.5000 0.7108 4.6980 0.7108 4.8000 0.4343 4.9980 0.4343 5.1000 0.3918 5.2980 0.3918 5.4000 0.3234 5.5980 0.3234 5.7000 0.4716 5.8980 0.4716 6.0000 0.4783 6.1980 0.4783 6.3000 0.5142 6.4980 0.5142 6.6000 0.5902 6.7980 0.5902 6.9000 0.4637 7.0980 0.4637 7.2000 0.5412 7.3980 0.5412 7.5000 0.5887 7.6980 0.5887 7.8000 0.6116 7.9980 0.6116 8.1000 0.5033 8.2980 0.5033 8.4000 0.5913 8.5980 0.5913 8.7000 0.6190 8.8980 0.6190 9.0000 0.5692 9.1980 0.5692 9.3000 0.5961 9.4980 0.5961 9.6000 0.6150 9.7980 0.6150 9.9000 0.5696 10.0980 0.5696 10.2000 0.6065 10.3980 0.6065 10.5000 0.6194 10.6980 0.6194 10.8000 0.5673 10.9980 0.5673 11.1000 0.6056 11.2980 0.6056 11.4000 0.5477 11.5980 0.5477 11.7000 0.5860 11.8980 0.5860 12.0000 0.5723 12.1980 0.5723 12.3000 0.6247 12.4980 0.6247 12.6000 0.5668 12.7980 0.5668 12.9000 0.5998 13.0980 0.5998 13.2000 0.5790 13.3980 0.5790 13.5000 0.6068 13.6980 0.6068 13.8000 0.5960 13.9980 0.5960 14.1000 0.6236 14.2980 0.6236 14.4000 0.5892 14.5980 0.5892 14.7000 0.6006 14.8980 0.6006 15.0000 0.5466 15.1980 0.5466 15.3000 0.5968 15.4980 0.5968 15.6000 0.5883 15.7980 0.5883 15.9000 0.6004 16.0980 0.6004 16.2000 0.5933 16.3980 0.5933 16.5000 0.5768 16.6980 0.5768 16.8000 0.6007 16.9980 0.6007 17.1000 0.6082 17.2980 0.6082 17.4000 0.5745 17.5980 0.5745 17.7000 0.5786 17.8980 0.5786 18.0000 0.5939 18.1980 0.5939 18.3000 0.6088 18.4980 0.6088 18.6000 0.5452 18.7980 0.5452 18.9000 0.5821 19.0980 0.5821 19.2000 0.7448 19.3980 0.7448 19.5000 0.6057 19.6980 0.6057 19.8000 0.5458 19.9980 0.5458 20.1000 0.6020 20.2980 0.6020 20.4000 0.5708 20.5980 0.5708 20.7000 0.5164 20.8980 0.5164 21.0000 0.5718 21.1980 0.5718 21.3000 0.5754 21.4980 0.5754 21.6000 0.4335 21.7980 0.4335 21.9000 0.4885 22.0980 0.4885 22.2000 0.4856 22.3980 0.4856 22.5000 0.4180 22.6980 0.4180 22.8000 0.5773 22.9980 0.5773 23.1000 0.3323 23.2980 0.3323 23.4000 0.7012 23.5980 0.7012 23.7000 0.6574 23.8980 0.6574 24.0000 0.3615 24.1980 0.3615 24.3000 0.4251 24.4980 0.4251 24.6000 0.5457 24.7980 0.5457 24.9000 0.5207 25.0980 0.5207 25.2000 0.5663 25.3980 0.5663 25.5000 0.4060 25.6980 0.4060 25.8000 0.4588 25.9980 0.4588 26.1000 0.7108 26.2980 0.7108 26.4000 0.4343 26.5980 0.4343 26.7000 0.3918 26.8980 0.3918 27.0000 0.3234 27.1980 0.3234 27.3000 0.4716 27.4980 0.4716 27.6000 0.4783 27.7980 0.4783 27.9000 0.5142 28.0980 0.5142 28.2000 0.5902 28.3980 0.5902 28.5000 0.4637 28.6980 0.4637 28.8000 0.5412 28.9980 0.5412 29.1000 0.5887 29.2980 0.5887 29.4000 0.6116 29.5980 0.6116 29.7000 0.5033 29.8980 0.5033 30.0000 0.5913 30.1980 0.5913 30.3000 0.6190 30.4980 0.6190 30.6000 0.5692 30.7980 0.5692 30.9000 0.5961 31.0980 0.5961 31.2000 0.6150 31.3980 0.6150 31.5000 0.5696 31.6980 0.5696 31.8000 0.6065 31.9980 0.6065 32.1000 0.6194 32.2980 0.6194 32.4000 0.5673 32.5980 0.5673 32.7000 0.6056 32.8980 0.6056 33.0000 0.5477 33.1980 0.5477 33.3000 0.5860 33.4980 0.5860 33.6000 0.5723 33.7980 0.5723 33.9000 0.6247 34.0980 0.6247 34.2000 0.5668 34.3980 0.5668 34.5000 0.5998 34.6980 0.5998 34.8000 0.5790 34.9980 0.5790 35.1000 0.6068 35.2980 0.6068 35.4000 0.5960 35.5980 0.5960 35.7000 0.6236 35.8980 0.6236 36.0000 0.5892 36.1980 0.5892 36.3000 0.6006 36.4980 0.6006 36.6000 0.5466 36.7980 0.5466 36.9000 0.5968 37.0980 0.5968 37.2000 0.5883 37.3980 0.5883 37.5000 0.6004 37.6980 0.6004 37.8000 0.5933 37.9980 0.5933 38.1000 0.5768 38.2980 0.5768 38.4000 0.6007 38.5980 0.6007 38.7000 0.6082 38.8980 0.6082 39.0000 0.5745 39.1980 0.5745 39.3000 0.5786 39.4980 0.5786 39.6000 0.5939 39.7980 0.5939 39.9000 0.6088 40.0980 0.6088 40.2000 0.5452 40.3980 0.5452 40.5000 0.5821 40.6980 0.5821 40.8000 0.7448 40.9980 0.7448 41.1000 0.6057 41.2980 0.6057 41.4000 0.5458 41.5980 0.5458 41.7000 0.6020 41.8980 0.6020 42.0000 0.5708 42.1980 0.5708 42.3000 0.5164 42.4980 0.5164 42.6000 0.5718 42.7980 0.5718 42.9000 0.5754 43.0980 0.5754 43.2000 0.4335 43.3980 0.4335 43.5000 0.4885 43.6980 0.4885 43.8000 0.4856 43.9980 0.4856 44.1000 0.4180 44.2980 0.4180 44.4000 0.5773 44.5980 0.5773 44.7000 0.3323 44.8980 0.3323 45.0000 0.7012 45.1980 0.7012 45.3000 0.6574 45.4980 0.6574 45.6000 0.3615 45.7980 0.3615 45.9000 0.4251 46.0980 0.4251 46.2000 0.5457 46.3980 0.5457 46.5000 0.5207 46.6980 0.5207 46.8000 0.5663 46.9980 0.5663 47.1000 0.4060 47.2980 0.4060 47.4000 0.4588 47.5980 0.4588 47.7000 0.7108 47.8980 0.7108 48.0000 0.4343 48.1980 0.4343 48.3000 0.3918 48.4980 0.3918 48.6000 0.3234 48.7980 0.3234 48.9000 0.4716 49.0980 0.4716 49.2000 0.4783 49.3980 0.4783 49.5000 0.5142 49.6980 0.5142 49.8000 0.5902 49.9980 0.5902 50.1000 0.4637 50.2980 0.4637 50.4000 0.5412 50.5980 0.5412 50.7000 0.5887 50.8980 0.5887 51.0000 0.6116 51.1980 0.6116 51.3000 0.5033 51.4980 0.5033 51.6000 0.5913 51.7980 0.5913 51.9000 0.6190 52.0980 0.6190 52.2000 0.5692 52.3980 0.5692 52.5000 0.5961 52.6980 0.5961 52.8000 0.6150 52.9980 0.6150 53.1000 0.5696 53.2980 0.5696 53.4000 0.6065 53.5980 0.6065 53.7000 0.6194 53.8980 0.6194 54.0000 0.5673 54.1980 0.5673 54.3000 0.6056 54.4980 0.6056 54.6000 0.5477 54.7980 0.5477 54.9000 0.5860 55.0980 0.5860 55.2000 0.5723 55.3980 0.5723 55.5000 0.6247 55.6980 0.6247 55.8000 0.5668 55.9980 0.5668 56.1000 0.5998 56.2980 0.5998 56.4000 0.5790 56.5980 0.5790 56.7000 0.6068 56.8980 0.6068 57.0000 0.5960 57.1980 0.5960 57.3000 0.6236 57.4980 0.6236 57.6000 0.5892 57.7980 0.5892 57.9000 0.6006 58.0980 0.6006 58.2000 0.5466 58.3980 0.5466 58.5000 0.5968 58.6980 0.5968 58.8000 0.5883 58.9980 0.5883 59.1000 0.6004 59.2980 0.6004 59.4000 0.5933 59.5980 0.5933 59.7000 0.5768 59.8980 0.5768 60.0000 0.6007 60.1980 0.6007 60.3000 0.6082 60.4980 0.6082 60.6000 0.5745 60.7980 0.5745 60.9000 0.5786 61.0980 0.5786 61.2000 0.5939 61.3980 0.5939 61.5000 0.6088 61.6980 0.6088 61.8000 0.5452 61.9980 0.5452 62.1000 0.5821 62.2980 0.5821 62.4000 0.7448 62.5980 0.7448 62.7000 0.6057 62.8980 0.6057 63.0000 0.5458 63.1980 0.5458 63.3000 0.6020 63.4980 0.6020 63.6000 0.5708 63.7980 0.5708 63.9000 0.5164 64.0980 0.5164 64.2000 0.5718 64.3980 0.5718 64.5000 0.5754 64.6980 0.5754 64.8000 0.4335 64.9980 0.4335 65.1000 0.4885 65.2980 0.4885 65.4000 0.4856 65.5980 0.4856 65.7000 0.4180 65.8980 0.4180 66.0000 0.5773 66.1980 0.5773 66.3000 0.3323 66.4980 0.3323 66.6000 0.7012 66.7980 0.7012 66.9000 0.6574 67.0980 0.6574 67.2000 0.3615 67.3980 0.3615 67.5000 0.4251 67.6980 0.4251 67.8000 0.5457 67.9980 0.5457 68.1000 0.5207 68.2980 0.5207 68.4000 0.5663 68.5980 0.5663 68.7000 0.4060 68.8980 0.4060 69.0000 0.4588 69.1980 0.4588 69.3000 0.7108 69.4980 0.7108 69.6000 0.4343 69.7980 0.4343 69.9000 0.3918 70.0980 0.3918 70.2000 0.3234 70.3980 0.3234 70.5000 0.4716 70.6980 0.4716 70.8000 0.4783 70.9980 0.4783 71.1000 0.5142 71.2980 0.5142 71.4000 0.5902 71.5980 0.5902 71.7000 0.4637 71.8980 0.4637 72.0000 0.5412 72.1980 0.5412 72.3000 0.5887 72.4980 0.5887 72.6000 0.6116 72.7980 0.6116 72.9000 0.5033 73.0980 0.5033 73.2000 0.5913 73.3980 0.5913 73.5000 0.6190 73.6980 0.6190 73.8000 0.5692 73.9980 0.5692 74.1000 0.5961 74.2980 0.5961 74.4000 0.6150 74.5980 0.6150 74.7000 0.5696 74.8980 0.5696 75.0000 0.6065 75.1980 0.6065 75.3000 0.6194 75.4980 0.6194 75.6000 0.5673 75.7980 0.5673 75.9000 0.6056 76.0980 0.6056 76.2000 0.5477 76.3980 0.5477 76.5000 0.5860 76.6980 0.5860 76.8000 0.5723 76.9980 0.5723 77.1000 0.6247 77.2980 0.6247 77.4000 0.5668 77.5980 0.5668 77.7000 0.5998 77.8980 0.5998 78.0000 0.5790 78.1980 0.5790 78.3000 0.6068 78.4980 0.6068 78.6000 0.5960 78.7980 0.5960 78.9000 0.6236 79.0980 0.6236 79.2000 0.5892 79.3980 0.5892 79.5000 0.6006 79.6980 0.6006 79.8000 0.5466 79.9980 0.5466 80.1000 0.5968 80.2980 0.5968 80.4000 0.5883 80.5980 0.5883 80.7000 0.6004 80.8980 0.6004 81.0000 0.5933 81.1980 0.5933 81.3000 0.5768 81.4980 0.5768 81.6000 0.6007 81.7980 0.6007 81.9000 0.6082 82.0980 0.6082 82.2000 0.5745 82.3980 0.5745 82.5000 0.5786 82.6980 0.5786 82.8000 0.5939 82.9980 0.5939 83.1000 0.6088 83.2980 0.6088 83.4000 0.5452 83.5980 0.5452 83.7000 0.5821 83.8980 0.5821 84.0000 0.7448 84.1980 0.7448 84.3000 0.6057 84.4980 0.6057 84.6000 0.5458 84.7980 0.5458 84.9000 0.6020 85.0980 0.6020 85.2000 0.5708 85.3980 0.5708 85.5000 0.5164 85.6980 0.5164 85.8000 0.5718 85.9980 0.5718 86.1000 0.5754 86.2980 0.5754 86.4000 0.4335 86.5980 0.4335 86.7000 0.4885 86.8980 0.4885 87.0000 0.4856 87.1980 0.4856 87.3000 0.4180 87.4980 0.4180 87.6000 0.5773 87.7980 0.5773 87.9000 0.3323 88.0980 0.3323 88.2000 0.7012 88.3980 0.7012 88.5000 0.6574 88.6980 0.6574 88.8000 0.3615 88.9980 0.3615 89.1000 0.4251 89.2980 0.4251 89.4000 0.5457 89.5980 0.5457 89.7000 0.5207 89.8980 0.5207 90.0000 0.5663 90.1980 0.5663 90.3000 0.4060 90.4980 0.4060 90.6000 0.4588 90.7980 0.4588 90.9000 0.7108 91.0980 0.7108 91.2000 0.4343 91.3980 0.4343 91.5000 0.3918 91.6980 0.3918 91.8000 0.3234 91.9980 0.3234 92.1000 0.4716 92.2980 0.4716 92.4000 0.4783 92.5980 0.4783 92.7000 0.5142 92.8980 0.5142 93.0000 0.5902 93.1980 0.5902 93.3000 0.4637 93.4980 0.4637 93.6000 0.5412 93.7980 0.5412 93.9000 0.5887 94.0980 0.5887 94.2000 0.6116 94.3980 0.6116 94.5000 0.5033 94.6980 0.5033 94.8000 0.5913 94.9980 0.5913 95.1000 0.6190 95.2980 0.6190 95.4000 0.5692 95.5980 0.5692 95.7000 0.5961 95.8980 0.5961 96.0000 0.6150 96.1980 0.6150 96.3000 0.5696 96.4980 0.5696 96.6000 0.6065 96.7980 0.6065 96.9000 0.6194 97.0980 0.6194 97.2000 0.5673 97.3980 0.5673 97.5000 0.6056 97.6980 0.6056 97.8000 0.5477 97.9980 0.5477 98.1000 0.5860 98.2980 0.5860 98.4000 0.5723 98.5980 0.5723 98.7000 0.6247 98.8980 0.6247 99.0000 0.5668 99.1980 0.5668 99.3000 0.5998 99.4980 0.5998 99.6000 0.5790 99.7980 0.5790 99.9000 0.6068 100.0980 0.6068 100.2000 0.5960 100.3980 0.5960 100.5000 0.6236 100.6980 0.6236 100.8000 0.5892 100.9980 0.5892 101.1000 0.6006 101.2980 0.6006 101.4000 0.5466 101.5980 0.5466 101.7000 0.5968 101.8980 0.5968 102.0000 0.5883 102.1980 0.5883 102.3000 0.6004 102.4980 0.6004 102.6000 0.5933 102.7980 0.5933 102.9000 0.5768 103.0980 0.5768 103.2000 0.6007 103.3980 0.6007 103.5000 0.6082 103.6980 0.6082 103.8000 0.5745 103.9980 0.5745 104.1000 0.5786 104.2980 0.5786 104.4000 0.5939 104.5980 0.5939 104.7000 0.6088 104.8980 0.6088 105.0000 0.5452 105.1980 0.5452 105.3000 0.5821 105.4980 0.5821 105.6000 0.7448 105.7980 0.7448 105.9000 0.6057 106.0980 0.6057 106.2000 0.5458 106.3980 0.5458 106.5000 0.6020 106.6980 0.6020 106.8000 0.5708 106.9980 0.5708 107.1000 0.5164 107.2980 0.5164 107.4000 0.5718 107.5980 0.5718 107.7000 0.5754 107.8980 0.5754 108.0000 0.4335 108.1980 0.4335 108.3000 0.4885 108.4980 0.4885 108.6000 0.4856 108.7980 0.4856 108.9000 0.4180 109.0980 0.4180 109.2000 0.5773 109.3980 0.5773 109.5000 0.3323 109.6980 0.3323 109.8000 0.7012 109.9980 0.7012 110.1000 0.6574 110.2980 0.6574 110.4000 0.3615 110.5980 0.3615 110.7000 0.4251 110.8980 0.4251 111.0000 0.5457 111.1980 0.5457 111.3000 0.5207 111.4980 0.5207 111.6000 0.5663 111.7980 0.5663 111.9000 0.4060 112.0980 0.4060 112.2000 0.4588 112.3980 0.4588 112.5000 0.7108 112.6980 0.7108 112.8000 0.4343 112.9980 0.4343 113.1000 0.3918 113.2980 0.3918 113.4000 0.3234 113.5980 0.3234 113.7000 0.4716 113.8980 0.4716 114.0000 0.4783 114.1980 0.4783 114.3000 0.5142 114.4980 0.5142 114.6000 0.5902 114.7980 0.5902 114.9000 0.4637 115.0980 0.4637 115.2000 0.5412 115.3980 0.5412 115.5000 0.5887 115.6980 0.5887 115.8000 0.6116 115.9980 0.6116 116.1000 0.5033 116.2980 0.5033 116.4000 0.5913 116.5980 0.5913 116.7000 0.6190 116.8980 0.6190 117.0000 0.5692 117.1980 0.5692 117.3000 0.5961 117.4980 0.5961 117.6000 0.6150 117.7980 0.6150 117.9000 0.5696 118.0980 0.5696 118.2000 0.6065 118.3980 0.6065 118.5000 0.6194 118.6980 0.6194 118.8000 0.5673 118.9980 0.5673 119.1000 0.6056 119.2980 0.6056 119.4000 0.5477 119.5980 0.5477 119.7000 0.5860 119.8980 0.5860 120.0000 0.5723 120.1980 0.5723 120.3000 0.6247 120.4980 0.6247 120.6000 0.5668 120.7980 0.5668 120.9000 0.5998 121.0980 0.5998 121.2000 0.5790 121.3980 0.5790 121.5000 0.6068 121.6980 0.6068 121.8000 0.5960 121.9980 0.5960 122.1000 0.6236 122.2980 0.6236 122.4000 0.5892 122.5980 0.5892 122.7000 0.6006 122.8980 0.6006 123.0000 0.5466 123.1980 0.5466 123.3000 0.5968 123.4980 0.5968 123.6000 0.5883 123.7980 0.5883 123.9000 0.6004 124.0980 0.6004 124.2000 0.5933 124.3980 0.5933 124.5000 0.5768 124.6980 0.5768 124.8000 0.6007 124.9980 0.6007 125.1000 0.6082 125.2980 0.6082 125.4000 0.5745 125.5980 0.5745 125.7000 0.5786 125.8980 0.5786 126.0000 0.5939 126.1980 0.5939 126.3000 0.6088 126.4980 0.6088 126.6000 0.5452 126.7980 0.5452 126.9000 0.5821 127.0980 0.5821 127.2000 0.7448 127.3980 0.7448 127.5000 0.6057 127.6980 0.6057 127.8000 0.5458 127.9980 0.5458 128.1000 0.6020 128.2980 0.6020 128.4000 0.5708 128.5980 0.5708 128.7000 0.5164 128.8980 0.5164 129.0000 0.5718 129.1980 0.5718 129.3000 0.5754 129.4980 0.5754 129.6000 0.4335 129.7980 0.4335 129.9000 0.4885 130.0980 0.4885 130.2000 0.4856 130.3980 0.4856 130.5000 0.4180 130.6980 0.4180 130.8000 0.5773 130.9980 0.5773 131.1000 0.3323 131.2980 0.3323 131.4000 0.7012 131.5980 0.7012 131.7000 0.6574 131.8980 0.6574 132.0000 0.3615 132.1980 0.3615 132.3000 0.4251 132.4980 0.4251 132.6000 0.5457 132.7980 0.5457 132.9000 0.5207 133.0980 0.5207 133.2000 0.5663 133.3980 0.5663 133.5000 0.4060 133.6980 0.4060 133.8000 0.4588 133.9980 0.4588 134.1000 0.7108 134.2980 0.7108 134.4000 0.4343 134.5980 0.4343 134.7000 0.3918 134.8980 0.3918 135.0000 0.3234 135.1980 0.3234 135.3000 0.4716 135.4980 0.4716 135.6000 0.4783 135.7980 0.4783 135.9000 0.5142 136.0980 0.5142 136.2000 0.5902 136.3980 0.5902 136.5000 0.4637 136.6980 0.4637 136.8000 0.5412 136.9980 0.5412 137.1000 0.5887 137.2980 0.5887 137.4000 0.6116 137.5980 0.6116 137.7000 0.5033 137.8980 0.5033 138.0000 0.5913 138.1980 0.5913 138.3000 0.6190 138.4980 0.6190 138.6000 0.5692 138.7980 0.5692 138.9000 0.5961 139.0980 0.5961 139.2000 0.6150 139.3980 0.6150 139.5000 0.5696 139.6980 0.5696 139.8000 0.6065 139.9980 0.6065 140.1000 0.6194 140.2980 0.6194 140.4000 0.5673 140.5980 0.5673 140.7000 0.6056 140.8980 0.6056 141.0000 0.5477 141.1980 0.5477 141.3000 0.5860 141.4980 0.5860 141.6000 0.5723 141.7980 0.5723 141.9000 0.6247 142.0980 0.6247 142.2000 0.5668 142.3980 0.5668 142.5000 0.5998 142.6980 0.5998 142.8000 0.5790 142.9980 0.5790 143.1000 0.6068 143.2980 0.6068 143.4000 0.5960 143.5980 0.5960 143.7000 0.6236 143.8980 0.6236 144.0000 0.5892 144.1980 0.5892 144.3000 0.6006 144.4980 0.6006 144.6000 0.5466 144.7980 0.5466 144.9000 0.5968 145.0980 0.5968 145.2000 0.5883 145.3980 0.5883 145.5000 0.6004 145.6980 0.6004 145.8000 0.5933 145.9980 0.5933 146.1000 0.5768 146.2980 0.5768 146.4000 0.6007 146.5980 0.6007 146.7000 0.6082 146.8980 0.6082 147.0000 0.5745 147.1980 0.5745 147.3000 0.5786 147.4980 0.5786 147.6000 0.5939 147.7980 0.5939 147.9000 0.6088 148.0980 0.6088 148.2000 0.5452 148.3980 0.5452 148.5000 0.5821 148.6980 0.5821 148.8000 0.7448 148.9980 0.7448 149.1000 0.6057 149.2980 0.6057 149.4000 0.5458 149.5980 0.5458 149.7000 0.6020 149.8980 0.6020 150.0000 0.5708 150.1980 0.5708 150.3000 0.5164 150.4980 0.5164 150.6000 0.5718 150.7980 0.5718 150.9000 0.5754 151.0980 0.5754 151.2000 0.4335 151.3980 0.4335 151.5000 0.4885 151.6980 0.4885 151.8000 0.4856 151.9980 0.4856 152.1000 0.4180 152.2980 0.4180 152.4000 0.5773 152.5980 0.5773 152.7000 0.3323 152.8980 0.3323 153.0000 0.7012 153.1980 0.7012 153.3000 0.6574 153.4980 0.6574 153.6000 0.3615 153.7980 0.3615 153.9000 0.4251 154.0980 0.4251 154.2000 0.5457 154.3980 0.5457 154.5000 0.5207 154.6980 0.5207 154.8000 0.5663 154.9980 0.5663 155.1000 0.4060 155.2980 0.4060 155.4000 0.4588 155.5980 0.4588 155.7000 0.7108 155.8980 0.7108 156.0000 0.4343 156.1980 0.4343 156.3000 0.3918 156.4980 0.3918 156.6000 0.3234 156.7980 0.3234 156.9000 0.4716 157.0980 0.4716 157.2000 0.4783 157.3980 0.4783 157.5000 0.5142 157.6980 0.5142 157.8000 0.5902 157.9980 0.5902 158.1000 0.4637 158.2980 0.4637 158.4000 0.5412 158.5980 0.5412 158.7000 0.5887 158.8980 0.5887 159.0000 0.6116 159.1980 0.6116 159.3000 0.5033 159.4980 0.5033 159.6000 0.5913 159.7980 0.5913 159.9000 0.6190 160.0980 0.6190 160.2000 0.5692 160.3980 0.5692 160.5000 0.5961 160.6980 0.5961 160.8000 0.6150 160.9980 0.6150 161.1000 0.5696 161.2980 0.5696 161.4000 0.6065 161.5980 0.6065 161.7000 0.6194 161.8980 0.6194 162.0000 0.5673 162.1980 0.5673 162.3000 0.6056 162.4980 0.6056 162.6000 0.5477 162.7980 0.5477 162.9000 0.5860 163.0980 0.5860 163.2000 0.5723 163.3980 0.5723 163.5000 0.6247 163.6980 0.6247 163.8000 0.5668 163.9980 0.5668 164.1000 0.5998 164.2980 0.5998 164.4000 0.5790 164.5980 0.5790 164.7000 0.6068 164.8980 0.6068 165.0000 0.5960 165.1980 0.5960 165.3000 0.6236 165.4980 0.6236 165.6000 0.5892 165.7980 0.5892 165.9000 0.6006 166.0980 0.6006 166.2000 0.5466 166.3980 0.5466 166.5000 0.5968 166.6980 0.5968 166.8000 0.5883 166.9980 0.5883 167.1000 0.6004 167.2980 0.6004 167.4000 0.5933 167.5980 0.5933 167.7000 0.5768 167.8980 0.5768 168.0000 0.6007 168.1980 0.6007 168.3000 0.6082 168.4980 0.6082 168.6000 0.5745 168.7980 0.5745 168.9000 0.5786 169.0980 0.5786 169.2000 0.5939 169.3980 0.5939 169.5000 0.6088 169.6980 0.6088 169.8000 0.5452 169.9980 0.5452 170.1000 0.5821 170.2980 0.5821 170.4000 0.7448 170.5980 0.7448 170.7000 0.6057 170.8980 0.6057 171.0000 0.5458 171.1980 0.5458 171.3000 0.6020 171.4980 0.6020 171.6000 0.5708 171.7980 0.5708 171.9000 0.5164 172.0980 0.5164 172.2000 0.5718 172.3980 0.5718 172.5000 0.5754 172.6980 0.5754 172.8000 0.4335 172.9980 0.4335 173.1000 0.4885 173.2980 0.4885 173.4000 0.4856 173.5980 0.4856 173.7000 0.4180 173.8980 0.4180 174.0000 0.5773 174.1980 0.5773 174.3000 0.3323 174.4980 0.3323 174.6000 0.7012 174.7980 0.7012 174.9000 0.6574 175.0980 0.6574 175.2000 0.3615 175.3980 0.3615 175.5000 0.4251 175.6980 0.4251 175.8000 0.5457 175.9980 0.5457 176.1000 0.5207 176.2980 0.5207 176.4000 0.5663 176.5980 0.5663 176.7000 0.4060 176.8980 0.4060 177.0000 0.4588 177.1980 0.4588 177.3000 0.7108 177.4980 0.7108 177.6000 0.4343 177.7980 0.4343 177.9000 0.3918 178.0980 0.3918 178.2000 0.3234 178.3980 0.3234 178.5000 0.4716 178.6980 0.4716 178.8000 0.4783 178.9980 0.4783 179.1000 0.5142 179.2980 0.5142 179.4000 0.5902 179.5980 0.5902 179.7000 0.4637 179.8980 0.4637 180.0000 0.5412 180.1980 0.5412 180.3000 0.5887 180.4980 0.5887 180.6000 0.6116 180.7980 0.6116 180.9000 0.5033 181.0980 0.5033 181.2000 0.5913 181.3980 0.5913 181.5000 0.6190 181.6980 0.6190 181.8000 0.5692 181.9980 0.5692 182.1000 0.5961 182.2980 0.5961 182.4000 0.6150 182.5980 0.6150 182.7000 0.5696 182.8980 0.5696 183.0000 0.6065 183.1980 0.6065 183.3000 0.6194 183.4980 0.6194 183.6000 0.5673 183.7980 0.5673 183.9000 0.6056 184.0980 0.6056 184.2000 0.5477 184.3980 0.5477 184.5000 0.5860 184.6980 0.5860 184.8000 0.5723 184.9980 0.5723 185.1000 0.6247 185.2980 0.6247 185.4000 0.5668 185.5980 0.5668 185.7000 0.5998 185.8980 0.5998 186.0000 0.5790 186.1980 0.5790 186.3000 0.6068 186.4980 0.6068 186.6000 0.5960 186.7980 0.5960 186.9000 0.6236 187.0980 0.6236 187.2000 0.5892 187.3980 0.5892 187.5000 0.6006 187.6980 0.6006 187.8000 0.5466 187.9980 0.5466 188.1000 0.5968 188.2980 0.5968 188.4000 0.5883 188.5980 0.5883 188.7000 0.6004 188.8980 0.6004 189.0000 0.5933 189.1980 0.5933 189.3000 0.5768 189.4980 0.5768 189.6000 0.6007 189.7980 0.6007 189.9000 0.6082 190.0980 0.6082 190.2000 0.5745 190.3980 0.5745 190.5000 0.5786 190.6980 0.5786 190.8000 0.5939 190.9980 0.5939 191.1000 0.6088 191.2980 0.6088 191.4000 0.5452 191.5980 0.5452 191.7000 0.5821 191.8980 0.5821 192.0000 0.7448 192.1980 0.7448 192.3000 0.6057 192.4980 0.6057 192.6000 0.5458 192.7980 0.5458 192.9000 0.6020 193.0980 0.6020 193.2000 0.5708 193.3980 0.5708 193.5000 0.5164 193.6980 0.5164 193.8000 0.5718 193.9980 0.5718 194.1000 0.5754 194.2980 0.5754 194.4000 0.4335 194.5980 0.4335 194.7000 0.4885 194.8980 0.4885 195.0000 0.4856 195.1980 0.4856 195.3000 0.4180 195.4980 0.4180 195.6000 0.5773 195.7980 0.5773 195.9000 0.3323 196.0980 0.3323 196.2000 0.7012 196.3980 0.7012 196.5000 0.6574 196.6980 0.6574 196.8000 0.3615 196.9980 0.3615 197.1000 0.4251 197.2980 0.4251 197.4000 0.5457 197.5980 0.5457 197.7000 0.5207 197.8980 0.5207 198.0000 0.5663 198.1980 0.5663 198.3000 0.4060 198.4980 0.4060 198.6000 0.4588 198.7980 0.4588 198.9000 0.7108 199.0980 0.7108 199.2000 0.4343 199.3980 0.4343 199.5000 0.3918 199.6980 0.3918 199.8000 0.3234 199.9980 0.3234 200.1000 0.4716 200.2980 0.4716 200.4000 0.4783 200.5980 0.4783 200.7000 0.5142 200.8980 0.5142 201.0000 0.5902 201.1980 0.5902 201.3000 0.4637 201.4980 0.4637 201.6000 0.5412 201.7980 0.5412 201.9000 0.5887 202.0980 0.5887 202.2000 0.6116 202.3980 0.6116 202.5000 0.5033 202.6980 0.5033 202.8000 0.5913 202.9980 0.5913 203.1000 0.6190 203.2980 0.6190 203.4000 0.5692 203.5980 0.5692 203.7000 0.5961 203.8980 0.5961 204.0000 0.6150 204.1980 0.6150 204.3000 0.5696 204.4980 0.5696 204.6000 0.6065 204.7980 0.6065 204.9000 0.6194 205.0980 0.6194 205.2000 0.5673 205.3980 0.5673 205.5000 0.6056 205.6980 0.6056 205.8000 0.5477 205.9980 0.5477 206.1000 0.5860 206.2980 0.5860 206.4000 0.5723 206.5980 0.5723 206.7000 0.6247 206.8980 0.6247 207.0000 0.5668 207.1980 0.5668 207.3000 0.5998 207.4980 0.5998 207.6000 0.5790 207.7980 0.5790 207.9000 0.6068 208.0980 0.6068 208.2000 0.5960 208.3980 0.5960 208.5000 0.6236 208.6980 0.6236 208.8000 0.5892 208.9980 0.5892 209.1000 0.6006 209.2980 0.6006 209.4000 0.5466 209.5980 0.5466 209.7000 0.5968 209.8980 0.5968 210.0000 0.5883 210.1980 0.5883 210.3000 0.6004 210.4980 0.6004 210.6000 0.5933 210.7980 0.5933 210.9000 0.5768 211.0980 0.5768 211.2000 0.6007 211.3980 0.6007 211.5000 0.6082 211.6980 0.6082 211.8000 0.5745 211.9980 0.5745 212.1000 0.5786 212.2980 0.5786 212.4000 0.5939 212.5980 0.5939 212.7000 0.6088 212.8980 0.6088 213.0000 0.5452 213.1980 0.5452 213.3000 0.5821 213.4980 0.5821 213.6000 0.7448 213.7980 0.7448 213.9000 0.6057 214.0980 0.6057 214.2000 0.5458 214.3980 0.5458 214.5000 0.6020 214.6980 0.6020 214.8000 0.5708 214.9980 0.5708 215.1000 0.5164 215.2980 0.5164 215.4000 0.5718 215.5980 0.5718 215.7000 0.5754 215.8980 0.5754 216.0000 0.4335 216.1980 0.4335 216.3000 0.4885 216.4980 0.4885 216.6000 0.4856 216.7980 0.4856 216.9000 0.4180 217.0980 0.4180 217.2000 0.5773 217.3980 0.5773 217.5000 0.3323 217.6980 0.3323 217.8000 0.7012 217.9980 0.7012 218.1000 0.6574 218.2980 0.6574 218.4000 0.3615 218.5980 0.3615 218.7000 0.4251 218.8980 0.4251 219.0000 0.5457 219.1980 0.5457 219.3000 0.5207 219.4980 0.5207 219.6000 0.5663 219.7980 0.5663 219.9000 0.4060 220.0980 0.4060 220.2000 0.4588 220.3980 0.4588 220.5000 0.7108 220.6980 0.7108 220.8000 0.4343 220.9980 0.4343 221.1000 0.3918 221.2980 0.3918 221.4000 0.3234 221.5980 0.3234 221.7000 0.4716 221.8980 0.4716 222.0000 0.4783 222.1980 0.4783 222.3000 0.5142 222.4980 0.5142 222.6000 0.5902 222.7980 0.5902 222.9000 0.4637 223.0980 0.4637 223.2000 0.5412 223.3980 0.5412 223.5000 0.5887 223.6980 0.5887 223.8000 0.6116 223.9980 0.6116 224.1000 0.5033 224.2980 0.5033 224.4000 0.5913 224.5980 0.5913 224.7000 0.6190 224.8980 0.6190 225.0000 0.5692 225.1980 0.5692 225.3000 0.5961 225.4980 0.5961 225.6000 0.6150 225.7980 0.6150 225.9000 0.5696 226.0980 0.5696 226.2000 0.6065 226.3980 0.6065 226.5000 0.6194 226.6980 0.6194 226.8000 0.5673 226.9980 0.5673 227.1000 0.6056 227.2980 0.6056 227.4000 0.5477 227.5980 0.5477 227.7000 0.5860 227.8980 0.5860 228.0000 0.5723 228.1980 0.5723 228.3000 0.6247 228.4980 0.6247 228.6000 0.5668 228.7980 0.5668 228.9000 0.5998 229.0980 0.5998 229.2000 0.5790 229.3980 0.5790 229.5000 0.6068 229.6980 0.6068 229.8000 0.5960 229.9980 0.5960 230.1000 0.6236 230.2980 0.6236 230.4000 0.5892 230.5980 0.5892 230.7000 0.6006 230.8980 0.6006 231.0000 0.5466 231.1980 0.5466 231.3000 0.5968 231.4980 0.5968 231.6000 0.5883 231.7980 0.5883 231.9000 0.6004 232.0980 0.6004 232.2000 0.5933 232.3980 0.5933 232.5000 0.5768 232.6980 0.5768 232.8000 0.6007 232.9980 0.6007 233.1000 0.6082 233.2980 0.6082 233.4000 0.5745 233.5980 0.5745 233.7000 0.5786 233.8980 0.5786 234.0000 0.5939 234.1980 0.5939 234.3000 0.6088 234.4980 0.6088 234.6000 0.5452 234.7980 0.5452 234.9000 0.5821 235.0980 0.5821 235.2000 0.7448 235.3980 0.7448 235.5000 0.6057 235.6980 0.6057 235.8000 0.5458 235.9980 0.5458 236.1000 0.6020 236.2980 0.6020 236.4000 0.5708 236.5980 0.5708 236.7000 0.5164 236.8980 0.5164 237.0000 0.5718 237.1980 0.5718 237.3000 0.5754 237.4980 0.5754 237.6000 0.4335 237.7980 0.4335 237.9000 0.4885 238.0980 0.4885 238.2000 0.4856 238.3980 0.4856 238.5000 0.4180 238.6980 0.4180 238.8000 0.5773 238.9980 0.5773 239.1000 0.3323 239.2980 0.3323 239.4000 0.7012 239.5980 0.7012 239.7000 0.6574 239.8980 0.6574 240.0000 0.3615 240.1980 0.3615 240.3000 0.4251 240.4980 0.4251 240.6000 0.5457 240.7980 0.5457 240.9000 0.5207 241.0980 0.5207 241.2000 0.5663 241.3980 0.5663 241.5000 0.4060 241.6980 0.4060 241.8000 0.4588 241.9980 0.4588 242.1000 0.7108 242.2980 0.7108 242.4000 0.4343 242.5980 0.4343 242.7000 0.3918 242.8980 0.3918 243.0000 0.3234 243.1980 0.3234 243.3000 0.4716 243.4980 0.4716 243.6000 0.4783 243.7980 0.4783 243.9000 0.5142 244.0980 0.5142 244.2000 0.5902 244.3980 0.5902 244.5000 0.4637 244.6980 0.4637 244.8000 0.5412 244.9980 0.5412 245.1000 0.5887 245.2980 0.5887 245.4000 0.6116 245.5980 0.6116 245.7000 0.5033 245.8980 0.5033 246.0000 0.5913 246.1980 0.5913 246.3000 0.6190 246.4980 0.6190 246.6000 0.5692 246.7980 0.5692 246.9000 0.5961 247.0980 0.5961 247.2000 0.6150 247.3980 0.6150 247.5000 0.5696 247.6980 0.5696 247.8000 0.6065 247.9980 0.6065 248.1000 0.6194 248.2980 0.6194 248.4000 0.5673 248.5980 0.5673 248.7000 0.6056 248.8980 0.6056 249.0000 0.5477 249.1980 0.5477 249.3000 0.5860 249.4980 0.5860 249.6000 0.5723 249.7980 0.5723 249.9000 0.6247 250.0980 0.6247 250.2000 0.5668 250.3980 0.5668 250.5000 0.5998 250.6980 0.5998 250.8000 0.5790 250.9980 0.5790 251.1000 0.6068 251.2980 0.6068 251.4000 0.5960 251.5980 0.5960 251.7000 0.6236 251.8980 0.6236 252.0000 0.5892 252.1980 0.5892 252.3000 0.6006 252.4980 0.6006 252.6000 0.5466 252.7980 0.5466 252.9000 0.5968 253.0980 0.5968 253.2000 0.5883 253.3980 0.5883 253.5000 0.6004 253.6980 0.6004 253.8000 0.5933 253.9980 0.5933 254.1000 0.5768 254.2980 0.5768 254.4000 0.6007 254.5980 0.6007 254.7000 0.6082 254.8980 0.6082 255.0000 0.5745 255.1980 0.5745 255.3000 0.5786 255.4980 0.5786 255.6000 0.5939 255.7980 0.5939 255.9000 0.6088 256.0980 0.6088 256.2000 0.5452 256.3980 0.5452 256.5000 0.5821 256.6980 0.5821 256.8000 0.7448 256.9980 0.7448 257.1000 0.6057 257.2980 0.6057 257.4000 0.5458 257.5980 0.5458 257.7000 0.6020 257.8980 0.6020 258.0000 0.5708 258.1980 0.5708 258.3000 0.5164 258.4980 0.5164 258.6000 0.5718 258.7980 0.5718 258.9000 0.5754 259.0980 0.5754 259.2000 0.4335 259.3980 0.4335 259.5000 0.4885 259.6980 0.4885 259.8000 0.4856 259.9980 0.4856 260.1000 0.4180 260.2980 0.4180 260.4000 0.5773 260.5980 0.5773 260.7000 0.3323 260.8980 0.3323 261.0000 0.7012 261.1980 0.7012 261.3000 0.6574 261.4980 0.6574 261.6000 0.3615 261.7980 0.3615 261.9000 0.4251 262.0980 0.4251 262.2000 0.5457 262.3980 0.5457 262.5000 0.5207 262.6980 0.5207 262.8000 0.5663 262.9980 0.5663 263.1000 0.4060 263.2980 0.4060 263.4000 0.4588 263.5980 0.4588 263.7000 0.7108 263.8980 0.7108 264.0000 0.4343 264.1980 0.4343 264.3000 0.3918 264.4980 0.3918 264.6000 0.3234 264.7980 0.3234 264.9000 0.4716 265.0980 0.4716 265.2000 0.4783 265.3980 0.4783 265.5000 0.5142 265.6980 0.5142 265.8000 0.5902 265.9980 0.5902 266.1000 0.4637 266.2980 0.4637 266.4000 0.5412 266.5980 0.5412 266.7000 0.5887 266.8980 0.5887 267.0000 0.6116 267.1980 0.6116 267.3000 0.5033 267.4980 0.5033 267.6000 0.5913 267.7980 0.5913 267.9000 0.6190 268.0980 0.6190 268.2000 0.5692 268.3980 0.5692 268.5000 0.5961 268.6980 0.5961 268.8000 0.6150 268.9980 0.6150 269.1000 0.5696 269.2980 0.5696 269.4000 0.6065 269.5980 0.6065 269.7000 0.6194 269.8980 0.6194 270.0000 0.5673 270.1980 0.5673 270.3000 0.6056 270.4980 0.6056 270.6000 0.5477 270.7980 0.5477 270.9000 0.5860 271.0980 0.5860 271.2000 0.5723 271.3980 0.5723 271.5000 0.6247 271.6980 0.6247 271.8000 0.5668 271.9980 0.5668 272.1000 0.5998 272.2980 0.5998 272.4000 0.5790 272.5980 0.5790 272.7000 0.6068 272.8980 0.6068 273.0000 0.5960 273.1980 0.5960 273.3000 0.6236 273.4980 0.6236 273.6000 0.5892 273.7980 0.5892 273.9000 0.6006 274.0980 0.6006 274.2000 0.5466 274.3980 0.5466 274.5000 0.5968 274.6980 0.5968 274.8000 0.5883 274.9980 0.5883 275.1000 0.6004 275.2980 0.6004 275.4000 0.5933 275.5980 0.5933 275.7000 0.5768 275.8980 0.5768 276.0000 0.6007 276.1980 0.6007 276.3000 0.6082 276.4980 0.6082 276.6000 0.5745 276.7980 0.5745 276.9000 0.5786 277.0980 0.5786 277.2000 0.5939 277.3980 0.5939 277.5000 0.6088 277.6980 0.6088 277.8000 0.5452 277.9980 0.5452 278.1000 0.5821 278.2980 0.5821 278.4000 0.7448 278.5980 0.7448 278.7000 0.6057 278.8980 0.6057 279.0000 0.5458 279.1980 0.5458 279.3000 0.6020 279.4980 0.6020 279.6000 0.5708 279.7980 0.5708 279.9000 0.5164 280.0980 0.5164 280.2000 0.5718 280.3980 0.5718 280.5000 0.5754 280.6980 0.5754 280.8000 0.4335 280.9980 0.4335 281.1000 0.4885 281.2980 0.4885 281.4000 0.4856 281.5980 0.4856 281.7000 0.4180 281.8980 0.4180 282.0000 0.5773 282.1980 0.5773 282.3000 0.3323 282.4980 0.3323 282.6000 0.7012 282.7980 0.7012 282.9000 0.6574 283.0980 0.6574 283.2000 0.3615 283.3980 0.3615 283.5000 0.4251 283.6980 0.4251 283.8000 0.5457 283.9980 0.5457 284.1000 0.5207 284.2980 0.5207 284.4000 0.5663 284.5980 0.5663 284.7000 0.4060 284.8980 0.4060 285.0000 0.4588 285.1980 0.4588 285.3000 0.7108 285.4980 0.7108 285.6000 0.4343 285.7980 0.4343 285.9000 0.3918 286.0980 0.3918 286.2000 0.3234 286.3980 0.3234 286.5000 0.4716 286.6980 0.4716 286.8000 0.4783 286.9980 0.4783 287.1000 0.5142 287.2980 0.5142 287.4000 0.5902 287.5980 0.5902 287.7000 0.4637 287.8980 0.4637 288.0000 0.5412 288.1980 0.5412 288.3000 0.5887 288.4980 0.5887 288.6000 0.6116 288.7980 0.6116 288.9000 0.5033 289.0980 0.5033 289.2000 0.5913 289.3980 0.5913 289.5000 0.6190 289.6980 0.6190 289.8000 0.5692 289.9980 0.5692 290.1000 0.5961 290.2980 0.5961 290.4000 0.6150 290.5980 0.6150 290.7000 0.5696 290.8980 0.5696 291.0000 0.6065 291.1980 0.6065 291.3000 0.6194 291.4980 0.6194 291.6000 0.5673 291.7980 0.5673 291.9000 0.6056 292.0980 0.6056 292.2000 0.5477 292.3980 0.5477 292.5000 0.5860 292.6980 0.5860 292.8000 0.5723 292.9980 0.5723 293.1000 0.6247 293.2980 0.6247 293.4000 0.5668 293.5980 0.5668 293.7000 0.5998 293.8980 0.5998 294.0000 0.5790 294.1980 0.5790 294.3000 0.6068 294.4980 0.6068 294.6000 0.5960 294.7980 0.5960 294.9000 0.6236 295.0980 0.6236 295.2000 0.5892 295.3980 0.5892 295.5000 0.6006 295.6980 0.6006 295.8000 0.5466 295.9980 0.5466 296.1000 0.5968 296.2980 0.5968 296.4000 0.5883 296.5980 0.5883 296.7000 0.6004 296.8980 0.6004 297.0000 0.5933 297.1980 0.5933 297.3000 0.5768 297.4980 0.5768 297.6000 0.6007 297.7980 0.6007 297.9000 0.6082 298.0980 0.6082 298.2000 0.5745 298.3980 0.5745 298.5000 0.5786 298.6980 0.5786 298.8000 0.5939 298.9980 0.5939 299.1000 0.6088 299.2980 0.6088 299.4000 0.5452 299.5980 0.5452 299.7000 0.5821 299.8980 0.5821 300.0000 0.7448 300.1980 0.7448 300.3000 0.6057 300.4980 0.6057 300.6000 0.5458 300.7980 0.5458 300.9000 0.6020 301.0980 0.6020 301.2000 0.5708 301.3980 0.5708 301.5000 0.5164 301.6980 0.5164 301.8000 0.5718 301.9980 0.5718 302.1000 0.5754 302.2980 0.5754 302.4000 0.4335 302.5980 0.4335 302.7000 0.4885 302.8980 0.4885 303.0000 0.4856 303.1980 0.4856 303.3000 0.4180 303.4980 0.4180 303.6000 0.5773 303.7980 0.5773 303.9000 0.3323 304.0980 0.3323 304.2000 0.7012 304.3980 0.7012 304.5000 0.6574 304.6980 0.6574 304.8000 0.3615 304.9980 0.3615 305.1000 0.4251 305.2980 0.4251 305.4000 0.5457 305.5980 0.5457 305.7000 0.5207 305.8980 0.5207 306.0000 0.5663 306.1980 0.5663 306.3000 0.4060 306.4980 0.4060 306.6000 0.4588 306.7980 0.4588 306.9000 0.7108 307.0980 0.7108 307.2000 0.4343 307.3980 0.4343 307.5000 0.3918 307.6980 0.3918 307.8000 0.3234 307.9980 0.3234 308.1000 0.4716 308.2980 0.4716 308.4000 0.4783 308.5980 0.4783 308.7000 0.5142 308.8980 0.5142 309.0000 0.5902 309.1980 0.5902 309.3000 0.4637 309.4980 0.4637 309.6000 0.5412 309.7980 0.5412 309.9000 0.5887 310.0980 0.5887 310.2000 0.6116 310.3980 0.6116 310.5000 0.5033 310.6980 0.5033 310.8000 0.5913 310.9980 0.5913 311.1000 0.6190 311.2980 0.6190 311.4000 0.5692 311.5980 0.5692 311.7000 0.5961 311.8980 0.5961 312.0000 0.6150 312.1980 0.6150 312.3000 0.5696 312.4980 0.5696 312.6000 0.6065 312.7980 0.6065 312.9000 0.6194 313.0980 0.6194 313.2000 0.5673 313.3980 0.5673 313.5000 0.6056 313.6980 0.6056 313.8000 0.5477 313.9980 0.5477 314.1000 0.5860 314.2980 0.5860 314.4000 0.5723 314.5980 0.5723 314.7000 0.6247 314.8980 0.6247 315.0000 0.5668 315.1980 0.5668 315.3000 0.5998 315.4980 0.5998 315.6000 0.5790 315.7980 0.5790 315.9000 0.6068 316.0980 0.6068 316.2000 0.5960 316.3980 0.5960 316.5000 0.6236 316.6980 0.6236 316.8000 0.5892 316.9980 0.5892 317.1000 0.6006 317.2980 0.6006 317.4000 0.5466 317.5980 0.5466 317.7000 0.5968 317.8980 0.5968 318.0000 0.5883 318.1980 0.5883 318.3000 0.6004 318.4980 0.6004 318.6000 0.5933 318.7980 0.5933 318.9000 0.5768 319.0980 0.5768 319.2000 0.6007 319.3980 0.6007 319.5000 0.6082 319.6980 0.6082 319.8000 0.5745 319.9980 0.5745 320.1000 0.5786 320.2980 0.5786 320.4000 0.5939 320.5980 0.5939 320.7000 0.6088 320.8980 0.6088 321.0000 0.5452 321.1980 0.5452 321.3000 0.5821 321.4980 0.5821 321.6000 0.7448 321.7980 0.7448 321.9000 0.6057 322.0980 0.6057 322.2000 0.5458 322.3980 0.5458 322.5000 0.6020 322.6980 0.6020 322.8000 0.5708 322.9980 0.5708 323.1000 0.5164 323.2980 0.5164 323.4000 0.5718 323.5980 0.5718 323.7000 0.5754 323.8980 0.5754 324.0000 0.4335 324.1980 0.4335 324.3000 0.4885 324.4980 0.4885 324.6000 0.4856 324.7980 0.4856 324.9000 0.4180 325.0980 0.4180 325.2000 0.5773 325.3980 0.5773 325.5000 0.3323 325.6980 0.3323 325.8000 0.7012 325.9980 0.7012 326.1000 0.6574 326.2980 0.6574 326.4000 0.3615 326.5980 0.3615 326.7000 0.4251 326.8980 0.4251 327.0000 0.5457 327.1980 0.5457 327.3000 0.5207 327.4980 0.5207 327.6000 0.5663 327.7980 0.5663 327.9000 0.4060 328.0980 0.4060 328.2000 0.4588 328.3980 0.4588 328.5000 0.7108 328.6980 0.7108 328.8000 0.4343 328.9980 0.4343 329.1000 0.3918 329.2980 0.3918 329.4000 0.3234 329.5980 0.3234 329.7000 0.4716 329.8980 0.4716 330.0000 0.4783 330.1980 0.4783 330.3000 0.5142 330.4980 0.5142 330.6000 0.5902 330.7980 0.5902 330.9000 0.4637 331.0980 0.4637 331.2000 0.5412 331.3980 0.5412 331.5000 0.5887 331.6980 0.5887 331.8000 0.6116 331.9980 0.6116 332.1000 0.5033 332.2980 0.5033 332.4000 0.5913 332.5980 0.5913 332.7000 0.6190 332.8980 0.6190 333.0000 0.5692 333.1980 0.5692 333.3000 0.5961 333.4980 0.5961 333.6000 0.6150 333.7980 0.6150 333.9000 0.5696 334.0980 0.5696 334.2000 0.6065 334.3980 0.6065 334.5000 0.6194 334.6980 0.6194 334.8000 0.5673 334.9980 0.5673 335.1000 0.6056 335.2980 0.6056 335.4000 0.5477 335.5980 0.5477 335.7000 0.5860 335.8980 0.5860 336.0000 0.5723 336.1980 0.5723 336.3000 0.6247 336.4980 0.6247 336.6000 0.5668 336.7980 0.5668 336.9000 0.5998 337.0980 0.5998 337.2000 0.5790 337.3980 0.5790 337.5000 0.6068 337.6980 0.6068 337.8000 0.5960 337.9980 0.5960 338.1000 0.6236 338.2980 0.6236 338.4000 0.5892 338.5980 0.5892 338.7000 0.6006 338.8980 0.6006 339.0000 0.5466 339.1980 0.5466 339.3000 0.5968 339.4980 0.5968 339.6000 0.5883 339.7980 0.5883 339.9000 0.6004 340.0980 0.6004 340.2000 0.5933 340.3980 0.5933 340.5000 0.5768 340.6980 0.5768 340.8000 0.6007 340.9980 0.6007 341.1000 0.6082 341.2980 0.6082 341.4000 0.5745 341.5980 0.5745 341.7000 0.5786 341.8980 0.5786 342.0000 0.5939 342.1980 0.5939 342.3000 0.6088 342.4980 0.6088 342.6000 0.5452 342.7980 0.5452 342.9000 0.5821 343.0980 0.5821 343.2000 0.7448 343.3980 0.7448 343.5000 0.6057 343.6980 0.6057 343.8000 0.5458 343.9980 0.5458 344.1000 0.6020 344.2980 0.6020 344.4000 0.5708 344.5980 0.5708 344.7000 0.5164 344.8980 0.5164 345.0000 0.5718 345.1980 0.5718 345.3000 0.5754 345.4980 0.5754 345.6000 0.4335 345.7980 0.4335 345.9000 0.4885 346.0980 0.4885 346.2000 0.4856 346.3980 0.4856 346.5000 0.4180 346.6980 0.4180 346.8000 0.5773 346.9980 0.5773 347.1000 0.3323 347.2980 0.3323 347.4000 0.7012 347.5980 0.7012 347.7000 0.6574 347.8980 0.6574 348.0000 0.3615 348.1980 0.3615 348.3000 0.4251 348.4980 0.4251 348.6000 0.5457 348.7980 0.5457 348.9000 0.5207 349.0980 0.5207 349.2000 0.5663 349.3980 0.5663 349.5000 0.4060 349.6980 0.4060 349.8000 0.4588 349.9980 0.4588 350.1000 0.7108 350.2980 0.7108 350.4000 0.4343 350.5980 0.4343 350.7000 0.3918 350.8980 0.3918 351.0000 0.3234 351.1980 0.3234 351.3000 0.4716 351.4980 0.4716 351.6000 0.4783 351.7980 0.4783 351.9000 0.5142 352.0980 0.5142 352.2000 0.5902 352.3980 0.5902 352.5000 0.4637 352.6980 0.4637 352.8000 0.5412 352.9980 0.5412 353.1000 0.5887 353.2980 0.5887 353.4000 0.6116 353.5980 0.6116 353.7000 0.5033 353.8980 0.5033 354.0000 0.5913 354.1980 0.5913 354.3000 0.6190 354.4980 0.6190 354.6000 0.5692 354.7980 0.5692 354.9000 0.5961 355.0980 0.5961 355.2000 0.6150 355.3980 0.6150 355.5000 0.5696 355.6980 0.5696 355.8000 0.6065 355.9980 0.6065 356.1000 0.6194 356.2980 0.6194 356.4000 0.5673 356.5980 0.5673 356.7000 0.6056 356.8980 0.6056 357.0000 0.5477 357.1980 0.5477 357.3000 0.5860 357.4980 0.5860 357.6000 0.5723 357.7980 0.5723 357.9000 0.6247 358.0980 0.6247 358.2000 0.5668 358.3980 0.5668 358.5000 0.5998 358.6980 0.5998 358.8000 0.5790 358.9980 0.5790 359.1000 0.6068 359.2980 0.6068 359.4000 0.5960 359.5980 0.5960 359.7000 0.6236 359.8980 0.6236 360.0000 0.5892 360.1980 0.5892 360.3000 0.6006 360.4980 0.6006 360.6000 0.5466 360.7980 0.5466 360.9000 0.5968 361.0980 0.5968 361.2000 0.5883 361.3980 0.5883 361.5000 0.6004 361.6980 0.6004 361.8000 0.5933 361.9980 0.5933 362.1000 0.5768 362.2980 0.5768 362.4000 0.6007 362.5980 0.6007 362.7000 0.6082 362.8980 0.6082 363.0000 0.5745 363.1980 0.5745 363.3000 0.5786 363.4980 0.5786 363.6000 0.5939 363.7980 0.5939 363.9000 0.6088 364.0980 0.6088 364.2000 0.5452 364.3980 0.5452 364.5000 0.5821 364.6980 0.5821 364.8000 0.7448 364.9980 0.7448 365.1000 0.6057 365.2980 0.6057 365.4000 0.5458 365.5980 0.5458 365.7000 0.6020 365.8980 0.6020 366.0000 0.5708 366.1980 0.5708 366.3000 0.5164 366.4980 0.5164 366.6000 0.5718 366.7980 0.5718 366.9000 0.5754 367.0980 0.5754 367.2000 0.4335 367.3980 0.4335 367.5000 0.4885 367.6980 0.4885 367.8000 0.4856 367.9980 0.4856 368.1000 0.4180 368.2980 0.4180 368.4000 0.5773 368.5980 0.5773 368.7000 0.3323 368.8980 0.3323 369.0000 0.7012 369.1980 0.7012 369.3000 0.6574 369.4980 0.6574 369.6000 0.3615 369.7980 0.3615 369.9000 0.4251 370.0980 0.4251 370.2000 0.5457 370.3980 0.5457 370.5000 0.5207 370.6980 0.5207 370.8000 0.5663 370.9980 0.5663 371.1000 0.4060 371.2980 0.4060 371.4000 0.4588 371.5980 0.4588 371.7000 0.7108 371.8980 0.7108 372.0000 0.4343 372.1980 0.4343 372.3000 0.3918 372.4980 0.3918 372.6000 0.3234 372.7980 0.3234 372.9000 0.4716 373.0980 0.4716 373.2000 0.4783 373.3980 0.4783 373.5000 0.5142 373.6980 0.5142 373.8000 0.5902 373.9980 0.5902 374.1000 0.4637 374.2980 0.4637 374.4000 0.5412 374.5980 0.5412 374.7000 0.5887 374.8980 0.5887 375.0000 0.6116 375.1980 0.6116 375.3000 0.5033 375.4980 0.5033 375.6000 0.5913 375.7980 0.5913 375.9000 0.6190 376.0980 0.6190 376.2000 0.5692 376.3980 0.5692 376.5000 0.5961 376.6980 0.5961 376.8000 0.6150 376.9980 0.6150 377.1000 0.5696 377.2980 0.5696 377.4000 0.6065 377.5980 0.6065 377.7000 0.6194 377.8980 0.6194 378.0000 0.5673 378.1980 0.5673 378.3000 0.6056 378.4980 0.6056 378.6000 0.5477 378.7980 0.5477 378.9000 0.5860 379.0980 0.5860 379.2000 0.5723 379.3980 0.5723 379.5000 0.6247 379.6980 0.6247 379.8000 0.5668 379.9980 0.5668 380.1000 0.5998 380.2980 0.5998 380.4000 0.5790 380.5980 0.5790 380.7000 0.6068 380.8980 0.6068 381.0000 0.5960 381.1980 0.5960 381.3000 0.6236 381.4980 0.6236 381.6000 0.5892 381.7980 0.5892 381.9000 0.6006 382.0980 0.6006 382.2000 0.5466 382.3980 0.5466 382.5000 0.5968 382.6980 0.5968 382.8000 0.5883 382.9980 0.5883 383.1000 0.6004 383.2980 0.6004 383.4000 0.5933 383.5980 0.5933 383.7000 0.5768 383.8980 0.5768 384.0000 0.6007 384.1980 0.6007 384.3000 0.6082 384.4980 0.6082 384.6000 0.5745 384.7980 0.5745 384.9000 0.5786 385.0980 0.5786 385.2000 0.5939 385.3980 0.5939 385.5000 0.6088 385.6980 0.6088 385.8000 0.5452 385.9980 0.5452 386.1000 0.5821 386.2980 0.5821 386.4000 0.7448 386.5980 0.7448 386.7000 0.6057 386.8980 0.6057 387.0000 0.5458 387.1980 0.5458 387.3000 0.6020 387.4980 0.6020 387.6000 0.5708 387.7980 0.5708 387.9000 0.5164 388.0980 0.5164 388.2000 0.5718 388.3980 0.5718 388.5000 0.5754 388.6980 0.5754 388.8000 0.4335 388.9980 0.4335 389.1000 0.4885 389.2980 0.4885 389.4000 0.4856 389.5980 0.4856 389.7000 0.4180 389.8980 0.4180 390.0000 0.5773 390.1980 0.5773 390.3000 0.3323 390.4980 0.3323 390.6000 0.7012 390.7980 0.7012 390.9000 0.6574 391.0980 0.6574 391.2000 0.3615 391.3980 0.3615 391.5000 0.4251 391.6980 0.4251 391.8000 0.5457 391.9980 0.5457 392.1000 0.5207 392.2980 0.5207 392.4000 0.5663 392.5980 0.5663 392.7000 0.4060 392.8980 0.4060 393.0000 0.4588 393.1980 0.4588 393.3000 0.7108 393.4980 0.7108 393.6000 0.4343 393.7980 0.4343 393.9000 0.3918 394.0980 0.3918 394.2000 0.3234 394.3980 0.3234 394.5000 0.4716 394.6980 0.4716 394.8000 0.4783 394.9980 0.4783 395.1000 0.5142 395.2980 0.5142 395.4000 0.5902 395.5980 0.5902 395.7000 0.4637 395.8980 0.4637 396.0000 0.5412 396.1980 0.5412 396.3000 0.5887 396.4980 0.5887 396.6000 0.6116 396.7980 0.6116 396.9000 0.5033 397.0980 0.5033 397.2000 0.5913 397.3980 0.5913 397.5000 0.6190 397.6980 0.6190 397.8000 0.5692 397.9980 0.5692 398.1000 0.5961 398.2980 0.5961 398.4000 0.6150 398.5980 0.6150 398.7000 0.5696 398.8980 0.5696 399.0000 0.6065 399.1980 0.6065 399.3000 0.6194 399.4980 0.6194 399.6000 0.5673 399.7980 0.5673 399.9000 0.6056 400.0980 0.6056 400.2000 0.5477 400.3980 0.5477 400.5000 0.5860 400.6980 0.5860 400.8000 0.5723 400.9980 0.5723 401.1000 0.6247 401.2980 0.6247 401.4000 0.5668 401.5980 0.5668 401.7000 0.5998 401.8980 0.5998 402.0000 0.5790 402.1980 0.5790 402.3000 0.6068 402.4980 0.6068 402.6000 0.5960 402.7980 0.5960 402.9000 0.6236 403.0980 0.6236 403.2000 0.5892 403.3980 0.5892 403.5000 0.6006 403.6980 0.6006 403.8000 0.5466 403.9980 0.5466 404.1000 0.5968 404.2980 0.5968 404.4000 0.5883 404.5980 0.5883 404.7000 0.6004 404.8980 0.6004 405.0000 0.5933 405.1980 0.5933 405.3000 0.5768 405.4980 0.5768 405.6000 0.6007 405.7980 0.6007 405.9000 0.6082 406.0980 0.6082 406.2000 0.5745 406.3980 0.5745 406.5000 0.5786 406.6980 0.5786 406.8000 0.5939 406.9980 0.5939 407.1000 0.6088 407.2980 0.6088 407.4000 0.5452 407.5980 0.5452 407.7000 0.5821 407.8980 0.5821 408.0000 0.7448 408.1980 0.7448 408.3000 0.6057 408.4980 0.6057 408.6000 0.5458 408.7980 0.5458 408.9000 0.6020 409.0980 0.6020 409.2000 0.5708 409.3980 0.5708 409.5000 0.5164 409.6980 0.5164 409.8000 0.5718 409.9980 0.5718 410.1000 0.5754 410.2980 0.5754 410.4000 0.4335 410.5980 0.4335 410.7000 0.4885 410.8980 0.4885 411.0000 0.4856 411.1980 0.4856 411.3000 0.4180 411.4980 0.4180 411.6000 0.5773 411.7980 0.5773 411.9000 0.3323 412.0980 0.3323 412.2000 0.7012 412.3980 0.7012 412.5000 0.6574 412.6980 0.6574 412.8000 0.3615 412.9980 0.3615 413.1000 0.4251 413.2980 0.4251 413.4000 0.5457 413.5980 0.5457 413.7000 0.5207 413.8980 0.5207 414.0000 0.5663 414.1980 0.5663 414.3000 0.4060 414.4980 0.4060 414.6000 0.4588 414.7980 0.4588 414.9000 0.7108 415.0980 0.7108 415.2000 0.4343 415.3980 0.4343 415.5000 0.3918 415.6980 0.3918 415.8000 0.3234 415.9980 0.3234 416.1000 0.4716 416.2980 0.4716 416.4000 0.4783 416.5980 0.4783 416.7000 0.5142 416.8980 0.5142 417.0000 0.5902 417.1980 0.5902 417.3000 0.4637 417.4980 0.4637 417.6000 0.5412 417.7980 0.5412 417.9000 0.5887 418.0980 0.5887 418.2000 0.6116 418.3980 0.6116 418.5000 0.5033 418.6980 0.5033 418.8000 0.5913 418.9980 0.5913 419.1000 0.6190 419.2980 0.6190 419.4000 0.5692 419.5980 0.5692 419.7000 0.5961 419.8980 0.5961 420.0000 0.6150 420.1980 0.6150 420.3000 0.5696 420.4980 0.5696 420.6000 0.6065 420.7980 0.6065 420.9000 0.6194 421.0980 0.6194 421.2000 0.5673 421.3980 0.5673 421.5000 0.6056 421.6980 0.6056 421.8000 0.5477 421.9980 0.5477 422.1000 0.5860 422.2980 0.5860 422.4000 0.5723 422.5980 0.5723 422.7000 0.6247 422.8980 0.6247 423.0000 0.5668 423.1980 0.5668 423.3000 0.5998 423.4980 0.5998 423.6000 0.5790 423.7980 0.5790 423.9000 0.6068 424.0980 0.6068 424.2000 0.5960 424.3980 0.5960 424.5000 0.6236 424.6980 0.6236 424.8000 0.5892 424.9980 0.5892 425.1000 0.6006 425.2980 0.6006 425.4000 0.5466 425.5980 0.5466 425.7000 0.5968 425.8980 0.5968 426.0000 0.5883 426.1980 0.5883 426.3000 0.6004 426.4980 0.6004 426.6000 0.5933 426.7980 0.5933 426.9000 0.5768 427.0980 0.5768 427.2000 0.6007 427.3980 0.6007 427.5000 0.6082 427.6980 0.6082 427.8000 0.5745 427.9980 0.5745 428.1000 0.5786 428.2980 0.5786 428.4000 0.5939 428.5980 0.5939 428.7000 0.6088 428.8980 0.6088 429.0000 0.5452 429.1980 0.5452 429.3000 0.5821 429.4980 0.5821 429.6000 0.7448 429.7980 0.7448 429.9000 0.6057 430.0980 0.6057 430.2000 0.5458 430.3980 0.5458 430.5000 0.6020 430.6980 0.6020 430.8000 0.5708 430.9980 0.5708 431.1000 0.5164 431.2980 0.5164 431.4000 0.5718 431.5980 0.5718 431.7000 0.5754 431.8980 0.5754 432.0000 0.4335 432.1980 0.4335 432.3000 0.4885 432.4980 0.4885 432.6000 0.4856 432.7980 0.4856 432.9000 0.4180 433.0980 0.4180 433.2000 0.5773 433.3980 0.5773 433.5000 0.3323 433.6980 0.3323 433.8000 0.7012 433.9980 0.7012 434.1000 0.6574 434.2980 0.6574 434.4000 0.3615 434.5980 0.3615 434.7000 0.4251 434.8980 0.4251 435.0000 0.5457 435.1980 0.5457 435.3000 0.5207 435.4980 0.5207 435.6000 0.5663 435.7980 0.5663 435.9000 0.4060 436.0980 0.4060 436.2000 0.4588 436.3980 0.4588 436.5000 0.7108 436.6980 0.7108 436.8000 0.4343 436.9980 0.4343 437.1000 0.3918 437.2980 0.3918 437.4000 0.3234 437.5980 0.3234 437.7000 0.4716 437.8980 0.4716 438.0000 0.4783 438.1980 0.4783 438.3000 0.5142 438.4980 0.5142 438.6000 0.5902 438.7980 0.5902 438.9000 0.4637 439.0980 0.4637 439.2000 0.5412 439.3980 0.5412 439.5000 0.5887 439.6980 0.5887 439.8000 0.6116 439.9980 0.6116 440.1000 0.5033 440.2980 0.5033 440.4000 0.5913 440.5980 0.5913 440.7000 0.6190 440.8980 0.6190 441.0000 0.5692 441.1980 0.5692 441.3000 0.5961 441.4980 0.5961 441.6000 0.6150 441.7980 0.6150 441.9000 0.5696 442.0980 0.5696 442.2000 0.6065 442.3980 0.6065 442.5000 0.6194 442.6980 0.6194 442.8000 0.5673 442.9980 0.5673 443.1000 0.6056 443.2980 0.6056 443.4000 0.5477 443.5980 0.5477 443.7000 0.5860 443.8980 0.5860 444.0000 0.5723 444.1980 0.5723 444.3000 0.6247 444.4980 0.6247 444.6000 0.5668 444.7980 0.5668 444.9000 0.5998 445.0980 0.5998 445.2000 0.5790 445.3980 0.5790 445.5000 0.6068 445.6980 0.6068 445.8000 0.5960 445.9980 0.5960 446.1000 0.6236 446.2980 0.6236 446.4000 0.5892 446.5980 0.5892 446.7000 0.6006 446.8980 0.6006 447.0000 0.5466 447.1980 0.5466 447.3000 0.5968 447.4980 0.5968 447.6000 0.5883 447.7980 0.5883 447.9000 0.6004 448.0980 0.6004 448.2000 0.5933 448.3980 0.5933 448.5000 0.5768 448.6980 0.5768 448.8000 0.6007 448.9980 0.6007 449.1000 0.6082 449.2980 0.6082 449.4000 0.5745 449.5980 0.5745 449.7000 0.5786 449.8980 0.5786 450.0000 0.5939 450.1980 0.5939 450.3000 0.6088 450.4980 0.6088 450.6000 0.5452 450.7980 0.5452 450.9000 0.5821 451.0980 0.5821 451.2000 0.7448 451.3980 0.7448 451.5000 0.6057 451.6980 0.6057 451.8000 0.5458 451.9980 0.5458 452.1000 0.6020 452.2980 0.6020 452.4000 0.5708 452.5980 0.5708 452.7000 0.5164 452.8980 0.5164 453.0000 0.5718 453.1980 0.5718 453.3000 0.5754 453.4980 0.5754 453.6000 0.4335 453.7980 0.4335 453.9000 0.4885 454.0980 0.4885 454.2000 0.4856 454.3980 0.4856 454.5000 0.4180 454.6980 0.4180 454.8000 0.5773 454.9980 0.5773 455.1000 0.3323 455.2980 0.3323 455.4000 0.7012 455.5980 0.7012 455.7000 0.6574 455.8980 0.6574 456.0000 0.3615 456.1980 0.3615 456.3000 0.4251 456.4980 0.4251 456.6000 0.5457 456.7980 0.5457 456.9000 0.5207 457.0980 0.5207 457.2000 0.5663 457.3980 0.5663 457.5000 0.4060 457.6980 0.4060 457.8000 0.4588 457.9980 0.4588 458.1000 0.7108 458.2980 0.7108 458.4000 0.4343 458.5980 0.4343 458.7000 0.3918 458.8980 0.3918 459.0000 0.3234 459.1980 0.3234 459.3000 0.4716 459.4980 0.4716 459.6000 0.4783 459.7980 0.4783 459.9000 0.5142 460.0980 0.5142 460.2000 0.5902 460.3980 0.5902 460.5000 0.4637 460.6980 0.4637 460.8000 0.5412 460.9980 0.5412 461.1000 0.5887 461.2980 0.5887 461.4000 0.6116 461.5980 0.6116 461.7000 0.5033 461.8980 0.5033 462.0000 0.5913 462.1980 0.5913 462.3000 0.6190 462.4980 0.6190 462.6000 0.5692 462.7980 0.5692 462.9000 0.5961 463.0980 0.5961 463.2000 0.6150 463.3980 0.6150 463.5000 0.5696 463.6980 0.5696 463.8000 0.6065 463.9980 0.6065 464.1000 0.6194 464.2980 0.6194 464.4000 0.5673 464.5980 0.5673 464.7000 0.6056 464.8980 0.6056 465.0000 0.5477 465.1980 0.5477 465.3000 0.5860 465.4980 0.5860 465.6000 0.5723 465.7980 0.5723 465.9000 0.6247 466.0980 0.6247 466.2000 0.5668 466.3980 0.5668 466.5000 0.5998 466.6980 0.5998 466.8000 0.5790 466.9980 0.5790 467.1000 0.6068 467.2980 0.6068 467.4000 0.5960 467.5980 0.5960 467.7000 0.6236 467.8980 0.6236 468.0000 0.5892 468.1980 0.5892 468.3000 0.6006 468.4980 0.6006 468.6000 0.5466 468.7980 0.5466 468.9000 0.5968 469.0980 0.5968 469.2000 0.5883 469.3980 0.5883 469.5000 0.6004 469.6980 0.6004 469.8000 0.5933 469.9980 0.5933 470.1000 0.5768 470.2980 0.5768 470.4000 0.6007 470.5980 0.6007 470.7000 0.6082 470.8980 0.6082 471.0000 0.5745 471.1980 0.5745 471.3000 0.5786 471.4980 0.5786 471.6000 0.5939 471.7980 0.5939 471.9000 0.6088 472.0980 0.6088 472.2000 0.5452 472.3980 0.5452 472.5000 0.5821 472.6980 0.5821 472.8000 0.7448 472.9980 0.7448 473.1000 0.6057 473.2980 0.6057 473.4000 0.5458 473.5980 0.5458 473.7000 0.6020 473.8980 0.6020 474.0000 0.5708 474.1980 0.5708 474.3000 0.5164 474.4980 0.5164 474.6000 0.5718 474.7980 0.5718 474.9000 0.5754 475.0980 0.5754 475.2000 0.4335 475.3980 0.4335 475.5000 0.4885 475.6980 0.4885 475.8000 0.4856 475.9980 0.4856 476.1000 0.4180 476.2980 0.4180 476.4000 0.5773 476.5980 0.5773 476.7000 0.3323 476.8980 0.3323 477.0000 0.7012 477.1980 0.7012 477.3000 0.6574 477.4980 0.6574 477.6000 0.3615 477.7980 0.3615 477.9000 0.4251 478.0980 0.4251 478.2000 0.5457 478.3980 0.5457 478.5000 0.5207 478.6980 0.5207 478.8000 0.5663 478.9980 0.5663 479.1000 0.4060 479.2980 0.4060 479.4000 0.4588 479.5980 0.4588 479.7000 0.7108 479.8980 0.7108 480.0000 0.4343 480.1980 0.4343 480.3000 0.3918 480.4980 0.3918 480.6000 0.3234 480.7980 0.3234 480.9000 0.4716 481.0980 0.4716 481.2000 0.4783 481.3980 0.4783 481.5000 0.5142 481.6980 0.5142 481.8000 0.5902 481.9980 0.5902 482.1000 0.4637 482.2980 0.4637 482.4000 0.5412 482.5980 0.5412 482.7000 0.5887 482.8980 0.5887 483.0000 0.6116 483.1980 0.6116 483.3000 0.5033 483.4980 0.5033 483.6000 0.5913 483.7980 0.5913 483.9000 0.6190 484.0980 0.6190 484.2000 0.5692 484.3980 0.5692 484.5000 0.5961 484.6980 0.5961 484.8000 0.6150 484.9980 0.6150 485.1000 0.5696 485.2980 0.5696 485.4000 0.6065 485.5980 0.6065 485.7000 0.6194 485.8980 0.6194 486.0000 0.5673 486.1980 0.5673 486.3000 0.6056 486.4980 0.6056 486.6000 0.5477 486.7980 0.5477 486.9000 0.5860 487.0980 0.5860 487.2000 0.5723 487.3980 0.5723 487.5000 0.6247 487.6980 0.6247 487.8000 0.5668 487.9980 0.5668 488.1000 0.5998 488.2980 0.5998 488.4000 0.5790 488.5980 0.5790 488.7000 0.6068 488.8980 0.6068 489.0000 0.5960 489.1980 0.5960 489.3000 0.6236 489.4980 0.6236 489.6000 0.5892 489.7980 0.5892 489.9000 0.6006 490.0980 0.6006 490.2000 0.5466 490.3980 0.5466 490.5000 0.5968 490.6980 0.5968 490.8000 0.5883 490.9980 0.5883 491.1000 0.6004 491.2980 0.6004 491.4000 0.5933 491.5980 0.5933 491.7000 0.5768 491.8980 0.5768 492.0000 0.6007 492.1980 0.6007 492.3000 0.6082 492.4980 0.6082 492.6000 0.5745 492.7980 0.5745 492.9000 0.5786 493.0980 0.5786 493.2000 0.5939 493.3980 0.5939 493.5000 0.6088 493.6980 0.6088 493.8000 0.5452 493.9980 0.5452 494.1000 0.5821 494.2980 0.5821 494.4000 0.7448 494.5980 0.7448 494.7000 0.6057 494.8980 0.6057 495.0000 0.5458 495.1980 0.5458 495.3000 0.6020 495.4980 0.6020 495.6000 0.5708 495.7980 0.5708 495.9000 0.5164 496.0980 0.5164 496.2000 0.5718 496.3980 0.5718 496.5000 0.5754 496.6980 0.5754 496.8000 0.4335 496.9980 0.4335 497.1000 0.4885 497.2980 0.4885 497.4000 0.4856 497.5980 0.4856 497.7000 0.4180 497.8980 0.4180 498.0000 0.5773 498.1980 0.5773 498.3000 0.3323 498.4980 0.3323 498.6000 0.7012 498.7980 0.7012 498.9000 0.6574 499.0980 0.6574 499.2000 0.3615 499.3980 0.3615 499.5000 0.4251 499.6980 0.4251 499.8000 0.5457 499.9980 0.5457 500.1000 0.5207 500.2980 0.5207 500.4000 0.5663 500.5980 0.5663 500.7000 0.4060 500.8980 0.4060 501.0000 0.4588 501.1980 0.4588 501.3000 0.7108 501.4980 0.7108 501.6000 0.4343 501.7980 0.4343 501.9000 0.3918 502.0980 0.3918 502.2000 0.3234 502.3980 0.3234 502.5000 0.4716 502.6980 0.4716 502.8000 0.4783 502.9980 0.4783 503.1000 0.5142 503.2980 0.5142 503.4000 0.5902 503.5980 0.5902 503.7000 0.4637 503.8980 0.4637 504.0000 0.5412 504.1980 0.5412 504.3000 0.5887 504.4980 0.5887 504.6000 0.6116 504.7980 0.6116 504.9000 0.5033 505.0980 0.5033 505.2000 0.5913 505.3980 0.5913 505.5000 0.6190 505.6980 0.6190 505.8000 0.5692 505.9980 0.5692 506.1000 0.5961 506.2980 0.5961 506.4000 0.6150 506.5980 0.6150 506.7000 0.5696 506.8980 0.5696 507.0000 0.6065 507.1980 0.6065 507.3000 0.6194 507.4980 0.6194 507.6000 0.5673 507.7980 0.5673 507.9000 0.6056 508.0980 0.6056 508.2000 0.5477 508.3980 0.5477 508.5000 0.5860 508.6980 0.5860 508.8000 0.5723 508.9980 0.5723 509.1000 0.6247 509.2980 0.6247 509.4000 0.5668 509.5980 0.5668 509.7000 0.5998 509.8980 0.5998 510.0000 0.5790 510.1980 0.5790 510.3000 0.6068 510.4980 0.6068 510.6000 0.5960 510.7980 0.5960 510.9000 0.6236 511.0980 0.6236 511.2000 0.5892 511.3980 0.5892 511.5000 0.6006 511.6980 0.6006 511.8000 0.5466 511.9980 0.5466 512.1000 0.5968 512.2980 0.5968 512.4000 0.5883 512.5980 0.5883 512.7000 0.6004 512.8980 0.6004 513.0000 0.5933 513.1980 0.5933 513.3000 0.5768 513.4980 0.5768 513.6000 0.6007 513.7980 0.6007 513.9000 0.6082 514.0980 0.6082 514.2000 0.5745 514.3980 0.5745 514.5000 0.5786 514.6980 0.5786 514.8000 0.5939 514.9980 0.5939 515.1000 0.6088 515.2980 0.6088 515.4000 0.5452 515.5980 0.5452 515.7000 0.5821 515.8980 0.5821 516.0000 0.7448 516.1980 0.7448 516.3000 0.6057 516.4980 0.6057 516.6000 0.5458 516.7980 0.5458 516.9000 0.6020 517.0980 0.6020 517.2000 0.5708 517.3980 0.5708 517.5000 0.5164 517.6980 0.5164 517.8000 0.5718 517.9980 0.5718 518.1000 0.5754 518.2980 0.5754 518.4000 0.4335 518.5980 0.4335 518.7000 0.4885 518.8980 0.4885 519.0000 0.4856 519.1980 0.4856 519.3000 0.4180 519.4980 0.4180 519.6000 0.5773 519.7980 0.5773 519.9000 0.3323 520.0980 0.3323 520.2000 0.7012 520.3980 0.7012 520.5000 0.6574 520.6980 0.6574 520.8000 0.3615 520.9980 0.3615 521.1000 0.4251 521.2980 0.4251 521.4000 0.5457 521.5980 0.5457 521.7000 0.5207 521.8980 0.5207 522.0000 0.5663 522.1980 0.5663 522.3000 0.4060 522.4980 0.4060 522.6000 0.4588 522.7980 0.4588 522.9000 0.7108 523.0980 0.7108 523.2000 0.4343 523.3980 0.4343 523.5000 0.3918 523.6980 0.3918 523.8000 0.3234 523.9980 0.3234 524.1000 0.4716 524.2980 0.4716 524.4000 0.4783 524.5980 0.4783 524.7000 0.5142 524.8980 0.5142 525.0000 0.5902 525.1980 0.5902 525.3000 0.4637 525.4980 0.4637 525.6000 0.5412 525.7980 0.5412 525.9000 0.5887 526.0980 0.5887 526.2000 0.6116 526.3980 0.6116 526.5000 0.5033 526.6980 0.5033 526.8000 0.5913 526.9980 0.5913 527.1000 0.6190 527.2980 0.6190 527.4000 0.5692 527.5980 0.5692 527.7000 0.5961 527.8980 0.5961 528.0000 0.6150 528.1980 0.6150 528.3000 0.5696 528.4980 0.5696 528.6000 0.6065 528.7980 0.6065 528.9000 0.6194 529.0980 0.6194 529.2000 0.5673 529.3980 0.5673 529.5000 0.6056 529.6980 0.6056 529.8000 0.5477 529.9980 0.5477 530.1000 0.5860 530.2980 0.5860 530.4000 0.5723 530.5980 0.5723 530.7000 0.6247 530.8980 0.6247 531.0000 0.5668 531.1980 0.5668 531.3000 0.5998 531.4980 0.5998 531.6000 0.5790 531.7980 0.5790 531.9000 0.6068 532.0980 0.6068 532.2000 0.5960 532.3980 0.5960 532.5000 0.6236 532.6980 0.6236 532.8000 0.5892 532.9980 0.5892 533.1000 0.6006 533.2980 0.6006 533.4000 0.5466 533.5980 0.5466 533.7000 0.5968 533.8980 0.5968 534.0000 0.5883 534.1980 0.5883 534.3000 0.6004 534.4980 0.6004 534.6000 0.5933 534.7980 0.5933 534.9000 0.5768 535.0980 0.5768 535.2000 0.6007 535.3980 0.6007 535.5000 0.6082 535.6980 0.6082 535.8000 0.5745 535.9980 0.5745 536.1000 0.5786 536.2980 0.5786 536.4000 0.5939 536.5980 0.5939 536.7000 0.6088 536.8980 0.6088 537.0000 0.5452 537.1980 0.5452 537.3000 0.5821 537.4980 0.5821 537.6000 0.7448 537.7980 0.7448 537.9000 0.6057 538.0980 0.6057 538.2000 0.5458 538.3980 0.5458 538.5000 0.6020 538.6980 0.6020 538.8000 0.5708 538.9980 0.5708 539.1000 0.5164 539.2980 0.5164 539.4000 0.5718 539.5980 0.5718 539.7000 0.5754 539.8980 0.5754 540.0000 0.4335 540.1980 0.4335 540.3000 0.4885 540.4980 0.4885 540.6000 0.4856 540.7980 0.4856 540.9000 0.4180 541.0980 0.4180 541.2000 0.5773 541.3980 0.5773 541.5000 0.3323 541.6980 0.3323 541.8000 0.7012 541.9980 0.7012 542.1000 0.6574 542.2980 0.6574 542.4000 0.3615 542.5980 0.3615 542.7000 0.4251 542.8980 0.4251 543.0000 0.5457 543.1980 0.5457 543.3000 0.5207 543.4980 0.5207 543.6000 0.5663 543.7980 0.5663 543.9000 0.4060 544.0980 0.4060 544.2000 0.4588 544.3980 0.4588 544.5000 0.7108 544.6980 0.7108 544.8000 0.4343 544.9980 0.4343 545.1000 0.3918 545.2980 0.3918 545.4000 0.3234 545.5980 0.3234 545.7000 0.4716 545.8980 0.4716 546.0000 0.4783 546.1980 0.4783 546.3000 0.5142 546.4980 0.5142 546.6000 0.5902 546.7980 0.5902 546.9000 0.4637 547.0980 0.4637 547.2000 0.5412 547.3980 0.5412 547.5000 0.5887 547.6980 0.5887 547.8000 0.6116 547.9980 0.6116 548.1000 0.5033 548.2980 0.5033 548.4000 0.5913 548.5980 0.5913 548.7000 0.6190 548.8980 0.6190 549.0000 0.5692 549.1980 0.5692 549.3000 0.5961 549.4980 0.5961 549.6000 0.6150 549.7980 0.6150 549.9000 0.5696 550.0980 0.5696 550.2000 0.6065 550.3980 0.6065 550.5000 0.6194 550.6980 0.6194 550.8000 0.5673 550.9980 0.5673 551.1000 0.6056 551.2980 0.6056 551.4000 0.5477 551.5980 0.5477 551.7000 0.5860 551.8980 0.5860 552.0000 0.5723 552.1980 0.5723 552.3000 0.6247 552.4980 0.6247 552.6000 0.5668 552.7980 0.5668 552.9000 0.5998 553.0980 0.5998 553.2000 0.5790 553.3980 0.5790 553.5000 0.6068 553.6980 0.6068 553.8000 0.5960 553.9980 0.5960 554.1000 0.6236 554.2980 0.6236 554.4000 0.5892 554.5980 0.5892 554.7000 0.6006 554.8980 0.6006 555.0000 0.5466 555.1980 0.5466 555.3000 0.5968 555.4980 0.5968 555.6000 0.5883 555.7980 0.5883 555.9000 0.6004 556.0980 0.6004 556.2000 0.5933 556.3980 0.5933 556.5000 0.5768 556.6980 0.5768 556.8000 0.6007 556.9980 0.6007 557.1000 0.6082 557.2980 0.6082 557.4000 0.5745 557.5980 0.5745 557.7000 0.5786 557.8980 0.5786 558.0000 0.5939 558.1980 0.5939 558.3000 0.6088 558.4980 0.6088 558.6000 0.5452 558.7980 0.5452 558.9000 0.5821 559.0980 0.5821 559.2000 0.7448 559.3980 0.7448 559.5000 0.6057 559.6980 0.6057 559.8000 0.5458 559.9980 0.5458 560.1000 0.6020 560.2980 0.6020 560.4000 0.5708 560.5980 0.5708 560.7000 0.5164 560.8980 0.5164 561.0000 0.5718 561.1980 0.5718 561.3000 0.5754 561.4980 0.5754 561.6000 0.4335 561.7980 0.4335 561.9000 0.4885 562.0980 0.4885 562.2000 0.4856 562.3980 0.4856 562.5000 0.4180 562.6980 0.4180 562.8000 0.5773 562.9980 0.5773 563.1000 0.3323 563.2980 0.3323 563.4000 0.7012 563.5980 0.7012 563.7000 0.6574 563.8980 0.6574 564.0000 0.3615 564.1980 0.3615 564.3000 0.4251 564.4980 0.4251 564.6000 0.5457 564.7980 0.5457 564.9000 0.5207 565.0980 0.5207 565.2000 0.5663 565.3980 0.5663 565.5000 0.4060 565.6980 0.4060 565.8000 0.4588 565.9980 0.4588 566.1000 0.7108 566.2980 0.7108 566.4000 0.4343 566.5980 0.4343 566.7000 0.3918 566.8980 0.3918 567.0000 0.3234 567.1980 0.3234 567.3000 0.4716 567.4980 0.4716 567.6000 0.4783 567.7980 0.4783 567.9000 0.5142 568.0980 0.5142 568.2000 0.5902 568.3980 0.5902 568.5000 0.4637 568.6980 0.4637 568.8000 0.5412 568.9980 0.5412 569.1000 0.5887 569.2980 0.5887 569.4000 0.6116 569.5980 0.6116 569.7000 0.5033 569.8980 0.5033 570.0000 0.5913 570.1980 0.5913 570.3000 0.6190 570.4980 0.6190 570.6000 0.5692 570.7980 0.5692 570.9000 0.5961 571.0980 0.5961 571.2000 0.6150 571.3980 0.6150 571.5000 0.5696 571.6980 0.5696 571.8000 0.6065 571.9980 0.6065 572.1000 0.6194 572.2980 0.6194 572.4000 0.5673 572.5980 0.5673 572.7000 0.6056 572.8980 0.6056 573.0000 0.5477 573.1980 0.5477 573.3000 0.5860 573.4980 0.5860 573.6000 0.5723 573.7980 0.5723 573.9000 0.6247 574.0980 0.6247 574.2000 0.5668 574.3980 0.5668 574.5000 0.5998 574.6980 0.5998 574.8000 0.5790 574.9980 0.5790 575.1000 0.6068 575.2980 0.6068 575.4000 0.5960 575.5980 0.5960 575.7000 0.6236 575.8980 0.6236 576.0000 0.5892 576.1980 0.5892 576.3000 0.6006 576.4980 0.6006 576.6000 0.5466 576.7980 0.5466 576.9000 0.5968 577.0980 0.5968 577.2000 0.5883 577.3980 0.5883 577.5000 0.6004 577.6980 0.6004 577.8000 0.5933 577.9980 0.5933 578.1000 0.5768 578.2980 0.5768 578.4000 0.6007 578.5980 0.6007 578.7000 0.6082 578.8980 0.6082 579.0000 0.5745 579.1980 0.5745 579.3000 0.5786 579.4980 0.5786 579.6000 0.5939 579.7980 0.5939 579.9000 0.6088 580.0980 0.6088 580.2000 0.5452 580.3980 0.5452 580.5000 0.5821 580.6980 0.5821 580.8000 0.7448 580.9980 0.7448 581.1000 0.6057 581.2980 0.6057 581.4000 0.5458 581.5980 0.5458 581.7000 0.6020 581.8980 0.6020 582.0000 0.5708 582.1980 0.5708 582.3000 0.5164 582.4980 0.5164 582.6000 0.5718 582.7980 0.5718 582.9000 0.5754 583.0980 0.5754 583.2000 0.4335 583.3980 0.4335 583.5000 0.4885 583.6980 0.4885 583.8000 0.4856 583.9980 0.4856 584.1000 0.4180 584.2980 0.4180 584.4000 0.5773 584.5980 0.5773 584.7000 0.3323 584.8980 0.3323 585.0000 0.7012 585.1980 0.7012 585.3000 0.6574 585.4980 0.6574 585.6000 0.3615 585.7980 0.3615 585.9000 0.4251 586.0980 0.4251 586.2000 0.5457 586.3980 0.5457 586.5000 0.5207 586.6980 0.5207 586.8000 0.5663 586.9980 0.5663 587.1000 0.4060 587.2980 0.4060 587.4000 0.4588 587.5980 0.4588 587.7000 0.7108 587.8980 0.7108 588.0000 0.4343 588.1980 0.4343 588.3000 0.3918 588.4980 0.3918 588.6000 0.3234 588.7980 0.3234 588.9000 0.4716 589.0980 0.4716 589.2000 0.4783 589.3980 0.4783 589.5000 0.5142 589.6980 0.5142 589.8000 0.5902 589.9980 0.5902 590.1000 0.4637 590.2980 0.4637 590.4000 0.5412 590.5980 0.5412 590.7000 0.5887 590.8980 0.5887 591.0000 0.6116 591.1980 0.6116 591.3000 0.5033 591.4980 0.5033 591.6000 0.5913 591.7980 0.5913 591.9000 0.6190 592.0980 0.6190 592.2000 0.5692 592.3980 0.5692 592.5000 0.5961 592.6980 0.5961 592.8000 0.6150 592.9980 0.6150 593.1000 0.5696 593.2980 0.5696 593.4000 0.6065 593.5980 0.6065 593.7000 0.6194 593.8980 0.6194 594.0000 0.5673 594.1980 0.5673 594.3000 0.6056 594.4980 0.6056 594.6000 0.5477 594.7980 0.5477 594.9000 0.5860 595.0980 0.5860 595.2000 0.5723 595.3980 0.5723 595.5000 0.6247 595.6980 0.6247 595.8000 0.5668 595.9980 0.5668 596.1000 0.5998 596.2980 0.5998 596.4000 0.5790 596.5980 0.5790 596.7000 0.6068 596.8980 0.6068 597.0000 0.5960 597.1980 0.5960 597.3000 0.6236 597.4980 0.6236 597.6000 0.5892 597.7980 0.5892 597.9000 0.6006 598.0980 0.6006 598.2000 0.5466 598.3980 0.5466 598.5000 0.5968 598.6980 0.5968 598.8000 0.5883 598.9980 0.5883 599.1000 0.6004 599.2980 0.6004 599.4000 0.5933 599.5980 0.5933 599.7000 0.5768 599.8980 0.5768 600.0000 0.5768)
Va13 a13 0 PWL(0.0000 1.5497 0.1980 1.5497 0.3000 0.9032 0.4980 0.9032 0.6000 0.6491 0.7980 0.6491 0.9000 0.9059 1.0980 0.9059 1.2000 1.3139 1.3980 1.3139 1.5000 1.0666 1.6980 1.0666 1.8000 1.4669 1.9980 1.4669 2.1000 1.0274 2.2980 1.0274 2.4000 0.8702 2.5980 0.8702 2.7000 1.1680 2.8980 1.1680 3.0000 0.9272 3.1980 0.9272 3.3000 1.2976 3.4980 1.2976 3.6000 1.2611 3.7980 1.2611 3.9000 1.2131 4.0980 1.2131 4.2000 1.1808 4.3980 1.1808 4.5000 1.1221 4.6980 1.1221 4.8000 1.3576 4.9980 1.3576 5.1000 1.0884 5.2980 1.0884 5.4000 0.9163 5.5980 0.9163 5.7000 1.3159 5.8980 1.3159 6.0000 1.1552 6.1980 1.1552 6.3000 0.9317 6.4980 0.9317 6.6000 0.8998 6.7980 0.8998 6.9000 0.7836 7.0980 0.7836 7.2000 1.0457 7.3980 1.0457 7.5000 0.5887 7.6980 0.5887 7.8000 1.1468 7.9980 1.1468 8.1000 0.9922 8.2980 0.9922 8.4000 1.2583 8.5980 1.2583 8.7000 1.2130 8.8980 1.2130 9.0000 1.1361 9.1980 1.1361 9.3000 1.1791 9.4980 1.1791 9.6000 1.3453 9.7980 1.3453 9.9000 1.1417 10.0980 1.1417 10.2000 0.6065 10.3980 0.6065 10.5000 1.2029 10.6980 1.2029 10.8000 0.7549 10.9980 0.7549 11.1000 1.2676 11.2980 1.2676 11.4000 0.7102 11.5980 0.7102 11.7000 1.2650 11.8980 1.2650 12.0000 0.5963 12.1980 0.5963 12.3000 1.1428 12.4980 1.1428 12.6000 0.8441 12.7980 0.8441 12.9000 1.2201 13.0980 1.2201 13.2000 0.5790 13.3980 0.5790 13.5000 1.2508 13.6980 1.2508 13.8000 0.9231 13.9980 0.9231 14.1000 1.2347 14.2980 1.2347 14.4000 0.9325 14.5980 0.9325 14.7000 1.1977 14.8980 1.1977 15.0000 1.3375 15.1980 1.3375 15.3000 0.9544 15.4980 0.9544 15.6000 0.5883 15.7980 0.5883 15.9000 1.3247 16.0980 1.3247 16.2000 0.5933 16.3980 0.5933 16.5000 1.3739 16.6980 1.3739 16.8000 1.1663 16.9980 1.1663 17.1000 1.3500 17.2980 1.3500 17.4000 0.6807 17.5980 0.6807 17.7000 1.3903 17.8980 1.3903 18.0000 1.3720 18.1980 1.3720 18.3000 1.3636 18.4980 1.3636 18.6000 0.5452 18.7980 0.5452 18.9000 1.3260 19.0980 1.3260 19.2000 1.2891 19.3980 1.2891 19.5000 1.2799 19.6980 1.2799 19.8000 0.6872 19.9980 0.6872 20.1000 0.6020 20.2980 0.6020 20.4000 1.4772 20.5980 1.4772 20.7000 0.9818 20.8980 0.9818 21.0000 0.8978 21.1980 0.8978 21.3000 0.7177 21.4980 0.7177 21.6000 1.5497 21.7980 1.5497 21.9000 0.9032 22.0980 0.9032 22.2000 0.6491 22.3980 0.6491 22.5000 0.9059 22.6980 0.9059 22.8000 1.3139 22.9980 1.3139 23.1000 1.0666 23.2980 1.0666 23.4000 1.4669 23.5980 1.4669 23.7000 1.0274 23.8980 1.0274 24.0000 0.8702 24.1980 0.8702 24.3000 1.1680 24.4980 1.1680 24.6000 0.9272 24.7980 0.9272 24.9000 1.2976 25.0980 1.2976 25.2000 1.2611 25.3980 1.2611 25.5000 1.2131 25.6980 1.2131 25.8000 1.1808 25.9980 1.1808 26.1000 1.1221 26.2980 1.1221 26.4000 1.3576 26.5980 1.3576 26.7000 1.0884 26.8980 1.0884 27.0000 0.9163 27.1980 0.9163 27.3000 1.3159 27.4980 1.3159 27.6000 1.1552 27.7980 1.1552 27.9000 0.9317 28.0980 0.9317 28.2000 0.8998 28.3980 0.8998 28.5000 0.7836 28.6980 0.7836 28.8000 1.0457 28.9980 1.0457 29.1000 0.5887 29.2980 0.5887 29.4000 1.1468 29.5980 1.1468 29.7000 0.9922 29.8980 0.9922 30.0000 1.2583 30.1980 1.2583 30.3000 1.2130 30.4980 1.2130 30.6000 1.1361 30.7980 1.1361 30.9000 1.1791 31.0980 1.1791 31.2000 1.3453 31.3980 1.3453 31.5000 1.1417 31.6980 1.1417 31.8000 0.6065 31.9980 0.6065 32.1000 1.2029 32.2980 1.2029 32.4000 0.7549 32.5980 0.7549 32.7000 1.2676 32.8980 1.2676 33.0000 0.7102 33.1980 0.7102 33.3000 1.2650 33.4980 1.2650 33.6000 0.5963 33.7980 0.5963 33.9000 1.1428 34.0980 1.1428 34.2000 0.8441 34.3980 0.8441 34.5000 1.2201 34.6980 1.2201 34.8000 0.5790 34.9980 0.5790 35.1000 1.2508 35.2980 1.2508 35.4000 0.9231 35.5980 0.9231 35.7000 1.2347 35.8980 1.2347 36.0000 0.9325 36.1980 0.9325 36.3000 1.1977 36.4980 1.1977 36.6000 1.3375 36.7980 1.3375 36.9000 0.9544 37.0980 0.9544 37.2000 0.5883 37.3980 0.5883 37.5000 1.3247 37.6980 1.3247 37.8000 0.5933 37.9980 0.5933 38.1000 1.3739 38.2980 1.3739 38.4000 1.1663 38.5980 1.1663 38.7000 1.3500 38.8980 1.3500 39.0000 0.6807 39.1980 0.6807 39.3000 1.3903 39.4980 1.3903 39.6000 1.3720 39.7980 1.3720 39.9000 1.3636 40.0980 1.3636 40.2000 0.5452 40.3980 0.5452 40.5000 1.3260 40.6980 1.3260 40.8000 1.2891 40.9980 1.2891 41.1000 1.2799 41.2980 1.2799 41.4000 0.6872 41.5980 0.6872 41.7000 0.6020 41.8980 0.6020 42.0000 1.4772 42.1980 1.4772 42.3000 0.9818 42.4980 0.9818 42.6000 0.8978 42.7980 0.8978 42.9000 0.7177 43.0980 0.7177 43.2000 1.5497 43.3980 1.5497 43.5000 0.9032 43.6980 0.9032 43.8000 0.6491 43.9980 0.6491 44.1000 0.9059 44.2980 0.9059 44.4000 1.3139 44.5980 1.3139 44.7000 1.0666 44.8980 1.0666 45.0000 1.4669 45.1980 1.4669 45.3000 1.0274 45.4980 1.0274 45.6000 0.8702 45.7980 0.8702 45.9000 1.1680 46.0980 1.1680 46.2000 0.9272 46.3980 0.9272 46.5000 1.2976 46.6980 1.2976 46.8000 1.2611 46.9980 1.2611 47.1000 1.2131 47.2980 1.2131 47.4000 1.1808 47.5980 1.1808 47.7000 1.1221 47.8980 1.1221 48.0000 1.3576 48.1980 1.3576 48.3000 1.0884 48.4980 1.0884 48.6000 0.9163 48.7980 0.9163 48.9000 1.3159 49.0980 1.3159 49.2000 1.1552 49.3980 1.1552 49.5000 0.9317 49.6980 0.9317 49.8000 0.8998 49.9980 0.8998 50.1000 0.7836 50.2980 0.7836 50.4000 1.0457 50.5980 1.0457 50.7000 0.5887 50.8980 0.5887 51.0000 1.1468 51.1980 1.1468 51.3000 0.9922 51.4980 0.9922 51.6000 1.2583 51.7980 1.2583 51.9000 1.2130 52.0980 1.2130 52.2000 1.1361 52.3980 1.1361 52.5000 1.1791 52.6980 1.1791 52.8000 1.3453 52.9980 1.3453 53.1000 1.1417 53.2980 1.1417 53.4000 0.6065 53.5980 0.6065 53.7000 1.2029 53.8980 1.2029 54.0000 0.7549 54.1980 0.7549 54.3000 1.2676 54.4980 1.2676 54.6000 0.7102 54.7980 0.7102 54.9000 1.2650 55.0980 1.2650 55.2000 0.5963 55.3980 0.5963 55.5000 1.1428 55.6980 1.1428 55.8000 0.8441 55.9980 0.8441 56.1000 1.2201 56.2980 1.2201 56.4000 0.5790 56.5980 0.5790 56.7000 1.2508 56.8980 1.2508 57.0000 0.9231 57.1980 0.9231 57.3000 1.2347 57.4980 1.2347 57.6000 0.9325 57.7980 0.9325 57.9000 1.1977 58.0980 1.1977 58.2000 1.3375 58.3980 1.3375 58.5000 0.9544 58.6980 0.9544 58.8000 0.5883 58.9980 0.5883 59.1000 1.3247 59.2980 1.3247 59.4000 0.5933 59.5980 0.5933 59.7000 1.3739 59.8980 1.3739 60.0000 1.1663 60.1980 1.1663 60.3000 1.3500 60.4980 1.3500 60.6000 0.6807 60.7980 0.6807 60.9000 1.3903 61.0980 1.3903 61.2000 1.3720 61.3980 1.3720 61.5000 1.3636 61.6980 1.3636 61.8000 0.5452 61.9980 0.5452 62.1000 1.3260 62.2980 1.3260 62.4000 1.2891 62.5980 1.2891 62.7000 1.2799 62.8980 1.2799 63.0000 0.6872 63.1980 0.6872 63.3000 0.6020 63.4980 0.6020 63.6000 1.4772 63.7980 1.4772 63.9000 0.9818 64.0980 0.9818 64.2000 0.8978 64.3980 0.8978 64.5000 0.7177 64.6980 0.7177 64.8000 1.5497 64.9980 1.5497 65.1000 0.9032 65.2980 0.9032 65.4000 0.6491 65.5980 0.6491 65.7000 0.9059 65.8980 0.9059 66.0000 1.3139 66.1980 1.3139 66.3000 1.0666 66.4980 1.0666 66.6000 1.4669 66.7980 1.4669 66.9000 1.0274 67.0980 1.0274 67.2000 0.8702 67.3980 0.8702 67.5000 1.1680 67.6980 1.1680 67.8000 0.9272 67.9980 0.9272 68.1000 1.2976 68.2980 1.2976 68.4000 1.2611 68.5980 1.2611 68.7000 1.2131 68.8980 1.2131 69.0000 1.1808 69.1980 1.1808 69.3000 1.1221 69.4980 1.1221 69.6000 1.3576 69.7980 1.3576 69.9000 1.0884 70.0980 1.0884 70.2000 0.9163 70.3980 0.9163 70.5000 1.3159 70.6980 1.3159 70.8000 1.1552 70.9980 1.1552 71.1000 0.9317 71.2980 0.9317 71.4000 0.8998 71.5980 0.8998 71.7000 0.7836 71.8980 0.7836 72.0000 1.0457 72.1980 1.0457 72.3000 0.5887 72.4980 0.5887 72.6000 1.1468 72.7980 1.1468 72.9000 0.9922 73.0980 0.9922 73.2000 1.2583 73.3980 1.2583 73.5000 1.2130 73.6980 1.2130 73.8000 1.1361 73.9980 1.1361 74.1000 1.1791 74.2980 1.1791 74.4000 1.3453 74.5980 1.3453 74.7000 1.1417 74.8980 1.1417 75.0000 0.6065 75.1980 0.6065 75.3000 1.2029 75.4980 1.2029 75.6000 0.7549 75.7980 0.7549 75.9000 1.2676 76.0980 1.2676 76.2000 0.7102 76.3980 0.7102 76.5000 1.2650 76.6980 1.2650 76.8000 0.5963 76.9980 0.5963 77.1000 1.1428 77.2980 1.1428 77.4000 0.8441 77.5980 0.8441 77.7000 1.2201 77.8980 1.2201 78.0000 0.5790 78.1980 0.5790 78.3000 1.2508 78.4980 1.2508 78.6000 0.9231 78.7980 0.9231 78.9000 1.2347 79.0980 1.2347 79.2000 0.9325 79.3980 0.9325 79.5000 1.1977 79.6980 1.1977 79.8000 1.3375 79.9980 1.3375 80.1000 0.9544 80.2980 0.9544 80.4000 0.5883 80.5980 0.5883 80.7000 1.3247 80.8980 1.3247 81.0000 0.5933 81.1980 0.5933 81.3000 1.3739 81.4980 1.3739 81.6000 1.1663 81.7980 1.1663 81.9000 1.3500 82.0980 1.3500 82.2000 0.6807 82.3980 0.6807 82.5000 1.3903 82.6980 1.3903 82.8000 1.3720 82.9980 1.3720 83.1000 1.3636 83.2980 1.3636 83.4000 0.5452 83.5980 0.5452 83.7000 1.3260 83.8980 1.3260 84.0000 1.2891 84.1980 1.2891 84.3000 1.2799 84.4980 1.2799 84.6000 0.6872 84.7980 0.6872 84.9000 0.6020 85.0980 0.6020 85.2000 1.4772 85.3980 1.4772 85.5000 0.9818 85.6980 0.9818 85.8000 0.8978 85.9980 0.8978 86.1000 0.7177 86.2980 0.7177 86.4000 1.5497 86.5980 1.5497 86.7000 0.9032 86.8980 0.9032 87.0000 0.6491 87.1980 0.6491 87.3000 0.9059 87.4980 0.9059 87.6000 1.3139 87.7980 1.3139 87.9000 1.0666 88.0980 1.0666 88.2000 1.4669 88.3980 1.4669 88.5000 1.0274 88.6980 1.0274 88.8000 0.8702 88.9980 0.8702 89.1000 1.1680 89.2980 1.1680 89.4000 0.9272 89.5980 0.9272 89.7000 1.2976 89.8980 1.2976 90.0000 1.2611 90.1980 1.2611 90.3000 1.2131 90.4980 1.2131 90.6000 1.1808 90.7980 1.1808 90.9000 1.1221 91.0980 1.1221 91.2000 1.3576 91.3980 1.3576 91.5000 1.0884 91.6980 1.0884 91.8000 0.9163 91.9980 0.9163 92.1000 1.3159 92.2980 1.3159 92.4000 1.1552 92.5980 1.1552 92.7000 0.9317 92.8980 0.9317 93.0000 0.8998 93.1980 0.8998 93.3000 0.7836 93.4980 0.7836 93.6000 1.0457 93.7980 1.0457 93.9000 0.5887 94.0980 0.5887 94.2000 1.1468 94.3980 1.1468 94.5000 0.9922 94.6980 0.9922 94.8000 1.2583 94.9980 1.2583 95.1000 1.2130 95.2980 1.2130 95.4000 1.1361 95.5980 1.1361 95.7000 1.1791 95.8980 1.1791 96.0000 1.3453 96.1980 1.3453 96.3000 1.1417 96.4980 1.1417 96.6000 0.6065 96.7980 0.6065 96.9000 1.2029 97.0980 1.2029 97.2000 0.7549 97.3980 0.7549 97.5000 1.2676 97.6980 1.2676 97.8000 0.7102 97.9980 0.7102 98.1000 1.2650 98.2980 1.2650 98.4000 0.5963 98.5980 0.5963 98.7000 1.1428 98.8980 1.1428 99.0000 0.8441 99.1980 0.8441 99.3000 1.2201 99.4980 1.2201 99.6000 0.5790 99.7980 0.5790 99.9000 1.2508 100.0980 1.2508 100.2000 0.9231 100.3980 0.9231 100.5000 1.2347 100.6980 1.2347 100.8000 0.9325 100.9980 0.9325 101.1000 1.1977 101.2980 1.1977 101.4000 1.3375 101.5980 1.3375 101.7000 0.9544 101.8980 0.9544 102.0000 0.5883 102.1980 0.5883 102.3000 1.3247 102.4980 1.3247 102.6000 0.5933 102.7980 0.5933 102.9000 1.3739 103.0980 1.3739 103.2000 1.1663 103.3980 1.1663 103.5000 1.3500 103.6980 1.3500 103.8000 0.6807 103.9980 0.6807 104.1000 1.3903 104.2980 1.3903 104.4000 1.3720 104.5980 1.3720 104.7000 1.3636 104.8980 1.3636 105.0000 0.5452 105.1980 0.5452 105.3000 1.3260 105.4980 1.3260 105.6000 1.2891 105.7980 1.2891 105.9000 1.2799 106.0980 1.2799 106.2000 0.6872 106.3980 0.6872 106.5000 0.6020 106.6980 0.6020 106.8000 1.4772 106.9980 1.4772 107.1000 0.9818 107.2980 0.9818 107.4000 0.8978 107.5980 0.8978 107.7000 0.7177 107.8980 0.7177 108.0000 1.5497 108.1980 1.5497 108.3000 0.9032 108.4980 0.9032 108.6000 0.6491 108.7980 0.6491 108.9000 0.9059 109.0980 0.9059 109.2000 1.3139 109.3980 1.3139 109.5000 1.0666 109.6980 1.0666 109.8000 1.4669 109.9980 1.4669 110.1000 1.0274 110.2980 1.0274 110.4000 0.8702 110.5980 0.8702 110.7000 1.1680 110.8980 1.1680 111.0000 0.9272 111.1980 0.9272 111.3000 1.2976 111.4980 1.2976 111.6000 1.2611 111.7980 1.2611 111.9000 1.2131 112.0980 1.2131 112.2000 1.1808 112.3980 1.1808 112.5000 1.1221 112.6980 1.1221 112.8000 1.3576 112.9980 1.3576 113.1000 1.0884 113.2980 1.0884 113.4000 0.9163 113.5980 0.9163 113.7000 1.3159 113.8980 1.3159 114.0000 1.1552 114.1980 1.1552 114.3000 0.9317 114.4980 0.9317 114.6000 0.8998 114.7980 0.8998 114.9000 0.7836 115.0980 0.7836 115.2000 1.0457 115.3980 1.0457 115.5000 0.5887 115.6980 0.5887 115.8000 1.1468 115.9980 1.1468 116.1000 0.9922 116.2980 0.9922 116.4000 1.2583 116.5980 1.2583 116.7000 1.2130 116.8980 1.2130 117.0000 1.1361 117.1980 1.1361 117.3000 1.1791 117.4980 1.1791 117.6000 1.3453 117.7980 1.3453 117.9000 1.1417 118.0980 1.1417 118.2000 0.6065 118.3980 0.6065 118.5000 1.2029 118.6980 1.2029 118.8000 0.7549 118.9980 0.7549 119.1000 1.2676 119.2980 1.2676 119.4000 0.7102 119.5980 0.7102 119.7000 1.2650 119.8980 1.2650 120.0000 0.5963 120.1980 0.5963 120.3000 1.1428 120.4980 1.1428 120.6000 0.8441 120.7980 0.8441 120.9000 1.2201 121.0980 1.2201 121.2000 0.5790 121.3980 0.5790 121.5000 1.2508 121.6980 1.2508 121.8000 0.9231 121.9980 0.9231 122.1000 1.2347 122.2980 1.2347 122.4000 0.9325 122.5980 0.9325 122.7000 1.1977 122.8980 1.1977 123.0000 1.3375 123.1980 1.3375 123.3000 0.9544 123.4980 0.9544 123.6000 0.5883 123.7980 0.5883 123.9000 1.3247 124.0980 1.3247 124.2000 0.5933 124.3980 0.5933 124.5000 1.3739 124.6980 1.3739 124.8000 1.1663 124.9980 1.1663 125.1000 1.3500 125.2980 1.3500 125.4000 0.6807 125.5980 0.6807 125.7000 1.3903 125.8980 1.3903 126.0000 1.3720 126.1980 1.3720 126.3000 1.3636 126.4980 1.3636 126.6000 0.5452 126.7980 0.5452 126.9000 1.3260 127.0980 1.3260 127.2000 1.2891 127.3980 1.2891 127.5000 1.2799 127.6980 1.2799 127.8000 0.6872 127.9980 0.6872 128.1000 0.6020 128.2980 0.6020 128.4000 1.4772 128.5980 1.4772 128.7000 0.9818 128.8980 0.9818 129.0000 0.8978 129.1980 0.8978 129.3000 0.7177 129.4980 0.7177 129.6000 1.5497 129.7980 1.5497 129.9000 0.9032 130.0980 0.9032 130.2000 0.6491 130.3980 0.6491 130.5000 0.9059 130.6980 0.9059 130.8000 1.3139 130.9980 1.3139 131.1000 1.0666 131.2980 1.0666 131.4000 1.4669 131.5980 1.4669 131.7000 1.0274 131.8980 1.0274 132.0000 0.8702 132.1980 0.8702 132.3000 1.1680 132.4980 1.1680 132.6000 0.9272 132.7980 0.9272 132.9000 1.2976 133.0980 1.2976 133.2000 1.2611 133.3980 1.2611 133.5000 1.2131 133.6980 1.2131 133.8000 1.1808 133.9980 1.1808 134.1000 1.1221 134.2980 1.1221 134.4000 1.3576 134.5980 1.3576 134.7000 1.0884 134.8980 1.0884 135.0000 0.9163 135.1980 0.9163 135.3000 1.3159 135.4980 1.3159 135.6000 1.1552 135.7980 1.1552 135.9000 0.9317 136.0980 0.9317 136.2000 0.8998 136.3980 0.8998 136.5000 0.7836 136.6980 0.7836 136.8000 1.0457 136.9980 1.0457 137.1000 0.5887 137.2980 0.5887 137.4000 1.1468 137.5980 1.1468 137.7000 0.9922 137.8980 0.9922 138.0000 1.2583 138.1980 1.2583 138.3000 1.2130 138.4980 1.2130 138.6000 1.1361 138.7980 1.1361 138.9000 1.1791 139.0980 1.1791 139.2000 1.3453 139.3980 1.3453 139.5000 1.1417 139.6980 1.1417 139.8000 0.6065 139.9980 0.6065 140.1000 1.2029 140.2980 1.2029 140.4000 0.7549 140.5980 0.7549 140.7000 1.2676 140.8980 1.2676 141.0000 0.7102 141.1980 0.7102 141.3000 1.2650 141.4980 1.2650 141.6000 0.5963 141.7980 0.5963 141.9000 1.1428 142.0980 1.1428 142.2000 0.8441 142.3980 0.8441 142.5000 1.2201 142.6980 1.2201 142.8000 0.5790 142.9980 0.5790 143.1000 1.2508 143.2980 1.2508 143.4000 0.9231 143.5980 0.9231 143.7000 1.2347 143.8980 1.2347 144.0000 0.9325 144.1980 0.9325 144.3000 1.1977 144.4980 1.1977 144.6000 1.3375 144.7980 1.3375 144.9000 0.9544 145.0980 0.9544 145.2000 0.5883 145.3980 0.5883 145.5000 1.3247 145.6980 1.3247 145.8000 0.5933 145.9980 0.5933 146.1000 1.3739 146.2980 1.3739 146.4000 1.1663 146.5980 1.1663 146.7000 1.3500 146.8980 1.3500 147.0000 0.6807 147.1980 0.6807 147.3000 1.3903 147.4980 1.3903 147.6000 1.3720 147.7980 1.3720 147.9000 1.3636 148.0980 1.3636 148.2000 0.5452 148.3980 0.5452 148.5000 1.3260 148.6980 1.3260 148.8000 1.2891 148.9980 1.2891 149.1000 1.2799 149.2980 1.2799 149.4000 0.6872 149.5980 0.6872 149.7000 0.6020 149.8980 0.6020 150.0000 1.4772 150.1980 1.4772 150.3000 0.9818 150.4980 0.9818 150.6000 0.8978 150.7980 0.8978 150.9000 0.7177 151.0980 0.7177 151.2000 1.5497 151.3980 1.5497 151.5000 0.9032 151.6980 0.9032 151.8000 0.6491 151.9980 0.6491 152.1000 0.9059 152.2980 0.9059 152.4000 1.3139 152.5980 1.3139 152.7000 1.0666 152.8980 1.0666 153.0000 1.4669 153.1980 1.4669 153.3000 1.0274 153.4980 1.0274 153.6000 0.8702 153.7980 0.8702 153.9000 1.1680 154.0980 1.1680 154.2000 0.9272 154.3980 0.9272 154.5000 1.2976 154.6980 1.2976 154.8000 1.2611 154.9980 1.2611 155.1000 1.2131 155.2980 1.2131 155.4000 1.1808 155.5980 1.1808 155.7000 1.1221 155.8980 1.1221 156.0000 1.3576 156.1980 1.3576 156.3000 1.0884 156.4980 1.0884 156.6000 0.9163 156.7980 0.9163 156.9000 1.3159 157.0980 1.3159 157.2000 1.1552 157.3980 1.1552 157.5000 0.9317 157.6980 0.9317 157.8000 0.8998 157.9980 0.8998 158.1000 0.7836 158.2980 0.7836 158.4000 1.0457 158.5980 1.0457 158.7000 0.5887 158.8980 0.5887 159.0000 1.1468 159.1980 1.1468 159.3000 0.9922 159.4980 0.9922 159.6000 1.2583 159.7980 1.2583 159.9000 1.2130 160.0980 1.2130 160.2000 1.1361 160.3980 1.1361 160.5000 1.1791 160.6980 1.1791 160.8000 1.3453 160.9980 1.3453 161.1000 1.1417 161.2980 1.1417 161.4000 0.6065 161.5980 0.6065 161.7000 1.2029 161.8980 1.2029 162.0000 0.7549 162.1980 0.7549 162.3000 1.2676 162.4980 1.2676 162.6000 0.7102 162.7980 0.7102 162.9000 1.2650 163.0980 1.2650 163.2000 0.5963 163.3980 0.5963 163.5000 1.1428 163.6980 1.1428 163.8000 0.8441 163.9980 0.8441 164.1000 1.2201 164.2980 1.2201 164.4000 0.5790 164.5980 0.5790 164.7000 1.2508 164.8980 1.2508 165.0000 0.9231 165.1980 0.9231 165.3000 1.2347 165.4980 1.2347 165.6000 0.9325 165.7980 0.9325 165.9000 1.1977 166.0980 1.1977 166.2000 1.3375 166.3980 1.3375 166.5000 0.9544 166.6980 0.9544 166.8000 0.5883 166.9980 0.5883 167.1000 1.3247 167.2980 1.3247 167.4000 0.5933 167.5980 0.5933 167.7000 1.3739 167.8980 1.3739 168.0000 1.1663 168.1980 1.1663 168.3000 1.3500 168.4980 1.3500 168.6000 0.6807 168.7980 0.6807 168.9000 1.3903 169.0980 1.3903 169.2000 1.3720 169.3980 1.3720 169.5000 1.3636 169.6980 1.3636 169.8000 0.5452 169.9980 0.5452 170.1000 1.3260 170.2980 1.3260 170.4000 1.2891 170.5980 1.2891 170.7000 1.2799 170.8980 1.2799 171.0000 0.6872 171.1980 0.6872 171.3000 0.6020 171.4980 0.6020 171.6000 1.4772 171.7980 1.4772 171.9000 0.9818 172.0980 0.9818 172.2000 0.8978 172.3980 0.8978 172.5000 0.7177 172.6980 0.7177 172.8000 1.5497 172.9980 1.5497 173.1000 0.9032 173.2980 0.9032 173.4000 0.6491 173.5980 0.6491 173.7000 0.9059 173.8980 0.9059 174.0000 1.3139 174.1980 1.3139 174.3000 1.0666 174.4980 1.0666 174.6000 1.4669 174.7980 1.4669 174.9000 1.0274 175.0980 1.0274 175.2000 0.8702 175.3980 0.8702 175.5000 1.1680 175.6980 1.1680 175.8000 0.9272 175.9980 0.9272 176.1000 1.2976 176.2980 1.2976 176.4000 1.2611 176.5980 1.2611 176.7000 1.2131 176.8980 1.2131 177.0000 1.1808 177.1980 1.1808 177.3000 1.1221 177.4980 1.1221 177.6000 1.3576 177.7980 1.3576 177.9000 1.0884 178.0980 1.0884 178.2000 0.9163 178.3980 0.9163 178.5000 1.3159 178.6980 1.3159 178.8000 1.1552 178.9980 1.1552 179.1000 0.9317 179.2980 0.9317 179.4000 0.8998 179.5980 0.8998 179.7000 0.7836 179.8980 0.7836 180.0000 1.0457 180.1980 1.0457 180.3000 0.5887 180.4980 0.5887 180.6000 1.1468 180.7980 1.1468 180.9000 0.9922 181.0980 0.9922 181.2000 1.2583 181.3980 1.2583 181.5000 1.2130 181.6980 1.2130 181.8000 1.1361 181.9980 1.1361 182.1000 1.1791 182.2980 1.1791 182.4000 1.3453 182.5980 1.3453 182.7000 1.1417 182.8980 1.1417 183.0000 0.6065 183.1980 0.6065 183.3000 1.2029 183.4980 1.2029 183.6000 0.7549 183.7980 0.7549 183.9000 1.2676 184.0980 1.2676 184.2000 0.7102 184.3980 0.7102 184.5000 1.2650 184.6980 1.2650 184.8000 0.5963 184.9980 0.5963 185.1000 1.1428 185.2980 1.1428 185.4000 0.8441 185.5980 0.8441 185.7000 1.2201 185.8980 1.2201 186.0000 0.5790 186.1980 0.5790 186.3000 1.2508 186.4980 1.2508 186.6000 0.9231 186.7980 0.9231 186.9000 1.2347 187.0980 1.2347 187.2000 0.9325 187.3980 0.9325 187.5000 1.1977 187.6980 1.1977 187.8000 1.3375 187.9980 1.3375 188.1000 0.9544 188.2980 0.9544 188.4000 0.5883 188.5980 0.5883 188.7000 1.3247 188.8980 1.3247 189.0000 0.5933 189.1980 0.5933 189.3000 1.3739 189.4980 1.3739 189.6000 1.1663 189.7980 1.1663 189.9000 1.3500 190.0980 1.3500 190.2000 0.6807 190.3980 0.6807 190.5000 1.3903 190.6980 1.3903 190.8000 1.3720 190.9980 1.3720 191.1000 1.3636 191.2980 1.3636 191.4000 0.5452 191.5980 0.5452 191.7000 1.3260 191.8980 1.3260 192.0000 1.2891 192.1980 1.2891 192.3000 1.2799 192.4980 1.2799 192.6000 0.6872 192.7980 0.6872 192.9000 0.6020 193.0980 0.6020 193.2000 1.4772 193.3980 1.4772 193.5000 0.9818 193.6980 0.9818 193.8000 0.8978 193.9980 0.8978 194.1000 0.7177 194.2980 0.7177 194.4000 1.5497 194.5980 1.5497 194.7000 0.9032 194.8980 0.9032 195.0000 0.6491 195.1980 0.6491 195.3000 0.9059 195.4980 0.9059 195.6000 1.3139 195.7980 1.3139 195.9000 1.0666 196.0980 1.0666 196.2000 1.4669 196.3980 1.4669 196.5000 1.0274 196.6980 1.0274 196.8000 0.8702 196.9980 0.8702 197.1000 1.1680 197.2980 1.1680 197.4000 0.9272 197.5980 0.9272 197.7000 1.2976 197.8980 1.2976 198.0000 1.2611 198.1980 1.2611 198.3000 1.2131 198.4980 1.2131 198.6000 1.1808 198.7980 1.1808 198.9000 1.1221 199.0980 1.1221 199.2000 1.3576 199.3980 1.3576 199.5000 1.0884 199.6980 1.0884 199.8000 0.9163 199.9980 0.9163 200.1000 1.3159 200.2980 1.3159 200.4000 1.1552 200.5980 1.1552 200.7000 0.9317 200.8980 0.9317 201.0000 0.8998 201.1980 0.8998 201.3000 0.7836 201.4980 0.7836 201.6000 1.0457 201.7980 1.0457 201.9000 0.5887 202.0980 0.5887 202.2000 1.1468 202.3980 1.1468 202.5000 0.9922 202.6980 0.9922 202.8000 1.2583 202.9980 1.2583 203.1000 1.2130 203.2980 1.2130 203.4000 1.1361 203.5980 1.1361 203.7000 1.1791 203.8980 1.1791 204.0000 1.3453 204.1980 1.3453 204.3000 1.1417 204.4980 1.1417 204.6000 0.6065 204.7980 0.6065 204.9000 1.2029 205.0980 1.2029 205.2000 0.7549 205.3980 0.7549 205.5000 1.2676 205.6980 1.2676 205.8000 0.7102 205.9980 0.7102 206.1000 1.2650 206.2980 1.2650 206.4000 0.5963 206.5980 0.5963 206.7000 1.1428 206.8980 1.1428 207.0000 0.8441 207.1980 0.8441 207.3000 1.2201 207.4980 1.2201 207.6000 0.5790 207.7980 0.5790 207.9000 1.2508 208.0980 1.2508 208.2000 0.9231 208.3980 0.9231 208.5000 1.2347 208.6980 1.2347 208.8000 0.9325 208.9980 0.9325 209.1000 1.1977 209.2980 1.1977 209.4000 1.3375 209.5980 1.3375 209.7000 0.9544 209.8980 0.9544 210.0000 0.5883 210.1980 0.5883 210.3000 1.3247 210.4980 1.3247 210.6000 0.5933 210.7980 0.5933 210.9000 1.3739 211.0980 1.3739 211.2000 1.1663 211.3980 1.1663 211.5000 1.3500 211.6980 1.3500 211.8000 0.6807 211.9980 0.6807 212.1000 1.3903 212.2980 1.3903 212.4000 1.3720 212.5980 1.3720 212.7000 1.3636 212.8980 1.3636 213.0000 0.5452 213.1980 0.5452 213.3000 1.3260 213.4980 1.3260 213.6000 1.2891 213.7980 1.2891 213.9000 1.2799 214.0980 1.2799 214.2000 0.6872 214.3980 0.6872 214.5000 0.6020 214.6980 0.6020 214.8000 1.4772 214.9980 1.4772 215.1000 0.9818 215.2980 0.9818 215.4000 0.8978 215.5980 0.8978 215.7000 0.7177 215.8980 0.7177 216.0000 1.5497 216.1980 1.5497 216.3000 0.9032 216.4980 0.9032 216.6000 0.6491 216.7980 0.6491 216.9000 0.9059 217.0980 0.9059 217.2000 1.3139 217.3980 1.3139 217.5000 1.0666 217.6980 1.0666 217.8000 1.4669 217.9980 1.4669 218.1000 1.0274 218.2980 1.0274 218.4000 0.8702 218.5980 0.8702 218.7000 1.1680 218.8980 1.1680 219.0000 0.9272 219.1980 0.9272 219.3000 1.2976 219.4980 1.2976 219.6000 1.2611 219.7980 1.2611 219.9000 1.2131 220.0980 1.2131 220.2000 1.1808 220.3980 1.1808 220.5000 1.1221 220.6980 1.1221 220.8000 1.3576 220.9980 1.3576 221.1000 1.0884 221.2980 1.0884 221.4000 0.9163 221.5980 0.9163 221.7000 1.3159 221.8980 1.3159 222.0000 1.1552 222.1980 1.1552 222.3000 0.9317 222.4980 0.9317 222.6000 0.8998 222.7980 0.8998 222.9000 0.7836 223.0980 0.7836 223.2000 1.0457 223.3980 1.0457 223.5000 0.5887 223.6980 0.5887 223.8000 1.1468 223.9980 1.1468 224.1000 0.9922 224.2980 0.9922 224.4000 1.2583 224.5980 1.2583 224.7000 1.2130 224.8980 1.2130 225.0000 1.1361 225.1980 1.1361 225.3000 1.1791 225.4980 1.1791 225.6000 1.3453 225.7980 1.3453 225.9000 1.1417 226.0980 1.1417 226.2000 0.6065 226.3980 0.6065 226.5000 1.2029 226.6980 1.2029 226.8000 0.7549 226.9980 0.7549 227.1000 1.2676 227.2980 1.2676 227.4000 0.7102 227.5980 0.7102 227.7000 1.2650 227.8980 1.2650 228.0000 0.5963 228.1980 0.5963 228.3000 1.1428 228.4980 1.1428 228.6000 0.8441 228.7980 0.8441 228.9000 1.2201 229.0980 1.2201 229.2000 0.5790 229.3980 0.5790 229.5000 1.2508 229.6980 1.2508 229.8000 0.9231 229.9980 0.9231 230.1000 1.2347 230.2980 1.2347 230.4000 0.9325 230.5980 0.9325 230.7000 1.1977 230.8980 1.1977 231.0000 1.3375 231.1980 1.3375 231.3000 0.9544 231.4980 0.9544 231.6000 0.5883 231.7980 0.5883 231.9000 1.3247 232.0980 1.3247 232.2000 0.5933 232.3980 0.5933 232.5000 1.3739 232.6980 1.3739 232.8000 1.1663 232.9980 1.1663 233.1000 1.3500 233.2980 1.3500 233.4000 0.6807 233.5980 0.6807 233.7000 1.3903 233.8980 1.3903 234.0000 1.3720 234.1980 1.3720 234.3000 1.3636 234.4980 1.3636 234.6000 0.5452 234.7980 0.5452 234.9000 1.3260 235.0980 1.3260 235.2000 1.2891 235.3980 1.2891 235.5000 1.2799 235.6980 1.2799 235.8000 0.6872 235.9980 0.6872 236.1000 0.6020 236.2980 0.6020 236.4000 1.4772 236.5980 1.4772 236.7000 0.9818 236.8980 0.9818 237.0000 0.8978 237.1980 0.8978 237.3000 0.7177 237.4980 0.7177 237.6000 1.5497 237.7980 1.5497 237.9000 0.9032 238.0980 0.9032 238.2000 0.6491 238.3980 0.6491 238.5000 0.9059 238.6980 0.9059 238.8000 1.3139 238.9980 1.3139 239.1000 1.0666 239.2980 1.0666 239.4000 1.4669 239.5980 1.4669 239.7000 1.0274 239.8980 1.0274 240.0000 0.8702 240.1980 0.8702 240.3000 1.1680 240.4980 1.1680 240.6000 0.9272 240.7980 0.9272 240.9000 1.2976 241.0980 1.2976 241.2000 1.2611 241.3980 1.2611 241.5000 1.2131 241.6980 1.2131 241.8000 1.1808 241.9980 1.1808 242.1000 1.1221 242.2980 1.1221 242.4000 1.3576 242.5980 1.3576 242.7000 1.0884 242.8980 1.0884 243.0000 0.9163 243.1980 0.9163 243.3000 1.3159 243.4980 1.3159 243.6000 1.1552 243.7980 1.1552 243.9000 0.9317 244.0980 0.9317 244.2000 0.8998 244.3980 0.8998 244.5000 0.7836 244.6980 0.7836 244.8000 1.0457 244.9980 1.0457 245.1000 0.5887 245.2980 0.5887 245.4000 1.1468 245.5980 1.1468 245.7000 0.9922 245.8980 0.9922 246.0000 1.2583 246.1980 1.2583 246.3000 1.2130 246.4980 1.2130 246.6000 1.1361 246.7980 1.1361 246.9000 1.1791 247.0980 1.1791 247.2000 1.3453 247.3980 1.3453 247.5000 1.1417 247.6980 1.1417 247.8000 0.6065 247.9980 0.6065 248.1000 1.2029 248.2980 1.2029 248.4000 0.7549 248.5980 0.7549 248.7000 1.2676 248.8980 1.2676 249.0000 0.7102 249.1980 0.7102 249.3000 1.2650 249.4980 1.2650 249.6000 0.5963 249.7980 0.5963 249.9000 1.1428 250.0980 1.1428 250.2000 0.8441 250.3980 0.8441 250.5000 1.2201 250.6980 1.2201 250.8000 0.5790 250.9980 0.5790 251.1000 1.2508 251.2980 1.2508 251.4000 0.9231 251.5980 0.9231 251.7000 1.2347 251.8980 1.2347 252.0000 0.9325 252.1980 0.9325 252.3000 1.1977 252.4980 1.1977 252.6000 1.3375 252.7980 1.3375 252.9000 0.9544 253.0980 0.9544 253.2000 0.5883 253.3980 0.5883 253.5000 1.3247 253.6980 1.3247 253.8000 0.5933 253.9980 0.5933 254.1000 1.3739 254.2980 1.3739 254.4000 1.1663 254.5980 1.1663 254.7000 1.3500 254.8980 1.3500 255.0000 0.6807 255.1980 0.6807 255.3000 1.3903 255.4980 1.3903 255.6000 1.3720 255.7980 1.3720 255.9000 1.3636 256.0980 1.3636 256.2000 0.5452 256.3980 0.5452 256.5000 1.3260 256.6980 1.3260 256.8000 1.2891 256.9980 1.2891 257.1000 1.2799 257.2980 1.2799 257.4000 0.6872 257.5980 0.6872 257.7000 0.6020 257.8980 0.6020 258.0000 1.4772 258.1980 1.4772 258.3000 0.9818 258.4980 0.9818 258.6000 0.8978 258.7980 0.8978 258.9000 0.7177 259.0980 0.7177 259.2000 1.5497 259.3980 1.5497 259.5000 0.9032 259.6980 0.9032 259.8000 0.6491 259.9980 0.6491 260.1000 0.9059 260.2980 0.9059 260.4000 1.3139 260.5980 1.3139 260.7000 1.0666 260.8980 1.0666 261.0000 1.4669 261.1980 1.4669 261.3000 1.0274 261.4980 1.0274 261.6000 0.8702 261.7980 0.8702 261.9000 1.1680 262.0980 1.1680 262.2000 0.9272 262.3980 0.9272 262.5000 1.2976 262.6980 1.2976 262.8000 1.2611 262.9980 1.2611 263.1000 1.2131 263.2980 1.2131 263.4000 1.1808 263.5980 1.1808 263.7000 1.1221 263.8980 1.1221 264.0000 1.3576 264.1980 1.3576 264.3000 1.0884 264.4980 1.0884 264.6000 0.9163 264.7980 0.9163 264.9000 1.3159 265.0980 1.3159 265.2000 1.1552 265.3980 1.1552 265.5000 0.9317 265.6980 0.9317 265.8000 0.8998 265.9980 0.8998 266.1000 0.7836 266.2980 0.7836 266.4000 1.0457 266.5980 1.0457 266.7000 0.5887 266.8980 0.5887 267.0000 1.1468 267.1980 1.1468 267.3000 0.9922 267.4980 0.9922 267.6000 1.2583 267.7980 1.2583 267.9000 1.2130 268.0980 1.2130 268.2000 1.1361 268.3980 1.1361 268.5000 1.1791 268.6980 1.1791 268.8000 1.3453 268.9980 1.3453 269.1000 1.1417 269.2980 1.1417 269.4000 0.6065 269.5980 0.6065 269.7000 1.2029 269.8980 1.2029 270.0000 0.7549 270.1980 0.7549 270.3000 1.2676 270.4980 1.2676 270.6000 0.7102 270.7980 0.7102 270.9000 1.2650 271.0980 1.2650 271.2000 0.5963 271.3980 0.5963 271.5000 1.1428 271.6980 1.1428 271.8000 0.8441 271.9980 0.8441 272.1000 1.2201 272.2980 1.2201 272.4000 0.5790 272.5980 0.5790 272.7000 1.2508 272.8980 1.2508 273.0000 0.9231 273.1980 0.9231 273.3000 1.2347 273.4980 1.2347 273.6000 0.9325 273.7980 0.9325 273.9000 1.1977 274.0980 1.1977 274.2000 1.3375 274.3980 1.3375 274.5000 0.9544 274.6980 0.9544 274.8000 0.5883 274.9980 0.5883 275.1000 1.3247 275.2980 1.3247 275.4000 0.5933 275.5980 0.5933 275.7000 1.3739 275.8980 1.3739 276.0000 1.1663 276.1980 1.1663 276.3000 1.3500 276.4980 1.3500 276.6000 0.6807 276.7980 0.6807 276.9000 1.3903 277.0980 1.3903 277.2000 1.3720 277.3980 1.3720 277.5000 1.3636 277.6980 1.3636 277.8000 0.5452 277.9980 0.5452 278.1000 1.3260 278.2980 1.3260 278.4000 1.2891 278.5980 1.2891 278.7000 1.2799 278.8980 1.2799 279.0000 0.6872 279.1980 0.6872 279.3000 0.6020 279.4980 0.6020 279.6000 1.4772 279.7980 1.4772 279.9000 0.9818 280.0980 0.9818 280.2000 0.8978 280.3980 0.8978 280.5000 0.7177 280.6980 0.7177 280.8000 1.5497 280.9980 1.5497 281.1000 0.9032 281.2980 0.9032 281.4000 0.6491 281.5980 0.6491 281.7000 0.9059 281.8980 0.9059 282.0000 1.3139 282.1980 1.3139 282.3000 1.0666 282.4980 1.0666 282.6000 1.4669 282.7980 1.4669 282.9000 1.0274 283.0980 1.0274 283.2000 0.8702 283.3980 0.8702 283.5000 1.1680 283.6980 1.1680 283.8000 0.9272 283.9980 0.9272 284.1000 1.2976 284.2980 1.2976 284.4000 1.2611 284.5980 1.2611 284.7000 1.2131 284.8980 1.2131 285.0000 1.1808 285.1980 1.1808 285.3000 1.1221 285.4980 1.1221 285.6000 1.3576 285.7980 1.3576 285.9000 1.0884 286.0980 1.0884 286.2000 0.9163 286.3980 0.9163 286.5000 1.3159 286.6980 1.3159 286.8000 1.1552 286.9980 1.1552 287.1000 0.9317 287.2980 0.9317 287.4000 0.8998 287.5980 0.8998 287.7000 0.7836 287.8980 0.7836 288.0000 1.0457 288.1980 1.0457 288.3000 0.5887 288.4980 0.5887 288.6000 1.1468 288.7980 1.1468 288.9000 0.9922 289.0980 0.9922 289.2000 1.2583 289.3980 1.2583 289.5000 1.2130 289.6980 1.2130 289.8000 1.1361 289.9980 1.1361 290.1000 1.1791 290.2980 1.1791 290.4000 1.3453 290.5980 1.3453 290.7000 1.1417 290.8980 1.1417 291.0000 0.6065 291.1980 0.6065 291.3000 1.2029 291.4980 1.2029 291.6000 0.7549 291.7980 0.7549 291.9000 1.2676 292.0980 1.2676 292.2000 0.7102 292.3980 0.7102 292.5000 1.2650 292.6980 1.2650 292.8000 0.5963 292.9980 0.5963 293.1000 1.1428 293.2980 1.1428 293.4000 0.8441 293.5980 0.8441 293.7000 1.2201 293.8980 1.2201 294.0000 0.5790 294.1980 0.5790 294.3000 1.2508 294.4980 1.2508 294.6000 0.9231 294.7980 0.9231 294.9000 1.2347 295.0980 1.2347 295.2000 0.9325 295.3980 0.9325 295.5000 1.1977 295.6980 1.1977 295.8000 1.3375 295.9980 1.3375 296.1000 0.9544 296.2980 0.9544 296.4000 0.5883 296.5980 0.5883 296.7000 1.3247 296.8980 1.3247 297.0000 0.5933 297.1980 0.5933 297.3000 1.3739 297.4980 1.3739 297.6000 1.1663 297.7980 1.1663 297.9000 1.3500 298.0980 1.3500 298.2000 0.6807 298.3980 0.6807 298.5000 1.3903 298.6980 1.3903 298.8000 1.3720 298.9980 1.3720 299.1000 1.3636 299.2980 1.3636 299.4000 0.5452 299.5980 0.5452 299.7000 1.3260 299.8980 1.3260 300.0000 1.2891 300.1980 1.2891 300.3000 1.2799 300.4980 1.2799 300.6000 0.6872 300.7980 0.6872 300.9000 0.6020 301.0980 0.6020 301.2000 1.4772 301.3980 1.4772 301.5000 0.9818 301.6980 0.9818 301.8000 0.8978 301.9980 0.8978 302.1000 0.7177 302.2980 0.7177 302.4000 1.5497 302.5980 1.5497 302.7000 0.9032 302.8980 0.9032 303.0000 0.6491 303.1980 0.6491 303.3000 0.9059 303.4980 0.9059 303.6000 1.3139 303.7980 1.3139 303.9000 1.0666 304.0980 1.0666 304.2000 1.4669 304.3980 1.4669 304.5000 1.0274 304.6980 1.0274 304.8000 0.8702 304.9980 0.8702 305.1000 1.1680 305.2980 1.1680 305.4000 0.9272 305.5980 0.9272 305.7000 1.2976 305.8980 1.2976 306.0000 1.2611 306.1980 1.2611 306.3000 1.2131 306.4980 1.2131 306.6000 1.1808 306.7980 1.1808 306.9000 1.1221 307.0980 1.1221 307.2000 1.3576 307.3980 1.3576 307.5000 1.0884 307.6980 1.0884 307.8000 0.9163 307.9980 0.9163 308.1000 1.3159 308.2980 1.3159 308.4000 1.1552 308.5980 1.1552 308.7000 0.9317 308.8980 0.9317 309.0000 0.8998 309.1980 0.8998 309.3000 0.7836 309.4980 0.7836 309.6000 1.0457 309.7980 1.0457 309.9000 0.5887 310.0980 0.5887 310.2000 1.1468 310.3980 1.1468 310.5000 0.9922 310.6980 0.9922 310.8000 1.2583 310.9980 1.2583 311.1000 1.2130 311.2980 1.2130 311.4000 1.1361 311.5980 1.1361 311.7000 1.1791 311.8980 1.1791 312.0000 1.3453 312.1980 1.3453 312.3000 1.1417 312.4980 1.1417 312.6000 0.6065 312.7980 0.6065 312.9000 1.2029 313.0980 1.2029 313.2000 0.7549 313.3980 0.7549 313.5000 1.2676 313.6980 1.2676 313.8000 0.7102 313.9980 0.7102 314.1000 1.2650 314.2980 1.2650 314.4000 0.5963 314.5980 0.5963 314.7000 1.1428 314.8980 1.1428 315.0000 0.8441 315.1980 0.8441 315.3000 1.2201 315.4980 1.2201 315.6000 0.5790 315.7980 0.5790 315.9000 1.2508 316.0980 1.2508 316.2000 0.9231 316.3980 0.9231 316.5000 1.2347 316.6980 1.2347 316.8000 0.9325 316.9980 0.9325 317.1000 1.1977 317.2980 1.1977 317.4000 1.3375 317.5980 1.3375 317.7000 0.9544 317.8980 0.9544 318.0000 0.5883 318.1980 0.5883 318.3000 1.3247 318.4980 1.3247 318.6000 0.5933 318.7980 0.5933 318.9000 1.3739 319.0980 1.3739 319.2000 1.1663 319.3980 1.1663 319.5000 1.3500 319.6980 1.3500 319.8000 0.6807 319.9980 0.6807 320.1000 1.3903 320.2980 1.3903 320.4000 1.3720 320.5980 1.3720 320.7000 1.3636 320.8980 1.3636 321.0000 0.5452 321.1980 0.5452 321.3000 1.3260 321.4980 1.3260 321.6000 1.2891 321.7980 1.2891 321.9000 1.2799 322.0980 1.2799 322.2000 0.6872 322.3980 0.6872 322.5000 0.6020 322.6980 0.6020 322.8000 1.4772 322.9980 1.4772 323.1000 0.9818 323.2980 0.9818 323.4000 0.8978 323.5980 0.8978 323.7000 0.7177 323.8980 0.7177 324.0000 1.5497 324.1980 1.5497 324.3000 0.9032 324.4980 0.9032 324.6000 0.6491 324.7980 0.6491 324.9000 0.9059 325.0980 0.9059 325.2000 1.3139 325.3980 1.3139 325.5000 1.0666 325.6980 1.0666 325.8000 1.4669 325.9980 1.4669 326.1000 1.0274 326.2980 1.0274 326.4000 0.8702 326.5980 0.8702 326.7000 1.1680 326.8980 1.1680 327.0000 0.9272 327.1980 0.9272 327.3000 1.2976 327.4980 1.2976 327.6000 1.2611 327.7980 1.2611 327.9000 1.2131 328.0980 1.2131 328.2000 1.1808 328.3980 1.1808 328.5000 1.1221 328.6980 1.1221 328.8000 1.3576 328.9980 1.3576 329.1000 1.0884 329.2980 1.0884 329.4000 0.9163 329.5980 0.9163 329.7000 1.3159 329.8980 1.3159 330.0000 1.1552 330.1980 1.1552 330.3000 0.9317 330.4980 0.9317 330.6000 0.8998 330.7980 0.8998 330.9000 0.7836 331.0980 0.7836 331.2000 1.0457 331.3980 1.0457 331.5000 0.5887 331.6980 0.5887 331.8000 1.1468 331.9980 1.1468 332.1000 0.9922 332.2980 0.9922 332.4000 1.2583 332.5980 1.2583 332.7000 1.2130 332.8980 1.2130 333.0000 1.1361 333.1980 1.1361 333.3000 1.1791 333.4980 1.1791 333.6000 1.3453 333.7980 1.3453 333.9000 1.1417 334.0980 1.1417 334.2000 0.6065 334.3980 0.6065 334.5000 1.2029 334.6980 1.2029 334.8000 0.7549 334.9980 0.7549 335.1000 1.2676 335.2980 1.2676 335.4000 0.7102 335.5980 0.7102 335.7000 1.2650 335.8980 1.2650 336.0000 0.5963 336.1980 0.5963 336.3000 1.1428 336.4980 1.1428 336.6000 0.8441 336.7980 0.8441 336.9000 1.2201 337.0980 1.2201 337.2000 0.5790 337.3980 0.5790 337.5000 1.2508 337.6980 1.2508 337.8000 0.9231 337.9980 0.9231 338.1000 1.2347 338.2980 1.2347 338.4000 0.9325 338.5980 0.9325 338.7000 1.1977 338.8980 1.1977 339.0000 1.3375 339.1980 1.3375 339.3000 0.9544 339.4980 0.9544 339.6000 0.5883 339.7980 0.5883 339.9000 1.3247 340.0980 1.3247 340.2000 0.5933 340.3980 0.5933 340.5000 1.3739 340.6980 1.3739 340.8000 1.1663 340.9980 1.1663 341.1000 1.3500 341.2980 1.3500 341.4000 0.6807 341.5980 0.6807 341.7000 1.3903 341.8980 1.3903 342.0000 1.3720 342.1980 1.3720 342.3000 1.3636 342.4980 1.3636 342.6000 0.5452 342.7980 0.5452 342.9000 1.3260 343.0980 1.3260 343.2000 1.2891 343.3980 1.2891 343.5000 1.2799 343.6980 1.2799 343.8000 0.6872 343.9980 0.6872 344.1000 0.6020 344.2980 0.6020 344.4000 1.4772 344.5980 1.4772 344.7000 0.9818 344.8980 0.9818 345.0000 0.8978 345.1980 0.8978 345.3000 0.7177 345.4980 0.7177 345.6000 1.5497 345.7980 1.5497 345.9000 0.9032 346.0980 0.9032 346.2000 0.6491 346.3980 0.6491 346.5000 0.9059 346.6980 0.9059 346.8000 1.3139 346.9980 1.3139 347.1000 1.0666 347.2980 1.0666 347.4000 1.4669 347.5980 1.4669 347.7000 1.0274 347.8980 1.0274 348.0000 0.8702 348.1980 0.8702 348.3000 1.1680 348.4980 1.1680 348.6000 0.9272 348.7980 0.9272 348.9000 1.2976 349.0980 1.2976 349.2000 1.2611 349.3980 1.2611 349.5000 1.2131 349.6980 1.2131 349.8000 1.1808 349.9980 1.1808 350.1000 1.1221 350.2980 1.1221 350.4000 1.3576 350.5980 1.3576 350.7000 1.0884 350.8980 1.0884 351.0000 0.9163 351.1980 0.9163 351.3000 1.3159 351.4980 1.3159 351.6000 1.1552 351.7980 1.1552 351.9000 0.9317 352.0980 0.9317 352.2000 0.8998 352.3980 0.8998 352.5000 0.7836 352.6980 0.7836 352.8000 1.0457 352.9980 1.0457 353.1000 0.5887 353.2980 0.5887 353.4000 1.1468 353.5980 1.1468 353.7000 0.9922 353.8980 0.9922 354.0000 1.2583 354.1980 1.2583 354.3000 1.2130 354.4980 1.2130 354.6000 1.1361 354.7980 1.1361 354.9000 1.1791 355.0980 1.1791 355.2000 1.3453 355.3980 1.3453 355.5000 1.1417 355.6980 1.1417 355.8000 0.6065 355.9980 0.6065 356.1000 1.2029 356.2980 1.2029 356.4000 0.7549 356.5980 0.7549 356.7000 1.2676 356.8980 1.2676 357.0000 0.7102 357.1980 0.7102 357.3000 1.2650 357.4980 1.2650 357.6000 0.5963 357.7980 0.5963 357.9000 1.1428 358.0980 1.1428 358.2000 0.8441 358.3980 0.8441 358.5000 1.2201 358.6980 1.2201 358.8000 0.5790 358.9980 0.5790 359.1000 1.2508 359.2980 1.2508 359.4000 0.9231 359.5980 0.9231 359.7000 1.2347 359.8980 1.2347 360.0000 0.9325 360.1980 0.9325 360.3000 1.1977 360.4980 1.1977 360.6000 1.3375 360.7980 1.3375 360.9000 0.9544 361.0980 0.9544 361.2000 0.5883 361.3980 0.5883 361.5000 1.3247 361.6980 1.3247 361.8000 0.5933 361.9980 0.5933 362.1000 1.3739 362.2980 1.3739 362.4000 1.1663 362.5980 1.1663 362.7000 1.3500 362.8980 1.3500 363.0000 0.6807 363.1980 0.6807 363.3000 1.3903 363.4980 1.3903 363.6000 1.3720 363.7980 1.3720 363.9000 1.3636 364.0980 1.3636 364.2000 0.5452 364.3980 0.5452 364.5000 1.3260 364.6980 1.3260 364.8000 1.2891 364.9980 1.2891 365.1000 1.2799 365.2980 1.2799 365.4000 0.6872 365.5980 0.6872 365.7000 0.6020 365.8980 0.6020 366.0000 1.4772 366.1980 1.4772 366.3000 0.9818 366.4980 0.9818 366.6000 0.8978 366.7980 0.8978 366.9000 0.7177 367.0980 0.7177 367.2000 1.5497 367.3980 1.5497 367.5000 0.9032 367.6980 0.9032 367.8000 0.6491 367.9980 0.6491 368.1000 0.9059 368.2980 0.9059 368.4000 1.3139 368.5980 1.3139 368.7000 1.0666 368.8980 1.0666 369.0000 1.4669 369.1980 1.4669 369.3000 1.0274 369.4980 1.0274 369.6000 0.8702 369.7980 0.8702 369.9000 1.1680 370.0980 1.1680 370.2000 0.9272 370.3980 0.9272 370.5000 1.2976 370.6980 1.2976 370.8000 1.2611 370.9980 1.2611 371.1000 1.2131 371.2980 1.2131 371.4000 1.1808 371.5980 1.1808 371.7000 1.1221 371.8980 1.1221 372.0000 1.3576 372.1980 1.3576 372.3000 1.0884 372.4980 1.0884 372.6000 0.9163 372.7980 0.9163 372.9000 1.3159 373.0980 1.3159 373.2000 1.1552 373.3980 1.1552 373.5000 0.9317 373.6980 0.9317 373.8000 0.8998 373.9980 0.8998 374.1000 0.7836 374.2980 0.7836 374.4000 1.0457 374.5980 1.0457 374.7000 0.5887 374.8980 0.5887 375.0000 1.1468 375.1980 1.1468 375.3000 0.9922 375.4980 0.9922 375.6000 1.2583 375.7980 1.2583 375.9000 1.2130 376.0980 1.2130 376.2000 1.1361 376.3980 1.1361 376.5000 1.1791 376.6980 1.1791 376.8000 1.3453 376.9980 1.3453 377.1000 1.1417 377.2980 1.1417 377.4000 0.6065 377.5980 0.6065 377.7000 1.2029 377.8980 1.2029 378.0000 0.7549 378.1980 0.7549 378.3000 1.2676 378.4980 1.2676 378.6000 0.7102 378.7980 0.7102 378.9000 1.2650 379.0980 1.2650 379.2000 0.5963 379.3980 0.5963 379.5000 1.1428 379.6980 1.1428 379.8000 0.8441 379.9980 0.8441 380.1000 1.2201 380.2980 1.2201 380.4000 0.5790 380.5980 0.5790 380.7000 1.2508 380.8980 1.2508 381.0000 0.9231 381.1980 0.9231 381.3000 1.2347 381.4980 1.2347 381.6000 0.9325 381.7980 0.9325 381.9000 1.1977 382.0980 1.1977 382.2000 1.3375 382.3980 1.3375 382.5000 0.9544 382.6980 0.9544 382.8000 0.5883 382.9980 0.5883 383.1000 1.3247 383.2980 1.3247 383.4000 0.5933 383.5980 0.5933 383.7000 1.3739 383.8980 1.3739 384.0000 1.1663 384.1980 1.1663 384.3000 1.3500 384.4980 1.3500 384.6000 0.6807 384.7980 0.6807 384.9000 1.3903 385.0980 1.3903 385.2000 1.3720 385.3980 1.3720 385.5000 1.3636 385.6980 1.3636 385.8000 0.5452 385.9980 0.5452 386.1000 1.3260 386.2980 1.3260 386.4000 1.2891 386.5980 1.2891 386.7000 1.2799 386.8980 1.2799 387.0000 0.6872 387.1980 0.6872 387.3000 0.6020 387.4980 0.6020 387.6000 1.4772 387.7980 1.4772 387.9000 0.9818 388.0980 0.9818 388.2000 0.8978 388.3980 0.8978 388.5000 0.7177 388.6980 0.7177 388.8000 1.5497 388.9980 1.5497 389.1000 0.9032 389.2980 0.9032 389.4000 0.6491 389.5980 0.6491 389.7000 0.9059 389.8980 0.9059 390.0000 1.3139 390.1980 1.3139 390.3000 1.0666 390.4980 1.0666 390.6000 1.4669 390.7980 1.4669 390.9000 1.0274 391.0980 1.0274 391.2000 0.8702 391.3980 0.8702 391.5000 1.1680 391.6980 1.1680 391.8000 0.9272 391.9980 0.9272 392.1000 1.2976 392.2980 1.2976 392.4000 1.2611 392.5980 1.2611 392.7000 1.2131 392.8980 1.2131 393.0000 1.1808 393.1980 1.1808 393.3000 1.1221 393.4980 1.1221 393.6000 1.3576 393.7980 1.3576 393.9000 1.0884 394.0980 1.0884 394.2000 0.9163 394.3980 0.9163 394.5000 1.3159 394.6980 1.3159 394.8000 1.1552 394.9980 1.1552 395.1000 0.9317 395.2980 0.9317 395.4000 0.8998 395.5980 0.8998 395.7000 0.7836 395.8980 0.7836 396.0000 1.0457 396.1980 1.0457 396.3000 0.5887 396.4980 0.5887 396.6000 1.1468 396.7980 1.1468 396.9000 0.9922 397.0980 0.9922 397.2000 1.2583 397.3980 1.2583 397.5000 1.2130 397.6980 1.2130 397.8000 1.1361 397.9980 1.1361 398.1000 1.1791 398.2980 1.1791 398.4000 1.3453 398.5980 1.3453 398.7000 1.1417 398.8980 1.1417 399.0000 0.6065 399.1980 0.6065 399.3000 1.2029 399.4980 1.2029 399.6000 0.7549 399.7980 0.7549 399.9000 1.2676 400.0980 1.2676 400.2000 0.7102 400.3980 0.7102 400.5000 1.2650 400.6980 1.2650 400.8000 0.5963 400.9980 0.5963 401.1000 1.1428 401.2980 1.1428 401.4000 0.8441 401.5980 0.8441 401.7000 1.2201 401.8980 1.2201 402.0000 0.5790 402.1980 0.5790 402.3000 1.2508 402.4980 1.2508 402.6000 0.9231 402.7980 0.9231 402.9000 1.2347 403.0980 1.2347 403.2000 0.9325 403.3980 0.9325 403.5000 1.1977 403.6980 1.1977 403.8000 1.3375 403.9980 1.3375 404.1000 0.9544 404.2980 0.9544 404.4000 0.5883 404.5980 0.5883 404.7000 1.3247 404.8980 1.3247 405.0000 0.5933 405.1980 0.5933 405.3000 1.3739 405.4980 1.3739 405.6000 1.1663 405.7980 1.1663 405.9000 1.3500 406.0980 1.3500 406.2000 0.6807 406.3980 0.6807 406.5000 1.3903 406.6980 1.3903 406.8000 1.3720 406.9980 1.3720 407.1000 1.3636 407.2980 1.3636 407.4000 0.5452 407.5980 0.5452 407.7000 1.3260 407.8980 1.3260 408.0000 1.2891 408.1980 1.2891 408.3000 1.2799 408.4980 1.2799 408.6000 0.6872 408.7980 0.6872 408.9000 0.6020 409.0980 0.6020 409.2000 1.4772 409.3980 1.4772 409.5000 0.9818 409.6980 0.9818 409.8000 0.8978 409.9980 0.8978 410.1000 0.7177 410.2980 0.7177 410.4000 1.5497 410.5980 1.5497 410.7000 0.9032 410.8980 0.9032 411.0000 0.6491 411.1980 0.6491 411.3000 0.9059 411.4980 0.9059 411.6000 1.3139 411.7980 1.3139 411.9000 1.0666 412.0980 1.0666 412.2000 1.4669 412.3980 1.4669 412.5000 1.0274 412.6980 1.0274 412.8000 0.8702 412.9980 0.8702 413.1000 1.1680 413.2980 1.1680 413.4000 0.9272 413.5980 0.9272 413.7000 1.2976 413.8980 1.2976 414.0000 1.2611 414.1980 1.2611 414.3000 1.2131 414.4980 1.2131 414.6000 1.1808 414.7980 1.1808 414.9000 1.1221 415.0980 1.1221 415.2000 1.3576 415.3980 1.3576 415.5000 1.0884 415.6980 1.0884 415.8000 0.9163 415.9980 0.9163 416.1000 1.3159 416.2980 1.3159 416.4000 1.1552 416.5980 1.1552 416.7000 0.9317 416.8980 0.9317 417.0000 0.8998 417.1980 0.8998 417.3000 0.7836 417.4980 0.7836 417.6000 1.0457 417.7980 1.0457 417.9000 0.5887 418.0980 0.5887 418.2000 1.1468 418.3980 1.1468 418.5000 0.9922 418.6980 0.9922 418.8000 1.2583 418.9980 1.2583 419.1000 1.2130 419.2980 1.2130 419.4000 1.1361 419.5980 1.1361 419.7000 1.1791 419.8980 1.1791 420.0000 1.3453 420.1980 1.3453 420.3000 1.1417 420.4980 1.1417 420.6000 0.6065 420.7980 0.6065 420.9000 1.2029 421.0980 1.2029 421.2000 0.7549 421.3980 0.7549 421.5000 1.2676 421.6980 1.2676 421.8000 0.7102 421.9980 0.7102 422.1000 1.2650 422.2980 1.2650 422.4000 0.5963 422.5980 0.5963 422.7000 1.1428 422.8980 1.1428 423.0000 0.8441 423.1980 0.8441 423.3000 1.2201 423.4980 1.2201 423.6000 0.5790 423.7980 0.5790 423.9000 1.2508 424.0980 1.2508 424.2000 0.9231 424.3980 0.9231 424.5000 1.2347 424.6980 1.2347 424.8000 0.9325 424.9980 0.9325 425.1000 1.1977 425.2980 1.1977 425.4000 1.3375 425.5980 1.3375 425.7000 0.9544 425.8980 0.9544 426.0000 0.5883 426.1980 0.5883 426.3000 1.3247 426.4980 1.3247 426.6000 0.5933 426.7980 0.5933 426.9000 1.3739 427.0980 1.3739 427.2000 1.1663 427.3980 1.1663 427.5000 1.3500 427.6980 1.3500 427.8000 0.6807 427.9980 0.6807 428.1000 1.3903 428.2980 1.3903 428.4000 1.3720 428.5980 1.3720 428.7000 1.3636 428.8980 1.3636 429.0000 0.5452 429.1980 0.5452 429.3000 1.3260 429.4980 1.3260 429.6000 1.2891 429.7980 1.2891 429.9000 1.2799 430.0980 1.2799 430.2000 0.6872 430.3980 0.6872 430.5000 0.6020 430.6980 0.6020 430.8000 1.4772 430.9980 1.4772 431.1000 0.9818 431.2980 0.9818 431.4000 0.8978 431.5980 0.8978 431.7000 0.7177 431.8980 0.7177 432.0000 1.5497 432.1980 1.5497 432.3000 0.9032 432.4980 0.9032 432.6000 0.6491 432.7980 0.6491 432.9000 0.9059 433.0980 0.9059 433.2000 1.3139 433.3980 1.3139 433.5000 1.0666 433.6980 1.0666 433.8000 1.4669 433.9980 1.4669 434.1000 1.0274 434.2980 1.0274 434.4000 0.8702 434.5980 0.8702 434.7000 1.1680 434.8980 1.1680 435.0000 0.9272 435.1980 0.9272 435.3000 1.2976 435.4980 1.2976 435.6000 1.2611 435.7980 1.2611 435.9000 1.2131 436.0980 1.2131 436.2000 1.1808 436.3980 1.1808 436.5000 1.1221 436.6980 1.1221 436.8000 1.3576 436.9980 1.3576 437.1000 1.0884 437.2980 1.0884 437.4000 0.9163 437.5980 0.9163 437.7000 1.3159 437.8980 1.3159 438.0000 1.1552 438.1980 1.1552 438.3000 0.9317 438.4980 0.9317 438.6000 0.8998 438.7980 0.8998 438.9000 0.7836 439.0980 0.7836 439.2000 1.0457 439.3980 1.0457 439.5000 0.5887 439.6980 0.5887 439.8000 1.1468 439.9980 1.1468 440.1000 0.9922 440.2980 0.9922 440.4000 1.2583 440.5980 1.2583 440.7000 1.2130 440.8980 1.2130 441.0000 1.1361 441.1980 1.1361 441.3000 1.1791 441.4980 1.1791 441.6000 1.3453 441.7980 1.3453 441.9000 1.1417 442.0980 1.1417 442.2000 0.6065 442.3980 0.6065 442.5000 1.2029 442.6980 1.2029 442.8000 0.7549 442.9980 0.7549 443.1000 1.2676 443.2980 1.2676 443.4000 0.7102 443.5980 0.7102 443.7000 1.2650 443.8980 1.2650 444.0000 0.5963 444.1980 0.5963 444.3000 1.1428 444.4980 1.1428 444.6000 0.8441 444.7980 0.8441 444.9000 1.2201 445.0980 1.2201 445.2000 0.5790 445.3980 0.5790 445.5000 1.2508 445.6980 1.2508 445.8000 0.9231 445.9980 0.9231 446.1000 1.2347 446.2980 1.2347 446.4000 0.9325 446.5980 0.9325 446.7000 1.1977 446.8980 1.1977 447.0000 1.3375 447.1980 1.3375 447.3000 0.9544 447.4980 0.9544 447.6000 0.5883 447.7980 0.5883 447.9000 1.3247 448.0980 1.3247 448.2000 0.5933 448.3980 0.5933 448.5000 1.3739 448.6980 1.3739 448.8000 1.1663 448.9980 1.1663 449.1000 1.3500 449.2980 1.3500 449.4000 0.6807 449.5980 0.6807 449.7000 1.3903 449.8980 1.3903 450.0000 1.3720 450.1980 1.3720 450.3000 1.3636 450.4980 1.3636 450.6000 0.5452 450.7980 0.5452 450.9000 1.3260 451.0980 1.3260 451.2000 1.2891 451.3980 1.2891 451.5000 1.2799 451.6980 1.2799 451.8000 0.6872 451.9980 0.6872 452.1000 0.6020 452.2980 0.6020 452.4000 1.4772 452.5980 1.4772 452.7000 0.9818 452.8980 0.9818 453.0000 0.8978 453.1980 0.8978 453.3000 0.7177 453.4980 0.7177 453.6000 1.5497 453.7980 1.5497 453.9000 0.9032 454.0980 0.9032 454.2000 0.6491 454.3980 0.6491 454.5000 0.9059 454.6980 0.9059 454.8000 1.3139 454.9980 1.3139 455.1000 1.0666 455.2980 1.0666 455.4000 1.4669 455.5980 1.4669 455.7000 1.0274 455.8980 1.0274 456.0000 0.8702 456.1980 0.8702 456.3000 1.1680 456.4980 1.1680 456.6000 0.9272 456.7980 0.9272 456.9000 1.2976 457.0980 1.2976 457.2000 1.2611 457.3980 1.2611 457.5000 1.2131 457.6980 1.2131 457.8000 1.1808 457.9980 1.1808 458.1000 1.1221 458.2980 1.1221 458.4000 1.3576 458.5980 1.3576 458.7000 1.0884 458.8980 1.0884 459.0000 0.9163 459.1980 0.9163 459.3000 1.3159 459.4980 1.3159 459.6000 1.1552 459.7980 1.1552 459.9000 0.9317 460.0980 0.9317 460.2000 0.8998 460.3980 0.8998 460.5000 0.7836 460.6980 0.7836 460.8000 1.0457 460.9980 1.0457 461.1000 0.5887 461.2980 0.5887 461.4000 1.1468 461.5980 1.1468 461.7000 0.9922 461.8980 0.9922 462.0000 1.2583 462.1980 1.2583 462.3000 1.2130 462.4980 1.2130 462.6000 1.1361 462.7980 1.1361 462.9000 1.1791 463.0980 1.1791 463.2000 1.3453 463.3980 1.3453 463.5000 1.1417 463.6980 1.1417 463.8000 0.6065 463.9980 0.6065 464.1000 1.2029 464.2980 1.2029 464.4000 0.7549 464.5980 0.7549 464.7000 1.2676 464.8980 1.2676 465.0000 0.7102 465.1980 0.7102 465.3000 1.2650 465.4980 1.2650 465.6000 0.5963 465.7980 0.5963 465.9000 1.1428 466.0980 1.1428 466.2000 0.8441 466.3980 0.8441 466.5000 1.2201 466.6980 1.2201 466.8000 0.5790 466.9980 0.5790 467.1000 1.2508 467.2980 1.2508 467.4000 0.9231 467.5980 0.9231 467.7000 1.2347 467.8980 1.2347 468.0000 0.9325 468.1980 0.9325 468.3000 1.1977 468.4980 1.1977 468.6000 1.3375 468.7980 1.3375 468.9000 0.9544 469.0980 0.9544 469.2000 0.5883 469.3980 0.5883 469.5000 1.3247 469.6980 1.3247 469.8000 0.5933 469.9980 0.5933 470.1000 1.3739 470.2980 1.3739 470.4000 1.1663 470.5980 1.1663 470.7000 1.3500 470.8980 1.3500 471.0000 0.6807 471.1980 0.6807 471.3000 1.3903 471.4980 1.3903 471.6000 1.3720 471.7980 1.3720 471.9000 1.3636 472.0980 1.3636 472.2000 0.5452 472.3980 0.5452 472.5000 1.3260 472.6980 1.3260 472.8000 1.2891 472.9980 1.2891 473.1000 1.2799 473.2980 1.2799 473.4000 0.6872 473.5980 0.6872 473.7000 0.6020 473.8980 0.6020 474.0000 1.4772 474.1980 1.4772 474.3000 0.9818 474.4980 0.9818 474.6000 0.8978 474.7980 0.8978 474.9000 0.7177 475.0980 0.7177 475.2000 1.5497 475.3980 1.5497 475.5000 0.9032 475.6980 0.9032 475.8000 0.6491 475.9980 0.6491 476.1000 0.9059 476.2980 0.9059 476.4000 1.3139 476.5980 1.3139 476.7000 1.0666 476.8980 1.0666 477.0000 1.4669 477.1980 1.4669 477.3000 1.0274 477.4980 1.0274 477.6000 0.8702 477.7980 0.8702 477.9000 1.1680 478.0980 1.1680 478.2000 0.9272 478.3980 0.9272 478.5000 1.2976 478.6980 1.2976 478.8000 1.2611 478.9980 1.2611 479.1000 1.2131 479.2980 1.2131 479.4000 1.1808 479.5980 1.1808 479.7000 1.1221 479.8980 1.1221 480.0000 1.3576 480.1980 1.3576 480.3000 1.0884 480.4980 1.0884 480.6000 0.9163 480.7980 0.9163 480.9000 1.3159 481.0980 1.3159 481.2000 1.1552 481.3980 1.1552 481.5000 0.9317 481.6980 0.9317 481.8000 0.8998 481.9980 0.8998 482.1000 0.7836 482.2980 0.7836 482.4000 1.0457 482.5980 1.0457 482.7000 0.5887 482.8980 0.5887 483.0000 1.1468 483.1980 1.1468 483.3000 0.9922 483.4980 0.9922 483.6000 1.2583 483.7980 1.2583 483.9000 1.2130 484.0980 1.2130 484.2000 1.1361 484.3980 1.1361 484.5000 1.1791 484.6980 1.1791 484.8000 1.3453 484.9980 1.3453 485.1000 1.1417 485.2980 1.1417 485.4000 0.6065 485.5980 0.6065 485.7000 1.2029 485.8980 1.2029 486.0000 0.7549 486.1980 0.7549 486.3000 1.2676 486.4980 1.2676 486.6000 0.7102 486.7980 0.7102 486.9000 1.2650 487.0980 1.2650 487.2000 0.5963 487.3980 0.5963 487.5000 1.1428 487.6980 1.1428 487.8000 0.8441 487.9980 0.8441 488.1000 1.2201 488.2980 1.2201 488.4000 0.5790 488.5980 0.5790 488.7000 1.2508 488.8980 1.2508 489.0000 0.9231 489.1980 0.9231 489.3000 1.2347 489.4980 1.2347 489.6000 0.9325 489.7980 0.9325 489.9000 1.1977 490.0980 1.1977 490.2000 1.3375 490.3980 1.3375 490.5000 0.9544 490.6980 0.9544 490.8000 0.5883 490.9980 0.5883 491.1000 1.3247 491.2980 1.3247 491.4000 0.5933 491.5980 0.5933 491.7000 1.3739 491.8980 1.3739 492.0000 1.1663 492.1980 1.1663 492.3000 1.3500 492.4980 1.3500 492.6000 0.6807 492.7980 0.6807 492.9000 1.3903 493.0980 1.3903 493.2000 1.3720 493.3980 1.3720 493.5000 1.3636 493.6980 1.3636 493.8000 0.5452 493.9980 0.5452 494.1000 1.3260 494.2980 1.3260 494.4000 1.2891 494.5980 1.2891 494.7000 1.2799 494.8980 1.2799 495.0000 0.6872 495.1980 0.6872 495.3000 0.6020 495.4980 0.6020 495.6000 1.4772 495.7980 1.4772 495.9000 0.9818 496.0980 0.9818 496.2000 0.8978 496.3980 0.8978 496.5000 0.7177 496.6980 0.7177 496.8000 1.5497 496.9980 1.5497 497.1000 0.9032 497.2980 0.9032 497.4000 0.6491 497.5980 0.6491 497.7000 0.9059 497.8980 0.9059 498.0000 1.3139 498.1980 1.3139 498.3000 1.0666 498.4980 1.0666 498.6000 1.4669 498.7980 1.4669 498.9000 1.0274 499.0980 1.0274 499.2000 0.8702 499.3980 0.8702 499.5000 1.1680 499.6980 1.1680 499.8000 0.9272 499.9980 0.9272 500.1000 1.2976 500.2980 1.2976 500.4000 1.2611 500.5980 1.2611 500.7000 1.2131 500.8980 1.2131 501.0000 1.1808 501.1980 1.1808 501.3000 1.1221 501.4980 1.1221 501.6000 1.3576 501.7980 1.3576 501.9000 1.0884 502.0980 1.0884 502.2000 0.9163 502.3980 0.9163 502.5000 1.3159 502.6980 1.3159 502.8000 1.1552 502.9980 1.1552 503.1000 0.9317 503.2980 0.9317 503.4000 0.8998 503.5980 0.8998 503.7000 0.7836 503.8980 0.7836 504.0000 1.0457 504.1980 1.0457 504.3000 0.5887 504.4980 0.5887 504.6000 1.1468 504.7980 1.1468 504.9000 0.9922 505.0980 0.9922 505.2000 1.2583 505.3980 1.2583 505.5000 1.2130 505.6980 1.2130 505.8000 1.1361 505.9980 1.1361 506.1000 1.1791 506.2980 1.1791 506.4000 1.3453 506.5980 1.3453 506.7000 1.1417 506.8980 1.1417 507.0000 0.6065 507.1980 0.6065 507.3000 1.2029 507.4980 1.2029 507.6000 0.7549 507.7980 0.7549 507.9000 1.2676 508.0980 1.2676 508.2000 0.7102 508.3980 0.7102 508.5000 1.2650 508.6980 1.2650 508.8000 0.5963 508.9980 0.5963 509.1000 1.1428 509.2980 1.1428 509.4000 0.8441 509.5980 0.8441 509.7000 1.2201 509.8980 1.2201 510.0000 0.5790 510.1980 0.5790 510.3000 1.2508 510.4980 1.2508 510.6000 0.9231 510.7980 0.9231 510.9000 1.2347 511.0980 1.2347 511.2000 0.9325 511.3980 0.9325 511.5000 1.1977 511.6980 1.1977 511.8000 1.3375 511.9980 1.3375 512.1000 0.9544 512.2980 0.9544 512.4000 0.5883 512.5980 0.5883 512.7000 1.3247 512.8980 1.3247 513.0000 0.5933 513.1980 0.5933 513.3000 1.3739 513.4980 1.3739 513.6000 1.1663 513.7980 1.1663 513.9000 1.3500 514.0980 1.3500 514.2000 0.6807 514.3980 0.6807 514.5000 1.3903 514.6980 1.3903 514.8000 1.3720 514.9980 1.3720 515.1000 1.3636 515.2980 1.3636 515.4000 0.5452 515.5980 0.5452 515.7000 1.3260 515.8980 1.3260 516.0000 1.2891 516.1980 1.2891 516.3000 1.2799 516.4980 1.2799 516.6000 0.6872 516.7980 0.6872 516.9000 0.6020 517.0980 0.6020 517.2000 1.4772 517.3980 1.4772 517.5000 0.9818 517.6980 0.9818 517.8000 0.8978 517.9980 0.8978 518.1000 0.7177 518.2980 0.7177 518.4000 1.5497 518.5980 1.5497 518.7000 0.9032 518.8980 0.9032 519.0000 0.6491 519.1980 0.6491 519.3000 0.9059 519.4980 0.9059 519.6000 1.3139 519.7980 1.3139 519.9000 1.0666 520.0980 1.0666 520.2000 1.4669 520.3980 1.4669 520.5000 1.0274 520.6980 1.0274 520.8000 0.8702 520.9980 0.8702 521.1000 1.1680 521.2980 1.1680 521.4000 0.9272 521.5980 0.9272 521.7000 1.2976 521.8980 1.2976 522.0000 1.2611 522.1980 1.2611 522.3000 1.2131 522.4980 1.2131 522.6000 1.1808 522.7980 1.1808 522.9000 1.1221 523.0980 1.1221 523.2000 1.3576 523.3980 1.3576 523.5000 1.0884 523.6980 1.0884 523.8000 0.9163 523.9980 0.9163 524.1000 1.3159 524.2980 1.3159 524.4000 1.1552 524.5980 1.1552 524.7000 0.9317 524.8980 0.9317 525.0000 0.8998 525.1980 0.8998 525.3000 0.7836 525.4980 0.7836 525.6000 1.0457 525.7980 1.0457 525.9000 0.5887 526.0980 0.5887 526.2000 1.1468 526.3980 1.1468 526.5000 0.9922 526.6980 0.9922 526.8000 1.2583 526.9980 1.2583 527.1000 1.2130 527.2980 1.2130 527.4000 1.1361 527.5980 1.1361 527.7000 1.1791 527.8980 1.1791 528.0000 1.3453 528.1980 1.3453 528.3000 1.1417 528.4980 1.1417 528.6000 0.6065 528.7980 0.6065 528.9000 1.2029 529.0980 1.2029 529.2000 0.7549 529.3980 0.7549 529.5000 1.2676 529.6980 1.2676 529.8000 0.7102 529.9980 0.7102 530.1000 1.2650 530.2980 1.2650 530.4000 0.5963 530.5980 0.5963 530.7000 1.1428 530.8980 1.1428 531.0000 0.8441 531.1980 0.8441 531.3000 1.2201 531.4980 1.2201 531.6000 0.5790 531.7980 0.5790 531.9000 1.2508 532.0980 1.2508 532.2000 0.9231 532.3980 0.9231 532.5000 1.2347 532.6980 1.2347 532.8000 0.9325 532.9980 0.9325 533.1000 1.1977 533.2980 1.1977 533.4000 1.3375 533.5980 1.3375 533.7000 0.9544 533.8980 0.9544 534.0000 0.5883 534.1980 0.5883 534.3000 1.3247 534.4980 1.3247 534.6000 0.5933 534.7980 0.5933 534.9000 1.3739 535.0980 1.3739 535.2000 1.1663 535.3980 1.1663 535.5000 1.3500 535.6980 1.3500 535.8000 0.6807 535.9980 0.6807 536.1000 1.3903 536.2980 1.3903 536.4000 1.3720 536.5980 1.3720 536.7000 1.3636 536.8980 1.3636 537.0000 0.5452 537.1980 0.5452 537.3000 1.3260 537.4980 1.3260 537.6000 1.2891 537.7980 1.2891 537.9000 1.2799 538.0980 1.2799 538.2000 0.6872 538.3980 0.6872 538.5000 0.6020 538.6980 0.6020 538.8000 1.4772 538.9980 1.4772 539.1000 0.9818 539.2980 0.9818 539.4000 0.8978 539.5980 0.8978 539.7000 0.7177 539.8980 0.7177 540.0000 1.5497 540.1980 1.5497 540.3000 0.9032 540.4980 0.9032 540.6000 0.6491 540.7980 0.6491 540.9000 0.9059 541.0980 0.9059 541.2000 1.3139 541.3980 1.3139 541.5000 1.0666 541.6980 1.0666 541.8000 1.4669 541.9980 1.4669 542.1000 1.0274 542.2980 1.0274 542.4000 0.8702 542.5980 0.8702 542.7000 1.1680 542.8980 1.1680 543.0000 0.9272 543.1980 0.9272 543.3000 1.2976 543.4980 1.2976 543.6000 1.2611 543.7980 1.2611 543.9000 1.2131 544.0980 1.2131 544.2000 1.1808 544.3980 1.1808 544.5000 1.1221 544.6980 1.1221 544.8000 1.3576 544.9980 1.3576 545.1000 1.0884 545.2980 1.0884 545.4000 0.9163 545.5980 0.9163 545.7000 1.3159 545.8980 1.3159 546.0000 1.1552 546.1980 1.1552 546.3000 0.9317 546.4980 0.9317 546.6000 0.8998 546.7980 0.8998 546.9000 0.7836 547.0980 0.7836 547.2000 1.0457 547.3980 1.0457 547.5000 0.5887 547.6980 0.5887 547.8000 1.1468 547.9980 1.1468 548.1000 0.9922 548.2980 0.9922 548.4000 1.2583 548.5980 1.2583 548.7000 1.2130 548.8980 1.2130 549.0000 1.1361 549.1980 1.1361 549.3000 1.1791 549.4980 1.1791 549.6000 1.3453 549.7980 1.3453 549.9000 1.1417 550.0980 1.1417 550.2000 0.6065 550.3980 0.6065 550.5000 1.2029 550.6980 1.2029 550.8000 0.7549 550.9980 0.7549 551.1000 1.2676 551.2980 1.2676 551.4000 0.7102 551.5980 0.7102 551.7000 1.2650 551.8980 1.2650 552.0000 0.5963 552.1980 0.5963 552.3000 1.1428 552.4980 1.1428 552.6000 0.8441 552.7980 0.8441 552.9000 1.2201 553.0980 1.2201 553.2000 0.5790 553.3980 0.5790 553.5000 1.2508 553.6980 1.2508 553.8000 0.9231 553.9980 0.9231 554.1000 1.2347 554.2980 1.2347 554.4000 0.9325 554.5980 0.9325 554.7000 1.1977 554.8980 1.1977 555.0000 1.3375 555.1980 1.3375 555.3000 0.9544 555.4980 0.9544 555.6000 0.5883 555.7980 0.5883 555.9000 1.3247 556.0980 1.3247 556.2000 0.5933 556.3980 0.5933 556.5000 1.3739 556.6980 1.3739 556.8000 1.1663 556.9980 1.1663 557.1000 1.3500 557.2980 1.3500 557.4000 0.6807 557.5980 0.6807 557.7000 1.3903 557.8980 1.3903 558.0000 1.3720 558.1980 1.3720 558.3000 1.3636 558.4980 1.3636 558.6000 0.5452 558.7980 0.5452 558.9000 1.3260 559.0980 1.3260 559.2000 1.2891 559.3980 1.2891 559.5000 1.2799 559.6980 1.2799 559.8000 0.6872 559.9980 0.6872 560.1000 0.6020 560.2980 0.6020 560.4000 1.4772 560.5980 1.4772 560.7000 0.9818 560.8980 0.9818 561.0000 0.8978 561.1980 0.8978 561.3000 0.7177 561.4980 0.7177 561.6000 1.5497 561.7980 1.5497 561.9000 0.9032 562.0980 0.9032 562.2000 0.6491 562.3980 0.6491 562.5000 0.9059 562.6980 0.9059 562.8000 1.3139 562.9980 1.3139 563.1000 1.0666 563.2980 1.0666 563.4000 1.4669 563.5980 1.4669 563.7000 1.0274 563.8980 1.0274 564.0000 0.8702 564.1980 0.8702 564.3000 1.1680 564.4980 1.1680 564.6000 0.9272 564.7980 0.9272 564.9000 1.2976 565.0980 1.2976 565.2000 1.2611 565.3980 1.2611 565.5000 1.2131 565.6980 1.2131 565.8000 1.1808 565.9980 1.1808 566.1000 1.1221 566.2980 1.1221 566.4000 1.3576 566.5980 1.3576 566.7000 1.0884 566.8980 1.0884 567.0000 0.9163 567.1980 0.9163 567.3000 1.3159 567.4980 1.3159 567.6000 1.1552 567.7980 1.1552 567.9000 0.9317 568.0980 0.9317 568.2000 0.8998 568.3980 0.8998 568.5000 0.7836 568.6980 0.7836 568.8000 1.0457 568.9980 1.0457 569.1000 0.5887 569.2980 0.5887 569.4000 1.1468 569.5980 1.1468 569.7000 0.9922 569.8980 0.9922 570.0000 1.2583 570.1980 1.2583 570.3000 1.2130 570.4980 1.2130 570.6000 1.1361 570.7980 1.1361 570.9000 1.1791 571.0980 1.1791 571.2000 1.3453 571.3980 1.3453 571.5000 1.1417 571.6980 1.1417 571.8000 0.6065 571.9980 0.6065 572.1000 1.2029 572.2980 1.2029 572.4000 0.7549 572.5980 0.7549 572.7000 1.2676 572.8980 1.2676 573.0000 0.7102 573.1980 0.7102 573.3000 1.2650 573.4980 1.2650 573.6000 0.5963 573.7980 0.5963 573.9000 1.1428 574.0980 1.1428 574.2000 0.8441 574.3980 0.8441 574.5000 1.2201 574.6980 1.2201 574.8000 0.5790 574.9980 0.5790 575.1000 1.2508 575.2980 1.2508 575.4000 0.9231 575.5980 0.9231 575.7000 1.2347 575.8980 1.2347 576.0000 0.9325 576.1980 0.9325 576.3000 1.1977 576.4980 1.1977 576.6000 1.3375 576.7980 1.3375 576.9000 0.9544 577.0980 0.9544 577.2000 0.5883 577.3980 0.5883 577.5000 1.3247 577.6980 1.3247 577.8000 0.5933 577.9980 0.5933 578.1000 1.3739 578.2980 1.3739 578.4000 1.1663 578.5980 1.1663 578.7000 1.3500 578.8980 1.3500 579.0000 0.6807 579.1980 0.6807 579.3000 1.3903 579.4980 1.3903 579.6000 1.3720 579.7980 1.3720 579.9000 1.3636 580.0980 1.3636 580.2000 0.5452 580.3980 0.5452 580.5000 1.3260 580.6980 1.3260 580.8000 1.2891 580.9980 1.2891 581.1000 1.2799 581.2980 1.2799 581.4000 0.6872 581.5980 0.6872 581.7000 0.6020 581.8980 0.6020 582.0000 1.4772 582.1980 1.4772 582.3000 0.9818 582.4980 0.9818 582.6000 0.8978 582.7980 0.8978 582.9000 0.7177 583.0980 0.7177 583.2000 1.5497 583.3980 1.5497 583.5000 0.9032 583.6980 0.9032 583.8000 0.6491 583.9980 0.6491 584.1000 0.9059 584.2980 0.9059 584.4000 1.3139 584.5980 1.3139 584.7000 1.0666 584.8980 1.0666 585.0000 1.4669 585.1980 1.4669 585.3000 1.0274 585.4980 1.0274 585.6000 0.8702 585.7980 0.8702 585.9000 1.1680 586.0980 1.1680 586.2000 0.9272 586.3980 0.9272 586.5000 1.2976 586.6980 1.2976 586.8000 1.2611 586.9980 1.2611 587.1000 1.2131 587.2980 1.2131 587.4000 1.1808 587.5980 1.1808 587.7000 1.1221 587.8980 1.1221 588.0000 1.3576 588.1980 1.3576 588.3000 1.0884 588.4980 1.0884 588.6000 0.9163 588.7980 0.9163 588.9000 1.3159 589.0980 1.3159 589.2000 1.1552 589.3980 1.1552 589.5000 0.9317 589.6980 0.9317 589.8000 0.8998 589.9980 0.8998 590.1000 0.7836 590.2980 0.7836 590.4000 1.0457 590.5980 1.0457 590.7000 0.5887 590.8980 0.5887 591.0000 1.1468 591.1980 1.1468 591.3000 0.9922 591.4980 0.9922 591.6000 1.2583 591.7980 1.2583 591.9000 1.2130 592.0980 1.2130 592.2000 1.1361 592.3980 1.1361 592.5000 1.1791 592.6980 1.1791 592.8000 1.3453 592.9980 1.3453 593.1000 1.1417 593.2980 1.1417 593.4000 0.6065 593.5980 0.6065 593.7000 1.2029 593.8980 1.2029 594.0000 0.7549 594.1980 0.7549 594.3000 1.2676 594.4980 1.2676 594.6000 0.7102 594.7980 0.7102 594.9000 1.2650 595.0980 1.2650 595.2000 0.5963 595.3980 0.5963 595.5000 1.1428 595.6980 1.1428 595.8000 0.8441 595.9980 0.8441 596.1000 1.2201 596.2980 1.2201 596.4000 0.5790 596.5980 0.5790 596.7000 1.2508 596.8980 1.2508 597.0000 0.9231 597.1980 0.9231 597.3000 1.2347 597.4980 1.2347 597.6000 0.9325 597.7980 0.9325 597.9000 1.1977 598.0980 1.1977 598.2000 1.3375 598.3980 1.3375 598.5000 0.9544 598.6980 0.9544 598.8000 0.5883 598.9980 0.5883 599.1000 1.3247 599.2980 1.3247 599.4000 0.5933 599.5980 0.5933 599.7000 1.3739 599.8980 1.3739 600.0000 1.3739)
Va14 a14 0 PWL(0.0000 0.6085 0.1980 0.6085 0.3000 1.3180 0.4980 1.3180 0.6000 0.5514 0.7980 0.5514 0.9000 0.7238 1.0980 0.7238 1.2000 0.7537 1.3980 0.7537 1.5000 1.2783 1.6980 1.2783 1.8000 0.6066 1.9980 0.6066 2.1000 0.5095 2.2980 0.5095 2.4000 1.4333 2.5980 1.4333 2.7000 0.8570 2.8980 0.8570 3.0000 0.6176 3.1980 0.6176 3.3000 0.9701 3.4980 0.9701 3.6000 0.6528 3.7980 0.6528 3.9000 1.1509 4.0980 1.1509 4.2000 1.0184 4.3980 1.0184 4.5000 0.4468 4.6980 0.4468 4.8000 0.6256 4.9980 0.6256 5.1000 1.0163 5.2980 1.0163 5.4000 0.9945 5.5980 0.9945 5.7000 0.6057 5.8980 0.6057 6.0000 0.6136 6.1980 0.6136 6.3000 0.9102 6.4980 0.9102 6.6000 0.6995 6.7980 0.6995 6.9000 0.9915 7.0980 0.9915 7.2000 0.7132 7.3980 0.7132 7.5000 1.3101 7.6980 1.3101 7.8000 0.5985 7.9980 0.5985 8.1000 0.7398 8.2980 0.7398 8.4000 0.5913 8.5980 0.5913 8.7000 0.6190 8.8980 0.6190 9.0000 0.8524 9.1980 0.8524 9.3000 0.5966 9.4980 0.5966 9.6000 0.6150 9.7980 0.6150 9.9000 0.5868 10.0980 0.5868 10.2000 1.1816 10.3980 1.1816 10.5000 0.6194 10.6980 0.6194 10.8000 1.3419 10.9980 1.3419 11.1000 0.6056 11.2980 0.6056 11.4000 1.1514 11.5980 1.1514 11.7000 0.6160 11.8980 0.6160 12.0000 1.1558 12.1980 1.1558 12.3000 0.6247 12.4980 0.6247 12.6000 0.9282 12.7980 0.9282 12.9000 0.5998 13.0980 0.5998 13.2000 1.1919 13.3980 1.1919 13.5000 0.6068 13.6980 0.6068 13.8000 1.0710 13.9980 1.0710 14.1000 0.6236 14.2980 0.6236 14.4000 0.9793 14.5980 0.9793 14.7000 0.6006 14.8980 0.6006 15.0000 0.8397 15.1980 0.8397 15.3000 0.9624 15.4980 0.9624 15.6000 1.0401 15.7980 1.0401 15.9000 0.7296 16.0980 0.7296 16.2000 1.4246 16.3980 1.4246 16.5000 0.5968 16.6980 0.5968 16.8000 0.8478 16.9980 0.8478 17.1000 0.6984 17.2980 0.6984 17.4000 1.0998 17.5980 1.0998 17.7000 0.6467 17.8980 0.6467 18.0000 0.5559 18.1980 0.5559 18.3000 0.6529 18.4980 0.6529 18.6000 1.1880 18.7980 1.1880 18.9000 0.5955 19.0980 0.5955 19.2000 0.5732 19.3980 0.5732 19.5000 0.6107 19.6980 0.6107 19.8000 1.1202 19.9980 1.1202 20.1000 1.4030 20.2980 1.4030 20.4000 0.5745 20.5980 0.5745 20.7000 1.0638 20.8980 1.0638 21.0000 1.0247 21.1980 1.0247 21.3000 1.1806 21.4980 1.1806 21.6000 0.6085 21.7980 0.6085 21.9000 1.3180 22.0980 1.3180 22.2000 0.5514 22.3980 0.5514 22.5000 0.7238 22.6980 0.7238 22.8000 0.7537 22.9980 0.7537 23.1000 1.2783 23.2980 1.2783 23.4000 0.6066 23.5980 0.6066 23.7000 0.5095 23.8980 0.5095 24.0000 1.4333 24.1980 1.4333 24.3000 0.8570 24.4980 0.8570 24.6000 0.6176 24.7980 0.6176 24.9000 0.9701 25.0980 0.9701 25.2000 0.6528 25.3980 0.6528 25.5000 1.1509 25.6980 1.1509 25.8000 1.0184 25.9980 1.0184 26.1000 0.4468 26.2980 0.4468 26.4000 0.6256 26.5980 0.6256 26.7000 1.0163 26.8980 1.0163 27.0000 0.9945 27.1980 0.9945 27.3000 0.6057 27.4980 0.6057 27.6000 0.6136 27.7980 0.6136 27.9000 0.9102 28.0980 0.9102 28.2000 0.6995 28.3980 0.6995 28.5000 0.9915 28.6980 0.9915 28.8000 0.7132 28.9980 0.7132 29.1000 1.3101 29.2980 1.3101 29.4000 0.5985 29.5980 0.5985 29.7000 0.7398 29.8980 0.7398 30.0000 0.5913 30.1980 0.5913 30.3000 0.6190 30.4980 0.6190 30.6000 0.8524 30.7980 0.8524 30.9000 0.5966 31.0980 0.5966 31.2000 0.6150 31.3980 0.6150 31.5000 0.5868 31.6980 0.5868 31.8000 1.1816 31.9980 1.1816 32.1000 0.6194 32.2980 0.6194 32.4000 1.3419 32.5980 1.3419 32.7000 0.6056 32.8980 0.6056 33.0000 1.1514 33.1980 1.1514 33.3000 0.6160 33.4980 0.6160 33.6000 1.1558 33.7980 1.1558 33.9000 0.6247 34.0980 0.6247 34.2000 0.9282 34.3980 0.9282 34.5000 0.5998 34.6980 0.5998 34.8000 1.1919 34.9980 1.1919 35.1000 0.6068 35.2980 0.6068 35.4000 1.0710 35.5980 1.0710 35.7000 0.6236 35.8980 0.6236 36.0000 0.9793 36.1980 0.9793 36.3000 0.6006 36.4980 0.6006 36.6000 0.8397 36.7980 0.8397 36.9000 0.9624 37.0980 0.9624 37.2000 1.0401 37.3980 1.0401 37.5000 0.7296 37.6980 0.7296 37.8000 1.4246 37.9980 1.4246 38.1000 0.5968 38.2980 0.5968 38.4000 0.8478 38.5980 0.8478 38.7000 0.6984 38.8980 0.6984 39.0000 1.0998 39.1980 1.0998 39.3000 0.6467 39.4980 0.6467 39.6000 0.5559 39.7980 0.5559 39.9000 0.6529 40.0980 0.6529 40.2000 1.1880 40.3980 1.1880 40.5000 0.5955 40.6980 0.5955 40.8000 0.5732 40.9980 0.5732 41.1000 0.6107 41.2980 0.6107 41.4000 1.1202 41.5980 1.1202 41.7000 1.4030 41.8980 1.4030 42.0000 0.5745 42.1980 0.5745 42.3000 1.0638 42.4980 1.0638 42.6000 1.0247 42.7980 1.0247 42.9000 1.1806 43.0980 1.1806 43.2000 0.6085 43.3980 0.6085 43.5000 1.3180 43.6980 1.3180 43.8000 0.5514 43.9980 0.5514 44.1000 0.7238 44.2980 0.7238 44.4000 0.7537 44.5980 0.7537 44.7000 1.2783 44.8980 1.2783 45.0000 0.6066 45.1980 0.6066 45.3000 0.5095 45.4980 0.5095 45.6000 1.4333 45.7980 1.4333 45.9000 0.8570 46.0980 0.8570 46.2000 0.6176 46.3980 0.6176 46.5000 0.9701 46.6980 0.9701 46.8000 0.6528 46.9980 0.6528 47.1000 1.1509 47.2980 1.1509 47.4000 1.0184 47.5980 1.0184 47.7000 0.4468 47.8980 0.4468 48.0000 0.6256 48.1980 0.6256 48.3000 1.0163 48.4980 1.0163 48.6000 0.9945 48.7980 0.9945 48.9000 0.6057 49.0980 0.6057 49.2000 0.6136 49.3980 0.6136 49.5000 0.9102 49.6980 0.9102 49.8000 0.6995 49.9980 0.6995 50.1000 0.9915 50.2980 0.9915 50.4000 0.7132 50.5980 0.7132 50.7000 1.3101 50.8980 1.3101 51.0000 0.5985 51.1980 0.5985 51.3000 0.7398 51.4980 0.7398 51.6000 0.5913 51.7980 0.5913 51.9000 0.6190 52.0980 0.6190 52.2000 0.8524 52.3980 0.8524 52.5000 0.5966 52.6980 0.5966 52.8000 0.6150 52.9980 0.6150 53.1000 0.5868 53.2980 0.5868 53.4000 1.1816 53.5980 1.1816 53.7000 0.6194 53.8980 0.6194 54.0000 1.3419 54.1980 1.3419 54.3000 0.6056 54.4980 0.6056 54.6000 1.1514 54.7980 1.1514 54.9000 0.6160 55.0980 0.6160 55.2000 1.1558 55.3980 1.1558 55.5000 0.6247 55.6980 0.6247 55.8000 0.9282 55.9980 0.9282 56.1000 0.5998 56.2980 0.5998 56.4000 1.1919 56.5980 1.1919 56.7000 0.6068 56.8980 0.6068 57.0000 1.0710 57.1980 1.0710 57.3000 0.6236 57.4980 0.6236 57.6000 0.9793 57.7980 0.9793 57.9000 0.6006 58.0980 0.6006 58.2000 0.8397 58.3980 0.8397 58.5000 0.9624 58.6980 0.9624 58.8000 1.0401 58.9980 1.0401 59.1000 0.7296 59.2980 0.7296 59.4000 1.4246 59.5980 1.4246 59.7000 0.5968 59.8980 0.5968 60.0000 0.8478 60.1980 0.8478 60.3000 0.6984 60.4980 0.6984 60.6000 1.0998 60.7980 1.0998 60.9000 0.6467 61.0980 0.6467 61.2000 0.5559 61.3980 0.5559 61.5000 0.6529 61.6980 0.6529 61.8000 1.1880 61.9980 1.1880 62.1000 0.5955 62.2980 0.5955 62.4000 0.5732 62.5980 0.5732 62.7000 0.6107 62.8980 0.6107 63.0000 1.1202 63.1980 1.1202 63.3000 1.4030 63.4980 1.4030 63.6000 0.5745 63.7980 0.5745 63.9000 1.0638 64.0980 1.0638 64.2000 1.0247 64.3980 1.0247 64.5000 1.1806 64.6980 1.1806 64.8000 0.6085 64.9980 0.6085 65.1000 1.3180 65.2980 1.3180 65.4000 0.5514 65.5980 0.5514 65.7000 0.7238 65.8980 0.7238 66.0000 0.7537 66.1980 0.7537 66.3000 1.2783 66.4980 1.2783 66.6000 0.6066 66.7980 0.6066 66.9000 0.5095 67.0980 0.5095 67.2000 1.4333 67.3980 1.4333 67.5000 0.8570 67.6980 0.8570 67.8000 0.6176 67.9980 0.6176 68.1000 0.9701 68.2980 0.9701 68.4000 0.6528 68.5980 0.6528 68.7000 1.1509 68.8980 1.1509 69.0000 1.0184 69.1980 1.0184 69.3000 0.4468 69.4980 0.4468 69.6000 0.6256 69.7980 0.6256 69.9000 1.0163 70.0980 1.0163 70.2000 0.9945 70.3980 0.9945 70.5000 0.6057 70.6980 0.6057 70.8000 0.6136 70.9980 0.6136 71.1000 0.9102 71.2980 0.9102 71.4000 0.6995 71.5980 0.6995 71.7000 0.9915 71.8980 0.9915 72.0000 0.7132 72.1980 0.7132 72.3000 1.3101 72.4980 1.3101 72.6000 0.5985 72.7980 0.5985 72.9000 0.7398 73.0980 0.7398 73.2000 0.5913 73.3980 0.5913 73.5000 0.6190 73.6980 0.6190 73.8000 0.8524 73.9980 0.8524 74.1000 0.5966 74.2980 0.5966 74.4000 0.6150 74.5980 0.6150 74.7000 0.5868 74.8980 0.5868 75.0000 1.1816 75.1980 1.1816 75.3000 0.6194 75.4980 0.6194 75.6000 1.3419 75.7980 1.3419 75.9000 0.6056 76.0980 0.6056 76.2000 1.1514 76.3980 1.1514 76.5000 0.6160 76.6980 0.6160 76.8000 1.1558 76.9980 1.1558 77.1000 0.6247 77.2980 0.6247 77.4000 0.9282 77.5980 0.9282 77.7000 0.5998 77.8980 0.5998 78.0000 1.1919 78.1980 1.1919 78.3000 0.6068 78.4980 0.6068 78.6000 1.0710 78.7980 1.0710 78.9000 0.6236 79.0980 0.6236 79.2000 0.9793 79.3980 0.9793 79.5000 0.6006 79.6980 0.6006 79.8000 0.8397 79.9980 0.8397 80.1000 0.9624 80.2980 0.9624 80.4000 1.0401 80.5980 1.0401 80.7000 0.7296 80.8980 0.7296 81.0000 1.4246 81.1980 1.4246 81.3000 0.5968 81.4980 0.5968 81.6000 0.8478 81.7980 0.8478 81.9000 0.6984 82.0980 0.6984 82.2000 1.0998 82.3980 1.0998 82.5000 0.6467 82.6980 0.6467 82.8000 0.5559 82.9980 0.5559 83.1000 0.6529 83.2980 0.6529 83.4000 1.1880 83.5980 1.1880 83.7000 0.5955 83.8980 0.5955 84.0000 0.5732 84.1980 0.5732 84.3000 0.6107 84.4980 0.6107 84.6000 1.1202 84.7980 1.1202 84.9000 1.4030 85.0980 1.4030 85.2000 0.5745 85.3980 0.5745 85.5000 1.0638 85.6980 1.0638 85.8000 1.0247 85.9980 1.0247 86.1000 1.1806 86.2980 1.1806 86.4000 0.6085 86.5980 0.6085 86.7000 1.3180 86.8980 1.3180 87.0000 0.5514 87.1980 0.5514 87.3000 0.7238 87.4980 0.7238 87.6000 0.7537 87.7980 0.7537 87.9000 1.2783 88.0980 1.2783 88.2000 0.6066 88.3980 0.6066 88.5000 0.5095 88.6980 0.5095 88.8000 1.4333 88.9980 1.4333 89.1000 0.8570 89.2980 0.8570 89.4000 0.6176 89.5980 0.6176 89.7000 0.9701 89.8980 0.9701 90.0000 0.6528 90.1980 0.6528 90.3000 1.1509 90.4980 1.1509 90.6000 1.0184 90.7980 1.0184 90.9000 0.4468 91.0980 0.4468 91.2000 0.6256 91.3980 0.6256 91.5000 1.0163 91.6980 1.0163 91.8000 0.9945 91.9980 0.9945 92.1000 0.6057 92.2980 0.6057 92.4000 0.6136 92.5980 0.6136 92.7000 0.9102 92.8980 0.9102 93.0000 0.6995 93.1980 0.6995 93.3000 0.9915 93.4980 0.9915 93.6000 0.7132 93.7980 0.7132 93.9000 1.3101 94.0980 1.3101 94.2000 0.5985 94.3980 0.5985 94.5000 0.7398 94.6980 0.7398 94.8000 0.5913 94.9980 0.5913 95.1000 0.6190 95.2980 0.6190 95.4000 0.8524 95.5980 0.8524 95.7000 0.5966 95.8980 0.5966 96.0000 0.6150 96.1980 0.6150 96.3000 0.5868 96.4980 0.5868 96.6000 1.1816 96.7980 1.1816 96.9000 0.6194 97.0980 0.6194 97.2000 1.3419 97.3980 1.3419 97.5000 0.6056 97.6980 0.6056 97.8000 1.1514 97.9980 1.1514 98.1000 0.6160 98.2980 0.6160 98.4000 1.1558 98.5980 1.1558 98.7000 0.6247 98.8980 0.6247 99.0000 0.9282 99.1980 0.9282 99.3000 0.5998 99.4980 0.5998 99.6000 1.1919 99.7980 1.1919 99.9000 0.6068 100.0980 0.6068 100.2000 1.0710 100.3980 1.0710 100.5000 0.6236 100.6980 0.6236 100.8000 0.9793 100.9980 0.9793 101.1000 0.6006 101.2980 0.6006 101.4000 0.8397 101.5980 0.8397 101.7000 0.9624 101.8980 0.9624 102.0000 1.0401 102.1980 1.0401 102.3000 0.7296 102.4980 0.7296 102.6000 1.4246 102.7980 1.4246 102.9000 0.5968 103.0980 0.5968 103.2000 0.8478 103.3980 0.8478 103.5000 0.6984 103.6980 0.6984 103.8000 1.0998 103.9980 1.0998 104.1000 0.6467 104.2980 0.6467 104.4000 0.5559 104.5980 0.5559 104.7000 0.6529 104.8980 0.6529 105.0000 1.1880 105.1980 1.1880 105.3000 0.5955 105.4980 0.5955 105.6000 0.5732 105.7980 0.5732 105.9000 0.6107 106.0980 0.6107 106.2000 1.1202 106.3980 1.1202 106.5000 1.4030 106.6980 1.4030 106.8000 0.5745 106.9980 0.5745 107.1000 1.0638 107.2980 1.0638 107.4000 1.0247 107.5980 1.0247 107.7000 1.1806 107.8980 1.1806 108.0000 0.6085 108.1980 0.6085 108.3000 1.3180 108.4980 1.3180 108.6000 0.5514 108.7980 0.5514 108.9000 0.7238 109.0980 0.7238 109.2000 0.7537 109.3980 0.7537 109.5000 1.2783 109.6980 1.2783 109.8000 0.6066 109.9980 0.6066 110.1000 0.5095 110.2980 0.5095 110.4000 1.4333 110.5980 1.4333 110.7000 0.8570 110.8980 0.8570 111.0000 0.6176 111.1980 0.6176 111.3000 0.9701 111.4980 0.9701 111.6000 0.6528 111.7980 0.6528 111.9000 1.1509 112.0980 1.1509 112.2000 1.0184 112.3980 1.0184 112.5000 0.4468 112.6980 0.4468 112.8000 0.6256 112.9980 0.6256 113.1000 1.0163 113.2980 1.0163 113.4000 0.9945 113.5980 0.9945 113.7000 0.6057 113.8980 0.6057 114.0000 0.6136 114.1980 0.6136 114.3000 0.9102 114.4980 0.9102 114.6000 0.6995 114.7980 0.6995 114.9000 0.9915 115.0980 0.9915 115.2000 0.7132 115.3980 0.7132 115.5000 1.3101 115.6980 1.3101 115.8000 0.5985 115.9980 0.5985 116.1000 0.7398 116.2980 0.7398 116.4000 0.5913 116.5980 0.5913 116.7000 0.6190 116.8980 0.6190 117.0000 0.8524 117.1980 0.8524 117.3000 0.5966 117.4980 0.5966 117.6000 0.6150 117.7980 0.6150 117.9000 0.5868 118.0980 0.5868 118.2000 1.1816 118.3980 1.1816 118.5000 0.6194 118.6980 0.6194 118.8000 1.3419 118.9980 1.3419 119.1000 0.6056 119.2980 0.6056 119.4000 1.1514 119.5980 1.1514 119.7000 0.6160 119.8980 0.6160 120.0000 1.1558 120.1980 1.1558 120.3000 0.6247 120.4980 0.6247 120.6000 0.9282 120.7980 0.9282 120.9000 0.5998 121.0980 0.5998 121.2000 1.1919 121.3980 1.1919 121.5000 0.6068 121.6980 0.6068 121.8000 1.0710 121.9980 1.0710 122.1000 0.6236 122.2980 0.6236 122.4000 0.9793 122.5980 0.9793 122.7000 0.6006 122.8980 0.6006 123.0000 0.8397 123.1980 0.8397 123.3000 0.9624 123.4980 0.9624 123.6000 1.0401 123.7980 1.0401 123.9000 0.7296 124.0980 0.7296 124.2000 1.4246 124.3980 1.4246 124.5000 0.5968 124.6980 0.5968 124.8000 0.8478 124.9980 0.8478 125.1000 0.6984 125.2980 0.6984 125.4000 1.0998 125.5980 1.0998 125.7000 0.6467 125.8980 0.6467 126.0000 0.5559 126.1980 0.5559 126.3000 0.6529 126.4980 0.6529 126.6000 1.1880 126.7980 1.1880 126.9000 0.5955 127.0980 0.5955 127.2000 0.5732 127.3980 0.5732 127.5000 0.6107 127.6980 0.6107 127.8000 1.1202 127.9980 1.1202 128.1000 1.4030 128.2980 1.4030 128.4000 0.5745 128.5980 0.5745 128.7000 1.0638 128.8980 1.0638 129.0000 1.0247 129.1980 1.0247 129.3000 1.1806 129.4980 1.1806 129.6000 0.6085 129.7980 0.6085 129.9000 1.3180 130.0980 1.3180 130.2000 0.5514 130.3980 0.5514 130.5000 0.7238 130.6980 0.7238 130.8000 0.7537 130.9980 0.7537 131.1000 1.2783 131.2980 1.2783 131.4000 0.6066 131.5980 0.6066 131.7000 0.5095 131.8980 0.5095 132.0000 1.4333 132.1980 1.4333 132.3000 0.8570 132.4980 0.8570 132.6000 0.6176 132.7980 0.6176 132.9000 0.9701 133.0980 0.9701 133.2000 0.6528 133.3980 0.6528 133.5000 1.1509 133.6980 1.1509 133.8000 1.0184 133.9980 1.0184 134.1000 0.4468 134.2980 0.4468 134.4000 0.6256 134.5980 0.6256 134.7000 1.0163 134.8980 1.0163 135.0000 0.9945 135.1980 0.9945 135.3000 0.6057 135.4980 0.6057 135.6000 0.6136 135.7980 0.6136 135.9000 0.9102 136.0980 0.9102 136.2000 0.6995 136.3980 0.6995 136.5000 0.9915 136.6980 0.9915 136.8000 0.7132 136.9980 0.7132 137.1000 1.3101 137.2980 1.3101 137.4000 0.5985 137.5980 0.5985 137.7000 0.7398 137.8980 0.7398 138.0000 0.5913 138.1980 0.5913 138.3000 0.6190 138.4980 0.6190 138.6000 0.8524 138.7980 0.8524 138.9000 0.5966 139.0980 0.5966 139.2000 0.6150 139.3980 0.6150 139.5000 0.5868 139.6980 0.5868 139.8000 1.1816 139.9980 1.1816 140.1000 0.6194 140.2980 0.6194 140.4000 1.3419 140.5980 1.3419 140.7000 0.6056 140.8980 0.6056 141.0000 1.1514 141.1980 1.1514 141.3000 0.6160 141.4980 0.6160 141.6000 1.1558 141.7980 1.1558 141.9000 0.6247 142.0980 0.6247 142.2000 0.9282 142.3980 0.9282 142.5000 0.5998 142.6980 0.5998 142.8000 1.1919 142.9980 1.1919 143.1000 0.6068 143.2980 0.6068 143.4000 1.0710 143.5980 1.0710 143.7000 0.6236 143.8980 0.6236 144.0000 0.9793 144.1980 0.9793 144.3000 0.6006 144.4980 0.6006 144.6000 0.8397 144.7980 0.8397 144.9000 0.9624 145.0980 0.9624 145.2000 1.0401 145.3980 1.0401 145.5000 0.7296 145.6980 0.7296 145.8000 1.4246 145.9980 1.4246 146.1000 0.5968 146.2980 0.5968 146.4000 0.8478 146.5980 0.8478 146.7000 0.6984 146.8980 0.6984 147.0000 1.0998 147.1980 1.0998 147.3000 0.6467 147.4980 0.6467 147.6000 0.5559 147.7980 0.5559 147.9000 0.6529 148.0980 0.6529 148.2000 1.1880 148.3980 1.1880 148.5000 0.5955 148.6980 0.5955 148.8000 0.5732 148.9980 0.5732 149.1000 0.6107 149.2980 0.6107 149.4000 1.1202 149.5980 1.1202 149.7000 1.4030 149.8980 1.4030 150.0000 0.5745 150.1980 0.5745 150.3000 1.0638 150.4980 1.0638 150.6000 1.0247 150.7980 1.0247 150.9000 1.1806 151.0980 1.1806 151.2000 0.6085 151.3980 0.6085 151.5000 1.3180 151.6980 1.3180 151.8000 0.5514 151.9980 0.5514 152.1000 0.7238 152.2980 0.7238 152.4000 0.7537 152.5980 0.7537 152.7000 1.2783 152.8980 1.2783 153.0000 0.6066 153.1980 0.6066 153.3000 0.5095 153.4980 0.5095 153.6000 1.4333 153.7980 1.4333 153.9000 0.8570 154.0980 0.8570 154.2000 0.6176 154.3980 0.6176 154.5000 0.9701 154.6980 0.9701 154.8000 0.6528 154.9980 0.6528 155.1000 1.1509 155.2980 1.1509 155.4000 1.0184 155.5980 1.0184 155.7000 0.4468 155.8980 0.4468 156.0000 0.6256 156.1980 0.6256 156.3000 1.0163 156.4980 1.0163 156.6000 0.9945 156.7980 0.9945 156.9000 0.6057 157.0980 0.6057 157.2000 0.6136 157.3980 0.6136 157.5000 0.9102 157.6980 0.9102 157.8000 0.6995 157.9980 0.6995 158.1000 0.9915 158.2980 0.9915 158.4000 0.7132 158.5980 0.7132 158.7000 1.3101 158.8980 1.3101 159.0000 0.5985 159.1980 0.5985 159.3000 0.7398 159.4980 0.7398 159.6000 0.5913 159.7980 0.5913 159.9000 0.6190 160.0980 0.6190 160.2000 0.8524 160.3980 0.8524 160.5000 0.5966 160.6980 0.5966 160.8000 0.6150 160.9980 0.6150 161.1000 0.5868 161.2980 0.5868 161.4000 1.1816 161.5980 1.1816 161.7000 0.6194 161.8980 0.6194 162.0000 1.3419 162.1980 1.3419 162.3000 0.6056 162.4980 0.6056 162.6000 1.1514 162.7980 1.1514 162.9000 0.6160 163.0980 0.6160 163.2000 1.1558 163.3980 1.1558 163.5000 0.6247 163.6980 0.6247 163.8000 0.9282 163.9980 0.9282 164.1000 0.5998 164.2980 0.5998 164.4000 1.1919 164.5980 1.1919 164.7000 0.6068 164.8980 0.6068 165.0000 1.0710 165.1980 1.0710 165.3000 0.6236 165.4980 0.6236 165.6000 0.9793 165.7980 0.9793 165.9000 0.6006 166.0980 0.6006 166.2000 0.8397 166.3980 0.8397 166.5000 0.9624 166.6980 0.9624 166.8000 1.0401 166.9980 1.0401 167.1000 0.7296 167.2980 0.7296 167.4000 1.4246 167.5980 1.4246 167.7000 0.5968 167.8980 0.5968 168.0000 0.8478 168.1980 0.8478 168.3000 0.6984 168.4980 0.6984 168.6000 1.0998 168.7980 1.0998 168.9000 0.6467 169.0980 0.6467 169.2000 0.5559 169.3980 0.5559 169.5000 0.6529 169.6980 0.6529 169.8000 1.1880 169.9980 1.1880 170.1000 0.5955 170.2980 0.5955 170.4000 0.5732 170.5980 0.5732 170.7000 0.6107 170.8980 0.6107 171.0000 1.1202 171.1980 1.1202 171.3000 1.4030 171.4980 1.4030 171.6000 0.5745 171.7980 0.5745 171.9000 1.0638 172.0980 1.0638 172.2000 1.0247 172.3980 1.0247 172.5000 1.1806 172.6980 1.1806 172.8000 0.6085 172.9980 0.6085 173.1000 1.3180 173.2980 1.3180 173.4000 0.5514 173.5980 0.5514 173.7000 0.7238 173.8980 0.7238 174.0000 0.7537 174.1980 0.7537 174.3000 1.2783 174.4980 1.2783 174.6000 0.6066 174.7980 0.6066 174.9000 0.5095 175.0980 0.5095 175.2000 1.4333 175.3980 1.4333 175.5000 0.8570 175.6980 0.8570 175.8000 0.6176 175.9980 0.6176 176.1000 0.9701 176.2980 0.9701 176.4000 0.6528 176.5980 0.6528 176.7000 1.1509 176.8980 1.1509 177.0000 1.0184 177.1980 1.0184 177.3000 0.4468 177.4980 0.4468 177.6000 0.6256 177.7980 0.6256 177.9000 1.0163 178.0980 1.0163 178.2000 0.9945 178.3980 0.9945 178.5000 0.6057 178.6980 0.6057 178.8000 0.6136 178.9980 0.6136 179.1000 0.9102 179.2980 0.9102 179.4000 0.6995 179.5980 0.6995 179.7000 0.9915 179.8980 0.9915 180.0000 0.7132 180.1980 0.7132 180.3000 1.3101 180.4980 1.3101 180.6000 0.5985 180.7980 0.5985 180.9000 0.7398 181.0980 0.7398 181.2000 0.5913 181.3980 0.5913 181.5000 0.6190 181.6980 0.6190 181.8000 0.8524 181.9980 0.8524 182.1000 0.5966 182.2980 0.5966 182.4000 0.6150 182.5980 0.6150 182.7000 0.5868 182.8980 0.5868 183.0000 1.1816 183.1980 1.1816 183.3000 0.6194 183.4980 0.6194 183.6000 1.3419 183.7980 1.3419 183.9000 0.6056 184.0980 0.6056 184.2000 1.1514 184.3980 1.1514 184.5000 0.6160 184.6980 0.6160 184.8000 1.1558 184.9980 1.1558 185.1000 0.6247 185.2980 0.6247 185.4000 0.9282 185.5980 0.9282 185.7000 0.5998 185.8980 0.5998 186.0000 1.1919 186.1980 1.1919 186.3000 0.6068 186.4980 0.6068 186.6000 1.0710 186.7980 1.0710 186.9000 0.6236 187.0980 0.6236 187.2000 0.9793 187.3980 0.9793 187.5000 0.6006 187.6980 0.6006 187.8000 0.8397 187.9980 0.8397 188.1000 0.9624 188.2980 0.9624 188.4000 1.0401 188.5980 1.0401 188.7000 0.7296 188.8980 0.7296 189.0000 1.4246 189.1980 1.4246 189.3000 0.5968 189.4980 0.5968 189.6000 0.8478 189.7980 0.8478 189.9000 0.6984 190.0980 0.6984 190.2000 1.0998 190.3980 1.0998 190.5000 0.6467 190.6980 0.6467 190.8000 0.5559 190.9980 0.5559 191.1000 0.6529 191.2980 0.6529 191.4000 1.1880 191.5980 1.1880 191.7000 0.5955 191.8980 0.5955 192.0000 0.5732 192.1980 0.5732 192.3000 0.6107 192.4980 0.6107 192.6000 1.1202 192.7980 1.1202 192.9000 1.4030 193.0980 1.4030 193.2000 0.5745 193.3980 0.5745 193.5000 1.0638 193.6980 1.0638 193.8000 1.0247 193.9980 1.0247 194.1000 1.1806 194.2980 1.1806 194.4000 0.6085 194.5980 0.6085 194.7000 1.3180 194.8980 1.3180 195.0000 0.5514 195.1980 0.5514 195.3000 0.7238 195.4980 0.7238 195.6000 0.7537 195.7980 0.7537 195.9000 1.2783 196.0980 1.2783 196.2000 0.6066 196.3980 0.6066 196.5000 0.5095 196.6980 0.5095 196.8000 1.4333 196.9980 1.4333 197.1000 0.8570 197.2980 0.8570 197.4000 0.6176 197.5980 0.6176 197.7000 0.9701 197.8980 0.9701 198.0000 0.6528 198.1980 0.6528 198.3000 1.1509 198.4980 1.1509 198.6000 1.0184 198.7980 1.0184 198.9000 0.4468 199.0980 0.4468 199.2000 0.6256 199.3980 0.6256 199.5000 1.0163 199.6980 1.0163 199.8000 0.9945 199.9980 0.9945 200.1000 0.6057 200.2980 0.6057 200.4000 0.6136 200.5980 0.6136 200.7000 0.9102 200.8980 0.9102 201.0000 0.6995 201.1980 0.6995 201.3000 0.9915 201.4980 0.9915 201.6000 0.7132 201.7980 0.7132 201.9000 1.3101 202.0980 1.3101 202.2000 0.5985 202.3980 0.5985 202.5000 0.7398 202.6980 0.7398 202.8000 0.5913 202.9980 0.5913 203.1000 0.6190 203.2980 0.6190 203.4000 0.8524 203.5980 0.8524 203.7000 0.5966 203.8980 0.5966 204.0000 0.6150 204.1980 0.6150 204.3000 0.5868 204.4980 0.5868 204.6000 1.1816 204.7980 1.1816 204.9000 0.6194 205.0980 0.6194 205.2000 1.3419 205.3980 1.3419 205.5000 0.6056 205.6980 0.6056 205.8000 1.1514 205.9980 1.1514 206.1000 0.6160 206.2980 0.6160 206.4000 1.1558 206.5980 1.1558 206.7000 0.6247 206.8980 0.6247 207.0000 0.9282 207.1980 0.9282 207.3000 0.5998 207.4980 0.5998 207.6000 1.1919 207.7980 1.1919 207.9000 0.6068 208.0980 0.6068 208.2000 1.0710 208.3980 1.0710 208.5000 0.6236 208.6980 0.6236 208.8000 0.9793 208.9980 0.9793 209.1000 0.6006 209.2980 0.6006 209.4000 0.8397 209.5980 0.8397 209.7000 0.9624 209.8980 0.9624 210.0000 1.0401 210.1980 1.0401 210.3000 0.7296 210.4980 0.7296 210.6000 1.4246 210.7980 1.4246 210.9000 0.5968 211.0980 0.5968 211.2000 0.8478 211.3980 0.8478 211.5000 0.6984 211.6980 0.6984 211.8000 1.0998 211.9980 1.0998 212.1000 0.6467 212.2980 0.6467 212.4000 0.5559 212.5980 0.5559 212.7000 0.6529 212.8980 0.6529 213.0000 1.1880 213.1980 1.1880 213.3000 0.5955 213.4980 0.5955 213.6000 0.5732 213.7980 0.5732 213.9000 0.6107 214.0980 0.6107 214.2000 1.1202 214.3980 1.1202 214.5000 1.4030 214.6980 1.4030 214.8000 0.5745 214.9980 0.5745 215.1000 1.0638 215.2980 1.0638 215.4000 1.0247 215.5980 1.0247 215.7000 1.1806 215.8980 1.1806 216.0000 0.6085 216.1980 0.6085 216.3000 1.3180 216.4980 1.3180 216.6000 0.5514 216.7980 0.5514 216.9000 0.7238 217.0980 0.7238 217.2000 0.7537 217.3980 0.7537 217.5000 1.2783 217.6980 1.2783 217.8000 0.6066 217.9980 0.6066 218.1000 0.5095 218.2980 0.5095 218.4000 1.4333 218.5980 1.4333 218.7000 0.8570 218.8980 0.8570 219.0000 0.6176 219.1980 0.6176 219.3000 0.9701 219.4980 0.9701 219.6000 0.6528 219.7980 0.6528 219.9000 1.1509 220.0980 1.1509 220.2000 1.0184 220.3980 1.0184 220.5000 0.4468 220.6980 0.4468 220.8000 0.6256 220.9980 0.6256 221.1000 1.0163 221.2980 1.0163 221.4000 0.9945 221.5980 0.9945 221.7000 0.6057 221.8980 0.6057 222.0000 0.6136 222.1980 0.6136 222.3000 0.9102 222.4980 0.9102 222.6000 0.6995 222.7980 0.6995 222.9000 0.9915 223.0980 0.9915 223.2000 0.7132 223.3980 0.7132 223.5000 1.3101 223.6980 1.3101 223.8000 0.5985 223.9980 0.5985 224.1000 0.7398 224.2980 0.7398 224.4000 0.5913 224.5980 0.5913 224.7000 0.6190 224.8980 0.6190 225.0000 0.8524 225.1980 0.8524 225.3000 0.5966 225.4980 0.5966 225.6000 0.6150 225.7980 0.6150 225.9000 0.5868 226.0980 0.5868 226.2000 1.1816 226.3980 1.1816 226.5000 0.6194 226.6980 0.6194 226.8000 1.3419 226.9980 1.3419 227.1000 0.6056 227.2980 0.6056 227.4000 1.1514 227.5980 1.1514 227.7000 0.6160 227.8980 0.6160 228.0000 1.1558 228.1980 1.1558 228.3000 0.6247 228.4980 0.6247 228.6000 0.9282 228.7980 0.9282 228.9000 0.5998 229.0980 0.5998 229.2000 1.1919 229.3980 1.1919 229.5000 0.6068 229.6980 0.6068 229.8000 1.0710 229.9980 1.0710 230.1000 0.6236 230.2980 0.6236 230.4000 0.9793 230.5980 0.9793 230.7000 0.6006 230.8980 0.6006 231.0000 0.8397 231.1980 0.8397 231.3000 0.9624 231.4980 0.9624 231.6000 1.0401 231.7980 1.0401 231.9000 0.7296 232.0980 0.7296 232.2000 1.4246 232.3980 1.4246 232.5000 0.5968 232.6980 0.5968 232.8000 0.8478 232.9980 0.8478 233.1000 0.6984 233.2980 0.6984 233.4000 1.0998 233.5980 1.0998 233.7000 0.6467 233.8980 0.6467 234.0000 0.5559 234.1980 0.5559 234.3000 0.6529 234.4980 0.6529 234.6000 1.1880 234.7980 1.1880 234.9000 0.5955 235.0980 0.5955 235.2000 0.5732 235.3980 0.5732 235.5000 0.6107 235.6980 0.6107 235.8000 1.1202 235.9980 1.1202 236.1000 1.4030 236.2980 1.4030 236.4000 0.5745 236.5980 0.5745 236.7000 1.0638 236.8980 1.0638 237.0000 1.0247 237.1980 1.0247 237.3000 1.1806 237.4980 1.1806 237.6000 0.6085 237.7980 0.6085 237.9000 1.3180 238.0980 1.3180 238.2000 0.5514 238.3980 0.5514 238.5000 0.7238 238.6980 0.7238 238.8000 0.7537 238.9980 0.7537 239.1000 1.2783 239.2980 1.2783 239.4000 0.6066 239.5980 0.6066 239.7000 0.5095 239.8980 0.5095 240.0000 1.4333 240.1980 1.4333 240.3000 0.8570 240.4980 0.8570 240.6000 0.6176 240.7980 0.6176 240.9000 0.9701 241.0980 0.9701 241.2000 0.6528 241.3980 0.6528 241.5000 1.1509 241.6980 1.1509 241.8000 1.0184 241.9980 1.0184 242.1000 0.4468 242.2980 0.4468 242.4000 0.6256 242.5980 0.6256 242.7000 1.0163 242.8980 1.0163 243.0000 0.9945 243.1980 0.9945 243.3000 0.6057 243.4980 0.6057 243.6000 0.6136 243.7980 0.6136 243.9000 0.9102 244.0980 0.9102 244.2000 0.6995 244.3980 0.6995 244.5000 0.9915 244.6980 0.9915 244.8000 0.7132 244.9980 0.7132 245.1000 1.3101 245.2980 1.3101 245.4000 0.5985 245.5980 0.5985 245.7000 0.7398 245.8980 0.7398 246.0000 0.5913 246.1980 0.5913 246.3000 0.6190 246.4980 0.6190 246.6000 0.8524 246.7980 0.8524 246.9000 0.5966 247.0980 0.5966 247.2000 0.6150 247.3980 0.6150 247.5000 0.5868 247.6980 0.5868 247.8000 1.1816 247.9980 1.1816 248.1000 0.6194 248.2980 0.6194 248.4000 1.3419 248.5980 1.3419 248.7000 0.6056 248.8980 0.6056 249.0000 1.1514 249.1980 1.1514 249.3000 0.6160 249.4980 0.6160 249.6000 1.1558 249.7980 1.1558 249.9000 0.6247 250.0980 0.6247 250.2000 0.9282 250.3980 0.9282 250.5000 0.5998 250.6980 0.5998 250.8000 1.1919 250.9980 1.1919 251.1000 0.6068 251.2980 0.6068 251.4000 1.0710 251.5980 1.0710 251.7000 0.6236 251.8980 0.6236 252.0000 0.9793 252.1980 0.9793 252.3000 0.6006 252.4980 0.6006 252.6000 0.8397 252.7980 0.8397 252.9000 0.9624 253.0980 0.9624 253.2000 1.0401 253.3980 1.0401 253.5000 0.7296 253.6980 0.7296 253.8000 1.4246 253.9980 1.4246 254.1000 0.5968 254.2980 0.5968 254.4000 0.8478 254.5980 0.8478 254.7000 0.6984 254.8980 0.6984 255.0000 1.0998 255.1980 1.0998 255.3000 0.6467 255.4980 0.6467 255.6000 0.5559 255.7980 0.5559 255.9000 0.6529 256.0980 0.6529 256.2000 1.1880 256.3980 1.1880 256.5000 0.5955 256.6980 0.5955 256.8000 0.5732 256.9980 0.5732 257.1000 0.6107 257.2980 0.6107 257.4000 1.1202 257.5980 1.1202 257.7000 1.4030 257.8980 1.4030 258.0000 0.5745 258.1980 0.5745 258.3000 1.0638 258.4980 1.0638 258.6000 1.0247 258.7980 1.0247 258.9000 1.1806 259.0980 1.1806 259.2000 0.6085 259.3980 0.6085 259.5000 1.3180 259.6980 1.3180 259.8000 0.5514 259.9980 0.5514 260.1000 0.7238 260.2980 0.7238 260.4000 0.7537 260.5980 0.7537 260.7000 1.2783 260.8980 1.2783 261.0000 0.6066 261.1980 0.6066 261.3000 0.5095 261.4980 0.5095 261.6000 1.4333 261.7980 1.4333 261.9000 0.8570 262.0980 0.8570 262.2000 0.6176 262.3980 0.6176 262.5000 0.9701 262.6980 0.9701 262.8000 0.6528 262.9980 0.6528 263.1000 1.1509 263.2980 1.1509 263.4000 1.0184 263.5980 1.0184 263.7000 0.4468 263.8980 0.4468 264.0000 0.6256 264.1980 0.6256 264.3000 1.0163 264.4980 1.0163 264.6000 0.9945 264.7980 0.9945 264.9000 0.6057 265.0980 0.6057 265.2000 0.6136 265.3980 0.6136 265.5000 0.9102 265.6980 0.9102 265.8000 0.6995 265.9980 0.6995 266.1000 0.9915 266.2980 0.9915 266.4000 0.7132 266.5980 0.7132 266.7000 1.3101 266.8980 1.3101 267.0000 0.5985 267.1980 0.5985 267.3000 0.7398 267.4980 0.7398 267.6000 0.5913 267.7980 0.5913 267.9000 0.6190 268.0980 0.6190 268.2000 0.8524 268.3980 0.8524 268.5000 0.5966 268.6980 0.5966 268.8000 0.6150 268.9980 0.6150 269.1000 0.5868 269.2980 0.5868 269.4000 1.1816 269.5980 1.1816 269.7000 0.6194 269.8980 0.6194 270.0000 1.3419 270.1980 1.3419 270.3000 0.6056 270.4980 0.6056 270.6000 1.1514 270.7980 1.1514 270.9000 0.6160 271.0980 0.6160 271.2000 1.1558 271.3980 1.1558 271.5000 0.6247 271.6980 0.6247 271.8000 0.9282 271.9980 0.9282 272.1000 0.5998 272.2980 0.5998 272.4000 1.1919 272.5980 1.1919 272.7000 0.6068 272.8980 0.6068 273.0000 1.0710 273.1980 1.0710 273.3000 0.6236 273.4980 0.6236 273.6000 0.9793 273.7980 0.9793 273.9000 0.6006 274.0980 0.6006 274.2000 0.8397 274.3980 0.8397 274.5000 0.9624 274.6980 0.9624 274.8000 1.0401 274.9980 1.0401 275.1000 0.7296 275.2980 0.7296 275.4000 1.4246 275.5980 1.4246 275.7000 0.5968 275.8980 0.5968 276.0000 0.8478 276.1980 0.8478 276.3000 0.6984 276.4980 0.6984 276.6000 1.0998 276.7980 1.0998 276.9000 0.6467 277.0980 0.6467 277.2000 0.5559 277.3980 0.5559 277.5000 0.6529 277.6980 0.6529 277.8000 1.1880 277.9980 1.1880 278.1000 0.5955 278.2980 0.5955 278.4000 0.5732 278.5980 0.5732 278.7000 0.6107 278.8980 0.6107 279.0000 1.1202 279.1980 1.1202 279.3000 1.4030 279.4980 1.4030 279.6000 0.5745 279.7980 0.5745 279.9000 1.0638 280.0980 1.0638 280.2000 1.0247 280.3980 1.0247 280.5000 1.1806 280.6980 1.1806 280.8000 0.6085 280.9980 0.6085 281.1000 1.3180 281.2980 1.3180 281.4000 0.5514 281.5980 0.5514 281.7000 0.7238 281.8980 0.7238 282.0000 0.7537 282.1980 0.7537 282.3000 1.2783 282.4980 1.2783 282.6000 0.6066 282.7980 0.6066 282.9000 0.5095 283.0980 0.5095 283.2000 1.4333 283.3980 1.4333 283.5000 0.8570 283.6980 0.8570 283.8000 0.6176 283.9980 0.6176 284.1000 0.9701 284.2980 0.9701 284.4000 0.6528 284.5980 0.6528 284.7000 1.1509 284.8980 1.1509 285.0000 1.0184 285.1980 1.0184 285.3000 0.4468 285.4980 0.4468 285.6000 0.6256 285.7980 0.6256 285.9000 1.0163 286.0980 1.0163 286.2000 0.9945 286.3980 0.9945 286.5000 0.6057 286.6980 0.6057 286.8000 0.6136 286.9980 0.6136 287.1000 0.9102 287.2980 0.9102 287.4000 0.6995 287.5980 0.6995 287.7000 0.9915 287.8980 0.9915 288.0000 0.7132 288.1980 0.7132 288.3000 1.3101 288.4980 1.3101 288.6000 0.5985 288.7980 0.5985 288.9000 0.7398 289.0980 0.7398 289.2000 0.5913 289.3980 0.5913 289.5000 0.6190 289.6980 0.6190 289.8000 0.8524 289.9980 0.8524 290.1000 0.5966 290.2980 0.5966 290.4000 0.6150 290.5980 0.6150 290.7000 0.5868 290.8980 0.5868 291.0000 1.1816 291.1980 1.1816 291.3000 0.6194 291.4980 0.6194 291.6000 1.3419 291.7980 1.3419 291.9000 0.6056 292.0980 0.6056 292.2000 1.1514 292.3980 1.1514 292.5000 0.6160 292.6980 0.6160 292.8000 1.1558 292.9980 1.1558 293.1000 0.6247 293.2980 0.6247 293.4000 0.9282 293.5980 0.9282 293.7000 0.5998 293.8980 0.5998 294.0000 1.1919 294.1980 1.1919 294.3000 0.6068 294.4980 0.6068 294.6000 1.0710 294.7980 1.0710 294.9000 0.6236 295.0980 0.6236 295.2000 0.9793 295.3980 0.9793 295.5000 0.6006 295.6980 0.6006 295.8000 0.8397 295.9980 0.8397 296.1000 0.9624 296.2980 0.9624 296.4000 1.0401 296.5980 1.0401 296.7000 0.7296 296.8980 0.7296 297.0000 1.4246 297.1980 1.4246 297.3000 0.5968 297.4980 0.5968 297.6000 0.8478 297.7980 0.8478 297.9000 0.6984 298.0980 0.6984 298.2000 1.0998 298.3980 1.0998 298.5000 0.6467 298.6980 0.6467 298.8000 0.5559 298.9980 0.5559 299.1000 0.6529 299.2980 0.6529 299.4000 1.1880 299.5980 1.1880 299.7000 0.5955 299.8980 0.5955 300.0000 0.5732 300.1980 0.5732 300.3000 0.6107 300.4980 0.6107 300.6000 1.1202 300.7980 1.1202 300.9000 1.4030 301.0980 1.4030 301.2000 0.5745 301.3980 0.5745 301.5000 1.0638 301.6980 1.0638 301.8000 1.0247 301.9980 1.0247 302.1000 1.1806 302.2980 1.1806 302.4000 0.6085 302.5980 0.6085 302.7000 1.3180 302.8980 1.3180 303.0000 0.5514 303.1980 0.5514 303.3000 0.7238 303.4980 0.7238 303.6000 0.7537 303.7980 0.7537 303.9000 1.2783 304.0980 1.2783 304.2000 0.6066 304.3980 0.6066 304.5000 0.5095 304.6980 0.5095 304.8000 1.4333 304.9980 1.4333 305.1000 0.8570 305.2980 0.8570 305.4000 0.6176 305.5980 0.6176 305.7000 0.9701 305.8980 0.9701 306.0000 0.6528 306.1980 0.6528 306.3000 1.1509 306.4980 1.1509 306.6000 1.0184 306.7980 1.0184 306.9000 0.4468 307.0980 0.4468 307.2000 0.6256 307.3980 0.6256 307.5000 1.0163 307.6980 1.0163 307.8000 0.9945 307.9980 0.9945 308.1000 0.6057 308.2980 0.6057 308.4000 0.6136 308.5980 0.6136 308.7000 0.9102 308.8980 0.9102 309.0000 0.6995 309.1980 0.6995 309.3000 0.9915 309.4980 0.9915 309.6000 0.7132 309.7980 0.7132 309.9000 1.3101 310.0980 1.3101 310.2000 0.5985 310.3980 0.5985 310.5000 0.7398 310.6980 0.7398 310.8000 0.5913 310.9980 0.5913 311.1000 0.6190 311.2980 0.6190 311.4000 0.8524 311.5980 0.8524 311.7000 0.5966 311.8980 0.5966 312.0000 0.6150 312.1980 0.6150 312.3000 0.5868 312.4980 0.5868 312.6000 1.1816 312.7980 1.1816 312.9000 0.6194 313.0980 0.6194 313.2000 1.3419 313.3980 1.3419 313.5000 0.6056 313.6980 0.6056 313.8000 1.1514 313.9980 1.1514 314.1000 0.6160 314.2980 0.6160 314.4000 1.1558 314.5980 1.1558 314.7000 0.6247 314.8980 0.6247 315.0000 0.9282 315.1980 0.9282 315.3000 0.5998 315.4980 0.5998 315.6000 1.1919 315.7980 1.1919 315.9000 0.6068 316.0980 0.6068 316.2000 1.0710 316.3980 1.0710 316.5000 0.6236 316.6980 0.6236 316.8000 0.9793 316.9980 0.9793 317.1000 0.6006 317.2980 0.6006 317.4000 0.8397 317.5980 0.8397 317.7000 0.9624 317.8980 0.9624 318.0000 1.0401 318.1980 1.0401 318.3000 0.7296 318.4980 0.7296 318.6000 1.4246 318.7980 1.4246 318.9000 0.5968 319.0980 0.5968 319.2000 0.8478 319.3980 0.8478 319.5000 0.6984 319.6980 0.6984 319.8000 1.0998 319.9980 1.0998 320.1000 0.6467 320.2980 0.6467 320.4000 0.5559 320.5980 0.5559 320.7000 0.6529 320.8980 0.6529 321.0000 1.1880 321.1980 1.1880 321.3000 0.5955 321.4980 0.5955 321.6000 0.5732 321.7980 0.5732 321.9000 0.6107 322.0980 0.6107 322.2000 1.1202 322.3980 1.1202 322.5000 1.4030 322.6980 1.4030 322.8000 0.5745 322.9980 0.5745 323.1000 1.0638 323.2980 1.0638 323.4000 1.0247 323.5980 1.0247 323.7000 1.1806 323.8980 1.1806 324.0000 0.6085 324.1980 0.6085 324.3000 1.3180 324.4980 1.3180 324.6000 0.5514 324.7980 0.5514 324.9000 0.7238 325.0980 0.7238 325.2000 0.7537 325.3980 0.7537 325.5000 1.2783 325.6980 1.2783 325.8000 0.6066 325.9980 0.6066 326.1000 0.5095 326.2980 0.5095 326.4000 1.4333 326.5980 1.4333 326.7000 0.8570 326.8980 0.8570 327.0000 0.6176 327.1980 0.6176 327.3000 0.9701 327.4980 0.9701 327.6000 0.6528 327.7980 0.6528 327.9000 1.1509 328.0980 1.1509 328.2000 1.0184 328.3980 1.0184 328.5000 0.4468 328.6980 0.4468 328.8000 0.6256 328.9980 0.6256 329.1000 1.0163 329.2980 1.0163 329.4000 0.9945 329.5980 0.9945 329.7000 0.6057 329.8980 0.6057 330.0000 0.6136 330.1980 0.6136 330.3000 0.9102 330.4980 0.9102 330.6000 0.6995 330.7980 0.6995 330.9000 0.9915 331.0980 0.9915 331.2000 0.7132 331.3980 0.7132 331.5000 1.3101 331.6980 1.3101 331.8000 0.5985 331.9980 0.5985 332.1000 0.7398 332.2980 0.7398 332.4000 0.5913 332.5980 0.5913 332.7000 0.6190 332.8980 0.6190 333.0000 0.8524 333.1980 0.8524 333.3000 0.5966 333.4980 0.5966 333.6000 0.6150 333.7980 0.6150 333.9000 0.5868 334.0980 0.5868 334.2000 1.1816 334.3980 1.1816 334.5000 0.6194 334.6980 0.6194 334.8000 1.3419 334.9980 1.3419 335.1000 0.6056 335.2980 0.6056 335.4000 1.1514 335.5980 1.1514 335.7000 0.6160 335.8980 0.6160 336.0000 1.1558 336.1980 1.1558 336.3000 0.6247 336.4980 0.6247 336.6000 0.9282 336.7980 0.9282 336.9000 0.5998 337.0980 0.5998 337.2000 1.1919 337.3980 1.1919 337.5000 0.6068 337.6980 0.6068 337.8000 1.0710 337.9980 1.0710 338.1000 0.6236 338.2980 0.6236 338.4000 0.9793 338.5980 0.9793 338.7000 0.6006 338.8980 0.6006 339.0000 0.8397 339.1980 0.8397 339.3000 0.9624 339.4980 0.9624 339.6000 1.0401 339.7980 1.0401 339.9000 0.7296 340.0980 0.7296 340.2000 1.4246 340.3980 1.4246 340.5000 0.5968 340.6980 0.5968 340.8000 0.8478 340.9980 0.8478 341.1000 0.6984 341.2980 0.6984 341.4000 1.0998 341.5980 1.0998 341.7000 0.6467 341.8980 0.6467 342.0000 0.5559 342.1980 0.5559 342.3000 0.6529 342.4980 0.6529 342.6000 1.1880 342.7980 1.1880 342.9000 0.5955 343.0980 0.5955 343.2000 0.5732 343.3980 0.5732 343.5000 0.6107 343.6980 0.6107 343.8000 1.1202 343.9980 1.1202 344.1000 1.4030 344.2980 1.4030 344.4000 0.5745 344.5980 0.5745 344.7000 1.0638 344.8980 1.0638 345.0000 1.0247 345.1980 1.0247 345.3000 1.1806 345.4980 1.1806 345.6000 0.6085 345.7980 0.6085 345.9000 1.3180 346.0980 1.3180 346.2000 0.5514 346.3980 0.5514 346.5000 0.7238 346.6980 0.7238 346.8000 0.7537 346.9980 0.7537 347.1000 1.2783 347.2980 1.2783 347.4000 0.6066 347.5980 0.6066 347.7000 0.5095 347.8980 0.5095 348.0000 1.4333 348.1980 1.4333 348.3000 0.8570 348.4980 0.8570 348.6000 0.6176 348.7980 0.6176 348.9000 0.9701 349.0980 0.9701 349.2000 0.6528 349.3980 0.6528 349.5000 1.1509 349.6980 1.1509 349.8000 1.0184 349.9980 1.0184 350.1000 0.4468 350.2980 0.4468 350.4000 0.6256 350.5980 0.6256 350.7000 1.0163 350.8980 1.0163 351.0000 0.9945 351.1980 0.9945 351.3000 0.6057 351.4980 0.6057 351.6000 0.6136 351.7980 0.6136 351.9000 0.9102 352.0980 0.9102 352.2000 0.6995 352.3980 0.6995 352.5000 0.9915 352.6980 0.9915 352.8000 0.7132 352.9980 0.7132 353.1000 1.3101 353.2980 1.3101 353.4000 0.5985 353.5980 0.5985 353.7000 0.7398 353.8980 0.7398 354.0000 0.5913 354.1980 0.5913 354.3000 0.6190 354.4980 0.6190 354.6000 0.8524 354.7980 0.8524 354.9000 0.5966 355.0980 0.5966 355.2000 0.6150 355.3980 0.6150 355.5000 0.5868 355.6980 0.5868 355.8000 1.1816 355.9980 1.1816 356.1000 0.6194 356.2980 0.6194 356.4000 1.3419 356.5980 1.3419 356.7000 0.6056 356.8980 0.6056 357.0000 1.1514 357.1980 1.1514 357.3000 0.6160 357.4980 0.6160 357.6000 1.1558 357.7980 1.1558 357.9000 0.6247 358.0980 0.6247 358.2000 0.9282 358.3980 0.9282 358.5000 0.5998 358.6980 0.5998 358.8000 1.1919 358.9980 1.1919 359.1000 0.6068 359.2980 0.6068 359.4000 1.0710 359.5980 1.0710 359.7000 0.6236 359.8980 0.6236 360.0000 0.9793 360.1980 0.9793 360.3000 0.6006 360.4980 0.6006 360.6000 0.8397 360.7980 0.8397 360.9000 0.9624 361.0980 0.9624 361.2000 1.0401 361.3980 1.0401 361.5000 0.7296 361.6980 0.7296 361.8000 1.4246 361.9980 1.4246 362.1000 0.5968 362.2980 0.5968 362.4000 0.8478 362.5980 0.8478 362.7000 0.6984 362.8980 0.6984 363.0000 1.0998 363.1980 1.0998 363.3000 0.6467 363.4980 0.6467 363.6000 0.5559 363.7980 0.5559 363.9000 0.6529 364.0980 0.6529 364.2000 1.1880 364.3980 1.1880 364.5000 0.5955 364.6980 0.5955 364.8000 0.5732 364.9980 0.5732 365.1000 0.6107 365.2980 0.6107 365.4000 1.1202 365.5980 1.1202 365.7000 1.4030 365.8980 1.4030 366.0000 0.5745 366.1980 0.5745 366.3000 1.0638 366.4980 1.0638 366.6000 1.0247 366.7980 1.0247 366.9000 1.1806 367.0980 1.1806 367.2000 0.6085 367.3980 0.6085 367.5000 1.3180 367.6980 1.3180 367.8000 0.5514 367.9980 0.5514 368.1000 0.7238 368.2980 0.7238 368.4000 0.7537 368.5980 0.7537 368.7000 1.2783 368.8980 1.2783 369.0000 0.6066 369.1980 0.6066 369.3000 0.5095 369.4980 0.5095 369.6000 1.4333 369.7980 1.4333 369.9000 0.8570 370.0980 0.8570 370.2000 0.6176 370.3980 0.6176 370.5000 0.9701 370.6980 0.9701 370.8000 0.6528 370.9980 0.6528 371.1000 1.1509 371.2980 1.1509 371.4000 1.0184 371.5980 1.0184 371.7000 0.4468 371.8980 0.4468 372.0000 0.6256 372.1980 0.6256 372.3000 1.0163 372.4980 1.0163 372.6000 0.9945 372.7980 0.9945 372.9000 0.6057 373.0980 0.6057 373.2000 0.6136 373.3980 0.6136 373.5000 0.9102 373.6980 0.9102 373.8000 0.6995 373.9980 0.6995 374.1000 0.9915 374.2980 0.9915 374.4000 0.7132 374.5980 0.7132 374.7000 1.3101 374.8980 1.3101 375.0000 0.5985 375.1980 0.5985 375.3000 0.7398 375.4980 0.7398 375.6000 0.5913 375.7980 0.5913 375.9000 0.6190 376.0980 0.6190 376.2000 0.8524 376.3980 0.8524 376.5000 0.5966 376.6980 0.5966 376.8000 0.6150 376.9980 0.6150 377.1000 0.5868 377.2980 0.5868 377.4000 1.1816 377.5980 1.1816 377.7000 0.6194 377.8980 0.6194 378.0000 1.3419 378.1980 1.3419 378.3000 0.6056 378.4980 0.6056 378.6000 1.1514 378.7980 1.1514 378.9000 0.6160 379.0980 0.6160 379.2000 1.1558 379.3980 1.1558 379.5000 0.6247 379.6980 0.6247 379.8000 0.9282 379.9980 0.9282 380.1000 0.5998 380.2980 0.5998 380.4000 1.1919 380.5980 1.1919 380.7000 0.6068 380.8980 0.6068 381.0000 1.0710 381.1980 1.0710 381.3000 0.6236 381.4980 0.6236 381.6000 0.9793 381.7980 0.9793 381.9000 0.6006 382.0980 0.6006 382.2000 0.8397 382.3980 0.8397 382.5000 0.9624 382.6980 0.9624 382.8000 1.0401 382.9980 1.0401 383.1000 0.7296 383.2980 0.7296 383.4000 1.4246 383.5980 1.4246 383.7000 0.5968 383.8980 0.5968 384.0000 0.8478 384.1980 0.8478 384.3000 0.6984 384.4980 0.6984 384.6000 1.0998 384.7980 1.0998 384.9000 0.6467 385.0980 0.6467 385.2000 0.5559 385.3980 0.5559 385.5000 0.6529 385.6980 0.6529 385.8000 1.1880 385.9980 1.1880 386.1000 0.5955 386.2980 0.5955 386.4000 0.5732 386.5980 0.5732 386.7000 0.6107 386.8980 0.6107 387.0000 1.1202 387.1980 1.1202 387.3000 1.4030 387.4980 1.4030 387.6000 0.5745 387.7980 0.5745 387.9000 1.0638 388.0980 1.0638 388.2000 1.0247 388.3980 1.0247 388.5000 1.1806 388.6980 1.1806 388.8000 0.6085 388.9980 0.6085 389.1000 1.3180 389.2980 1.3180 389.4000 0.5514 389.5980 0.5514 389.7000 0.7238 389.8980 0.7238 390.0000 0.7537 390.1980 0.7537 390.3000 1.2783 390.4980 1.2783 390.6000 0.6066 390.7980 0.6066 390.9000 0.5095 391.0980 0.5095 391.2000 1.4333 391.3980 1.4333 391.5000 0.8570 391.6980 0.8570 391.8000 0.6176 391.9980 0.6176 392.1000 0.9701 392.2980 0.9701 392.4000 0.6528 392.5980 0.6528 392.7000 1.1509 392.8980 1.1509 393.0000 1.0184 393.1980 1.0184 393.3000 0.4468 393.4980 0.4468 393.6000 0.6256 393.7980 0.6256 393.9000 1.0163 394.0980 1.0163 394.2000 0.9945 394.3980 0.9945 394.5000 0.6057 394.6980 0.6057 394.8000 0.6136 394.9980 0.6136 395.1000 0.9102 395.2980 0.9102 395.4000 0.6995 395.5980 0.6995 395.7000 0.9915 395.8980 0.9915 396.0000 0.7132 396.1980 0.7132 396.3000 1.3101 396.4980 1.3101 396.6000 0.5985 396.7980 0.5985 396.9000 0.7398 397.0980 0.7398 397.2000 0.5913 397.3980 0.5913 397.5000 0.6190 397.6980 0.6190 397.8000 0.8524 397.9980 0.8524 398.1000 0.5966 398.2980 0.5966 398.4000 0.6150 398.5980 0.6150 398.7000 0.5868 398.8980 0.5868 399.0000 1.1816 399.1980 1.1816 399.3000 0.6194 399.4980 0.6194 399.6000 1.3419 399.7980 1.3419 399.9000 0.6056 400.0980 0.6056 400.2000 1.1514 400.3980 1.1514 400.5000 0.6160 400.6980 0.6160 400.8000 1.1558 400.9980 1.1558 401.1000 0.6247 401.2980 0.6247 401.4000 0.9282 401.5980 0.9282 401.7000 0.5998 401.8980 0.5998 402.0000 1.1919 402.1980 1.1919 402.3000 0.6068 402.4980 0.6068 402.6000 1.0710 402.7980 1.0710 402.9000 0.6236 403.0980 0.6236 403.2000 0.9793 403.3980 0.9793 403.5000 0.6006 403.6980 0.6006 403.8000 0.8397 403.9980 0.8397 404.1000 0.9624 404.2980 0.9624 404.4000 1.0401 404.5980 1.0401 404.7000 0.7296 404.8980 0.7296 405.0000 1.4246 405.1980 1.4246 405.3000 0.5968 405.4980 0.5968 405.6000 0.8478 405.7980 0.8478 405.9000 0.6984 406.0980 0.6984 406.2000 1.0998 406.3980 1.0998 406.5000 0.6467 406.6980 0.6467 406.8000 0.5559 406.9980 0.5559 407.1000 0.6529 407.2980 0.6529 407.4000 1.1880 407.5980 1.1880 407.7000 0.5955 407.8980 0.5955 408.0000 0.5732 408.1980 0.5732 408.3000 0.6107 408.4980 0.6107 408.6000 1.1202 408.7980 1.1202 408.9000 1.4030 409.0980 1.4030 409.2000 0.5745 409.3980 0.5745 409.5000 1.0638 409.6980 1.0638 409.8000 1.0247 409.9980 1.0247 410.1000 1.1806 410.2980 1.1806 410.4000 0.6085 410.5980 0.6085 410.7000 1.3180 410.8980 1.3180 411.0000 0.5514 411.1980 0.5514 411.3000 0.7238 411.4980 0.7238 411.6000 0.7537 411.7980 0.7537 411.9000 1.2783 412.0980 1.2783 412.2000 0.6066 412.3980 0.6066 412.5000 0.5095 412.6980 0.5095 412.8000 1.4333 412.9980 1.4333 413.1000 0.8570 413.2980 0.8570 413.4000 0.6176 413.5980 0.6176 413.7000 0.9701 413.8980 0.9701 414.0000 0.6528 414.1980 0.6528 414.3000 1.1509 414.4980 1.1509 414.6000 1.0184 414.7980 1.0184 414.9000 0.4468 415.0980 0.4468 415.2000 0.6256 415.3980 0.6256 415.5000 1.0163 415.6980 1.0163 415.8000 0.9945 415.9980 0.9945 416.1000 0.6057 416.2980 0.6057 416.4000 0.6136 416.5980 0.6136 416.7000 0.9102 416.8980 0.9102 417.0000 0.6995 417.1980 0.6995 417.3000 0.9915 417.4980 0.9915 417.6000 0.7132 417.7980 0.7132 417.9000 1.3101 418.0980 1.3101 418.2000 0.5985 418.3980 0.5985 418.5000 0.7398 418.6980 0.7398 418.8000 0.5913 418.9980 0.5913 419.1000 0.6190 419.2980 0.6190 419.4000 0.8524 419.5980 0.8524 419.7000 0.5966 419.8980 0.5966 420.0000 0.6150 420.1980 0.6150 420.3000 0.5868 420.4980 0.5868 420.6000 1.1816 420.7980 1.1816 420.9000 0.6194 421.0980 0.6194 421.2000 1.3419 421.3980 1.3419 421.5000 0.6056 421.6980 0.6056 421.8000 1.1514 421.9980 1.1514 422.1000 0.6160 422.2980 0.6160 422.4000 1.1558 422.5980 1.1558 422.7000 0.6247 422.8980 0.6247 423.0000 0.9282 423.1980 0.9282 423.3000 0.5998 423.4980 0.5998 423.6000 1.1919 423.7980 1.1919 423.9000 0.6068 424.0980 0.6068 424.2000 1.0710 424.3980 1.0710 424.5000 0.6236 424.6980 0.6236 424.8000 0.9793 424.9980 0.9793 425.1000 0.6006 425.2980 0.6006 425.4000 0.8397 425.5980 0.8397 425.7000 0.9624 425.8980 0.9624 426.0000 1.0401 426.1980 1.0401 426.3000 0.7296 426.4980 0.7296 426.6000 1.4246 426.7980 1.4246 426.9000 0.5968 427.0980 0.5968 427.2000 0.8478 427.3980 0.8478 427.5000 0.6984 427.6980 0.6984 427.8000 1.0998 427.9980 1.0998 428.1000 0.6467 428.2980 0.6467 428.4000 0.5559 428.5980 0.5559 428.7000 0.6529 428.8980 0.6529 429.0000 1.1880 429.1980 1.1880 429.3000 0.5955 429.4980 0.5955 429.6000 0.5732 429.7980 0.5732 429.9000 0.6107 430.0980 0.6107 430.2000 1.1202 430.3980 1.1202 430.5000 1.4030 430.6980 1.4030 430.8000 0.5745 430.9980 0.5745 431.1000 1.0638 431.2980 1.0638 431.4000 1.0247 431.5980 1.0247 431.7000 1.1806 431.8980 1.1806 432.0000 0.6085 432.1980 0.6085 432.3000 1.3180 432.4980 1.3180 432.6000 0.5514 432.7980 0.5514 432.9000 0.7238 433.0980 0.7238 433.2000 0.7537 433.3980 0.7537 433.5000 1.2783 433.6980 1.2783 433.8000 0.6066 433.9980 0.6066 434.1000 0.5095 434.2980 0.5095 434.4000 1.4333 434.5980 1.4333 434.7000 0.8570 434.8980 0.8570 435.0000 0.6176 435.1980 0.6176 435.3000 0.9701 435.4980 0.9701 435.6000 0.6528 435.7980 0.6528 435.9000 1.1509 436.0980 1.1509 436.2000 1.0184 436.3980 1.0184 436.5000 0.4468 436.6980 0.4468 436.8000 0.6256 436.9980 0.6256 437.1000 1.0163 437.2980 1.0163 437.4000 0.9945 437.5980 0.9945 437.7000 0.6057 437.8980 0.6057 438.0000 0.6136 438.1980 0.6136 438.3000 0.9102 438.4980 0.9102 438.6000 0.6995 438.7980 0.6995 438.9000 0.9915 439.0980 0.9915 439.2000 0.7132 439.3980 0.7132 439.5000 1.3101 439.6980 1.3101 439.8000 0.5985 439.9980 0.5985 440.1000 0.7398 440.2980 0.7398 440.4000 0.5913 440.5980 0.5913 440.7000 0.6190 440.8980 0.6190 441.0000 0.8524 441.1980 0.8524 441.3000 0.5966 441.4980 0.5966 441.6000 0.6150 441.7980 0.6150 441.9000 0.5868 442.0980 0.5868 442.2000 1.1816 442.3980 1.1816 442.5000 0.6194 442.6980 0.6194 442.8000 1.3419 442.9980 1.3419 443.1000 0.6056 443.2980 0.6056 443.4000 1.1514 443.5980 1.1514 443.7000 0.6160 443.8980 0.6160 444.0000 1.1558 444.1980 1.1558 444.3000 0.6247 444.4980 0.6247 444.6000 0.9282 444.7980 0.9282 444.9000 0.5998 445.0980 0.5998 445.2000 1.1919 445.3980 1.1919 445.5000 0.6068 445.6980 0.6068 445.8000 1.0710 445.9980 1.0710 446.1000 0.6236 446.2980 0.6236 446.4000 0.9793 446.5980 0.9793 446.7000 0.6006 446.8980 0.6006 447.0000 0.8397 447.1980 0.8397 447.3000 0.9624 447.4980 0.9624 447.6000 1.0401 447.7980 1.0401 447.9000 0.7296 448.0980 0.7296 448.2000 1.4246 448.3980 1.4246 448.5000 0.5968 448.6980 0.5968 448.8000 0.8478 448.9980 0.8478 449.1000 0.6984 449.2980 0.6984 449.4000 1.0998 449.5980 1.0998 449.7000 0.6467 449.8980 0.6467 450.0000 0.5559 450.1980 0.5559 450.3000 0.6529 450.4980 0.6529 450.6000 1.1880 450.7980 1.1880 450.9000 0.5955 451.0980 0.5955 451.2000 0.5732 451.3980 0.5732 451.5000 0.6107 451.6980 0.6107 451.8000 1.1202 451.9980 1.1202 452.1000 1.4030 452.2980 1.4030 452.4000 0.5745 452.5980 0.5745 452.7000 1.0638 452.8980 1.0638 453.0000 1.0247 453.1980 1.0247 453.3000 1.1806 453.4980 1.1806 453.6000 0.6085 453.7980 0.6085 453.9000 1.3180 454.0980 1.3180 454.2000 0.5514 454.3980 0.5514 454.5000 0.7238 454.6980 0.7238 454.8000 0.7537 454.9980 0.7537 455.1000 1.2783 455.2980 1.2783 455.4000 0.6066 455.5980 0.6066 455.7000 0.5095 455.8980 0.5095 456.0000 1.4333 456.1980 1.4333 456.3000 0.8570 456.4980 0.8570 456.6000 0.6176 456.7980 0.6176 456.9000 0.9701 457.0980 0.9701 457.2000 0.6528 457.3980 0.6528 457.5000 1.1509 457.6980 1.1509 457.8000 1.0184 457.9980 1.0184 458.1000 0.4468 458.2980 0.4468 458.4000 0.6256 458.5980 0.6256 458.7000 1.0163 458.8980 1.0163 459.0000 0.9945 459.1980 0.9945 459.3000 0.6057 459.4980 0.6057 459.6000 0.6136 459.7980 0.6136 459.9000 0.9102 460.0980 0.9102 460.2000 0.6995 460.3980 0.6995 460.5000 0.9915 460.6980 0.9915 460.8000 0.7132 460.9980 0.7132 461.1000 1.3101 461.2980 1.3101 461.4000 0.5985 461.5980 0.5985 461.7000 0.7398 461.8980 0.7398 462.0000 0.5913 462.1980 0.5913 462.3000 0.6190 462.4980 0.6190 462.6000 0.8524 462.7980 0.8524 462.9000 0.5966 463.0980 0.5966 463.2000 0.6150 463.3980 0.6150 463.5000 0.5868 463.6980 0.5868 463.8000 1.1816 463.9980 1.1816 464.1000 0.6194 464.2980 0.6194 464.4000 1.3419 464.5980 1.3419 464.7000 0.6056 464.8980 0.6056 465.0000 1.1514 465.1980 1.1514 465.3000 0.6160 465.4980 0.6160 465.6000 1.1558 465.7980 1.1558 465.9000 0.6247 466.0980 0.6247 466.2000 0.9282 466.3980 0.9282 466.5000 0.5998 466.6980 0.5998 466.8000 1.1919 466.9980 1.1919 467.1000 0.6068 467.2980 0.6068 467.4000 1.0710 467.5980 1.0710 467.7000 0.6236 467.8980 0.6236 468.0000 0.9793 468.1980 0.9793 468.3000 0.6006 468.4980 0.6006 468.6000 0.8397 468.7980 0.8397 468.9000 0.9624 469.0980 0.9624 469.2000 1.0401 469.3980 1.0401 469.5000 0.7296 469.6980 0.7296 469.8000 1.4246 469.9980 1.4246 470.1000 0.5968 470.2980 0.5968 470.4000 0.8478 470.5980 0.8478 470.7000 0.6984 470.8980 0.6984 471.0000 1.0998 471.1980 1.0998 471.3000 0.6467 471.4980 0.6467 471.6000 0.5559 471.7980 0.5559 471.9000 0.6529 472.0980 0.6529 472.2000 1.1880 472.3980 1.1880 472.5000 0.5955 472.6980 0.5955 472.8000 0.5732 472.9980 0.5732 473.1000 0.6107 473.2980 0.6107 473.4000 1.1202 473.5980 1.1202 473.7000 1.4030 473.8980 1.4030 474.0000 0.5745 474.1980 0.5745 474.3000 1.0638 474.4980 1.0638 474.6000 1.0247 474.7980 1.0247 474.9000 1.1806 475.0980 1.1806 475.2000 0.6085 475.3980 0.6085 475.5000 1.3180 475.6980 1.3180 475.8000 0.5514 475.9980 0.5514 476.1000 0.7238 476.2980 0.7238 476.4000 0.7537 476.5980 0.7537 476.7000 1.2783 476.8980 1.2783 477.0000 0.6066 477.1980 0.6066 477.3000 0.5095 477.4980 0.5095 477.6000 1.4333 477.7980 1.4333 477.9000 0.8570 478.0980 0.8570 478.2000 0.6176 478.3980 0.6176 478.5000 0.9701 478.6980 0.9701 478.8000 0.6528 478.9980 0.6528 479.1000 1.1509 479.2980 1.1509 479.4000 1.0184 479.5980 1.0184 479.7000 0.4468 479.8980 0.4468 480.0000 0.6256 480.1980 0.6256 480.3000 1.0163 480.4980 1.0163 480.6000 0.9945 480.7980 0.9945 480.9000 0.6057 481.0980 0.6057 481.2000 0.6136 481.3980 0.6136 481.5000 0.9102 481.6980 0.9102 481.8000 0.6995 481.9980 0.6995 482.1000 0.9915 482.2980 0.9915 482.4000 0.7132 482.5980 0.7132 482.7000 1.3101 482.8980 1.3101 483.0000 0.5985 483.1980 0.5985 483.3000 0.7398 483.4980 0.7398 483.6000 0.5913 483.7980 0.5913 483.9000 0.6190 484.0980 0.6190 484.2000 0.8524 484.3980 0.8524 484.5000 0.5966 484.6980 0.5966 484.8000 0.6150 484.9980 0.6150 485.1000 0.5868 485.2980 0.5868 485.4000 1.1816 485.5980 1.1816 485.7000 0.6194 485.8980 0.6194 486.0000 1.3419 486.1980 1.3419 486.3000 0.6056 486.4980 0.6056 486.6000 1.1514 486.7980 1.1514 486.9000 0.6160 487.0980 0.6160 487.2000 1.1558 487.3980 1.1558 487.5000 0.6247 487.6980 0.6247 487.8000 0.9282 487.9980 0.9282 488.1000 0.5998 488.2980 0.5998 488.4000 1.1919 488.5980 1.1919 488.7000 0.6068 488.8980 0.6068 489.0000 1.0710 489.1980 1.0710 489.3000 0.6236 489.4980 0.6236 489.6000 0.9793 489.7980 0.9793 489.9000 0.6006 490.0980 0.6006 490.2000 0.8397 490.3980 0.8397 490.5000 0.9624 490.6980 0.9624 490.8000 1.0401 490.9980 1.0401 491.1000 0.7296 491.2980 0.7296 491.4000 1.4246 491.5980 1.4246 491.7000 0.5968 491.8980 0.5968 492.0000 0.8478 492.1980 0.8478 492.3000 0.6984 492.4980 0.6984 492.6000 1.0998 492.7980 1.0998 492.9000 0.6467 493.0980 0.6467 493.2000 0.5559 493.3980 0.5559 493.5000 0.6529 493.6980 0.6529 493.8000 1.1880 493.9980 1.1880 494.1000 0.5955 494.2980 0.5955 494.4000 0.5732 494.5980 0.5732 494.7000 0.6107 494.8980 0.6107 495.0000 1.1202 495.1980 1.1202 495.3000 1.4030 495.4980 1.4030 495.6000 0.5745 495.7980 0.5745 495.9000 1.0638 496.0980 1.0638 496.2000 1.0247 496.3980 1.0247 496.5000 1.1806 496.6980 1.1806 496.8000 0.6085 496.9980 0.6085 497.1000 1.3180 497.2980 1.3180 497.4000 0.5514 497.5980 0.5514 497.7000 0.7238 497.8980 0.7238 498.0000 0.7537 498.1980 0.7537 498.3000 1.2783 498.4980 1.2783 498.6000 0.6066 498.7980 0.6066 498.9000 0.5095 499.0980 0.5095 499.2000 1.4333 499.3980 1.4333 499.5000 0.8570 499.6980 0.8570 499.8000 0.6176 499.9980 0.6176 500.1000 0.9701 500.2980 0.9701 500.4000 0.6528 500.5980 0.6528 500.7000 1.1509 500.8980 1.1509 501.0000 1.0184 501.1980 1.0184 501.3000 0.4468 501.4980 0.4468 501.6000 0.6256 501.7980 0.6256 501.9000 1.0163 502.0980 1.0163 502.2000 0.9945 502.3980 0.9945 502.5000 0.6057 502.6980 0.6057 502.8000 0.6136 502.9980 0.6136 503.1000 0.9102 503.2980 0.9102 503.4000 0.6995 503.5980 0.6995 503.7000 0.9915 503.8980 0.9915 504.0000 0.7132 504.1980 0.7132 504.3000 1.3101 504.4980 1.3101 504.6000 0.5985 504.7980 0.5985 504.9000 0.7398 505.0980 0.7398 505.2000 0.5913 505.3980 0.5913 505.5000 0.6190 505.6980 0.6190 505.8000 0.8524 505.9980 0.8524 506.1000 0.5966 506.2980 0.5966 506.4000 0.6150 506.5980 0.6150 506.7000 0.5868 506.8980 0.5868 507.0000 1.1816 507.1980 1.1816 507.3000 0.6194 507.4980 0.6194 507.6000 1.3419 507.7980 1.3419 507.9000 0.6056 508.0980 0.6056 508.2000 1.1514 508.3980 1.1514 508.5000 0.6160 508.6980 0.6160 508.8000 1.1558 508.9980 1.1558 509.1000 0.6247 509.2980 0.6247 509.4000 0.9282 509.5980 0.9282 509.7000 0.5998 509.8980 0.5998 510.0000 1.1919 510.1980 1.1919 510.3000 0.6068 510.4980 0.6068 510.6000 1.0710 510.7980 1.0710 510.9000 0.6236 511.0980 0.6236 511.2000 0.9793 511.3980 0.9793 511.5000 0.6006 511.6980 0.6006 511.8000 0.8397 511.9980 0.8397 512.1000 0.9624 512.2980 0.9624 512.4000 1.0401 512.5980 1.0401 512.7000 0.7296 512.8980 0.7296 513.0000 1.4246 513.1980 1.4246 513.3000 0.5968 513.4980 0.5968 513.6000 0.8478 513.7980 0.8478 513.9000 0.6984 514.0980 0.6984 514.2000 1.0998 514.3980 1.0998 514.5000 0.6467 514.6980 0.6467 514.8000 0.5559 514.9980 0.5559 515.1000 0.6529 515.2980 0.6529 515.4000 1.1880 515.5980 1.1880 515.7000 0.5955 515.8980 0.5955 516.0000 0.5732 516.1980 0.5732 516.3000 0.6107 516.4980 0.6107 516.6000 1.1202 516.7980 1.1202 516.9000 1.4030 517.0980 1.4030 517.2000 0.5745 517.3980 0.5745 517.5000 1.0638 517.6980 1.0638 517.8000 1.0247 517.9980 1.0247 518.1000 1.1806 518.2980 1.1806 518.4000 0.6085 518.5980 0.6085 518.7000 1.3180 518.8980 1.3180 519.0000 0.5514 519.1980 0.5514 519.3000 0.7238 519.4980 0.7238 519.6000 0.7537 519.7980 0.7537 519.9000 1.2783 520.0980 1.2783 520.2000 0.6066 520.3980 0.6066 520.5000 0.5095 520.6980 0.5095 520.8000 1.4333 520.9980 1.4333 521.1000 0.8570 521.2980 0.8570 521.4000 0.6176 521.5980 0.6176 521.7000 0.9701 521.8980 0.9701 522.0000 0.6528 522.1980 0.6528 522.3000 1.1509 522.4980 1.1509 522.6000 1.0184 522.7980 1.0184 522.9000 0.4468 523.0980 0.4468 523.2000 0.6256 523.3980 0.6256 523.5000 1.0163 523.6980 1.0163 523.8000 0.9945 523.9980 0.9945 524.1000 0.6057 524.2980 0.6057 524.4000 0.6136 524.5980 0.6136 524.7000 0.9102 524.8980 0.9102 525.0000 0.6995 525.1980 0.6995 525.3000 0.9915 525.4980 0.9915 525.6000 0.7132 525.7980 0.7132 525.9000 1.3101 526.0980 1.3101 526.2000 0.5985 526.3980 0.5985 526.5000 0.7398 526.6980 0.7398 526.8000 0.5913 526.9980 0.5913 527.1000 0.6190 527.2980 0.6190 527.4000 0.8524 527.5980 0.8524 527.7000 0.5966 527.8980 0.5966 528.0000 0.6150 528.1980 0.6150 528.3000 0.5868 528.4980 0.5868 528.6000 1.1816 528.7980 1.1816 528.9000 0.6194 529.0980 0.6194 529.2000 1.3419 529.3980 1.3419 529.5000 0.6056 529.6980 0.6056 529.8000 1.1514 529.9980 1.1514 530.1000 0.6160 530.2980 0.6160 530.4000 1.1558 530.5980 1.1558 530.7000 0.6247 530.8980 0.6247 531.0000 0.9282 531.1980 0.9282 531.3000 0.5998 531.4980 0.5998 531.6000 1.1919 531.7980 1.1919 531.9000 0.6068 532.0980 0.6068 532.2000 1.0710 532.3980 1.0710 532.5000 0.6236 532.6980 0.6236 532.8000 0.9793 532.9980 0.9793 533.1000 0.6006 533.2980 0.6006 533.4000 0.8397 533.5980 0.8397 533.7000 0.9624 533.8980 0.9624 534.0000 1.0401 534.1980 1.0401 534.3000 0.7296 534.4980 0.7296 534.6000 1.4246 534.7980 1.4246 534.9000 0.5968 535.0980 0.5968 535.2000 0.8478 535.3980 0.8478 535.5000 0.6984 535.6980 0.6984 535.8000 1.0998 535.9980 1.0998 536.1000 0.6467 536.2980 0.6467 536.4000 0.5559 536.5980 0.5559 536.7000 0.6529 536.8980 0.6529 537.0000 1.1880 537.1980 1.1880 537.3000 0.5955 537.4980 0.5955 537.6000 0.5732 537.7980 0.5732 537.9000 0.6107 538.0980 0.6107 538.2000 1.1202 538.3980 1.1202 538.5000 1.4030 538.6980 1.4030 538.8000 0.5745 538.9980 0.5745 539.1000 1.0638 539.2980 1.0638 539.4000 1.0247 539.5980 1.0247 539.7000 1.1806 539.8980 1.1806 540.0000 0.6085 540.1980 0.6085 540.3000 1.3180 540.4980 1.3180 540.6000 0.5514 540.7980 0.5514 540.9000 0.7238 541.0980 0.7238 541.2000 0.7537 541.3980 0.7537 541.5000 1.2783 541.6980 1.2783 541.8000 0.6066 541.9980 0.6066 542.1000 0.5095 542.2980 0.5095 542.4000 1.4333 542.5980 1.4333 542.7000 0.8570 542.8980 0.8570 543.0000 0.6176 543.1980 0.6176 543.3000 0.9701 543.4980 0.9701 543.6000 0.6528 543.7980 0.6528 543.9000 1.1509 544.0980 1.1509 544.2000 1.0184 544.3980 1.0184 544.5000 0.4468 544.6980 0.4468 544.8000 0.6256 544.9980 0.6256 545.1000 1.0163 545.2980 1.0163 545.4000 0.9945 545.5980 0.9945 545.7000 0.6057 545.8980 0.6057 546.0000 0.6136 546.1980 0.6136 546.3000 0.9102 546.4980 0.9102 546.6000 0.6995 546.7980 0.6995 546.9000 0.9915 547.0980 0.9915 547.2000 0.7132 547.3980 0.7132 547.5000 1.3101 547.6980 1.3101 547.8000 0.5985 547.9980 0.5985 548.1000 0.7398 548.2980 0.7398 548.4000 0.5913 548.5980 0.5913 548.7000 0.6190 548.8980 0.6190 549.0000 0.8524 549.1980 0.8524 549.3000 0.5966 549.4980 0.5966 549.6000 0.6150 549.7980 0.6150 549.9000 0.5868 550.0980 0.5868 550.2000 1.1816 550.3980 1.1816 550.5000 0.6194 550.6980 0.6194 550.8000 1.3419 550.9980 1.3419 551.1000 0.6056 551.2980 0.6056 551.4000 1.1514 551.5980 1.1514 551.7000 0.6160 551.8980 0.6160 552.0000 1.1558 552.1980 1.1558 552.3000 0.6247 552.4980 0.6247 552.6000 0.9282 552.7980 0.9282 552.9000 0.5998 553.0980 0.5998 553.2000 1.1919 553.3980 1.1919 553.5000 0.6068 553.6980 0.6068 553.8000 1.0710 553.9980 1.0710 554.1000 0.6236 554.2980 0.6236 554.4000 0.9793 554.5980 0.9793 554.7000 0.6006 554.8980 0.6006 555.0000 0.8397 555.1980 0.8397 555.3000 0.9624 555.4980 0.9624 555.6000 1.0401 555.7980 1.0401 555.9000 0.7296 556.0980 0.7296 556.2000 1.4246 556.3980 1.4246 556.5000 0.5968 556.6980 0.5968 556.8000 0.8478 556.9980 0.8478 557.1000 0.6984 557.2980 0.6984 557.4000 1.0998 557.5980 1.0998 557.7000 0.6467 557.8980 0.6467 558.0000 0.5559 558.1980 0.5559 558.3000 0.6529 558.4980 0.6529 558.6000 1.1880 558.7980 1.1880 558.9000 0.5955 559.0980 0.5955 559.2000 0.5732 559.3980 0.5732 559.5000 0.6107 559.6980 0.6107 559.8000 1.1202 559.9980 1.1202 560.1000 1.4030 560.2980 1.4030 560.4000 0.5745 560.5980 0.5745 560.7000 1.0638 560.8980 1.0638 561.0000 1.0247 561.1980 1.0247 561.3000 1.1806 561.4980 1.1806 561.6000 0.6085 561.7980 0.6085 561.9000 1.3180 562.0980 1.3180 562.2000 0.5514 562.3980 0.5514 562.5000 0.7238 562.6980 0.7238 562.8000 0.7537 562.9980 0.7537 563.1000 1.2783 563.2980 1.2783 563.4000 0.6066 563.5980 0.6066 563.7000 0.5095 563.8980 0.5095 564.0000 1.4333 564.1980 1.4333 564.3000 0.8570 564.4980 0.8570 564.6000 0.6176 564.7980 0.6176 564.9000 0.9701 565.0980 0.9701 565.2000 0.6528 565.3980 0.6528 565.5000 1.1509 565.6980 1.1509 565.8000 1.0184 565.9980 1.0184 566.1000 0.4468 566.2980 0.4468 566.4000 0.6256 566.5980 0.6256 566.7000 1.0163 566.8980 1.0163 567.0000 0.9945 567.1980 0.9945 567.3000 0.6057 567.4980 0.6057 567.6000 0.6136 567.7980 0.6136 567.9000 0.9102 568.0980 0.9102 568.2000 0.6995 568.3980 0.6995 568.5000 0.9915 568.6980 0.9915 568.8000 0.7132 568.9980 0.7132 569.1000 1.3101 569.2980 1.3101 569.4000 0.5985 569.5980 0.5985 569.7000 0.7398 569.8980 0.7398 570.0000 0.5913 570.1980 0.5913 570.3000 0.6190 570.4980 0.6190 570.6000 0.8524 570.7980 0.8524 570.9000 0.5966 571.0980 0.5966 571.2000 0.6150 571.3980 0.6150 571.5000 0.5868 571.6980 0.5868 571.8000 1.1816 571.9980 1.1816 572.1000 0.6194 572.2980 0.6194 572.4000 1.3419 572.5980 1.3419 572.7000 0.6056 572.8980 0.6056 573.0000 1.1514 573.1980 1.1514 573.3000 0.6160 573.4980 0.6160 573.6000 1.1558 573.7980 1.1558 573.9000 0.6247 574.0980 0.6247 574.2000 0.9282 574.3980 0.9282 574.5000 0.5998 574.6980 0.5998 574.8000 1.1919 574.9980 1.1919 575.1000 0.6068 575.2980 0.6068 575.4000 1.0710 575.5980 1.0710 575.7000 0.6236 575.8980 0.6236 576.0000 0.9793 576.1980 0.9793 576.3000 0.6006 576.4980 0.6006 576.6000 0.8397 576.7980 0.8397 576.9000 0.9624 577.0980 0.9624 577.2000 1.0401 577.3980 1.0401 577.5000 0.7296 577.6980 0.7296 577.8000 1.4246 577.9980 1.4246 578.1000 0.5968 578.2980 0.5968 578.4000 0.8478 578.5980 0.8478 578.7000 0.6984 578.8980 0.6984 579.0000 1.0998 579.1980 1.0998 579.3000 0.6467 579.4980 0.6467 579.6000 0.5559 579.7980 0.5559 579.9000 0.6529 580.0980 0.6529 580.2000 1.1880 580.3980 1.1880 580.5000 0.5955 580.6980 0.5955 580.8000 0.5732 580.9980 0.5732 581.1000 0.6107 581.2980 0.6107 581.4000 1.1202 581.5980 1.1202 581.7000 1.4030 581.8980 1.4030 582.0000 0.5745 582.1980 0.5745 582.3000 1.0638 582.4980 1.0638 582.6000 1.0247 582.7980 1.0247 582.9000 1.1806 583.0980 1.1806 583.2000 0.6085 583.3980 0.6085 583.5000 1.3180 583.6980 1.3180 583.8000 0.5514 583.9980 0.5514 584.1000 0.7238 584.2980 0.7238 584.4000 0.7537 584.5980 0.7537 584.7000 1.2783 584.8980 1.2783 585.0000 0.6066 585.1980 0.6066 585.3000 0.5095 585.4980 0.5095 585.6000 1.4333 585.7980 1.4333 585.9000 0.8570 586.0980 0.8570 586.2000 0.6176 586.3980 0.6176 586.5000 0.9701 586.6980 0.9701 586.8000 0.6528 586.9980 0.6528 587.1000 1.1509 587.2980 1.1509 587.4000 1.0184 587.5980 1.0184 587.7000 0.4468 587.8980 0.4468 588.0000 0.6256 588.1980 0.6256 588.3000 1.0163 588.4980 1.0163 588.6000 0.9945 588.7980 0.9945 588.9000 0.6057 589.0980 0.6057 589.2000 0.6136 589.3980 0.6136 589.5000 0.9102 589.6980 0.9102 589.8000 0.6995 589.9980 0.6995 590.1000 0.9915 590.2980 0.9915 590.4000 0.7132 590.5980 0.7132 590.7000 1.3101 590.8980 1.3101 591.0000 0.5985 591.1980 0.5985 591.3000 0.7398 591.4980 0.7398 591.6000 0.5913 591.7980 0.5913 591.9000 0.6190 592.0980 0.6190 592.2000 0.8524 592.3980 0.8524 592.5000 0.5966 592.6980 0.5966 592.8000 0.6150 592.9980 0.6150 593.1000 0.5868 593.2980 0.5868 593.4000 1.1816 593.5980 1.1816 593.7000 0.6194 593.8980 0.6194 594.0000 1.3419 594.1980 1.3419 594.3000 0.6056 594.4980 0.6056 594.6000 1.1514 594.7980 1.1514 594.9000 0.6160 595.0980 0.6160 595.2000 1.1558 595.3980 1.1558 595.5000 0.6247 595.6980 0.6247 595.8000 0.9282 595.9980 0.9282 596.1000 0.5998 596.2980 0.5998 596.4000 1.1919 596.5980 1.1919 596.7000 0.6068 596.8980 0.6068 597.0000 1.0710 597.1980 1.0710 597.3000 0.6236 597.4980 0.6236 597.6000 0.9793 597.7980 0.9793 597.9000 0.6006 598.0980 0.6006 598.2000 0.8397 598.3980 0.8397 598.5000 0.9624 598.6980 0.9624 598.8000 1.0401 598.9980 1.0401 599.1000 0.7296 599.2980 0.7296 599.4000 1.4246 599.5980 1.4246 599.7000 0.5968 599.8980 0.5968 600.0000 0.5968)
Va15 a15 0 PWL(0.0000 0.3000 0.1980 0.3000 0.3000 0.4885 0.4980 0.4885 0.6000 0.4856 0.7980 0.4856 0.9000 0.4105 1.0980 0.4105 1.2000 0.3627 1.3980 0.3627 1.5000 0.3323 1.6980 0.3323 1.8000 0.3675 1.9980 0.3675 2.1000 0.5095 2.2980 0.5095 2.4000 0.4462 2.5980 0.4462 2.7000 0.3139 2.8980 0.3139 3.0000 0.5457 3.1980 0.5457 3.3000 0.3702 3.4980 0.3702 3.6000 0.4044 3.7980 0.4044 3.9000 0.4060 4.0980 0.4060 4.2000 0.4588 4.3980 0.4588 4.5000 0.3712 4.6980 0.3712 4.8000 0.3843 4.9980 0.3843 5.1000 0.3918 5.2980 0.3918 5.4000 0.3375 5.5980 0.3375 5.7000 0.4569 5.8980 0.4569 6.0000 0.3840 6.1980 0.3840 6.3000 0.5142 6.4980 0.5142 6.6000 0.8335 6.7980 0.8335 6.9000 0.4637 7.0980 0.4637 7.2000 0.5412 7.3980 0.5412 7.5000 0.5887 7.6980 0.5887 7.8000 0.5985 7.9980 0.5985 8.1000 0.5033 8.2980 0.5033 8.4000 0.5913 8.5980 0.5913 8.7000 0.6190 8.8980 0.6190 9.0000 0.5692 9.1980 0.5692 9.3000 0.5961 9.4980 0.5961 9.6000 0.6150 9.7980 0.6150 9.9000 0.5696 10.0980 0.5696 10.2000 0.6065 10.3980 0.6065 10.5000 0.6194 10.6980 0.6194 10.8000 0.5673 10.9980 0.5673 11.1000 0.6056 11.2980 0.6056 11.4000 0.5477 11.5980 0.5477 11.7000 0.5860 11.8980 0.5860 12.0000 0.5723 12.1980 0.5723 12.3000 0.6247 12.4980 0.6247 12.6000 0.5668 12.7980 0.5668 12.9000 0.5998 13.0980 0.5998 13.2000 0.5790 13.3980 0.5790 13.5000 0.6068 13.6980 0.6068 13.8000 0.5960 13.9980 0.5960 14.1000 0.6236 14.2980 0.6236 14.4000 0.5892 14.5980 0.5892 14.7000 0.6006 14.8980 0.6006 15.0000 0.5466 15.1980 0.5466 15.3000 0.5968 15.4980 0.5968 15.6000 0.8374 15.7980 0.8374 15.9000 0.6004 16.0980 0.6004 16.2000 0.5933 16.3980 0.5933 16.5000 0.5768 16.6980 0.5768 16.8000 0.6007 16.9980 0.6007 17.1000 0.6082 17.2980 0.6082 17.4000 0.5745 17.5980 0.5745 17.7000 0.5786 17.8980 0.5786 18.0000 0.5559 18.1980 0.5559 18.3000 0.6088 18.4980 0.6088 18.6000 0.5452 18.7980 0.5452 18.9000 0.5821 19.0980 0.5821 19.2000 0.5732 19.3980 0.5732 19.5000 0.6057 19.6980 0.6057 19.8000 0.5458 19.9980 0.5458 20.1000 0.6020 20.2980 0.6020 20.4000 0.5708 20.5980 0.5708 20.7000 0.5164 20.8980 0.5164 21.0000 0.5718 21.1980 0.5718 21.3000 0.5754 21.4980 0.5754 21.6000 0.3000 21.7980 0.3000 21.9000 0.4885 22.0980 0.4885 22.2000 0.4856 22.3980 0.4856 22.5000 0.4105 22.6980 0.4105 22.8000 0.3627 22.9980 0.3627 23.1000 0.3323 23.2980 0.3323 23.4000 0.3675 23.5980 0.3675 23.7000 0.5095 23.8980 0.5095 24.0000 0.4462 24.1980 0.4462 24.3000 0.3139 24.4980 0.3139 24.6000 0.5457 24.7980 0.5457 24.9000 0.3702 25.0980 0.3702 25.2000 0.4044 25.3980 0.4044 25.5000 0.4060 25.6980 0.4060 25.8000 0.4588 25.9980 0.4588 26.1000 0.3712 26.2980 0.3712 26.4000 0.3843 26.5980 0.3843 26.7000 0.3918 26.8980 0.3918 27.0000 0.3375 27.1980 0.3375 27.3000 0.4569 27.4980 0.4569 27.6000 0.3840 27.7980 0.3840 27.9000 0.5142 28.0980 0.5142 28.2000 0.8335 28.3980 0.8335 28.5000 0.4637 28.6980 0.4637 28.8000 0.5412 28.9980 0.5412 29.1000 0.5887 29.2980 0.5887 29.4000 0.5985 29.5980 0.5985 29.7000 0.5033 29.8980 0.5033 30.0000 0.5913 30.1980 0.5913 30.3000 0.6190 30.4980 0.6190 30.6000 0.5692 30.7980 0.5692 30.9000 0.5961 31.0980 0.5961 31.2000 0.6150 31.3980 0.6150 31.5000 0.5696 31.6980 0.5696 31.8000 0.6065 31.9980 0.6065 32.1000 0.6194 32.2980 0.6194 32.4000 0.5673 32.5980 0.5673 32.7000 0.6056 32.8980 0.6056 33.0000 0.5477 33.1980 0.5477 33.3000 0.5860 33.4980 0.5860 33.6000 0.5723 33.7980 0.5723 33.9000 0.6247 34.0980 0.6247 34.2000 0.5668 34.3980 0.5668 34.5000 0.5998 34.6980 0.5998 34.8000 0.5790 34.9980 0.5790 35.1000 0.6068 35.2980 0.6068 35.4000 0.5960 35.5980 0.5960 35.7000 0.6236 35.8980 0.6236 36.0000 0.5892 36.1980 0.5892 36.3000 0.6006 36.4980 0.6006 36.6000 0.5466 36.7980 0.5466 36.9000 0.5968 37.0980 0.5968 37.2000 0.8374 37.3980 0.8374 37.5000 0.6004 37.6980 0.6004 37.8000 0.5933 37.9980 0.5933 38.1000 0.5768 38.2980 0.5768 38.4000 0.6007 38.5980 0.6007 38.7000 0.6082 38.8980 0.6082 39.0000 0.5745 39.1980 0.5745 39.3000 0.5786 39.4980 0.5786 39.6000 0.5559 39.7980 0.5559 39.9000 0.6088 40.0980 0.6088 40.2000 0.5452 40.3980 0.5452 40.5000 0.5821 40.6980 0.5821 40.8000 0.5732 40.9980 0.5732 41.1000 0.6057 41.2980 0.6057 41.4000 0.5458 41.5980 0.5458 41.7000 0.6020 41.8980 0.6020 42.0000 0.5708 42.1980 0.5708 42.3000 0.5164 42.4980 0.5164 42.6000 0.5718 42.7980 0.5718 42.9000 0.5754 43.0980 0.5754 43.2000 0.3000 43.3980 0.3000 43.5000 0.4885 43.6980 0.4885 43.8000 0.4856 43.9980 0.4856 44.1000 0.4105 44.2980 0.4105 44.4000 0.3627 44.5980 0.3627 44.7000 0.3323 44.8980 0.3323 45.0000 0.3675 45.1980 0.3675 45.3000 0.5095 45.4980 0.5095 45.6000 0.4462 45.7980 0.4462 45.9000 0.3139 46.0980 0.3139 46.2000 0.5457 46.3980 0.5457 46.5000 0.3702 46.6980 0.3702 46.8000 0.4044 46.9980 0.4044 47.1000 0.4060 47.2980 0.4060 47.4000 0.4588 47.5980 0.4588 47.7000 0.3712 47.8980 0.3712 48.0000 0.3843 48.1980 0.3843 48.3000 0.3918 48.4980 0.3918 48.6000 0.3375 48.7980 0.3375 48.9000 0.4569 49.0980 0.4569 49.2000 0.3840 49.3980 0.3840 49.5000 0.5142 49.6980 0.5142 49.8000 0.8335 49.9980 0.8335 50.1000 0.4637 50.2980 0.4637 50.4000 0.5412 50.5980 0.5412 50.7000 0.5887 50.8980 0.5887 51.0000 0.5985 51.1980 0.5985 51.3000 0.5033 51.4980 0.5033 51.6000 0.5913 51.7980 0.5913 51.9000 0.6190 52.0980 0.6190 52.2000 0.5692 52.3980 0.5692 52.5000 0.5961 52.6980 0.5961 52.8000 0.6150 52.9980 0.6150 53.1000 0.5696 53.2980 0.5696 53.4000 0.6065 53.5980 0.6065 53.7000 0.6194 53.8980 0.6194 54.0000 0.5673 54.1980 0.5673 54.3000 0.6056 54.4980 0.6056 54.6000 0.5477 54.7980 0.5477 54.9000 0.5860 55.0980 0.5860 55.2000 0.5723 55.3980 0.5723 55.5000 0.6247 55.6980 0.6247 55.8000 0.5668 55.9980 0.5668 56.1000 0.5998 56.2980 0.5998 56.4000 0.5790 56.5980 0.5790 56.7000 0.6068 56.8980 0.6068 57.0000 0.5960 57.1980 0.5960 57.3000 0.6236 57.4980 0.6236 57.6000 0.5892 57.7980 0.5892 57.9000 0.6006 58.0980 0.6006 58.2000 0.5466 58.3980 0.5466 58.5000 0.5968 58.6980 0.5968 58.8000 0.8374 58.9980 0.8374 59.1000 0.6004 59.2980 0.6004 59.4000 0.5933 59.5980 0.5933 59.7000 0.5768 59.8980 0.5768 60.0000 0.6007 60.1980 0.6007 60.3000 0.6082 60.4980 0.6082 60.6000 0.5745 60.7980 0.5745 60.9000 0.5786 61.0980 0.5786 61.2000 0.5559 61.3980 0.5559 61.5000 0.6088 61.6980 0.6088 61.8000 0.5452 61.9980 0.5452 62.1000 0.5821 62.2980 0.5821 62.4000 0.5732 62.5980 0.5732 62.7000 0.6057 62.8980 0.6057 63.0000 0.5458 63.1980 0.5458 63.3000 0.6020 63.4980 0.6020 63.6000 0.5708 63.7980 0.5708 63.9000 0.5164 64.0980 0.5164 64.2000 0.5718 64.3980 0.5718 64.5000 0.5754 64.6980 0.5754 64.8000 0.3000 64.9980 0.3000 65.1000 0.4885 65.2980 0.4885 65.4000 0.4856 65.5980 0.4856 65.7000 0.4105 65.8980 0.4105 66.0000 0.3627 66.1980 0.3627 66.3000 0.3323 66.4980 0.3323 66.6000 0.3675 66.7980 0.3675 66.9000 0.5095 67.0980 0.5095 67.2000 0.4462 67.3980 0.4462 67.5000 0.3139 67.6980 0.3139 67.8000 0.5457 67.9980 0.5457 68.1000 0.3702 68.2980 0.3702 68.4000 0.4044 68.5980 0.4044 68.7000 0.4060 68.8980 0.4060 69.0000 0.4588 69.1980 0.4588 69.3000 0.3712 69.4980 0.3712 69.6000 0.3843 69.7980 0.3843 69.9000 0.3918 70.0980 0.3918 70.2000 0.3375 70.3980 0.3375 70.5000 0.4569 70.6980 0.4569 70.8000 0.3840 70.9980 0.3840 71.1000 0.5142 71.2980 0.5142 71.4000 0.8335 71.5980 0.8335 71.7000 0.4637 71.8980 0.4637 72.0000 0.5412 72.1980 0.5412 72.3000 0.5887 72.4980 0.5887 72.6000 0.5985 72.7980 0.5985 72.9000 0.5033 73.0980 0.5033 73.2000 0.5913 73.3980 0.5913 73.5000 0.6190 73.6980 0.6190 73.8000 0.5692 73.9980 0.5692 74.1000 0.5961 74.2980 0.5961 74.4000 0.6150 74.5980 0.6150 74.7000 0.5696 74.8980 0.5696 75.0000 0.6065 75.1980 0.6065 75.3000 0.6194 75.4980 0.6194 75.6000 0.5673 75.7980 0.5673 75.9000 0.6056 76.0980 0.6056 76.2000 0.5477 76.3980 0.5477 76.5000 0.5860 76.6980 0.5860 76.8000 0.5723 76.9980 0.5723 77.1000 0.6247 77.2980 0.6247 77.4000 0.5668 77.5980 0.5668 77.7000 0.5998 77.8980 0.5998 78.0000 0.5790 78.1980 0.5790 78.3000 0.6068 78.4980 0.6068 78.6000 0.5960 78.7980 0.5960 78.9000 0.6236 79.0980 0.6236 79.2000 0.5892 79.3980 0.5892 79.5000 0.6006 79.6980 0.6006 79.8000 0.5466 79.9980 0.5466 80.1000 0.5968 80.2980 0.5968 80.4000 0.8374 80.5980 0.8374 80.7000 0.6004 80.8980 0.6004 81.0000 0.5933 81.1980 0.5933 81.3000 0.5768 81.4980 0.5768 81.6000 0.6007 81.7980 0.6007 81.9000 0.6082 82.0980 0.6082 82.2000 0.5745 82.3980 0.5745 82.5000 0.5786 82.6980 0.5786 82.8000 0.5559 82.9980 0.5559 83.1000 0.6088 83.2980 0.6088 83.4000 0.5452 83.5980 0.5452 83.7000 0.5821 83.8980 0.5821 84.0000 0.5732 84.1980 0.5732 84.3000 0.6057 84.4980 0.6057 84.6000 0.5458 84.7980 0.5458 84.9000 0.6020 85.0980 0.6020 85.2000 0.5708 85.3980 0.5708 85.5000 0.5164 85.6980 0.5164 85.8000 0.5718 85.9980 0.5718 86.1000 0.5754 86.2980 0.5754 86.4000 0.3000 86.5980 0.3000 86.7000 0.4885 86.8980 0.4885 87.0000 0.4856 87.1980 0.4856 87.3000 0.4105 87.4980 0.4105 87.6000 0.3627 87.7980 0.3627 87.9000 0.3323 88.0980 0.3323 88.2000 0.3675 88.3980 0.3675 88.5000 0.5095 88.6980 0.5095 88.8000 0.4462 88.9980 0.4462 89.1000 0.3139 89.2980 0.3139 89.4000 0.5457 89.5980 0.5457 89.7000 0.3702 89.8980 0.3702 90.0000 0.4044 90.1980 0.4044 90.3000 0.4060 90.4980 0.4060 90.6000 0.4588 90.7980 0.4588 90.9000 0.3712 91.0980 0.3712 91.2000 0.3843 91.3980 0.3843 91.5000 0.3918 91.6980 0.3918 91.8000 0.3375 91.9980 0.3375 92.1000 0.4569 92.2980 0.4569 92.4000 0.3840 92.5980 0.3840 92.7000 0.5142 92.8980 0.5142 93.0000 0.8335 93.1980 0.8335 93.3000 0.4637 93.4980 0.4637 93.6000 0.5412 93.7980 0.5412 93.9000 0.5887 94.0980 0.5887 94.2000 0.5985 94.3980 0.5985 94.5000 0.5033 94.6980 0.5033 94.8000 0.5913 94.9980 0.5913 95.1000 0.6190 95.2980 0.6190 95.4000 0.5692 95.5980 0.5692 95.7000 0.5961 95.8980 0.5961 96.0000 0.6150 96.1980 0.6150 96.3000 0.5696 96.4980 0.5696 96.6000 0.6065 96.7980 0.6065 96.9000 0.6194 97.0980 0.6194 97.2000 0.5673 97.3980 0.5673 97.5000 0.6056 97.6980 0.6056 97.8000 0.5477 97.9980 0.5477 98.1000 0.5860 98.2980 0.5860 98.4000 0.5723 98.5980 0.5723 98.7000 0.6247 98.8980 0.6247 99.0000 0.5668 99.1980 0.5668 99.3000 0.5998 99.4980 0.5998 99.6000 0.5790 99.7980 0.5790 99.9000 0.6068 100.0980 0.6068 100.2000 0.5960 100.3980 0.5960 100.5000 0.6236 100.6980 0.6236 100.8000 0.5892 100.9980 0.5892 101.1000 0.6006 101.2980 0.6006 101.4000 0.5466 101.5980 0.5466 101.7000 0.5968 101.8980 0.5968 102.0000 0.8374 102.1980 0.8374 102.3000 0.6004 102.4980 0.6004 102.6000 0.5933 102.7980 0.5933 102.9000 0.5768 103.0980 0.5768 103.2000 0.6007 103.3980 0.6007 103.5000 0.6082 103.6980 0.6082 103.8000 0.5745 103.9980 0.5745 104.1000 0.5786 104.2980 0.5786 104.4000 0.5559 104.5980 0.5559 104.7000 0.6088 104.8980 0.6088 105.0000 0.5452 105.1980 0.5452 105.3000 0.5821 105.4980 0.5821 105.6000 0.5732 105.7980 0.5732 105.9000 0.6057 106.0980 0.6057 106.2000 0.5458 106.3980 0.5458 106.5000 0.6020 106.6980 0.6020 106.8000 0.5708 106.9980 0.5708 107.1000 0.5164 107.2980 0.5164 107.4000 0.5718 107.5980 0.5718 107.7000 0.5754 107.8980 0.5754 108.0000 0.3000 108.1980 0.3000 108.3000 0.4885 108.4980 0.4885 108.6000 0.4856 108.7980 0.4856 108.9000 0.4105 109.0980 0.4105 109.2000 0.3627 109.3980 0.3627 109.5000 0.3323 109.6980 0.3323 109.8000 0.3675 109.9980 0.3675 110.1000 0.5095 110.2980 0.5095 110.4000 0.4462 110.5980 0.4462 110.7000 0.3139 110.8980 0.3139 111.0000 0.5457 111.1980 0.5457 111.3000 0.3702 111.4980 0.3702 111.6000 0.4044 111.7980 0.4044 111.9000 0.4060 112.0980 0.4060 112.2000 0.4588 112.3980 0.4588 112.5000 0.3712 112.6980 0.3712 112.8000 0.3843 112.9980 0.3843 113.1000 0.3918 113.2980 0.3918 113.4000 0.3375 113.5980 0.3375 113.7000 0.4569 113.8980 0.4569 114.0000 0.3840 114.1980 0.3840 114.3000 0.5142 114.4980 0.5142 114.6000 0.8335 114.7980 0.8335 114.9000 0.4637 115.0980 0.4637 115.2000 0.5412 115.3980 0.5412 115.5000 0.5887 115.6980 0.5887 115.8000 0.5985 115.9980 0.5985 116.1000 0.5033 116.2980 0.5033 116.4000 0.5913 116.5980 0.5913 116.7000 0.6190 116.8980 0.6190 117.0000 0.5692 117.1980 0.5692 117.3000 0.5961 117.4980 0.5961 117.6000 0.6150 117.7980 0.6150 117.9000 0.5696 118.0980 0.5696 118.2000 0.6065 118.3980 0.6065 118.5000 0.6194 118.6980 0.6194 118.8000 0.5673 118.9980 0.5673 119.1000 0.6056 119.2980 0.6056 119.4000 0.5477 119.5980 0.5477 119.7000 0.5860 119.8980 0.5860 120.0000 0.5723 120.1980 0.5723 120.3000 0.6247 120.4980 0.6247 120.6000 0.5668 120.7980 0.5668 120.9000 0.5998 121.0980 0.5998 121.2000 0.5790 121.3980 0.5790 121.5000 0.6068 121.6980 0.6068 121.8000 0.5960 121.9980 0.5960 122.1000 0.6236 122.2980 0.6236 122.4000 0.5892 122.5980 0.5892 122.7000 0.6006 122.8980 0.6006 123.0000 0.5466 123.1980 0.5466 123.3000 0.5968 123.4980 0.5968 123.6000 0.8374 123.7980 0.8374 123.9000 0.6004 124.0980 0.6004 124.2000 0.5933 124.3980 0.5933 124.5000 0.5768 124.6980 0.5768 124.8000 0.6007 124.9980 0.6007 125.1000 0.6082 125.2980 0.6082 125.4000 0.5745 125.5980 0.5745 125.7000 0.5786 125.8980 0.5786 126.0000 0.5559 126.1980 0.5559 126.3000 0.6088 126.4980 0.6088 126.6000 0.5452 126.7980 0.5452 126.9000 0.5821 127.0980 0.5821 127.2000 0.5732 127.3980 0.5732 127.5000 0.6057 127.6980 0.6057 127.8000 0.5458 127.9980 0.5458 128.1000 0.6020 128.2980 0.6020 128.4000 0.5708 128.5980 0.5708 128.7000 0.5164 128.8980 0.5164 129.0000 0.5718 129.1980 0.5718 129.3000 0.5754 129.4980 0.5754 129.6000 0.3000 129.7980 0.3000 129.9000 0.4885 130.0980 0.4885 130.2000 0.4856 130.3980 0.4856 130.5000 0.4105 130.6980 0.4105 130.8000 0.3627 130.9980 0.3627 131.1000 0.3323 131.2980 0.3323 131.4000 0.3675 131.5980 0.3675 131.7000 0.5095 131.8980 0.5095 132.0000 0.4462 132.1980 0.4462 132.3000 0.3139 132.4980 0.3139 132.6000 0.5457 132.7980 0.5457 132.9000 0.3702 133.0980 0.3702 133.2000 0.4044 133.3980 0.4044 133.5000 0.4060 133.6980 0.4060 133.8000 0.4588 133.9980 0.4588 134.1000 0.3712 134.2980 0.3712 134.4000 0.3843 134.5980 0.3843 134.7000 0.3918 134.8980 0.3918 135.0000 0.3375 135.1980 0.3375 135.3000 0.4569 135.4980 0.4569 135.6000 0.3840 135.7980 0.3840 135.9000 0.5142 136.0980 0.5142 136.2000 0.8335 136.3980 0.8335 136.5000 0.4637 136.6980 0.4637 136.8000 0.5412 136.9980 0.5412 137.1000 0.5887 137.2980 0.5887 137.4000 0.5985 137.5980 0.5985 137.7000 0.5033 137.8980 0.5033 138.0000 0.5913 138.1980 0.5913 138.3000 0.6190 138.4980 0.6190 138.6000 0.5692 138.7980 0.5692 138.9000 0.5961 139.0980 0.5961 139.2000 0.6150 139.3980 0.6150 139.5000 0.5696 139.6980 0.5696 139.8000 0.6065 139.9980 0.6065 140.1000 0.6194 140.2980 0.6194 140.4000 0.5673 140.5980 0.5673 140.7000 0.6056 140.8980 0.6056 141.0000 0.5477 141.1980 0.5477 141.3000 0.5860 141.4980 0.5860 141.6000 0.5723 141.7980 0.5723 141.9000 0.6247 142.0980 0.6247 142.2000 0.5668 142.3980 0.5668 142.5000 0.5998 142.6980 0.5998 142.8000 0.5790 142.9980 0.5790 143.1000 0.6068 143.2980 0.6068 143.4000 0.5960 143.5980 0.5960 143.7000 0.6236 143.8980 0.6236 144.0000 0.5892 144.1980 0.5892 144.3000 0.6006 144.4980 0.6006 144.6000 0.5466 144.7980 0.5466 144.9000 0.5968 145.0980 0.5968 145.2000 0.8374 145.3980 0.8374 145.5000 0.6004 145.6980 0.6004 145.8000 0.5933 145.9980 0.5933 146.1000 0.5768 146.2980 0.5768 146.4000 0.6007 146.5980 0.6007 146.7000 0.6082 146.8980 0.6082 147.0000 0.5745 147.1980 0.5745 147.3000 0.5786 147.4980 0.5786 147.6000 0.5559 147.7980 0.5559 147.9000 0.6088 148.0980 0.6088 148.2000 0.5452 148.3980 0.5452 148.5000 0.5821 148.6980 0.5821 148.8000 0.5732 148.9980 0.5732 149.1000 0.6057 149.2980 0.6057 149.4000 0.5458 149.5980 0.5458 149.7000 0.6020 149.8980 0.6020 150.0000 0.5708 150.1980 0.5708 150.3000 0.5164 150.4980 0.5164 150.6000 0.5718 150.7980 0.5718 150.9000 0.5754 151.0980 0.5754 151.2000 0.3000 151.3980 0.3000 151.5000 0.4885 151.6980 0.4885 151.8000 0.4856 151.9980 0.4856 152.1000 0.4105 152.2980 0.4105 152.4000 0.3627 152.5980 0.3627 152.7000 0.3323 152.8980 0.3323 153.0000 0.3675 153.1980 0.3675 153.3000 0.5095 153.4980 0.5095 153.6000 0.4462 153.7980 0.4462 153.9000 0.3139 154.0980 0.3139 154.2000 0.5457 154.3980 0.5457 154.5000 0.3702 154.6980 0.3702 154.8000 0.4044 154.9980 0.4044 155.1000 0.4060 155.2980 0.4060 155.4000 0.4588 155.5980 0.4588 155.7000 0.3712 155.8980 0.3712 156.0000 0.3843 156.1980 0.3843 156.3000 0.3918 156.4980 0.3918 156.6000 0.3375 156.7980 0.3375 156.9000 0.4569 157.0980 0.4569 157.2000 0.3840 157.3980 0.3840 157.5000 0.5142 157.6980 0.5142 157.8000 0.8335 157.9980 0.8335 158.1000 0.4637 158.2980 0.4637 158.4000 0.5412 158.5980 0.5412 158.7000 0.5887 158.8980 0.5887 159.0000 0.5985 159.1980 0.5985 159.3000 0.5033 159.4980 0.5033 159.6000 0.5913 159.7980 0.5913 159.9000 0.6190 160.0980 0.6190 160.2000 0.5692 160.3980 0.5692 160.5000 0.5961 160.6980 0.5961 160.8000 0.6150 160.9980 0.6150 161.1000 0.5696 161.2980 0.5696 161.4000 0.6065 161.5980 0.6065 161.7000 0.6194 161.8980 0.6194 162.0000 0.5673 162.1980 0.5673 162.3000 0.6056 162.4980 0.6056 162.6000 0.5477 162.7980 0.5477 162.9000 0.5860 163.0980 0.5860 163.2000 0.5723 163.3980 0.5723 163.5000 0.6247 163.6980 0.6247 163.8000 0.5668 163.9980 0.5668 164.1000 0.5998 164.2980 0.5998 164.4000 0.5790 164.5980 0.5790 164.7000 0.6068 164.8980 0.6068 165.0000 0.5960 165.1980 0.5960 165.3000 0.6236 165.4980 0.6236 165.6000 0.5892 165.7980 0.5892 165.9000 0.6006 166.0980 0.6006 166.2000 0.5466 166.3980 0.5466 166.5000 0.5968 166.6980 0.5968 166.8000 0.8374 166.9980 0.8374 167.1000 0.6004 167.2980 0.6004 167.4000 0.5933 167.5980 0.5933 167.7000 0.5768 167.8980 0.5768 168.0000 0.6007 168.1980 0.6007 168.3000 0.6082 168.4980 0.6082 168.6000 0.5745 168.7980 0.5745 168.9000 0.5786 169.0980 0.5786 169.2000 0.5559 169.3980 0.5559 169.5000 0.6088 169.6980 0.6088 169.8000 0.5452 169.9980 0.5452 170.1000 0.5821 170.2980 0.5821 170.4000 0.5732 170.5980 0.5732 170.7000 0.6057 170.8980 0.6057 171.0000 0.5458 171.1980 0.5458 171.3000 0.6020 171.4980 0.6020 171.6000 0.5708 171.7980 0.5708 171.9000 0.5164 172.0980 0.5164 172.2000 0.5718 172.3980 0.5718 172.5000 0.5754 172.6980 0.5754 172.8000 0.3000 172.9980 0.3000 173.1000 0.4885 173.2980 0.4885 173.4000 0.4856 173.5980 0.4856 173.7000 0.4105 173.8980 0.4105 174.0000 0.3627 174.1980 0.3627 174.3000 0.3323 174.4980 0.3323 174.6000 0.3675 174.7980 0.3675 174.9000 0.5095 175.0980 0.5095 175.2000 0.4462 175.3980 0.4462 175.5000 0.3139 175.6980 0.3139 175.8000 0.5457 175.9980 0.5457 176.1000 0.3702 176.2980 0.3702 176.4000 0.4044 176.5980 0.4044 176.7000 0.4060 176.8980 0.4060 177.0000 0.4588 177.1980 0.4588 177.3000 0.3712 177.4980 0.3712 177.6000 0.3843 177.7980 0.3843 177.9000 0.3918 178.0980 0.3918 178.2000 0.3375 178.3980 0.3375 178.5000 0.4569 178.6980 0.4569 178.8000 0.3840 178.9980 0.3840 179.1000 0.5142 179.2980 0.5142 179.4000 0.8335 179.5980 0.8335 179.7000 0.4637 179.8980 0.4637 180.0000 0.5412 180.1980 0.5412 180.3000 0.5887 180.4980 0.5887 180.6000 0.5985 180.7980 0.5985 180.9000 0.5033 181.0980 0.5033 181.2000 0.5913 181.3980 0.5913 181.5000 0.6190 181.6980 0.6190 181.8000 0.5692 181.9980 0.5692 182.1000 0.5961 182.2980 0.5961 182.4000 0.6150 182.5980 0.6150 182.7000 0.5696 182.8980 0.5696 183.0000 0.6065 183.1980 0.6065 183.3000 0.6194 183.4980 0.6194 183.6000 0.5673 183.7980 0.5673 183.9000 0.6056 184.0980 0.6056 184.2000 0.5477 184.3980 0.5477 184.5000 0.5860 184.6980 0.5860 184.8000 0.5723 184.9980 0.5723 185.1000 0.6247 185.2980 0.6247 185.4000 0.5668 185.5980 0.5668 185.7000 0.5998 185.8980 0.5998 186.0000 0.5790 186.1980 0.5790 186.3000 0.6068 186.4980 0.6068 186.6000 0.5960 186.7980 0.5960 186.9000 0.6236 187.0980 0.6236 187.2000 0.5892 187.3980 0.5892 187.5000 0.6006 187.6980 0.6006 187.8000 0.5466 187.9980 0.5466 188.1000 0.5968 188.2980 0.5968 188.4000 0.8374 188.5980 0.8374 188.7000 0.6004 188.8980 0.6004 189.0000 0.5933 189.1980 0.5933 189.3000 0.5768 189.4980 0.5768 189.6000 0.6007 189.7980 0.6007 189.9000 0.6082 190.0980 0.6082 190.2000 0.5745 190.3980 0.5745 190.5000 0.5786 190.6980 0.5786 190.8000 0.5559 190.9980 0.5559 191.1000 0.6088 191.2980 0.6088 191.4000 0.5452 191.5980 0.5452 191.7000 0.5821 191.8980 0.5821 192.0000 0.5732 192.1980 0.5732 192.3000 0.6057 192.4980 0.6057 192.6000 0.5458 192.7980 0.5458 192.9000 0.6020 193.0980 0.6020 193.2000 0.5708 193.3980 0.5708 193.5000 0.5164 193.6980 0.5164 193.8000 0.5718 193.9980 0.5718 194.1000 0.5754 194.2980 0.5754 194.4000 0.3000 194.5980 0.3000 194.7000 0.4885 194.8980 0.4885 195.0000 0.4856 195.1980 0.4856 195.3000 0.4105 195.4980 0.4105 195.6000 0.3627 195.7980 0.3627 195.9000 0.3323 196.0980 0.3323 196.2000 0.3675 196.3980 0.3675 196.5000 0.5095 196.6980 0.5095 196.8000 0.4462 196.9980 0.4462 197.1000 0.3139 197.2980 0.3139 197.4000 0.5457 197.5980 0.5457 197.7000 0.3702 197.8980 0.3702 198.0000 0.4044 198.1980 0.4044 198.3000 0.4060 198.4980 0.4060 198.6000 0.4588 198.7980 0.4588 198.9000 0.3712 199.0980 0.3712 199.2000 0.3843 199.3980 0.3843 199.5000 0.3918 199.6980 0.3918 199.8000 0.3375 199.9980 0.3375 200.1000 0.4569 200.2980 0.4569 200.4000 0.3840 200.5980 0.3840 200.7000 0.5142 200.8980 0.5142 201.0000 0.8335 201.1980 0.8335 201.3000 0.4637 201.4980 0.4637 201.6000 0.5412 201.7980 0.5412 201.9000 0.5887 202.0980 0.5887 202.2000 0.5985 202.3980 0.5985 202.5000 0.5033 202.6980 0.5033 202.8000 0.5913 202.9980 0.5913 203.1000 0.6190 203.2980 0.6190 203.4000 0.5692 203.5980 0.5692 203.7000 0.5961 203.8980 0.5961 204.0000 0.6150 204.1980 0.6150 204.3000 0.5696 204.4980 0.5696 204.6000 0.6065 204.7980 0.6065 204.9000 0.6194 205.0980 0.6194 205.2000 0.5673 205.3980 0.5673 205.5000 0.6056 205.6980 0.6056 205.8000 0.5477 205.9980 0.5477 206.1000 0.5860 206.2980 0.5860 206.4000 0.5723 206.5980 0.5723 206.7000 0.6247 206.8980 0.6247 207.0000 0.5668 207.1980 0.5668 207.3000 0.5998 207.4980 0.5998 207.6000 0.5790 207.7980 0.5790 207.9000 0.6068 208.0980 0.6068 208.2000 0.5960 208.3980 0.5960 208.5000 0.6236 208.6980 0.6236 208.8000 0.5892 208.9980 0.5892 209.1000 0.6006 209.2980 0.6006 209.4000 0.5466 209.5980 0.5466 209.7000 0.5968 209.8980 0.5968 210.0000 0.8374 210.1980 0.8374 210.3000 0.6004 210.4980 0.6004 210.6000 0.5933 210.7980 0.5933 210.9000 0.5768 211.0980 0.5768 211.2000 0.6007 211.3980 0.6007 211.5000 0.6082 211.6980 0.6082 211.8000 0.5745 211.9980 0.5745 212.1000 0.5786 212.2980 0.5786 212.4000 0.5559 212.5980 0.5559 212.7000 0.6088 212.8980 0.6088 213.0000 0.5452 213.1980 0.5452 213.3000 0.5821 213.4980 0.5821 213.6000 0.5732 213.7980 0.5732 213.9000 0.6057 214.0980 0.6057 214.2000 0.5458 214.3980 0.5458 214.5000 0.6020 214.6980 0.6020 214.8000 0.5708 214.9980 0.5708 215.1000 0.5164 215.2980 0.5164 215.4000 0.5718 215.5980 0.5718 215.7000 0.5754 215.8980 0.5754 216.0000 0.3000 216.1980 0.3000 216.3000 0.4885 216.4980 0.4885 216.6000 0.4856 216.7980 0.4856 216.9000 0.4105 217.0980 0.4105 217.2000 0.3627 217.3980 0.3627 217.5000 0.3323 217.6980 0.3323 217.8000 0.3675 217.9980 0.3675 218.1000 0.5095 218.2980 0.5095 218.4000 0.4462 218.5980 0.4462 218.7000 0.3139 218.8980 0.3139 219.0000 0.5457 219.1980 0.5457 219.3000 0.3702 219.4980 0.3702 219.6000 0.4044 219.7980 0.4044 219.9000 0.4060 220.0980 0.4060 220.2000 0.4588 220.3980 0.4588 220.5000 0.3712 220.6980 0.3712 220.8000 0.3843 220.9980 0.3843 221.1000 0.3918 221.2980 0.3918 221.4000 0.3375 221.5980 0.3375 221.7000 0.4569 221.8980 0.4569 222.0000 0.3840 222.1980 0.3840 222.3000 0.5142 222.4980 0.5142 222.6000 0.8335 222.7980 0.8335 222.9000 0.4637 223.0980 0.4637 223.2000 0.5412 223.3980 0.5412 223.5000 0.5887 223.6980 0.5887 223.8000 0.5985 223.9980 0.5985 224.1000 0.5033 224.2980 0.5033 224.4000 0.5913 224.5980 0.5913 224.7000 0.6190 224.8980 0.6190 225.0000 0.5692 225.1980 0.5692 225.3000 0.5961 225.4980 0.5961 225.6000 0.6150 225.7980 0.6150 225.9000 0.5696 226.0980 0.5696 226.2000 0.6065 226.3980 0.6065 226.5000 0.6194 226.6980 0.6194 226.8000 0.5673 226.9980 0.5673 227.1000 0.6056 227.2980 0.6056 227.4000 0.5477 227.5980 0.5477 227.7000 0.5860 227.8980 0.5860 228.0000 0.5723 228.1980 0.5723 228.3000 0.6247 228.4980 0.6247 228.6000 0.5668 228.7980 0.5668 228.9000 0.5998 229.0980 0.5998 229.2000 0.5790 229.3980 0.5790 229.5000 0.6068 229.6980 0.6068 229.8000 0.5960 229.9980 0.5960 230.1000 0.6236 230.2980 0.6236 230.4000 0.5892 230.5980 0.5892 230.7000 0.6006 230.8980 0.6006 231.0000 0.5466 231.1980 0.5466 231.3000 0.5968 231.4980 0.5968 231.6000 0.8374 231.7980 0.8374 231.9000 0.6004 232.0980 0.6004 232.2000 0.5933 232.3980 0.5933 232.5000 0.5768 232.6980 0.5768 232.8000 0.6007 232.9980 0.6007 233.1000 0.6082 233.2980 0.6082 233.4000 0.5745 233.5980 0.5745 233.7000 0.5786 233.8980 0.5786 234.0000 0.5559 234.1980 0.5559 234.3000 0.6088 234.4980 0.6088 234.6000 0.5452 234.7980 0.5452 234.9000 0.5821 235.0980 0.5821 235.2000 0.5732 235.3980 0.5732 235.5000 0.6057 235.6980 0.6057 235.8000 0.5458 235.9980 0.5458 236.1000 0.6020 236.2980 0.6020 236.4000 0.5708 236.5980 0.5708 236.7000 0.5164 236.8980 0.5164 237.0000 0.5718 237.1980 0.5718 237.3000 0.5754 237.4980 0.5754 237.6000 0.3000 237.7980 0.3000 237.9000 0.4885 238.0980 0.4885 238.2000 0.4856 238.3980 0.4856 238.5000 0.4105 238.6980 0.4105 238.8000 0.3627 238.9980 0.3627 239.1000 0.3323 239.2980 0.3323 239.4000 0.3675 239.5980 0.3675 239.7000 0.5095 239.8980 0.5095 240.0000 0.4462 240.1980 0.4462 240.3000 0.3139 240.4980 0.3139 240.6000 0.5457 240.7980 0.5457 240.9000 0.3702 241.0980 0.3702 241.2000 0.4044 241.3980 0.4044 241.5000 0.4060 241.6980 0.4060 241.8000 0.4588 241.9980 0.4588 242.1000 0.3712 242.2980 0.3712 242.4000 0.3843 242.5980 0.3843 242.7000 0.3918 242.8980 0.3918 243.0000 0.3375 243.1980 0.3375 243.3000 0.4569 243.4980 0.4569 243.6000 0.3840 243.7980 0.3840 243.9000 0.5142 244.0980 0.5142 244.2000 0.8335 244.3980 0.8335 244.5000 0.4637 244.6980 0.4637 244.8000 0.5412 244.9980 0.5412 245.1000 0.5887 245.2980 0.5887 245.4000 0.5985 245.5980 0.5985 245.7000 0.5033 245.8980 0.5033 246.0000 0.5913 246.1980 0.5913 246.3000 0.6190 246.4980 0.6190 246.6000 0.5692 246.7980 0.5692 246.9000 0.5961 247.0980 0.5961 247.2000 0.6150 247.3980 0.6150 247.5000 0.5696 247.6980 0.5696 247.8000 0.6065 247.9980 0.6065 248.1000 0.6194 248.2980 0.6194 248.4000 0.5673 248.5980 0.5673 248.7000 0.6056 248.8980 0.6056 249.0000 0.5477 249.1980 0.5477 249.3000 0.5860 249.4980 0.5860 249.6000 0.5723 249.7980 0.5723 249.9000 0.6247 250.0980 0.6247 250.2000 0.5668 250.3980 0.5668 250.5000 0.5998 250.6980 0.5998 250.8000 0.5790 250.9980 0.5790 251.1000 0.6068 251.2980 0.6068 251.4000 0.5960 251.5980 0.5960 251.7000 0.6236 251.8980 0.6236 252.0000 0.5892 252.1980 0.5892 252.3000 0.6006 252.4980 0.6006 252.6000 0.5466 252.7980 0.5466 252.9000 0.5968 253.0980 0.5968 253.2000 0.8374 253.3980 0.8374 253.5000 0.6004 253.6980 0.6004 253.8000 0.5933 253.9980 0.5933 254.1000 0.5768 254.2980 0.5768 254.4000 0.6007 254.5980 0.6007 254.7000 0.6082 254.8980 0.6082 255.0000 0.5745 255.1980 0.5745 255.3000 0.5786 255.4980 0.5786 255.6000 0.5559 255.7980 0.5559 255.9000 0.6088 256.0980 0.6088 256.2000 0.5452 256.3980 0.5452 256.5000 0.5821 256.6980 0.5821 256.8000 0.5732 256.9980 0.5732 257.1000 0.6057 257.2980 0.6057 257.4000 0.5458 257.5980 0.5458 257.7000 0.6020 257.8980 0.6020 258.0000 0.5708 258.1980 0.5708 258.3000 0.5164 258.4980 0.5164 258.6000 0.5718 258.7980 0.5718 258.9000 0.5754 259.0980 0.5754 259.2000 0.3000 259.3980 0.3000 259.5000 0.4885 259.6980 0.4885 259.8000 0.4856 259.9980 0.4856 260.1000 0.4105 260.2980 0.4105 260.4000 0.3627 260.5980 0.3627 260.7000 0.3323 260.8980 0.3323 261.0000 0.3675 261.1980 0.3675 261.3000 0.5095 261.4980 0.5095 261.6000 0.4462 261.7980 0.4462 261.9000 0.3139 262.0980 0.3139 262.2000 0.5457 262.3980 0.5457 262.5000 0.3702 262.6980 0.3702 262.8000 0.4044 262.9980 0.4044 263.1000 0.4060 263.2980 0.4060 263.4000 0.4588 263.5980 0.4588 263.7000 0.3712 263.8980 0.3712 264.0000 0.3843 264.1980 0.3843 264.3000 0.3918 264.4980 0.3918 264.6000 0.3375 264.7980 0.3375 264.9000 0.4569 265.0980 0.4569 265.2000 0.3840 265.3980 0.3840 265.5000 0.5142 265.6980 0.5142 265.8000 0.8335 265.9980 0.8335 266.1000 0.4637 266.2980 0.4637 266.4000 0.5412 266.5980 0.5412 266.7000 0.5887 266.8980 0.5887 267.0000 0.5985 267.1980 0.5985 267.3000 0.5033 267.4980 0.5033 267.6000 0.5913 267.7980 0.5913 267.9000 0.6190 268.0980 0.6190 268.2000 0.5692 268.3980 0.5692 268.5000 0.5961 268.6980 0.5961 268.8000 0.6150 268.9980 0.6150 269.1000 0.5696 269.2980 0.5696 269.4000 0.6065 269.5980 0.6065 269.7000 0.6194 269.8980 0.6194 270.0000 0.5673 270.1980 0.5673 270.3000 0.6056 270.4980 0.6056 270.6000 0.5477 270.7980 0.5477 270.9000 0.5860 271.0980 0.5860 271.2000 0.5723 271.3980 0.5723 271.5000 0.6247 271.6980 0.6247 271.8000 0.5668 271.9980 0.5668 272.1000 0.5998 272.2980 0.5998 272.4000 0.5790 272.5980 0.5790 272.7000 0.6068 272.8980 0.6068 273.0000 0.5960 273.1980 0.5960 273.3000 0.6236 273.4980 0.6236 273.6000 0.5892 273.7980 0.5892 273.9000 0.6006 274.0980 0.6006 274.2000 0.5466 274.3980 0.5466 274.5000 0.5968 274.6980 0.5968 274.8000 0.8374 274.9980 0.8374 275.1000 0.6004 275.2980 0.6004 275.4000 0.5933 275.5980 0.5933 275.7000 0.5768 275.8980 0.5768 276.0000 0.6007 276.1980 0.6007 276.3000 0.6082 276.4980 0.6082 276.6000 0.5745 276.7980 0.5745 276.9000 0.5786 277.0980 0.5786 277.2000 0.5559 277.3980 0.5559 277.5000 0.6088 277.6980 0.6088 277.8000 0.5452 277.9980 0.5452 278.1000 0.5821 278.2980 0.5821 278.4000 0.5732 278.5980 0.5732 278.7000 0.6057 278.8980 0.6057 279.0000 0.5458 279.1980 0.5458 279.3000 0.6020 279.4980 0.6020 279.6000 0.5708 279.7980 0.5708 279.9000 0.5164 280.0980 0.5164 280.2000 0.5718 280.3980 0.5718 280.5000 0.5754 280.6980 0.5754 280.8000 0.3000 280.9980 0.3000 281.1000 0.4885 281.2980 0.4885 281.4000 0.4856 281.5980 0.4856 281.7000 0.4105 281.8980 0.4105 282.0000 0.3627 282.1980 0.3627 282.3000 0.3323 282.4980 0.3323 282.6000 0.3675 282.7980 0.3675 282.9000 0.5095 283.0980 0.5095 283.2000 0.4462 283.3980 0.4462 283.5000 0.3139 283.6980 0.3139 283.8000 0.5457 283.9980 0.5457 284.1000 0.3702 284.2980 0.3702 284.4000 0.4044 284.5980 0.4044 284.7000 0.4060 284.8980 0.4060 285.0000 0.4588 285.1980 0.4588 285.3000 0.3712 285.4980 0.3712 285.6000 0.3843 285.7980 0.3843 285.9000 0.3918 286.0980 0.3918 286.2000 0.3375 286.3980 0.3375 286.5000 0.4569 286.6980 0.4569 286.8000 0.3840 286.9980 0.3840 287.1000 0.5142 287.2980 0.5142 287.4000 0.8335 287.5980 0.8335 287.7000 0.4637 287.8980 0.4637 288.0000 0.5412 288.1980 0.5412 288.3000 0.5887 288.4980 0.5887 288.6000 0.5985 288.7980 0.5985 288.9000 0.5033 289.0980 0.5033 289.2000 0.5913 289.3980 0.5913 289.5000 0.6190 289.6980 0.6190 289.8000 0.5692 289.9980 0.5692 290.1000 0.5961 290.2980 0.5961 290.4000 0.6150 290.5980 0.6150 290.7000 0.5696 290.8980 0.5696 291.0000 0.6065 291.1980 0.6065 291.3000 0.6194 291.4980 0.6194 291.6000 0.5673 291.7980 0.5673 291.9000 0.6056 292.0980 0.6056 292.2000 0.5477 292.3980 0.5477 292.5000 0.5860 292.6980 0.5860 292.8000 0.5723 292.9980 0.5723 293.1000 0.6247 293.2980 0.6247 293.4000 0.5668 293.5980 0.5668 293.7000 0.5998 293.8980 0.5998 294.0000 0.5790 294.1980 0.5790 294.3000 0.6068 294.4980 0.6068 294.6000 0.5960 294.7980 0.5960 294.9000 0.6236 295.0980 0.6236 295.2000 0.5892 295.3980 0.5892 295.5000 0.6006 295.6980 0.6006 295.8000 0.5466 295.9980 0.5466 296.1000 0.5968 296.2980 0.5968 296.4000 0.8374 296.5980 0.8374 296.7000 0.6004 296.8980 0.6004 297.0000 0.5933 297.1980 0.5933 297.3000 0.5768 297.4980 0.5768 297.6000 0.6007 297.7980 0.6007 297.9000 0.6082 298.0980 0.6082 298.2000 0.5745 298.3980 0.5745 298.5000 0.5786 298.6980 0.5786 298.8000 0.5559 298.9980 0.5559 299.1000 0.6088 299.2980 0.6088 299.4000 0.5452 299.5980 0.5452 299.7000 0.5821 299.8980 0.5821 300.0000 0.5732 300.1980 0.5732 300.3000 0.6057 300.4980 0.6057 300.6000 0.5458 300.7980 0.5458 300.9000 0.6020 301.0980 0.6020 301.2000 0.5708 301.3980 0.5708 301.5000 0.5164 301.6980 0.5164 301.8000 0.5718 301.9980 0.5718 302.1000 0.5754 302.2980 0.5754 302.4000 0.3000 302.5980 0.3000 302.7000 0.4885 302.8980 0.4885 303.0000 0.4856 303.1980 0.4856 303.3000 0.4105 303.4980 0.4105 303.6000 0.3627 303.7980 0.3627 303.9000 0.3323 304.0980 0.3323 304.2000 0.3675 304.3980 0.3675 304.5000 0.5095 304.6980 0.5095 304.8000 0.4462 304.9980 0.4462 305.1000 0.3139 305.2980 0.3139 305.4000 0.5457 305.5980 0.5457 305.7000 0.3702 305.8980 0.3702 306.0000 0.4044 306.1980 0.4044 306.3000 0.4060 306.4980 0.4060 306.6000 0.4588 306.7980 0.4588 306.9000 0.3712 307.0980 0.3712 307.2000 0.3843 307.3980 0.3843 307.5000 0.3918 307.6980 0.3918 307.8000 0.3375 307.9980 0.3375 308.1000 0.4569 308.2980 0.4569 308.4000 0.3840 308.5980 0.3840 308.7000 0.5142 308.8980 0.5142 309.0000 0.8335 309.1980 0.8335 309.3000 0.4637 309.4980 0.4637 309.6000 0.5412 309.7980 0.5412 309.9000 0.5887 310.0980 0.5887 310.2000 0.5985 310.3980 0.5985 310.5000 0.5033 310.6980 0.5033 310.8000 0.5913 310.9980 0.5913 311.1000 0.6190 311.2980 0.6190 311.4000 0.5692 311.5980 0.5692 311.7000 0.5961 311.8980 0.5961 312.0000 0.6150 312.1980 0.6150 312.3000 0.5696 312.4980 0.5696 312.6000 0.6065 312.7980 0.6065 312.9000 0.6194 313.0980 0.6194 313.2000 0.5673 313.3980 0.5673 313.5000 0.6056 313.6980 0.6056 313.8000 0.5477 313.9980 0.5477 314.1000 0.5860 314.2980 0.5860 314.4000 0.5723 314.5980 0.5723 314.7000 0.6247 314.8980 0.6247 315.0000 0.5668 315.1980 0.5668 315.3000 0.5998 315.4980 0.5998 315.6000 0.5790 315.7980 0.5790 315.9000 0.6068 316.0980 0.6068 316.2000 0.5960 316.3980 0.5960 316.5000 0.6236 316.6980 0.6236 316.8000 0.5892 316.9980 0.5892 317.1000 0.6006 317.2980 0.6006 317.4000 0.5466 317.5980 0.5466 317.7000 0.5968 317.8980 0.5968 318.0000 0.8374 318.1980 0.8374 318.3000 0.6004 318.4980 0.6004 318.6000 0.5933 318.7980 0.5933 318.9000 0.5768 319.0980 0.5768 319.2000 0.6007 319.3980 0.6007 319.5000 0.6082 319.6980 0.6082 319.8000 0.5745 319.9980 0.5745 320.1000 0.5786 320.2980 0.5786 320.4000 0.5559 320.5980 0.5559 320.7000 0.6088 320.8980 0.6088 321.0000 0.5452 321.1980 0.5452 321.3000 0.5821 321.4980 0.5821 321.6000 0.5732 321.7980 0.5732 321.9000 0.6057 322.0980 0.6057 322.2000 0.5458 322.3980 0.5458 322.5000 0.6020 322.6980 0.6020 322.8000 0.5708 322.9980 0.5708 323.1000 0.5164 323.2980 0.5164 323.4000 0.5718 323.5980 0.5718 323.7000 0.5754 323.8980 0.5754 324.0000 0.3000 324.1980 0.3000 324.3000 0.4885 324.4980 0.4885 324.6000 0.4856 324.7980 0.4856 324.9000 0.4105 325.0980 0.4105 325.2000 0.3627 325.3980 0.3627 325.5000 0.3323 325.6980 0.3323 325.8000 0.3675 325.9980 0.3675 326.1000 0.5095 326.2980 0.5095 326.4000 0.4462 326.5980 0.4462 326.7000 0.3139 326.8980 0.3139 327.0000 0.5457 327.1980 0.5457 327.3000 0.3702 327.4980 0.3702 327.6000 0.4044 327.7980 0.4044 327.9000 0.4060 328.0980 0.4060 328.2000 0.4588 328.3980 0.4588 328.5000 0.3712 328.6980 0.3712 328.8000 0.3843 328.9980 0.3843 329.1000 0.3918 329.2980 0.3918 329.4000 0.3375 329.5980 0.3375 329.7000 0.4569 329.8980 0.4569 330.0000 0.3840 330.1980 0.3840 330.3000 0.5142 330.4980 0.5142 330.6000 0.8335 330.7980 0.8335 330.9000 0.4637 331.0980 0.4637 331.2000 0.5412 331.3980 0.5412 331.5000 0.5887 331.6980 0.5887 331.8000 0.5985 331.9980 0.5985 332.1000 0.5033 332.2980 0.5033 332.4000 0.5913 332.5980 0.5913 332.7000 0.6190 332.8980 0.6190 333.0000 0.5692 333.1980 0.5692 333.3000 0.5961 333.4980 0.5961 333.6000 0.6150 333.7980 0.6150 333.9000 0.5696 334.0980 0.5696 334.2000 0.6065 334.3980 0.6065 334.5000 0.6194 334.6980 0.6194 334.8000 0.5673 334.9980 0.5673 335.1000 0.6056 335.2980 0.6056 335.4000 0.5477 335.5980 0.5477 335.7000 0.5860 335.8980 0.5860 336.0000 0.5723 336.1980 0.5723 336.3000 0.6247 336.4980 0.6247 336.6000 0.5668 336.7980 0.5668 336.9000 0.5998 337.0980 0.5998 337.2000 0.5790 337.3980 0.5790 337.5000 0.6068 337.6980 0.6068 337.8000 0.5960 337.9980 0.5960 338.1000 0.6236 338.2980 0.6236 338.4000 0.5892 338.5980 0.5892 338.7000 0.6006 338.8980 0.6006 339.0000 0.5466 339.1980 0.5466 339.3000 0.5968 339.4980 0.5968 339.6000 0.8374 339.7980 0.8374 339.9000 0.6004 340.0980 0.6004 340.2000 0.5933 340.3980 0.5933 340.5000 0.5768 340.6980 0.5768 340.8000 0.6007 340.9980 0.6007 341.1000 0.6082 341.2980 0.6082 341.4000 0.5745 341.5980 0.5745 341.7000 0.5786 341.8980 0.5786 342.0000 0.5559 342.1980 0.5559 342.3000 0.6088 342.4980 0.6088 342.6000 0.5452 342.7980 0.5452 342.9000 0.5821 343.0980 0.5821 343.2000 0.5732 343.3980 0.5732 343.5000 0.6057 343.6980 0.6057 343.8000 0.5458 343.9980 0.5458 344.1000 0.6020 344.2980 0.6020 344.4000 0.5708 344.5980 0.5708 344.7000 0.5164 344.8980 0.5164 345.0000 0.5718 345.1980 0.5718 345.3000 0.5754 345.4980 0.5754 345.6000 0.3000 345.7980 0.3000 345.9000 0.4885 346.0980 0.4885 346.2000 0.4856 346.3980 0.4856 346.5000 0.4105 346.6980 0.4105 346.8000 0.3627 346.9980 0.3627 347.1000 0.3323 347.2980 0.3323 347.4000 0.3675 347.5980 0.3675 347.7000 0.5095 347.8980 0.5095 348.0000 0.4462 348.1980 0.4462 348.3000 0.3139 348.4980 0.3139 348.6000 0.5457 348.7980 0.5457 348.9000 0.3702 349.0980 0.3702 349.2000 0.4044 349.3980 0.4044 349.5000 0.4060 349.6980 0.4060 349.8000 0.4588 349.9980 0.4588 350.1000 0.3712 350.2980 0.3712 350.4000 0.3843 350.5980 0.3843 350.7000 0.3918 350.8980 0.3918 351.0000 0.3375 351.1980 0.3375 351.3000 0.4569 351.4980 0.4569 351.6000 0.3840 351.7980 0.3840 351.9000 0.5142 352.0980 0.5142 352.2000 0.8335 352.3980 0.8335 352.5000 0.4637 352.6980 0.4637 352.8000 0.5412 352.9980 0.5412 353.1000 0.5887 353.2980 0.5887 353.4000 0.5985 353.5980 0.5985 353.7000 0.5033 353.8980 0.5033 354.0000 0.5913 354.1980 0.5913 354.3000 0.6190 354.4980 0.6190 354.6000 0.5692 354.7980 0.5692 354.9000 0.5961 355.0980 0.5961 355.2000 0.6150 355.3980 0.6150 355.5000 0.5696 355.6980 0.5696 355.8000 0.6065 355.9980 0.6065 356.1000 0.6194 356.2980 0.6194 356.4000 0.5673 356.5980 0.5673 356.7000 0.6056 356.8980 0.6056 357.0000 0.5477 357.1980 0.5477 357.3000 0.5860 357.4980 0.5860 357.6000 0.5723 357.7980 0.5723 357.9000 0.6247 358.0980 0.6247 358.2000 0.5668 358.3980 0.5668 358.5000 0.5998 358.6980 0.5998 358.8000 0.5790 358.9980 0.5790 359.1000 0.6068 359.2980 0.6068 359.4000 0.5960 359.5980 0.5960 359.7000 0.6236 359.8980 0.6236 360.0000 0.5892 360.1980 0.5892 360.3000 0.6006 360.4980 0.6006 360.6000 0.5466 360.7980 0.5466 360.9000 0.5968 361.0980 0.5968 361.2000 0.8374 361.3980 0.8374 361.5000 0.6004 361.6980 0.6004 361.8000 0.5933 361.9980 0.5933 362.1000 0.5768 362.2980 0.5768 362.4000 0.6007 362.5980 0.6007 362.7000 0.6082 362.8980 0.6082 363.0000 0.5745 363.1980 0.5745 363.3000 0.5786 363.4980 0.5786 363.6000 0.5559 363.7980 0.5559 363.9000 0.6088 364.0980 0.6088 364.2000 0.5452 364.3980 0.5452 364.5000 0.5821 364.6980 0.5821 364.8000 0.5732 364.9980 0.5732 365.1000 0.6057 365.2980 0.6057 365.4000 0.5458 365.5980 0.5458 365.7000 0.6020 365.8980 0.6020 366.0000 0.5708 366.1980 0.5708 366.3000 0.5164 366.4980 0.5164 366.6000 0.5718 366.7980 0.5718 366.9000 0.5754 367.0980 0.5754 367.2000 0.3000 367.3980 0.3000 367.5000 0.4885 367.6980 0.4885 367.8000 0.4856 367.9980 0.4856 368.1000 0.4105 368.2980 0.4105 368.4000 0.3627 368.5980 0.3627 368.7000 0.3323 368.8980 0.3323 369.0000 0.3675 369.1980 0.3675 369.3000 0.5095 369.4980 0.5095 369.6000 0.4462 369.7980 0.4462 369.9000 0.3139 370.0980 0.3139 370.2000 0.5457 370.3980 0.5457 370.5000 0.3702 370.6980 0.3702 370.8000 0.4044 370.9980 0.4044 371.1000 0.4060 371.2980 0.4060 371.4000 0.4588 371.5980 0.4588 371.7000 0.3712 371.8980 0.3712 372.0000 0.3843 372.1980 0.3843 372.3000 0.3918 372.4980 0.3918 372.6000 0.3375 372.7980 0.3375 372.9000 0.4569 373.0980 0.4569 373.2000 0.3840 373.3980 0.3840 373.5000 0.5142 373.6980 0.5142 373.8000 0.8335 373.9980 0.8335 374.1000 0.4637 374.2980 0.4637 374.4000 0.5412 374.5980 0.5412 374.7000 0.5887 374.8980 0.5887 375.0000 0.5985 375.1980 0.5985 375.3000 0.5033 375.4980 0.5033 375.6000 0.5913 375.7980 0.5913 375.9000 0.6190 376.0980 0.6190 376.2000 0.5692 376.3980 0.5692 376.5000 0.5961 376.6980 0.5961 376.8000 0.6150 376.9980 0.6150 377.1000 0.5696 377.2980 0.5696 377.4000 0.6065 377.5980 0.6065 377.7000 0.6194 377.8980 0.6194 378.0000 0.5673 378.1980 0.5673 378.3000 0.6056 378.4980 0.6056 378.6000 0.5477 378.7980 0.5477 378.9000 0.5860 379.0980 0.5860 379.2000 0.5723 379.3980 0.5723 379.5000 0.6247 379.6980 0.6247 379.8000 0.5668 379.9980 0.5668 380.1000 0.5998 380.2980 0.5998 380.4000 0.5790 380.5980 0.5790 380.7000 0.6068 380.8980 0.6068 381.0000 0.5960 381.1980 0.5960 381.3000 0.6236 381.4980 0.6236 381.6000 0.5892 381.7980 0.5892 381.9000 0.6006 382.0980 0.6006 382.2000 0.5466 382.3980 0.5466 382.5000 0.5968 382.6980 0.5968 382.8000 0.8374 382.9980 0.8374 383.1000 0.6004 383.2980 0.6004 383.4000 0.5933 383.5980 0.5933 383.7000 0.5768 383.8980 0.5768 384.0000 0.6007 384.1980 0.6007 384.3000 0.6082 384.4980 0.6082 384.6000 0.5745 384.7980 0.5745 384.9000 0.5786 385.0980 0.5786 385.2000 0.5559 385.3980 0.5559 385.5000 0.6088 385.6980 0.6088 385.8000 0.5452 385.9980 0.5452 386.1000 0.5821 386.2980 0.5821 386.4000 0.5732 386.5980 0.5732 386.7000 0.6057 386.8980 0.6057 387.0000 0.5458 387.1980 0.5458 387.3000 0.6020 387.4980 0.6020 387.6000 0.5708 387.7980 0.5708 387.9000 0.5164 388.0980 0.5164 388.2000 0.5718 388.3980 0.5718 388.5000 0.5754 388.6980 0.5754 388.8000 0.3000 388.9980 0.3000 389.1000 0.4885 389.2980 0.4885 389.4000 0.4856 389.5980 0.4856 389.7000 0.4105 389.8980 0.4105 390.0000 0.3627 390.1980 0.3627 390.3000 0.3323 390.4980 0.3323 390.6000 0.3675 390.7980 0.3675 390.9000 0.5095 391.0980 0.5095 391.2000 0.4462 391.3980 0.4462 391.5000 0.3139 391.6980 0.3139 391.8000 0.5457 391.9980 0.5457 392.1000 0.3702 392.2980 0.3702 392.4000 0.4044 392.5980 0.4044 392.7000 0.4060 392.8980 0.4060 393.0000 0.4588 393.1980 0.4588 393.3000 0.3712 393.4980 0.3712 393.6000 0.3843 393.7980 0.3843 393.9000 0.3918 394.0980 0.3918 394.2000 0.3375 394.3980 0.3375 394.5000 0.4569 394.6980 0.4569 394.8000 0.3840 394.9980 0.3840 395.1000 0.5142 395.2980 0.5142 395.4000 0.8335 395.5980 0.8335 395.7000 0.4637 395.8980 0.4637 396.0000 0.5412 396.1980 0.5412 396.3000 0.5887 396.4980 0.5887 396.6000 0.5985 396.7980 0.5985 396.9000 0.5033 397.0980 0.5033 397.2000 0.5913 397.3980 0.5913 397.5000 0.6190 397.6980 0.6190 397.8000 0.5692 397.9980 0.5692 398.1000 0.5961 398.2980 0.5961 398.4000 0.6150 398.5980 0.6150 398.7000 0.5696 398.8980 0.5696 399.0000 0.6065 399.1980 0.6065 399.3000 0.6194 399.4980 0.6194 399.6000 0.5673 399.7980 0.5673 399.9000 0.6056 400.0980 0.6056 400.2000 0.5477 400.3980 0.5477 400.5000 0.5860 400.6980 0.5860 400.8000 0.5723 400.9980 0.5723 401.1000 0.6247 401.2980 0.6247 401.4000 0.5668 401.5980 0.5668 401.7000 0.5998 401.8980 0.5998 402.0000 0.5790 402.1980 0.5790 402.3000 0.6068 402.4980 0.6068 402.6000 0.5960 402.7980 0.5960 402.9000 0.6236 403.0980 0.6236 403.2000 0.5892 403.3980 0.5892 403.5000 0.6006 403.6980 0.6006 403.8000 0.5466 403.9980 0.5466 404.1000 0.5968 404.2980 0.5968 404.4000 0.8374 404.5980 0.8374 404.7000 0.6004 404.8980 0.6004 405.0000 0.5933 405.1980 0.5933 405.3000 0.5768 405.4980 0.5768 405.6000 0.6007 405.7980 0.6007 405.9000 0.6082 406.0980 0.6082 406.2000 0.5745 406.3980 0.5745 406.5000 0.5786 406.6980 0.5786 406.8000 0.5559 406.9980 0.5559 407.1000 0.6088 407.2980 0.6088 407.4000 0.5452 407.5980 0.5452 407.7000 0.5821 407.8980 0.5821 408.0000 0.5732 408.1980 0.5732 408.3000 0.6057 408.4980 0.6057 408.6000 0.5458 408.7980 0.5458 408.9000 0.6020 409.0980 0.6020 409.2000 0.5708 409.3980 0.5708 409.5000 0.5164 409.6980 0.5164 409.8000 0.5718 409.9980 0.5718 410.1000 0.5754 410.2980 0.5754 410.4000 0.3000 410.5980 0.3000 410.7000 0.4885 410.8980 0.4885 411.0000 0.4856 411.1980 0.4856 411.3000 0.4105 411.4980 0.4105 411.6000 0.3627 411.7980 0.3627 411.9000 0.3323 412.0980 0.3323 412.2000 0.3675 412.3980 0.3675 412.5000 0.5095 412.6980 0.5095 412.8000 0.4462 412.9980 0.4462 413.1000 0.3139 413.2980 0.3139 413.4000 0.5457 413.5980 0.5457 413.7000 0.3702 413.8980 0.3702 414.0000 0.4044 414.1980 0.4044 414.3000 0.4060 414.4980 0.4060 414.6000 0.4588 414.7980 0.4588 414.9000 0.3712 415.0980 0.3712 415.2000 0.3843 415.3980 0.3843 415.5000 0.3918 415.6980 0.3918 415.8000 0.3375 415.9980 0.3375 416.1000 0.4569 416.2980 0.4569 416.4000 0.3840 416.5980 0.3840 416.7000 0.5142 416.8980 0.5142 417.0000 0.8335 417.1980 0.8335 417.3000 0.4637 417.4980 0.4637 417.6000 0.5412 417.7980 0.5412 417.9000 0.5887 418.0980 0.5887 418.2000 0.5985 418.3980 0.5985 418.5000 0.5033 418.6980 0.5033 418.8000 0.5913 418.9980 0.5913 419.1000 0.6190 419.2980 0.6190 419.4000 0.5692 419.5980 0.5692 419.7000 0.5961 419.8980 0.5961 420.0000 0.6150 420.1980 0.6150 420.3000 0.5696 420.4980 0.5696 420.6000 0.6065 420.7980 0.6065 420.9000 0.6194 421.0980 0.6194 421.2000 0.5673 421.3980 0.5673 421.5000 0.6056 421.6980 0.6056 421.8000 0.5477 421.9980 0.5477 422.1000 0.5860 422.2980 0.5860 422.4000 0.5723 422.5980 0.5723 422.7000 0.6247 422.8980 0.6247 423.0000 0.5668 423.1980 0.5668 423.3000 0.5998 423.4980 0.5998 423.6000 0.5790 423.7980 0.5790 423.9000 0.6068 424.0980 0.6068 424.2000 0.5960 424.3980 0.5960 424.5000 0.6236 424.6980 0.6236 424.8000 0.5892 424.9980 0.5892 425.1000 0.6006 425.2980 0.6006 425.4000 0.5466 425.5980 0.5466 425.7000 0.5968 425.8980 0.5968 426.0000 0.8374 426.1980 0.8374 426.3000 0.6004 426.4980 0.6004 426.6000 0.5933 426.7980 0.5933 426.9000 0.5768 427.0980 0.5768 427.2000 0.6007 427.3980 0.6007 427.5000 0.6082 427.6980 0.6082 427.8000 0.5745 427.9980 0.5745 428.1000 0.5786 428.2980 0.5786 428.4000 0.5559 428.5980 0.5559 428.7000 0.6088 428.8980 0.6088 429.0000 0.5452 429.1980 0.5452 429.3000 0.5821 429.4980 0.5821 429.6000 0.5732 429.7980 0.5732 429.9000 0.6057 430.0980 0.6057 430.2000 0.5458 430.3980 0.5458 430.5000 0.6020 430.6980 0.6020 430.8000 0.5708 430.9980 0.5708 431.1000 0.5164 431.2980 0.5164 431.4000 0.5718 431.5980 0.5718 431.7000 0.5754 431.8980 0.5754 432.0000 0.3000 432.1980 0.3000 432.3000 0.4885 432.4980 0.4885 432.6000 0.4856 432.7980 0.4856 432.9000 0.4105 433.0980 0.4105 433.2000 0.3627 433.3980 0.3627 433.5000 0.3323 433.6980 0.3323 433.8000 0.3675 433.9980 0.3675 434.1000 0.5095 434.2980 0.5095 434.4000 0.4462 434.5980 0.4462 434.7000 0.3139 434.8980 0.3139 435.0000 0.5457 435.1980 0.5457 435.3000 0.3702 435.4980 0.3702 435.6000 0.4044 435.7980 0.4044 435.9000 0.4060 436.0980 0.4060 436.2000 0.4588 436.3980 0.4588 436.5000 0.3712 436.6980 0.3712 436.8000 0.3843 436.9980 0.3843 437.1000 0.3918 437.2980 0.3918 437.4000 0.3375 437.5980 0.3375 437.7000 0.4569 437.8980 0.4569 438.0000 0.3840 438.1980 0.3840 438.3000 0.5142 438.4980 0.5142 438.6000 0.8335 438.7980 0.8335 438.9000 0.4637 439.0980 0.4637 439.2000 0.5412 439.3980 0.5412 439.5000 0.5887 439.6980 0.5887 439.8000 0.5985 439.9980 0.5985 440.1000 0.5033 440.2980 0.5033 440.4000 0.5913 440.5980 0.5913 440.7000 0.6190 440.8980 0.6190 441.0000 0.5692 441.1980 0.5692 441.3000 0.5961 441.4980 0.5961 441.6000 0.6150 441.7980 0.6150 441.9000 0.5696 442.0980 0.5696 442.2000 0.6065 442.3980 0.6065 442.5000 0.6194 442.6980 0.6194 442.8000 0.5673 442.9980 0.5673 443.1000 0.6056 443.2980 0.6056 443.4000 0.5477 443.5980 0.5477 443.7000 0.5860 443.8980 0.5860 444.0000 0.5723 444.1980 0.5723 444.3000 0.6247 444.4980 0.6247 444.6000 0.5668 444.7980 0.5668 444.9000 0.5998 445.0980 0.5998 445.2000 0.5790 445.3980 0.5790 445.5000 0.6068 445.6980 0.6068 445.8000 0.5960 445.9980 0.5960 446.1000 0.6236 446.2980 0.6236 446.4000 0.5892 446.5980 0.5892 446.7000 0.6006 446.8980 0.6006 447.0000 0.5466 447.1980 0.5466 447.3000 0.5968 447.4980 0.5968 447.6000 0.8374 447.7980 0.8374 447.9000 0.6004 448.0980 0.6004 448.2000 0.5933 448.3980 0.5933 448.5000 0.5768 448.6980 0.5768 448.8000 0.6007 448.9980 0.6007 449.1000 0.6082 449.2980 0.6082 449.4000 0.5745 449.5980 0.5745 449.7000 0.5786 449.8980 0.5786 450.0000 0.5559 450.1980 0.5559 450.3000 0.6088 450.4980 0.6088 450.6000 0.5452 450.7980 0.5452 450.9000 0.5821 451.0980 0.5821 451.2000 0.5732 451.3980 0.5732 451.5000 0.6057 451.6980 0.6057 451.8000 0.5458 451.9980 0.5458 452.1000 0.6020 452.2980 0.6020 452.4000 0.5708 452.5980 0.5708 452.7000 0.5164 452.8980 0.5164 453.0000 0.5718 453.1980 0.5718 453.3000 0.5754 453.4980 0.5754 453.6000 0.3000 453.7980 0.3000 453.9000 0.4885 454.0980 0.4885 454.2000 0.4856 454.3980 0.4856 454.5000 0.4105 454.6980 0.4105 454.8000 0.3627 454.9980 0.3627 455.1000 0.3323 455.2980 0.3323 455.4000 0.3675 455.5980 0.3675 455.7000 0.5095 455.8980 0.5095 456.0000 0.4462 456.1980 0.4462 456.3000 0.3139 456.4980 0.3139 456.6000 0.5457 456.7980 0.5457 456.9000 0.3702 457.0980 0.3702 457.2000 0.4044 457.3980 0.4044 457.5000 0.4060 457.6980 0.4060 457.8000 0.4588 457.9980 0.4588 458.1000 0.3712 458.2980 0.3712 458.4000 0.3843 458.5980 0.3843 458.7000 0.3918 458.8980 0.3918 459.0000 0.3375 459.1980 0.3375 459.3000 0.4569 459.4980 0.4569 459.6000 0.3840 459.7980 0.3840 459.9000 0.5142 460.0980 0.5142 460.2000 0.8335 460.3980 0.8335 460.5000 0.4637 460.6980 0.4637 460.8000 0.5412 460.9980 0.5412 461.1000 0.5887 461.2980 0.5887 461.4000 0.5985 461.5980 0.5985 461.7000 0.5033 461.8980 0.5033 462.0000 0.5913 462.1980 0.5913 462.3000 0.6190 462.4980 0.6190 462.6000 0.5692 462.7980 0.5692 462.9000 0.5961 463.0980 0.5961 463.2000 0.6150 463.3980 0.6150 463.5000 0.5696 463.6980 0.5696 463.8000 0.6065 463.9980 0.6065 464.1000 0.6194 464.2980 0.6194 464.4000 0.5673 464.5980 0.5673 464.7000 0.6056 464.8980 0.6056 465.0000 0.5477 465.1980 0.5477 465.3000 0.5860 465.4980 0.5860 465.6000 0.5723 465.7980 0.5723 465.9000 0.6247 466.0980 0.6247 466.2000 0.5668 466.3980 0.5668 466.5000 0.5998 466.6980 0.5998 466.8000 0.5790 466.9980 0.5790 467.1000 0.6068 467.2980 0.6068 467.4000 0.5960 467.5980 0.5960 467.7000 0.6236 467.8980 0.6236 468.0000 0.5892 468.1980 0.5892 468.3000 0.6006 468.4980 0.6006 468.6000 0.5466 468.7980 0.5466 468.9000 0.5968 469.0980 0.5968 469.2000 0.8374 469.3980 0.8374 469.5000 0.6004 469.6980 0.6004 469.8000 0.5933 469.9980 0.5933 470.1000 0.5768 470.2980 0.5768 470.4000 0.6007 470.5980 0.6007 470.7000 0.6082 470.8980 0.6082 471.0000 0.5745 471.1980 0.5745 471.3000 0.5786 471.4980 0.5786 471.6000 0.5559 471.7980 0.5559 471.9000 0.6088 472.0980 0.6088 472.2000 0.5452 472.3980 0.5452 472.5000 0.5821 472.6980 0.5821 472.8000 0.5732 472.9980 0.5732 473.1000 0.6057 473.2980 0.6057 473.4000 0.5458 473.5980 0.5458 473.7000 0.6020 473.8980 0.6020 474.0000 0.5708 474.1980 0.5708 474.3000 0.5164 474.4980 0.5164 474.6000 0.5718 474.7980 0.5718 474.9000 0.5754 475.0980 0.5754 475.2000 0.3000 475.3980 0.3000 475.5000 0.4885 475.6980 0.4885 475.8000 0.4856 475.9980 0.4856 476.1000 0.4105 476.2980 0.4105 476.4000 0.3627 476.5980 0.3627 476.7000 0.3323 476.8980 0.3323 477.0000 0.3675 477.1980 0.3675 477.3000 0.5095 477.4980 0.5095 477.6000 0.4462 477.7980 0.4462 477.9000 0.3139 478.0980 0.3139 478.2000 0.5457 478.3980 0.5457 478.5000 0.3702 478.6980 0.3702 478.8000 0.4044 478.9980 0.4044 479.1000 0.4060 479.2980 0.4060 479.4000 0.4588 479.5980 0.4588 479.7000 0.3712 479.8980 0.3712 480.0000 0.3843 480.1980 0.3843 480.3000 0.3918 480.4980 0.3918 480.6000 0.3375 480.7980 0.3375 480.9000 0.4569 481.0980 0.4569 481.2000 0.3840 481.3980 0.3840 481.5000 0.5142 481.6980 0.5142 481.8000 0.8335 481.9980 0.8335 482.1000 0.4637 482.2980 0.4637 482.4000 0.5412 482.5980 0.5412 482.7000 0.5887 482.8980 0.5887 483.0000 0.5985 483.1980 0.5985 483.3000 0.5033 483.4980 0.5033 483.6000 0.5913 483.7980 0.5913 483.9000 0.6190 484.0980 0.6190 484.2000 0.5692 484.3980 0.5692 484.5000 0.5961 484.6980 0.5961 484.8000 0.6150 484.9980 0.6150 485.1000 0.5696 485.2980 0.5696 485.4000 0.6065 485.5980 0.6065 485.7000 0.6194 485.8980 0.6194 486.0000 0.5673 486.1980 0.5673 486.3000 0.6056 486.4980 0.6056 486.6000 0.5477 486.7980 0.5477 486.9000 0.5860 487.0980 0.5860 487.2000 0.5723 487.3980 0.5723 487.5000 0.6247 487.6980 0.6247 487.8000 0.5668 487.9980 0.5668 488.1000 0.5998 488.2980 0.5998 488.4000 0.5790 488.5980 0.5790 488.7000 0.6068 488.8980 0.6068 489.0000 0.5960 489.1980 0.5960 489.3000 0.6236 489.4980 0.6236 489.6000 0.5892 489.7980 0.5892 489.9000 0.6006 490.0980 0.6006 490.2000 0.5466 490.3980 0.5466 490.5000 0.5968 490.6980 0.5968 490.8000 0.8374 490.9980 0.8374 491.1000 0.6004 491.2980 0.6004 491.4000 0.5933 491.5980 0.5933 491.7000 0.5768 491.8980 0.5768 492.0000 0.6007 492.1980 0.6007 492.3000 0.6082 492.4980 0.6082 492.6000 0.5745 492.7980 0.5745 492.9000 0.5786 493.0980 0.5786 493.2000 0.5559 493.3980 0.5559 493.5000 0.6088 493.6980 0.6088 493.8000 0.5452 493.9980 0.5452 494.1000 0.5821 494.2980 0.5821 494.4000 0.5732 494.5980 0.5732 494.7000 0.6057 494.8980 0.6057 495.0000 0.5458 495.1980 0.5458 495.3000 0.6020 495.4980 0.6020 495.6000 0.5708 495.7980 0.5708 495.9000 0.5164 496.0980 0.5164 496.2000 0.5718 496.3980 0.5718 496.5000 0.5754 496.6980 0.5754 496.8000 0.3000 496.9980 0.3000 497.1000 0.4885 497.2980 0.4885 497.4000 0.4856 497.5980 0.4856 497.7000 0.4105 497.8980 0.4105 498.0000 0.3627 498.1980 0.3627 498.3000 0.3323 498.4980 0.3323 498.6000 0.3675 498.7980 0.3675 498.9000 0.5095 499.0980 0.5095 499.2000 0.4462 499.3980 0.4462 499.5000 0.3139 499.6980 0.3139 499.8000 0.5457 499.9980 0.5457 500.1000 0.3702 500.2980 0.3702 500.4000 0.4044 500.5980 0.4044 500.7000 0.4060 500.8980 0.4060 501.0000 0.4588 501.1980 0.4588 501.3000 0.3712 501.4980 0.3712 501.6000 0.3843 501.7980 0.3843 501.9000 0.3918 502.0980 0.3918 502.2000 0.3375 502.3980 0.3375 502.5000 0.4569 502.6980 0.4569 502.8000 0.3840 502.9980 0.3840 503.1000 0.5142 503.2980 0.5142 503.4000 0.8335 503.5980 0.8335 503.7000 0.4637 503.8980 0.4637 504.0000 0.5412 504.1980 0.5412 504.3000 0.5887 504.4980 0.5887 504.6000 0.5985 504.7980 0.5985 504.9000 0.5033 505.0980 0.5033 505.2000 0.5913 505.3980 0.5913 505.5000 0.6190 505.6980 0.6190 505.8000 0.5692 505.9980 0.5692 506.1000 0.5961 506.2980 0.5961 506.4000 0.6150 506.5980 0.6150 506.7000 0.5696 506.8980 0.5696 507.0000 0.6065 507.1980 0.6065 507.3000 0.6194 507.4980 0.6194 507.6000 0.5673 507.7980 0.5673 507.9000 0.6056 508.0980 0.6056 508.2000 0.5477 508.3980 0.5477 508.5000 0.5860 508.6980 0.5860 508.8000 0.5723 508.9980 0.5723 509.1000 0.6247 509.2980 0.6247 509.4000 0.5668 509.5980 0.5668 509.7000 0.5998 509.8980 0.5998 510.0000 0.5790 510.1980 0.5790 510.3000 0.6068 510.4980 0.6068 510.6000 0.5960 510.7980 0.5960 510.9000 0.6236 511.0980 0.6236 511.2000 0.5892 511.3980 0.5892 511.5000 0.6006 511.6980 0.6006 511.8000 0.5466 511.9980 0.5466 512.1000 0.5968 512.2980 0.5968 512.4000 0.8374 512.5980 0.8374 512.7000 0.6004 512.8980 0.6004 513.0000 0.5933 513.1980 0.5933 513.3000 0.5768 513.4980 0.5768 513.6000 0.6007 513.7980 0.6007 513.9000 0.6082 514.0980 0.6082 514.2000 0.5745 514.3980 0.5745 514.5000 0.5786 514.6980 0.5786 514.8000 0.5559 514.9980 0.5559 515.1000 0.6088 515.2980 0.6088 515.4000 0.5452 515.5980 0.5452 515.7000 0.5821 515.8980 0.5821 516.0000 0.5732 516.1980 0.5732 516.3000 0.6057 516.4980 0.6057 516.6000 0.5458 516.7980 0.5458 516.9000 0.6020 517.0980 0.6020 517.2000 0.5708 517.3980 0.5708 517.5000 0.5164 517.6980 0.5164 517.8000 0.5718 517.9980 0.5718 518.1000 0.5754 518.2980 0.5754 518.4000 0.3000 518.5980 0.3000 518.7000 0.4885 518.8980 0.4885 519.0000 0.4856 519.1980 0.4856 519.3000 0.4105 519.4980 0.4105 519.6000 0.3627 519.7980 0.3627 519.9000 0.3323 520.0980 0.3323 520.2000 0.3675 520.3980 0.3675 520.5000 0.5095 520.6980 0.5095 520.8000 0.4462 520.9980 0.4462 521.1000 0.3139 521.2980 0.3139 521.4000 0.5457 521.5980 0.5457 521.7000 0.3702 521.8980 0.3702 522.0000 0.4044 522.1980 0.4044 522.3000 0.4060 522.4980 0.4060 522.6000 0.4588 522.7980 0.4588 522.9000 0.3712 523.0980 0.3712 523.2000 0.3843 523.3980 0.3843 523.5000 0.3918 523.6980 0.3918 523.8000 0.3375 523.9980 0.3375 524.1000 0.4569 524.2980 0.4569 524.4000 0.3840 524.5980 0.3840 524.7000 0.5142 524.8980 0.5142 525.0000 0.8335 525.1980 0.8335 525.3000 0.4637 525.4980 0.4637 525.6000 0.5412 525.7980 0.5412 525.9000 0.5887 526.0980 0.5887 526.2000 0.5985 526.3980 0.5985 526.5000 0.5033 526.6980 0.5033 526.8000 0.5913 526.9980 0.5913 527.1000 0.6190 527.2980 0.6190 527.4000 0.5692 527.5980 0.5692 527.7000 0.5961 527.8980 0.5961 528.0000 0.6150 528.1980 0.6150 528.3000 0.5696 528.4980 0.5696 528.6000 0.6065 528.7980 0.6065 528.9000 0.6194 529.0980 0.6194 529.2000 0.5673 529.3980 0.5673 529.5000 0.6056 529.6980 0.6056 529.8000 0.5477 529.9980 0.5477 530.1000 0.5860 530.2980 0.5860 530.4000 0.5723 530.5980 0.5723 530.7000 0.6247 530.8980 0.6247 531.0000 0.5668 531.1980 0.5668 531.3000 0.5998 531.4980 0.5998 531.6000 0.5790 531.7980 0.5790 531.9000 0.6068 532.0980 0.6068 532.2000 0.5960 532.3980 0.5960 532.5000 0.6236 532.6980 0.6236 532.8000 0.5892 532.9980 0.5892 533.1000 0.6006 533.2980 0.6006 533.4000 0.5466 533.5980 0.5466 533.7000 0.5968 533.8980 0.5968 534.0000 0.8374 534.1980 0.8374 534.3000 0.6004 534.4980 0.6004 534.6000 0.5933 534.7980 0.5933 534.9000 0.5768 535.0980 0.5768 535.2000 0.6007 535.3980 0.6007 535.5000 0.6082 535.6980 0.6082 535.8000 0.5745 535.9980 0.5745 536.1000 0.5786 536.2980 0.5786 536.4000 0.5559 536.5980 0.5559 536.7000 0.6088 536.8980 0.6088 537.0000 0.5452 537.1980 0.5452 537.3000 0.5821 537.4980 0.5821 537.6000 0.5732 537.7980 0.5732 537.9000 0.6057 538.0980 0.6057 538.2000 0.5458 538.3980 0.5458 538.5000 0.6020 538.6980 0.6020 538.8000 0.5708 538.9980 0.5708 539.1000 0.5164 539.2980 0.5164 539.4000 0.5718 539.5980 0.5718 539.7000 0.5754 539.8980 0.5754 540.0000 0.3000 540.1980 0.3000 540.3000 0.4885 540.4980 0.4885 540.6000 0.4856 540.7980 0.4856 540.9000 0.4105 541.0980 0.4105 541.2000 0.3627 541.3980 0.3627 541.5000 0.3323 541.6980 0.3323 541.8000 0.3675 541.9980 0.3675 542.1000 0.5095 542.2980 0.5095 542.4000 0.4462 542.5980 0.4462 542.7000 0.3139 542.8980 0.3139 543.0000 0.5457 543.1980 0.5457 543.3000 0.3702 543.4980 0.3702 543.6000 0.4044 543.7980 0.4044 543.9000 0.4060 544.0980 0.4060 544.2000 0.4588 544.3980 0.4588 544.5000 0.3712 544.6980 0.3712 544.8000 0.3843 544.9980 0.3843 545.1000 0.3918 545.2980 0.3918 545.4000 0.3375 545.5980 0.3375 545.7000 0.4569 545.8980 0.4569 546.0000 0.3840 546.1980 0.3840 546.3000 0.5142 546.4980 0.5142 546.6000 0.8335 546.7980 0.8335 546.9000 0.4637 547.0980 0.4637 547.2000 0.5412 547.3980 0.5412 547.5000 0.5887 547.6980 0.5887 547.8000 0.5985 547.9980 0.5985 548.1000 0.5033 548.2980 0.5033 548.4000 0.5913 548.5980 0.5913 548.7000 0.6190 548.8980 0.6190 549.0000 0.5692 549.1980 0.5692 549.3000 0.5961 549.4980 0.5961 549.6000 0.6150 549.7980 0.6150 549.9000 0.5696 550.0980 0.5696 550.2000 0.6065 550.3980 0.6065 550.5000 0.6194 550.6980 0.6194 550.8000 0.5673 550.9980 0.5673 551.1000 0.6056 551.2980 0.6056 551.4000 0.5477 551.5980 0.5477 551.7000 0.5860 551.8980 0.5860 552.0000 0.5723 552.1980 0.5723 552.3000 0.6247 552.4980 0.6247 552.6000 0.5668 552.7980 0.5668 552.9000 0.5998 553.0980 0.5998 553.2000 0.5790 553.3980 0.5790 553.5000 0.6068 553.6980 0.6068 553.8000 0.5960 553.9980 0.5960 554.1000 0.6236 554.2980 0.6236 554.4000 0.5892 554.5980 0.5892 554.7000 0.6006 554.8980 0.6006 555.0000 0.5466 555.1980 0.5466 555.3000 0.5968 555.4980 0.5968 555.6000 0.8374 555.7980 0.8374 555.9000 0.6004 556.0980 0.6004 556.2000 0.5933 556.3980 0.5933 556.5000 0.5768 556.6980 0.5768 556.8000 0.6007 556.9980 0.6007 557.1000 0.6082 557.2980 0.6082 557.4000 0.5745 557.5980 0.5745 557.7000 0.5786 557.8980 0.5786 558.0000 0.5559 558.1980 0.5559 558.3000 0.6088 558.4980 0.6088 558.6000 0.5452 558.7980 0.5452 558.9000 0.5821 559.0980 0.5821 559.2000 0.5732 559.3980 0.5732 559.5000 0.6057 559.6980 0.6057 559.8000 0.5458 559.9980 0.5458 560.1000 0.6020 560.2980 0.6020 560.4000 0.5708 560.5980 0.5708 560.7000 0.5164 560.8980 0.5164 561.0000 0.5718 561.1980 0.5718 561.3000 0.5754 561.4980 0.5754 561.6000 0.3000 561.7980 0.3000 561.9000 0.4885 562.0980 0.4885 562.2000 0.4856 562.3980 0.4856 562.5000 0.4105 562.6980 0.4105 562.8000 0.3627 562.9980 0.3627 563.1000 0.3323 563.2980 0.3323 563.4000 0.3675 563.5980 0.3675 563.7000 0.5095 563.8980 0.5095 564.0000 0.4462 564.1980 0.4462 564.3000 0.3139 564.4980 0.3139 564.6000 0.5457 564.7980 0.5457 564.9000 0.3702 565.0980 0.3702 565.2000 0.4044 565.3980 0.4044 565.5000 0.4060 565.6980 0.4060 565.8000 0.4588 565.9980 0.4588 566.1000 0.3712 566.2980 0.3712 566.4000 0.3843 566.5980 0.3843 566.7000 0.3918 566.8980 0.3918 567.0000 0.3375 567.1980 0.3375 567.3000 0.4569 567.4980 0.4569 567.6000 0.3840 567.7980 0.3840 567.9000 0.5142 568.0980 0.5142 568.2000 0.8335 568.3980 0.8335 568.5000 0.4637 568.6980 0.4637 568.8000 0.5412 568.9980 0.5412 569.1000 0.5887 569.2980 0.5887 569.4000 0.5985 569.5980 0.5985 569.7000 0.5033 569.8980 0.5033 570.0000 0.5913 570.1980 0.5913 570.3000 0.6190 570.4980 0.6190 570.6000 0.5692 570.7980 0.5692 570.9000 0.5961 571.0980 0.5961 571.2000 0.6150 571.3980 0.6150 571.5000 0.5696 571.6980 0.5696 571.8000 0.6065 571.9980 0.6065 572.1000 0.6194 572.2980 0.6194 572.4000 0.5673 572.5980 0.5673 572.7000 0.6056 572.8980 0.6056 573.0000 0.5477 573.1980 0.5477 573.3000 0.5860 573.4980 0.5860 573.6000 0.5723 573.7980 0.5723 573.9000 0.6247 574.0980 0.6247 574.2000 0.5668 574.3980 0.5668 574.5000 0.5998 574.6980 0.5998 574.8000 0.5790 574.9980 0.5790 575.1000 0.6068 575.2980 0.6068 575.4000 0.5960 575.5980 0.5960 575.7000 0.6236 575.8980 0.6236 576.0000 0.5892 576.1980 0.5892 576.3000 0.6006 576.4980 0.6006 576.6000 0.5466 576.7980 0.5466 576.9000 0.5968 577.0980 0.5968 577.2000 0.8374 577.3980 0.8374 577.5000 0.6004 577.6980 0.6004 577.8000 0.5933 577.9980 0.5933 578.1000 0.5768 578.2980 0.5768 578.4000 0.6007 578.5980 0.6007 578.7000 0.6082 578.8980 0.6082 579.0000 0.5745 579.1980 0.5745 579.3000 0.5786 579.4980 0.5786 579.6000 0.5559 579.7980 0.5559 579.9000 0.6088 580.0980 0.6088 580.2000 0.5452 580.3980 0.5452 580.5000 0.5821 580.6980 0.5821 580.8000 0.5732 580.9980 0.5732 581.1000 0.6057 581.2980 0.6057 581.4000 0.5458 581.5980 0.5458 581.7000 0.6020 581.8980 0.6020 582.0000 0.5708 582.1980 0.5708 582.3000 0.5164 582.4980 0.5164 582.6000 0.5718 582.7980 0.5718 582.9000 0.5754 583.0980 0.5754 583.2000 0.3000 583.3980 0.3000 583.5000 0.4885 583.6980 0.4885 583.8000 0.4856 583.9980 0.4856 584.1000 0.4105 584.2980 0.4105 584.4000 0.3627 584.5980 0.3627 584.7000 0.3323 584.8980 0.3323 585.0000 0.3675 585.1980 0.3675 585.3000 0.5095 585.4980 0.5095 585.6000 0.4462 585.7980 0.4462 585.9000 0.3139 586.0980 0.3139 586.2000 0.5457 586.3980 0.5457 586.5000 0.3702 586.6980 0.3702 586.8000 0.4044 586.9980 0.4044 587.1000 0.4060 587.2980 0.4060 587.4000 0.4588 587.5980 0.4588 587.7000 0.3712 587.8980 0.3712 588.0000 0.3843 588.1980 0.3843 588.3000 0.3918 588.4980 0.3918 588.6000 0.3375 588.7980 0.3375 588.9000 0.4569 589.0980 0.4569 589.2000 0.3840 589.3980 0.3840 589.5000 0.5142 589.6980 0.5142 589.8000 0.8335 589.9980 0.8335 590.1000 0.4637 590.2980 0.4637 590.4000 0.5412 590.5980 0.5412 590.7000 0.5887 590.8980 0.5887 591.0000 0.5985 591.1980 0.5985 591.3000 0.5033 591.4980 0.5033 591.6000 0.5913 591.7980 0.5913 591.9000 0.6190 592.0980 0.6190 592.2000 0.5692 592.3980 0.5692 592.5000 0.5961 592.6980 0.5961 592.8000 0.6150 592.9980 0.6150 593.1000 0.5696 593.2980 0.5696 593.4000 0.6065 593.5980 0.6065 593.7000 0.6194 593.8980 0.6194 594.0000 0.5673 594.1980 0.5673 594.3000 0.6056 594.4980 0.6056 594.6000 0.5477 594.7980 0.5477 594.9000 0.5860 595.0980 0.5860 595.2000 0.5723 595.3980 0.5723 595.5000 0.6247 595.6980 0.6247 595.8000 0.5668 595.9980 0.5668 596.1000 0.5998 596.2980 0.5998 596.4000 0.5790 596.5980 0.5790 596.7000 0.6068 596.8980 0.6068 597.0000 0.5960 597.1980 0.5960 597.3000 0.6236 597.4980 0.6236 597.6000 0.5892 597.7980 0.5892 597.9000 0.6006 598.0980 0.6006 598.2000 0.5466 598.3980 0.5466 598.5000 0.5968 598.6980 0.5968 598.8000 0.8374 598.9980 0.8374 599.1000 0.6004 599.2980 0.6004 599.4000 0.5933 599.5980 0.5933 599.7000 0.5768 599.8980 0.5768 600.0000 0.5768)
Vtg0 tg0 0 PWL(0.0000 1.0000 0.1980 1.0000 0.3000 1.0000 0.4980 1.0000 0.6000 1.0000 0.7980 1.0000 0.9000 1.0000 1.0980 1.0000 1.2000 1.0000 1.3980 1.0000 1.5000 1.0000 1.6980 1.0000 1.8000 1.0000 1.9980 1.0000 2.1000 1.0000 2.2980 1.0000 2.4000 1.0000 2.5980 1.0000 2.7000 1.0000 2.8980 1.0000 3.0000 1.0000 3.1980 1.0000 3.3000 1.0000 3.4980 1.0000 3.6000 1.0000 3.7980 1.0000 3.9000 1.0000 4.0980 1.0000 4.2000 1.0000 4.3980 1.0000 4.5000 1.0000 4.6980 1.0000 4.8000 1.0000 4.9980 1.0000 5.1000 1.0000 5.2980 1.0000 5.4000 1.0000 5.5980 1.0000 5.7000 1.0000 5.8980 1.0000 6.0000 1.0000 6.1980 1.0000 6.3000 1.0000 6.4980 1.0000 6.6000 1.0000 6.7980 1.0000 6.9000 1.0000 7.0980 1.0000 7.2000 0.0000 7.3980 0.0000 7.5000 0.0000 7.6980 0.0000 7.8000 0.0000 7.9980 0.0000 8.1000 0.0000 8.2980 0.0000 8.4000 0.0000 8.5980 0.0000 8.7000 0.0000 8.8980 0.0000 9.0000 0.0000 9.1980 0.0000 9.3000 0.0000 9.4980 0.0000 9.6000 0.0000 9.7980 0.0000 9.9000 0.0000 10.0980 0.0000 10.2000 0.0000 10.3980 0.0000 10.5000 0.0000 10.6980 0.0000 10.8000 0.0000 10.9980 0.0000 11.1000 0.0000 11.2980 0.0000 11.4000 0.0000 11.5980 0.0000 11.7000 0.0000 11.8980 0.0000 12.0000 0.0000 12.1980 0.0000 12.3000 0.0000 12.4980 0.0000 12.6000 0.0000 12.7980 0.0000 12.9000 0.0000 13.0980 0.0000 13.2000 0.0000 13.3980 0.0000 13.5000 0.0000 13.6980 0.0000 13.8000 0.0000 13.9980 0.0000 14.1000 0.0000 14.2980 0.0000 14.4000 0.0000 14.5980 0.0000 14.7000 0.0000 14.8980 0.0000 15.0000 0.0000 15.1980 0.0000 15.3000 0.0000 15.4980 0.0000 15.6000 0.0000 15.7980 0.0000 15.9000 0.0000 16.0980 0.0000 16.2000 0.0000 16.3980 0.0000 16.5000 0.0000 16.6980 0.0000 16.8000 0.0000 16.9980 0.0000 17.1000 0.0000 17.2980 0.0000 17.4000 0.0000 17.5980 0.0000 17.7000 0.0000 17.8980 0.0000 18.0000 0.0000 18.1980 0.0000 18.3000 0.0000 18.4980 0.0000 18.6000 0.0000 18.7980 0.0000 18.9000 0.0000 19.0980 0.0000 19.2000 0.0000 19.3980 0.0000 19.5000 0.0000 19.6980 0.0000 19.8000 0.0000 19.9980 0.0000 20.1000 0.0000 20.2980 0.0000 20.4000 0.0000 20.5980 0.0000 20.7000 0.0000 20.8980 0.0000 21.0000 0.0000 21.1980 0.0000 21.3000 0.0000 21.4980 0.0000 21.6000 1.0000 21.7980 1.0000 21.9000 1.0000 22.0980 1.0000 22.2000 1.0000 22.3980 1.0000 22.5000 1.0000 22.6980 1.0000 22.8000 1.0000 22.9980 1.0000 23.1000 1.0000 23.2980 1.0000 23.4000 1.0000 23.5980 1.0000 23.7000 1.0000 23.8980 1.0000 24.0000 1.0000 24.1980 1.0000 24.3000 1.0000 24.4980 1.0000 24.6000 1.0000 24.7980 1.0000 24.9000 1.0000 25.0980 1.0000 25.2000 1.0000 25.3980 1.0000 25.5000 1.0000 25.6980 1.0000 25.8000 1.0000 25.9980 1.0000 26.1000 1.0000 26.2980 1.0000 26.4000 1.0000 26.5980 1.0000 26.7000 1.0000 26.8980 1.0000 27.0000 1.0000 27.1980 1.0000 27.3000 1.0000 27.4980 1.0000 27.6000 1.0000 27.7980 1.0000 27.9000 1.0000 28.0980 1.0000 28.2000 1.0000 28.3980 1.0000 28.5000 1.0000 28.6980 1.0000 28.8000 0.0000 28.9980 0.0000 29.1000 0.0000 29.2980 0.0000 29.4000 0.0000 29.5980 0.0000 29.7000 0.0000 29.8980 0.0000 30.0000 0.0000 30.1980 0.0000 30.3000 0.0000 30.4980 0.0000 30.6000 0.0000 30.7980 0.0000 30.9000 0.0000 31.0980 0.0000 31.2000 0.0000 31.3980 0.0000 31.5000 0.0000 31.6980 0.0000 31.8000 0.0000 31.9980 0.0000 32.1000 0.0000 32.2980 0.0000 32.4000 0.0000 32.5980 0.0000 32.7000 0.0000 32.8980 0.0000 33.0000 0.0000 33.1980 0.0000 33.3000 0.0000 33.4980 0.0000 33.6000 0.0000 33.7980 0.0000 33.9000 0.0000 34.0980 0.0000 34.2000 0.0000 34.3980 0.0000 34.5000 0.0000 34.6980 0.0000 34.8000 0.0000 34.9980 0.0000 35.1000 0.0000 35.2980 0.0000 35.4000 0.0000 35.5980 0.0000 35.7000 0.0000 35.8980 0.0000 36.0000 0.0000 36.1980 0.0000 36.3000 0.0000 36.4980 0.0000 36.6000 0.0000 36.7980 0.0000 36.9000 0.0000 37.0980 0.0000 37.2000 0.0000 37.3980 0.0000 37.5000 0.0000 37.6980 0.0000 37.8000 0.0000 37.9980 0.0000 38.1000 0.0000 38.2980 0.0000 38.4000 0.0000 38.5980 0.0000 38.7000 0.0000 38.8980 0.0000 39.0000 0.0000 39.1980 0.0000 39.3000 0.0000 39.4980 0.0000 39.6000 0.0000 39.7980 0.0000 39.9000 0.0000 40.0980 0.0000 40.2000 0.0000 40.3980 0.0000 40.5000 0.0000 40.6980 0.0000 40.8000 0.0000 40.9980 0.0000 41.1000 0.0000 41.2980 0.0000 41.4000 0.0000 41.5980 0.0000 41.7000 0.0000 41.8980 0.0000 42.0000 0.0000 42.1980 0.0000 42.3000 0.0000 42.4980 0.0000 42.6000 0.0000 42.7980 0.0000 42.9000 0.0000 43.0980 0.0000 43.2000 1.0000 43.3980 1.0000 43.5000 1.0000 43.6980 1.0000 43.8000 1.0000 43.9980 1.0000 44.1000 1.0000 44.2980 1.0000 44.4000 1.0000 44.5980 1.0000 44.7000 1.0000 44.8980 1.0000 45.0000 1.0000 45.1980 1.0000 45.3000 1.0000 45.4980 1.0000 45.6000 1.0000 45.7980 1.0000 45.9000 1.0000 46.0980 1.0000 46.2000 1.0000 46.3980 1.0000 46.5000 1.0000 46.6980 1.0000 46.8000 1.0000 46.9980 1.0000 47.1000 1.0000 47.2980 1.0000 47.4000 1.0000 47.5980 1.0000 47.7000 1.0000 47.8980 1.0000 48.0000 1.0000 48.1980 1.0000 48.3000 1.0000 48.4980 1.0000 48.6000 1.0000 48.7980 1.0000 48.9000 1.0000 49.0980 1.0000 49.2000 1.0000 49.3980 1.0000 49.5000 1.0000 49.6980 1.0000 49.8000 1.0000 49.9980 1.0000 50.1000 1.0000 50.2980 1.0000 50.4000 0.0000 50.5980 0.0000 50.7000 0.0000 50.8980 0.0000 51.0000 0.0000 51.1980 0.0000 51.3000 0.0000 51.4980 0.0000 51.6000 0.0000 51.7980 0.0000 51.9000 0.0000 52.0980 0.0000 52.2000 0.0000 52.3980 0.0000 52.5000 0.0000 52.6980 0.0000 52.8000 0.0000 52.9980 0.0000 53.1000 0.0000 53.2980 0.0000 53.4000 0.0000 53.5980 0.0000 53.7000 0.0000 53.8980 0.0000 54.0000 0.0000 54.1980 0.0000 54.3000 0.0000 54.4980 0.0000 54.6000 0.0000 54.7980 0.0000 54.9000 0.0000 55.0980 0.0000 55.2000 0.0000 55.3980 0.0000 55.5000 0.0000 55.6980 0.0000 55.8000 0.0000 55.9980 0.0000 56.1000 0.0000 56.2980 0.0000 56.4000 0.0000 56.5980 0.0000 56.7000 0.0000 56.8980 0.0000 57.0000 0.0000 57.1980 0.0000 57.3000 0.0000 57.4980 0.0000 57.6000 0.0000 57.7980 0.0000 57.9000 0.0000 58.0980 0.0000 58.2000 0.0000 58.3980 0.0000 58.5000 0.0000 58.6980 0.0000 58.8000 0.0000 58.9980 0.0000 59.1000 0.0000 59.2980 0.0000 59.4000 0.0000 59.5980 0.0000 59.7000 0.0000 59.8980 0.0000 60.0000 0.0000 60.1980 0.0000 60.3000 0.0000 60.4980 0.0000 60.6000 0.0000 60.7980 0.0000 60.9000 0.0000 61.0980 0.0000 61.2000 0.0000 61.3980 0.0000 61.5000 0.0000 61.6980 0.0000 61.8000 0.0000 61.9980 0.0000 62.1000 0.0000 62.2980 0.0000 62.4000 0.0000 62.5980 0.0000 62.7000 0.0000 62.8980 0.0000 63.0000 0.0000 63.1980 0.0000 63.3000 0.0000 63.4980 0.0000 63.6000 0.0000 63.7980 0.0000 63.9000 0.0000 64.0980 0.0000 64.2000 0.0000 64.3980 0.0000 64.5000 0.0000 64.6980 0.0000 64.8000 1.0000 64.9980 1.0000 65.1000 1.0000 65.2980 1.0000 65.4000 1.0000 65.5980 1.0000 65.7000 1.0000 65.8980 1.0000 66.0000 1.0000 66.1980 1.0000 66.3000 1.0000 66.4980 1.0000 66.6000 1.0000 66.7980 1.0000 66.9000 1.0000 67.0980 1.0000 67.2000 1.0000 67.3980 1.0000 67.5000 1.0000 67.6980 1.0000 67.8000 1.0000 67.9980 1.0000 68.1000 1.0000 68.2980 1.0000 68.4000 1.0000 68.5980 1.0000 68.7000 1.0000 68.8980 1.0000 69.0000 1.0000 69.1980 1.0000 69.3000 1.0000 69.4980 1.0000 69.6000 1.0000 69.7980 1.0000 69.9000 1.0000 70.0980 1.0000 70.2000 1.0000 70.3980 1.0000 70.5000 1.0000 70.6980 1.0000 70.8000 1.0000 70.9980 1.0000 71.1000 1.0000 71.2980 1.0000 71.4000 1.0000 71.5980 1.0000 71.7000 1.0000 71.8980 1.0000 72.0000 0.0000 72.1980 0.0000 72.3000 0.0000 72.4980 0.0000 72.6000 0.0000 72.7980 0.0000 72.9000 0.0000 73.0980 0.0000 73.2000 0.0000 73.3980 0.0000 73.5000 0.0000 73.6980 0.0000 73.8000 0.0000 73.9980 0.0000 74.1000 0.0000 74.2980 0.0000 74.4000 0.0000 74.5980 0.0000 74.7000 0.0000 74.8980 0.0000 75.0000 0.0000 75.1980 0.0000 75.3000 0.0000 75.4980 0.0000 75.6000 0.0000 75.7980 0.0000 75.9000 0.0000 76.0980 0.0000 76.2000 0.0000 76.3980 0.0000 76.5000 0.0000 76.6980 0.0000 76.8000 0.0000 76.9980 0.0000 77.1000 0.0000 77.2980 0.0000 77.4000 0.0000 77.5980 0.0000 77.7000 0.0000 77.8980 0.0000 78.0000 0.0000 78.1980 0.0000 78.3000 0.0000 78.4980 0.0000 78.6000 0.0000 78.7980 0.0000 78.9000 0.0000 79.0980 0.0000 79.2000 0.0000 79.3980 0.0000 79.5000 0.0000 79.6980 0.0000 79.8000 0.0000 79.9980 0.0000 80.1000 0.0000 80.2980 0.0000 80.4000 0.0000 80.5980 0.0000 80.7000 0.0000 80.8980 0.0000 81.0000 0.0000 81.1980 0.0000 81.3000 0.0000 81.4980 0.0000 81.6000 0.0000 81.7980 0.0000 81.9000 0.0000 82.0980 0.0000 82.2000 0.0000 82.3980 0.0000 82.5000 0.0000 82.6980 0.0000 82.8000 0.0000 82.9980 0.0000 83.1000 0.0000 83.2980 0.0000 83.4000 0.0000 83.5980 0.0000 83.7000 0.0000 83.8980 0.0000 84.0000 0.0000 84.1980 0.0000 84.3000 0.0000 84.4980 0.0000 84.6000 0.0000 84.7980 0.0000 84.9000 0.0000 85.0980 0.0000 85.2000 0.0000 85.3980 0.0000 85.5000 0.0000 85.6980 0.0000 85.8000 0.0000 85.9980 0.0000 86.1000 0.0000 86.2980 0.0000 86.4000 1.0000 86.5980 1.0000 86.7000 1.0000 86.8980 1.0000 87.0000 1.0000 87.1980 1.0000 87.3000 1.0000 87.4980 1.0000 87.6000 1.0000 87.7980 1.0000 87.9000 1.0000 88.0980 1.0000 88.2000 1.0000 88.3980 1.0000 88.5000 1.0000 88.6980 1.0000 88.8000 1.0000 88.9980 1.0000 89.1000 1.0000 89.2980 1.0000 89.4000 1.0000 89.5980 1.0000 89.7000 1.0000 89.8980 1.0000 90.0000 1.0000 90.1980 1.0000 90.3000 1.0000 90.4980 1.0000 90.6000 1.0000 90.7980 1.0000 90.9000 1.0000 91.0980 1.0000 91.2000 1.0000 91.3980 1.0000 91.5000 1.0000 91.6980 1.0000 91.8000 1.0000 91.9980 1.0000 92.1000 1.0000 92.2980 1.0000 92.4000 1.0000 92.5980 1.0000 92.7000 1.0000 92.8980 1.0000 93.0000 1.0000 93.1980 1.0000 93.3000 1.0000 93.4980 1.0000 93.6000 0.0000 93.7980 0.0000 93.9000 0.0000 94.0980 0.0000 94.2000 0.0000 94.3980 0.0000 94.5000 0.0000 94.6980 0.0000 94.8000 0.0000 94.9980 0.0000 95.1000 0.0000 95.2980 0.0000 95.4000 0.0000 95.5980 0.0000 95.7000 0.0000 95.8980 0.0000 96.0000 0.0000 96.1980 0.0000 96.3000 0.0000 96.4980 0.0000 96.6000 0.0000 96.7980 0.0000 96.9000 0.0000 97.0980 0.0000 97.2000 0.0000 97.3980 0.0000 97.5000 0.0000 97.6980 0.0000 97.8000 0.0000 97.9980 0.0000 98.1000 0.0000 98.2980 0.0000 98.4000 0.0000 98.5980 0.0000 98.7000 0.0000 98.8980 0.0000 99.0000 0.0000 99.1980 0.0000 99.3000 0.0000 99.4980 0.0000 99.6000 0.0000 99.7980 0.0000 99.9000 0.0000 100.0980 0.0000 100.2000 0.0000 100.3980 0.0000 100.5000 0.0000 100.6980 0.0000 100.8000 0.0000 100.9980 0.0000 101.1000 0.0000 101.2980 0.0000 101.4000 0.0000 101.5980 0.0000 101.7000 0.0000 101.8980 0.0000 102.0000 0.0000 102.1980 0.0000 102.3000 0.0000 102.4980 0.0000 102.6000 0.0000 102.7980 0.0000 102.9000 0.0000 103.0980 0.0000 103.2000 0.0000 103.3980 0.0000 103.5000 0.0000 103.6980 0.0000 103.8000 0.0000 103.9980 0.0000 104.1000 0.0000 104.2980 0.0000 104.4000 0.0000 104.5980 0.0000 104.7000 0.0000 104.8980 0.0000 105.0000 0.0000 105.1980 0.0000 105.3000 0.0000 105.4980 0.0000 105.6000 0.0000 105.7980 0.0000 105.9000 0.0000 106.0980 0.0000 106.2000 0.0000 106.3980 0.0000 106.5000 0.0000 106.6980 0.0000 106.8000 0.0000 106.9980 0.0000 107.1000 0.0000 107.2980 0.0000 107.4000 0.0000 107.5980 0.0000 107.7000 0.0000 107.8980 0.0000 108.0000 1.0000 108.1980 1.0000 108.3000 1.0000 108.4980 1.0000 108.6000 1.0000 108.7980 1.0000 108.9000 1.0000 109.0980 1.0000 109.2000 1.0000 109.3980 1.0000 109.5000 1.0000 109.6980 1.0000 109.8000 1.0000 109.9980 1.0000 110.1000 1.0000 110.2980 1.0000 110.4000 1.0000 110.5980 1.0000 110.7000 1.0000 110.8980 1.0000 111.0000 1.0000 111.1980 1.0000 111.3000 1.0000 111.4980 1.0000 111.6000 1.0000 111.7980 1.0000 111.9000 1.0000 112.0980 1.0000 112.2000 1.0000 112.3980 1.0000 112.5000 1.0000 112.6980 1.0000 112.8000 1.0000 112.9980 1.0000 113.1000 1.0000 113.2980 1.0000 113.4000 1.0000 113.5980 1.0000 113.7000 1.0000 113.8980 1.0000 114.0000 1.0000 114.1980 1.0000 114.3000 1.0000 114.4980 1.0000 114.6000 1.0000 114.7980 1.0000 114.9000 1.0000 115.0980 1.0000 115.2000 0.0000 115.3980 0.0000 115.5000 0.0000 115.6980 0.0000 115.8000 0.0000 115.9980 0.0000 116.1000 0.0000 116.2980 0.0000 116.4000 0.0000 116.5980 0.0000 116.7000 0.0000 116.8980 0.0000 117.0000 0.0000 117.1980 0.0000 117.3000 0.0000 117.4980 0.0000 117.6000 0.0000 117.7980 0.0000 117.9000 0.0000 118.0980 0.0000 118.2000 0.0000 118.3980 0.0000 118.5000 0.0000 118.6980 0.0000 118.8000 0.0000 118.9980 0.0000 119.1000 0.0000 119.2980 0.0000 119.4000 0.0000 119.5980 0.0000 119.7000 0.0000 119.8980 0.0000 120.0000 0.0000 120.1980 0.0000 120.3000 0.0000 120.4980 0.0000 120.6000 0.0000 120.7980 0.0000 120.9000 0.0000 121.0980 0.0000 121.2000 0.0000 121.3980 0.0000 121.5000 0.0000 121.6980 0.0000 121.8000 0.0000 121.9980 0.0000 122.1000 0.0000 122.2980 0.0000 122.4000 0.0000 122.5980 0.0000 122.7000 0.0000 122.8980 0.0000 123.0000 0.0000 123.1980 0.0000 123.3000 0.0000 123.4980 0.0000 123.6000 0.0000 123.7980 0.0000 123.9000 0.0000 124.0980 0.0000 124.2000 0.0000 124.3980 0.0000 124.5000 0.0000 124.6980 0.0000 124.8000 0.0000 124.9980 0.0000 125.1000 0.0000 125.2980 0.0000 125.4000 0.0000 125.5980 0.0000 125.7000 0.0000 125.8980 0.0000 126.0000 0.0000 126.1980 0.0000 126.3000 0.0000 126.4980 0.0000 126.6000 0.0000 126.7980 0.0000 126.9000 0.0000 127.0980 0.0000 127.2000 0.0000 127.3980 0.0000 127.5000 0.0000 127.6980 0.0000 127.8000 0.0000 127.9980 0.0000 128.1000 0.0000 128.2980 0.0000 128.4000 0.0000 128.5980 0.0000 128.7000 0.0000 128.8980 0.0000 129.0000 0.0000 129.1980 0.0000 129.3000 0.0000 129.4980 0.0000 129.6000 1.0000 129.7980 1.0000 129.9000 1.0000 130.0980 1.0000 130.2000 1.0000 130.3980 1.0000 130.5000 1.0000 130.6980 1.0000 130.8000 1.0000 130.9980 1.0000 131.1000 1.0000 131.2980 1.0000 131.4000 1.0000 131.5980 1.0000 131.7000 1.0000 131.8980 1.0000 132.0000 1.0000 132.1980 1.0000 132.3000 1.0000 132.4980 1.0000 132.6000 1.0000 132.7980 1.0000 132.9000 1.0000 133.0980 1.0000 133.2000 1.0000 133.3980 1.0000 133.5000 1.0000 133.6980 1.0000 133.8000 1.0000 133.9980 1.0000 134.1000 1.0000 134.2980 1.0000 134.4000 1.0000 134.5980 1.0000 134.7000 1.0000 134.8980 1.0000 135.0000 1.0000 135.1980 1.0000 135.3000 1.0000 135.4980 1.0000 135.6000 1.0000 135.7980 1.0000 135.9000 1.0000 136.0980 1.0000 136.2000 1.0000 136.3980 1.0000 136.5000 1.0000 136.6980 1.0000 136.8000 0.0000 136.9980 0.0000 137.1000 0.0000 137.2980 0.0000 137.4000 0.0000 137.5980 0.0000 137.7000 0.0000 137.8980 0.0000 138.0000 0.0000 138.1980 0.0000 138.3000 0.0000 138.4980 0.0000 138.6000 0.0000 138.7980 0.0000 138.9000 0.0000 139.0980 0.0000 139.2000 0.0000 139.3980 0.0000 139.5000 0.0000 139.6980 0.0000 139.8000 0.0000 139.9980 0.0000 140.1000 0.0000 140.2980 0.0000 140.4000 0.0000 140.5980 0.0000 140.7000 0.0000 140.8980 0.0000 141.0000 0.0000 141.1980 0.0000 141.3000 0.0000 141.4980 0.0000 141.6000 0.0000 141.7980 0.0000 141.9000 0.0000 142.0980 0.0000 142.2000 0.0000 142.3980 0.0000 142.5000 0.0000 142.6980 0.0000 142.8000 0.0000 142.9980 0.0000 143.1000 0.0000 143.2980 0.0000 143.4000 0.0000 143.5980 0.0000 143.7000 0.0000 143.8980 0.0000 144.0000 0.0000 144.1980 0.0000 144.3000 0.0000 144.4980 0.0000 144.6000 0.0000 144.7980 0.0000 144.9000 0.0000 145.0980 0.0000 145.2000 0.0000 145.3980 0.0000 145.5000 0.0000 145.6980 0.0000 145.8000 0.0000 145.9980 0.0000 146.1000 0.0000 146.2980 0.0000 146.4000 0.0000 146.5980 0.0000 146.7000 0.0000 146.8980 0.0000 147.0000 0.0000 147.1980 0.0000 147.3000 0.0000 147.4980 0.0000 147.6000 0.0000 147.7980 0.0000 147.9000 0.0000 148.0980 0.0000 148.2000 0.0000 148.3980 0.0000 148.5000 0.0000 148.6980 0.0000 148.8000 0.0000 148.9980 0.0000 149.1000 0.0000 149.2980 0.0000 149.4000 0.0000 149.5980 0.0000 149.7000 0.0000 149.8980 0.0000 150.0000 0.0000 150.1980 0.0000 150.3000 0.0000 150.4980 0.0000 150.6000 0.0000 150.7980 0.0000 150.9000 0.0000 151.0980 0.0000 151.2000 1.0000 151.3980 1.0000 151.5000 1.0000 151.6980 1.0000 151.8000 1.0000 151.9980 1.0000 152.1000 1.0000 152.2980 1.0000 152.4000 1.0000 152.5980 1.0000 152.7000 1.0000 152.8980 1.0000 153.0000 1.0000 153.1980 1.0000 153.3000 1.0000 153.4980 1.0000 153.6000 1.0000 153.7980 1.0000 153.9000 1.0000 154.0980 1.0000 154.2000 1.0000 154.3980 1.0000 154.5000 1.0000 154.6980 1.0000 154.8000 1.0000 154.9980 1.0000 155.1000 1.0000 155.2980 1.0000 155.4000 1.0000 155.5980 1.0000 155.7000 1.0000 155.8980 1.0000 156.0000 1.0000 156.1980 1.0000 156.3000 1.0000 156.4980 1.0000 156.6000 1.0000 156.7980 1.0000 156.9000 1.0000 157.0980 1.0000 157.2000 1.0000 157.3980 1.0000 157.5000 1.0000 157.6980 1.0000 157.8000 1.0000 157.9980 1.0000 158.1000 1.0000 158.2980 1.0000 158.4000 0.0000 158.5980 0.0000 158.7000 0.0000 158.8980 0.0000 159.0000 0.0000 159.1980 0.0000 159.3000 0.0000 159.4980 0.0000 159.6000 0.0000 159.7980 0.0000 159.9000 0.0000 160.0980 0.0000 160.2000 0.0000 160.3980 0.0000 160.5000 0.0000 160.6980 0.0000 160.8000 0.0000 160.9980 0.0000 161.1000 0.0000 161.2980 0.0000 161.4000 0.0000 161.5980 0.0000 161.7000 0.0000 161.8980 0.0000 162.0000 0.0000 162.1980 0.0000 162.3000 0.0000 162.4980 0.0000 162.6000 0.0000 162.7980 0.0000 162.9000 0.0000 163.0980 0.0000 163.2000 0.0000 163.3980 0.0000 163.5000 0.0000 163.6980 0.0000 163.8000 0.0000 163.9980 0.0000 164.1000 0.0000 164.2980 0.0000 164.4000 0.0000 164.5980 0.0000 164.7000 0.0000 164.8980 0.0000 165.0000 0.0000 165.1980 0.0000 165.3000 0.0000 165.4980 0.0000 165.6000 0.0000 165.7980 0.0000 165.9000 0.0000 166.0980 0.0000 166.2000 0.0000 166.3980 0.0000 166.5000 0.0000 166.6980 0.0000 166.8000 0.0000 166.9980 0.0000 167.1000 0.0000 167.2980 0.0000 167.4000 0.0000 167.5980 0.0000 167.7000 0.0000 167.8980 0.0000 168.0000 0.0000 168.1980 0.0000 168.3000 0.0000 168.4980 0.0000 168.6000 0.0000 168.7980 0.0000 168.9000 0.0000 169.0980 0.0000 169.2000 0.0000 169.3980 0.0000 169.5000 0.0000 169.6980 0.0000 169.8000 0.0000 169.9980 0.0000 170.1000 0.0000 170.2980 0.0000 170.4000 0.0000 170.5980 0.0000 170.7000 0.0000 170.8980 0.0000 171.0000 0.0000 171.1980 0.0000 171.3000 0.0000 171.4980 0.0000 171.6000 0.0000 171.7980 0.0000 171.9000 0.0000 172.0980 0.0000 172.2000 0.0000 172.3980 0.0000 172.5000 0.0000 172.6980 0.0000 172.8000 1.0000 172.9980 1.0000 173.1000 1.0000 173.2980 1.0000 173.4000 1.0000 173.5980 1.0000 173.7000 1.0000 173.8980 1.0000 174.0000 1.0000 174.1980 1.0000 174.3000 1.0000 174.4980 1.0000 174.6000 1.0000 174.7980 1.0000 174.9000 1.0000 175.0980 1.0000 175.2000 1.0000 175.3980 1.0000 175.5000 1.0000 175.6980 1.0000 175.8000 1.0000 175.9980 1.0000 176.1000 1.0000 176.2980 1.0000 176.4000 1.0000 176.5980 1.0000 176.7000 1.0000 176.8980 1.0000 177.0000 1.0000 177.1980 1.0000 177.3000 1.0000 177.4980 1.0000 177.6000 1.0000 177.7980 1.0000 177.9000 1.0000 178.0980 1.0000 178.2000 1.0000 178.3980 1.0000 178.5000 1.0000 178.6980 1.0000 178.8000 1.0000 178.9980 1.0000 179.1000 1.0000 179.2980 1.0000 179.4000 1.0000 179.5980 1.0000 179.7000 1.0000 179.8980 1.0000 180.0000 0.0000 180.1980 0.0000 180.3000 0.0000 180.4980 0.0000 180.6000 0.0000 180.7980 0.0000 180.9000 0.0000 181.0980 0.0000 181.2000 0.0000 181.3980 0.0000 181.5000 0.0000 181.6980 0.0000 181.8000 0.0000 181.9980 0.0000 182.1000 0.0000 182.2980 0.0000 182.4000 0.0000 182.5980 0.0000 182.7000 0.0000 182.8980 0.0000 183.0000 0.0000 183.1980 0.0000 183.3000 0.0000 183.4980 0.0000 183.6000 0.0000 183.7980 0.0000 183.9000 0.0000 184.0980 0.0000 184.2000 0.0000 184.3980 0.0000 184.5000 0.0000 184.6980 0.0000 184.8000 0.0000 184.9980 0.0000 185.1000 0.0000 185.2980 0.0000 185.4000 0.0000 185.5980 0.0000 185.7000 0.0000 185.8980 0.0000 186.0000 0.0000 186.1980 0.0000 186.3000 0.0000 186.4980 0.0000 186.6000 0.0000 186.7980 0.0000 186.9000 0.0000 187.0980 0.0000 187.2000 0.0000 187.3980 0.0000 187.5000 0.0000 187.6980 0.0000 187.8000 0.0000 187.9980 0.0000 188.1000 0.0000 188.2980 0.0000 188.4000 0.0000 188.5980 0.0000 188.7000 0.0000 188.8980 0.0000 189.0000 0.0000 189.1980 0.0000 189.3000 0.0000 189.4980 0.0000 189.6000 0.0000 189.7980 0.0000 189.9000 0.0000 190.0980 0.0000 190.2000 0.0000 190.3980 0.0000 190.5000 0.0000 190.6980 0.0000 190.8000 0.0000 190.9980 0.0000 191.1000 0.0000 191.2980 0.0000 191.4000 0.0000 191.5980 0.0000 191.7000 0.0000 191.8980 0.0000 192.0000 0.0000 192.1980 0.0000 192.3000 0.0000 192.4980 0.0000 192.6000 0.0000 192.7980 0.0000 192.9000 0.0000 193.0980 0.0000 193.2000 0.0000 193.3980 0.0000 193.5000 0.0000 193.6980 0.0000 193.8000 0.0000 193.9980 0.0000 194.1000 0.0000 194.2980 0.0000 194.4000 1.0000 194.5980 1.0000 194.7000 1.0000 194.8980 1.0000 195.0000 1.0000 195.1980 1.0000 195.3000 1.0000 195.4980 1.0000 195.6000 1.0000 195.7980 1.0000 195.9000 1.0000 196.0980 1.0000 196.2000 1.0000 196.3980 1.0000 196.5000 1.0000 196.6980 1.0000 196.8000 1.0000 196.9980 1.0000 197.1000 1.0000 197.2980 1.0000 197.4000 1.0000 197.5980 1.0000 197.7000 1.0000 197.8980 1.0000 198.0000 1.0000 198.1980 1.0000 198.3000 1.0000 198.4980 1.0000 198.6000 1.0000 198.7980 1.0000 198.9000 1.0000 199.0980 1.0000 199.2000 1.0000 199.3980 1.0000 199.5000 1.0000 199.6980 1.0000 199.8000 1.0000 199.9980 1.0000 200.1000 1.0000 200.2980 1.0000 200.4000 1.0000 200.5980 1.0000 200.7000 1.0000 200.8980 1.0000 201.0000 1.0000 201.1980 1.0000 201.3000 1.0000 201.4980 1.0000 201.6000 0.0000 201.7980 0.0000 201.9000 0.0000 202.0980 0.0000 202.2000 0.0000 202.3980 0.0000 202.5000 0.0000 202.6980 0.0000 202.8000 0.0000 202.9980 0.0000 203.1000 0.0000 203.2980 0.0000 203.4000 0.0000 203.5980 0.0000 203.7000 0.0000 203.8980 0.0000 204.0000 0.0000 204.1980 0.0000 204.3000 0.0000 204.4980 0.0000 204.6000 0.0000 204.7980 0.0000 204.9000 0.0000 205.0980 0.0000 205.2000 0.0000 205.3980 0.0000 205.5000 0.0000 205.6980 0.0000 205.8000 0.0000 205.9980 0.0000 206.1000 0.0000 206.2980 0.0000 206.4000 0.0000 206.5980 0.0000 206.7000 0.0000 206.8980 0.0000 207.0000 0.0000 207.1980 0.0000 207.3000 0.0000 207.4980 0.0000 207.6000 0.0000 207.7980 0.0000 207.9000 0.0000 208.0980 0.0000 208.2000 0.0000 208.3980 0.0000 208.5000 0.0000 208.6980 0.0000 208.8000 0.0000 208.9980 0.0000 209.1000 0.0000 209.2980 0.0000 209.4000 0.0000 209.5980 0.0000 209.7000 0.0000 209.8980 0.0000 210.0000 0.0000 210.1980 0.0000 210.3000 0.0000 210.4980 0.0000 210.6000 0.0000 210.7980 0.0000 210.9000 0.0000 211.0980 0.0000 211.2000 0.0000 211.3980 0.0000 211.5000 0.0000 211.6980 0.0000 211.8000 0.0000 211.9980 0.0000 212.1000 0.0000 212.2980 0.0000 212.4000 0.0000 212.5980 0.0000 212.7000 0.0000 212.8980 0.0000 213.0000 0.0000 213.1980 0.0000 213.3000 0.0000 213.4980 0.0000 213.6000 0.0000 213.7980 0.0000 213.9000 0.0000 214.0980 0.0000 214.2000 0.0000 214.3980 0.0000 214.5000 0.0000 214.6980 0.0000 214.8000 0.0000 214.9980 0.0000 215.1000 0.0000 215.2980 0.0000 215.4000 0.0000 215.5980 0.0000 215.7000 0.0000 215.8980 0.0000 216.0000 1.0000 216.1980 1.0000 216.3000 1.0000 216.4980 1.0000 216.6000 1.0000 216.7980 1.0000 216.9000 1.0000 217.0980 1.0000 217.2000 1.0000 217.3980 1.0000 217.5000 1.0000 217.6980 1.0000 217.8000 1.0000 217.9980 1.0000 218.1000 1.0000 218.2980 1.0000 218.4000 1.0000 218.5980 1.0000 218.7000 1.0000 218.8980 1.0000 219.0000 1.0000 219.1980 1.0000 219.3000 1.0000 219.4980 1.0000 219.6000 1.0000 219.7980 1.0000 219.9000 1.0000 220.0980 1.0000 220.2000 1.0000 220.3980 1.0000 220.5000 1.0000 220.6980 1.0000 220.8000 1.0000 220.9980 1.0000 221.1000 1.0000 221.2980 1.0000 221.4000 1.0000 221.5980 1.0000 221.7000 1.0000 221.8980 1.0000 222.0000 1.0000 222.1980 1.0000 222.3000 1.0000 222.4980 1.0000 222.6000 1.0000 222.7980 1.0000 222.9000 1.0000 223.0980 1.0000 223.2000 0.0000 223.3980 0.0000 223.5000 0.0000 223.6980 0.0000 223.8000 0.0000 223.9980 0.0000 224.1000 0.0000 224.2980 0.0000 224.4000 0.0000 224.5980 0.0000 224.7000 0.0000 224.8980 0.0000 225.0000 0.0000 225.1980 0.0000 225.3000 0.0000 225.4980 0.0000 225.6000 0.0000 225.7980 0.0000 225.9000 0.0000 226.0980 0.0000 226.2000 0.0000 226.3980 0.0000 226.5000 0.0000 226.6980 0.0000 226.8000 0.0000 226.9980 0.0000 227.1000 0.0000 227.2980 0.0000 227.4000 0.0000 227.5980 0.0000 227.7000 0.0000 227.8980 0.0000 228.0000 0.0000 228.1980 0.0000 228.3000 0.0000 228.4980 0.0000 228.6000 0.0000 228.7980 0.0000 228.9000 0.0000 229.0980 0.0000 229.2000 0.0000 229.3980 0.0000 229.5000 0.0000 229.6980 0.0000 229.8000 0.0000 229.9980 0.0000 230.1000 0.0000 230.2980 0.0000 230.4000 0.0000 230.5980 0.0000 230.7000 0.0000 230.8980 0.0000 231.0000 0.0000 231.1980 0.0000 231.3000 0.0000 231.4980 0.0000 231.6000 0.0000 231.7980 0.0000 231.9000 0.0000 232.0980 0.0000 232.2000 0.0000 232.3980 0.0000 232.5000 0.0000 232.6980 0.0000 232.8000 0.0000 232.9980 0.0000 233.1000 0.0000 233.2980 0.0000 233.4000 0.0000 233.5980 0.0000 233.7000 0.0000 233.8980 0.0000 234.0000 0.0000 234.1980 0.0000 234.3000 0.0000 234.4980 0.0000 234.6000 0.0000 234.7980 0.0000 234.9000 0.0000 235.0980 0.0000 235.2000 0.0000 235.3980 0.0000 235.5000 0.0000 235.6980 0.0000 235.8000 0.0000 235.9980 0.0000 236.1000 0.0000 236.2980 0.0000 236.4000 0.0000 236.5980 0.0000 236.7000 0.0000 236.8980 0.0000 237.0000 0.0000 237.1980 0.0000 237.3000 0.0000 237.4980 0.0000 237.6000 1.0000 237.7980 1.0000 237.9000 1.0000 238.0980 1.0000 238.2000 1.0000 238.3980 1.0000 238.5000 1.0000 238.6980 1.0000 238.8000 1.0000 238.9980 1.0000 239.1000 1.0000 239.2980 1.0000 239.4000 1.0000 239.5980 1.0000 239.7000 1.0000 239.8980 1.0000 240.0000 1.0000 240.1980 1.0000 240.3000 1.0000 240.4980 1.0000 240.6000 1.0000 240.7980 1.0000 240.9000 1.0000 241.0980 1.0000 241.2000 1.0000 241.3980 1.0000 241.5000 1.0000 241.6980 1.0000 241.8000 1.0000 241.9980 1.0000 242.1000 1.0000 242.2980 1.0000 242.4000 1.0000 242.5980 1.0000 242.7000 1.0000 242.8980 1.0000 243.0000 1.0000 243.1980 1.0000 243.3000 1.0000 243.4980 1.0000 243.6000 1.0000 243.7980 1.0000 243.9000 1.0000 244.0980 1.0000 244.2000 1.0000 244.3980 1.0000 244.5000 1.0000 244.6980 1.0000 244.8000 0.0000 244.9980 0.0000 245.1000 0.0000 245.2980 0.0000 245.4000 0.0000 245.5980 0.0000 245.7000 0.0000 245.8980 0.0000 246.0000 0.0000 246.1980 0.0000 246.3000 0.0000 246.4980 0.0000 246.6000 0.0000 246.7980 0.0000 246.9000 0.0000 247.0980 0.0000 247.2000 0.0000 247.3980 0.0000 247.5000 0.0000 247.6980 0.0000 247.8000 0.0000 247.9980 0.0000 248.1000 0.0000 248.2980 0.0000 248.4000 0.0000 248.5980 0.0000 248.7000 0.0000 248.8980 0.0000 249.0000 0.0000 249.1980 0.0000 249.3000 0.0000 249.4980 0.0000 249.6000 0.0000 249.7980 0.0000 249.9000 0.0000 250.0980 0.0000 250.2000 0.0000 250.3980 0.0000 250.5000 0.0000 250.6980 0.0000 250.8000 0.0000 250.9980 0.0000 251.1000 0.0000 251.2980 0.0000 251.4000 0.0000 251.5980 0.0000 251.7000 0.0000 251.8980 0.0000 252.0000 0.0000 252.1980 0.0000 252.3000 0.0000 252.4980 0.0000 252.6000 0.0000 252.7980 0.0000 252.9000 0.0000 253.0980 0.0000 253.2000 0.0000 253.3980 0.0000 253.5000 0.0000 253.6980 0.0000 253.8000 0.0000 253.9980 0.0000 254.1000 0.0000 254.2980 0.0000 254.4000 0.0000 254.5980 0.0000 254.7000 0.0000 254.8980 0.0000 255.0000 0.0000 255.1980 0.0000 255.3000 0.0000 255.4980 0.0000 255.6000 0.0000 255.7980 0.0000 255.9000 0.0000 256.0980 0.0000 256.2000 0.0000 256.3980 0.0000 256.5000 0.0000 256.6980 0.0000 256.8000 0.0000 256.9980 0.0000 257.1000 0.0000 257.2980 0.0000 257.4000 0.0000 257.5980 0.0000 257.7000 0.0000 257.8980 0.0000 258.0000 0.0000 258.1980 0.0000 258.3000 0.0000 258.4980 0.0000 258.6000 0.0000 258.7980 0.0000 258.9000 0.0000 259.0980 0.0000 259.2000 1.0000 259.3980 1.0000 259.5000 1.0000 259.6980 1.0000 259.8000 1.0000 259.9980 1.0000 260.1000 1.0000 260.2980 1.0000 260.4000 1.0000 260.5980 1.0000 260.7000 1.0000 260.8980 1.0000 261.0000 1.0000 261.1980 1.0000 261.3000 1.0000 261.4980 1.0000 261.6000 1.0000 261.7980 1.0000 261.9000 1.0000 262.0980 1.0000 262.2000 1.0000 262.3980 1.0000 262.5000 1.0000 262.6980 1.0000 262.8000 1.0000 262.9980 1.0000 263.1000 1.0000 263.2980 1.0000 263.4000 1.0000 263.5980 1.0000 263.7000 1.0000 263.8980 1.0000 264.0000 1.0000 264.1980 1.0000 264.3000 1.0000 264.4980 1.0000 264.6000 1.0000 264.7980 1.0000 264.9000 1.0000 265.0980 1.0000 265.2000 1.0000 265.3980 1.0000 265.5000 1.0000 265.6980 1.0000 265.8000 1.0000 265.9980 1.0000 266.1000 1.0000 266.2980 1.0000 266.4000 0.0000 266.5980 0.0000 266.7000 0.0000 266.8980 0.0000 267.0000 0.0000 267.1980 0.0000 267.3000 0.0000 267.4980 0.0000 267.6000 0.0000 267.7980 0.0000 267.9000 0.0000 268.0980 0.0000 268.2000 0.0000 268.3980 0.0000 268.5000 0.0000 268.6980 0.0000 268.8000 0.0000 268.9980 0.0000 269.1000 0.0000 269.2980 0.0000 269.4000 0.0000 269.5980 0.0000 269.7000 0.0000 269.8980 0.0000 270.0000 0.0000 270.1980 0.0000 270.3000 0.0000 270.4980 0.0000 270.6000 0.0000 270.7980 0.0000 270.9000 0.0000 271.0980 0.0000 271.2000 0.0000 271.3980 0.0000 271.5000 0.0000 271.6980 0.0000 271.8000 0.0000 271.9980 0.0000 272.1000 0.0000 272.2980 0.0000 272.4000 0.0000 272.5980 0.0000 272.7000 0.0000 272.8980 0.0000 273.0000 0.0000 273.1980 0.0000 273.3000 0.0000 273.4980 0.0000 273.6000 0.0000 273.7980 0.0000 273.9000 0.0000 274.0980 0.0000 274.2000 0.0000 274.3980 0.0000 274.5000 0.0000 274.6980 0.0000 274.8000 0.0000 274.9980 0.0000 275.1000 0.0000 275.2980 0.0000 275.4000 0.0000 275.5980 0.0000 275.7000 0.0000 275.8980 0.0000 276.0000 0.0000 276.1980 0.0000 276.3000 0.0000 276.4980 0.0000 276.6000 0.0000 276.7980 0.0000 276.9000 0.0000 277.0980 0.0000 277.2000 0.0000 277.3980 0.0000 277.5000 0.0000 277.6980 0.0000 277.8000 0.0000 277.9980 0.0000 278.1000 0.0000 278.2980 0.0000 278.4000 0.0000 278.5980 0.0000 278.7000 0.0000 278.8980 0.0000 279.0000 0.0000 279.1980 0.0000 279.3000 0.0000 279.4980 0.0000 279.6000 0.0000 279.7980 0.0000 279.9000 0.0000 280.0980 0.0000 280.2000 0.0000 280.3980 0.0000 280.5000 0.0000 280.6980 0.0000 280.8000 1.0000 280.9980 1.0000 281.1000 1.0000 281.2980 1.0000 281.4000 1.0000 281.5980 1.0000 281.7000 1.0000 281.8980 1.0000 282.0000 1.0000 282.1980 1.0000 282.3000 1.0000 282.4980 1.0000 282.6000 1.0000 282.7980 1.0000 282.9000 1.0000 283.0980 1.0000 283.2000 1.0000 283.3980 1.0000 283.5000 1.0000 283.6980 1.0000 283.8000 1.0000 283.9980 1.0000 284.1000 1.0000 284.2980 1.0000 284.4000 1.0000 284.5980 1.0000 284.7000 1.0000 284.8980 1.0000 285.0000 1.0000 285.1980 1.0000 285.3000 1.0000 285.4980 1.0000 285.6000 1.0000 285.7980 1.0000 285.9000 1.0000 286.0980 1.0000 286.2000 1.0000 286.3980 1.0000 286.5000 1.0000 286.6980 1.0000 286.8000 1.0000 286.9980 1.0000 287.1000 1.0000 287.2980 1.0000 287.4000 1.0000 287.5980 1.0000 287.7000 1.0000 287.8980 1.0000 288.0000 0.0000 288.1980 0.0000 288.3000 0.0000 288.4980 0.0000 288.6000 0.0000 288.7980 0.0000 288.9000 0.0000 289.0980 0.0000 289.2000 0.0000 289.3980 0.0000 289.5000 0.0000 289.6980 0.0000 289.8000 0.0000 289.9980 0.0000 290.1000 0.0000 290.2980 0.0000 290.4000 0.0000 290.5980 0.0000 290.7000 0.0000 290.8980 0.0000 291.0000 0.0000 291.1980 0.0000 291.3000 0.0000 291.4980 0.0000 291.6000 0.0000 291.7980 0.0000 291.9000 0.0000 292.0980 0.0000 292.2000 0.0000 292.3980 0.0000 292.5000 0.0000 292.6980 0.0000 292.8000 0.0000 292.9980 0.0000 293.1000 0.0000 293.2980 0.0000 293.4000 0.0000 293.5980 0.0000 293.7000 0.0000 293.8980 0.0000 294.0000 0.0000 294.1980 0.0000 294.3000 0.0000 294.4980 0.0000 294.6000 0.0000 294.7980 0.0000 294.9000 0.0000 295.0980 0.0000 295.2000 0.0000 295.3980 0.0000 295.5000 0.0000 295.6980 0.0000 295.8000 0.0000 295.9980 0.0000 296.1000 0.0000 296.2980 0.0000 296.4000 0.0000 296.5980 0.0000 296.7000 0.0000 296.8980 0.0000 297.0000 0.0000 297.1980 0.0000 297.3000 0.0000 297.4980 0.0000 297.6000 0.0000 297.7980 0.0000 297.9000 0.0000 298.0980 0.0000 298.2000 0.0000 298.3980 0.0000 298.5000 0.0000 298.6980 0.0000 298.8000 0.0000 298.9980 0.0000 299.1000 0.0000 299.2980 0.0000 299.4000 0.0000 299.5980 0.0000 299.7000 0.0000 299.8980 0.0000 300.0000 0.0000 300.1980 0.0000 300.3000 0.0000 300.4980 0.0000 300.6000 0.0000 300.7980 0.0000 300.9000 0.0000 301.0980 0.0000 301.2000 0.0000 301.3980 0.0000 301.5000 0.0000 301.6980 0.0000 301.8000 0.0000 301.9980 0.0000 302.1000 0.0000 302.2980 0.0000 302.4000 1.0000 302.5980 1.0000 302.7000 1.0000 302.8980 1.0000 303.0000 1.0000 303.1980 1.0000 303.3000 1.0000 303.4980 1.0000 303.6000 1.0000 303.7980 1.0000 303.9000 1.0000 304.0980 1.0000 304.2000 1.0000 304.3980 1.0000 304.5000 1.0000 304.6980 1.0000 304.8000 1.0000 304.9980 1.0000 305.1000 1.0000 305.2980 1.0000 305.4000 1.0000 305.5980 1.0000 305.7000 1.0000 305.8980 1.0000 306.0000 1.0000 306.1980 1.0000 306.3000 1.0000 306.4980 1.0000 306.6000 1.0000 306.7980 1.0000 306.9000 1.0000 307.0980 1.0000 307.2000 1.0000 307.3980 1.0000 307.5000 1.0000 307.6980 1.0000 307.8000 1.0000 307.9980 1.0000 308.1000 1.0000 308.2980 1.0000 308.4000 1.0000 308.5980 1.0000 308.7000 1.0000 308.8980 1.0000 309.0000 1.0000 309.1980 1.0000 309.3000 1.0000 309.4980 1.0000 309.6000 0.0000 309.7980 0.0000 309.9000 0.0000 310.0980 0.0000 310.2000 0.0000 310.3980 0.0000 310.5000 0.0000 310.6980 0.0000 310.8000 0.0000 310.9980 0.0000 311.1000 0.0000 311.2980 0.0000 311.4000 0.0000 311.5980 0.0000 311.7000 0.0000 311.8980 0.0000 312.0000 0.0000 312.1980 0.0000 312.3000 0.0000 312.4980 0.0000 312.6000 0.0000 312.7980 0.0000 312.9000 0.0000 313.0980 0.0000 313.2000 0.0000 313.3980 0.0000 313.5000 0.0000 313.6980 0.0000 313.8000 0.0000 313.9980 0.0000 314.1000 0.0000 314.2980 0.0000 314.4000 0.0000 314.5980 0.0000 314.7000 0.0000 314.8980 0.0000 315.0000 0.0000 315.1980 0.0000 315.3000 0.0000 315.4980 0.0000 315.6000 0.0000 315.7980 0.0000 315.9000 0.0000 316.0980 0.0000 316.2000 0.0000 316.3980 0.0000 316.5000 0.0000 316.6980 0.0000 316.8000 0.0000 316.9980 0.0000 317.1000 0.0000 317.2980 0.0000 317.4000 0.0000 317.5980 0.0000 317.7000 0.0000 317.8980 0.0000 318.0000 0.0000 318.1980 0.0000 318.3000 0.0000 318.4980 0.0000 318.6000 0.0000 318.7980 0.0000 318.9000 0.0000 319.0980 0.0000 319.2000 0.0000 319.3980 0.0000 319.5000 0.0000 319.6980 0.0000 319.8000 0.0000 319.9980 0.0000 320.1000 0.0000 320.2980 0.0000 320.4000 0.0000 320.5980 0.0000 320.7000 0.0000 320.8980 0.0000 321.0000 0.0000 321.1980 0.0000 321.3000 0.0000 321.4980 0.0000 321.6000 0.0000 321.7980 0.0000 321.9000 0.0000 322.0980 0.0000 322.2000 0.0000 322.3980 0.0000 322.5000 0.0000 322.6980 0.0000 322.8000 0.0000 322.9980 0.0000 323.1000 0.0000 323.2980 0.0000 323.4000 0.0000 323.5980 0.0000 323.7000 0.0000 323.8980 0.0000 324.0000 1.0000 324.1980 1.0000 324.3000 1.0000 324.4980 1.0000 324.6000 1.0000 324.7980 1.0000 324.9000 1.0000 325.0980 1.0000 325.2000 1.0000 325.3980 1.0000 325.5000 1.0000 325.6980 1.0000 325.8000 1.0000 325.9980 1.0000 326.1000 1.0000 326.2980 1.0000 326.4000 1.0000 326.5980 1.0000 326.7000 1.0000 326.8980 1.0000 327.0000 1.0000 327.1980 1.0000 327.3000 1.0000 327.4980 1.0000 327.6000 1.0000 327.7980 1.0000 327.9000 1.0000 328.0980 1.0000 328.2000 1.0000 328.3980 1.0000 328.5000 1.0000 328.6980 1.0000 328.8000 1.0000 328.9980 1.0000 329.1000 1.0000 329.2980 1.0000 329.4000 1.0000 329.5980 1.0000 329.7000 1.0000 329.8980 1.0000 330.0000 1.0000 330.1980 1.0000 330.3000 1.0000 330.4980 1.0000 330.6000 1.0000 330.7980 1.0000 330.9000 1.0000 331.0980 1.0000 331.2000 0.0000 331.3980 0.0000 331.5000 0.0000 331.6980 0.0000 331.8000 0.0000 331.9980 0.0000 332.1000 0.0000 332.2980 0.0000 332.4000 0.0000 332.5980 0.0000 332.7000 0.0000 332.8980 0.0000 333.0000 0.0000 333.1980 0.0000 333.3000 0.0000 333.4980 0.0000 333.6000 0.0000 333.7980 0.0000 333.9000 0.0000 334.0980 0.0000 334.2000 0.0000 334.3980 0.0000 334.5000 0.0000 334.6980 0.0000 334.8000 0.0000 334.9980 0.0000 335.1000 0.0000 335.2980 0.0000 335.4000 0.0000 335.5980 0.0000 335.7000 0.0000 335.8980 0.0000 336.0000 0.0000 336.1980 0.0000 336.3000 0.0000 336.4980 0.0000 336.6000 0.0000 336.7980 0.0000 336.9000 0.0000 337.0980 0.0000 337.2000 0.0000 337.3980 0.0000 337.5000 0.0000 337.6980 0.0000 337.8000 0.0000 337.9980 0.0000 338.1000 0.0000 338.2980 0.0000 338.4000 0.0000 338.5980 0.0000 338.7000 0.0000 338.8980 0.0000 339.0000 0.0000 339.1980 0.0000 339.3000 0.0000 339.4980 0.0000 339.6000 0.0000 339.7980 0.0000 339.9000 0.0000 340.0980 0.0000 340.2000 0.0000 340.3980 0.0000 340.5000 0.0000 340.6980 0.0000 340.8000 0.0000 340.9980 0.0000 341.1000 0.0000 341.2980 0.0000 341.4000 0.0000 341.5980 0.0000 341.7000 0.0000 341.8980 0.0000 342.0000 0.0000 342.1980 0.0000 342.3000 0.0000 342.4980 0.0000 342.6000 0.0000 342.7980 0.0000 342.9000 0.0000 343.0980 0.0000 343.2000 0.0000 343.3980 0.0000 343.5000 0.0000 343.6980 0.0000 343.8000 0.0000 343.9980 0.0000 344.1000 0.0000 344.2980 0.0000 344.4000 0.0000 344.5980 0.0000 344.7000 0.0000 344.8980 0.0000 345.0000 0.0000 345.1980 0.0000 345.3000 0.0000 345.4980 0.0000 345.6000 1.0000 345.7980 1.0000 345.9000 1.0000 346.0980 1.0000 346.2000 1.0000 346.3980 1.0000 346.5000 1.0000 346.6980 1.0000 346.8000 1.0000 346.9980 1.0000 347.1000 1.0000 347.2980 1.0000 347.4000 1.0000 347.5980 1.0000 347.7000 1.0000 347.8980 1.0000 348.0000 1.0000 348.1980 1.0000 348.3000 1.0000 348.4980 1.0000 348.6000 1.0000 348.7980 1.0000 348.9000 1.0000 349.0980 1.0000 349.2000 1.0000 349.3980 1.0000 349.5000 1.0000 349.6980 1.0000 349.8000 1.0000 349.9980 1.0000 350.1000 1.0000 350.2980 1.0000 350.4000 1.0000 350.5980 1.0000 350.7000 1.0000 350.8980 1.0000 351.0000 1.0000 351.1980 1.0000 351.3000 1.0000 351.4980 1.0000 351.6000 1.0000 351.7980 1.0000 351.9000 1.0000 352.0980 1.0000 352.2000 1.0000 352.3980 1.0000 352.5000 1.0000 352.6980 1.0000 352.8000 0.0000 352.9980 0.0000 353.1000 0.0000 353.2980 0.0000 353.4000 0.0000 353.5980 0.0000 353.7000 0.0000 353.8980 0.0000 354.0000 0.0000 354.1980 0.0000 354.3000 0.0000 354.4980 0.0000 354.6000 0.0000 354.7980 0.0000 354.9000 0.0000 355.0980 0.0000 355.2000 0.0000 355.3980 0.0000 355.5000 0.0000 355.6980 0.0000 355.8000 0.0000 355.9980 0.0000 356.1000 0.0000 356.2980 0.0000 356.4000 0.0000 356.5980 0.0000 356.7000 0.0000 356.8980 0.0000 357.0000 0.0000 357.1980 0.0000 357.3000 0.0000 357.4980 0.0000 357.6000 0.0000 357.7980 0.0000 357.9000 0.0000 358.0980 0.0000 358.2000 0.0000 358.3980 0.0000 358.5000 0.0000 358.6980 0.0000 358.8000 0.0000 358.9980 0.0000 359.1000 0.0000 359.2980 0.0000 359.4000 0.0000 359.5980 0.0000 359.7000 0.0000 359.8980 0.0000 360.0000 0.0000 360.1980 0.0000 360.3000 0.0000 360.4980 0.0000 360.6000 0.0000 360.7980 0.0000 360.9000 0.0000 361.0980 0.0000 361.2000 0.0000 361.3980 0.0000 361.5000 0.0000 361.6980 0.0000 361.8000 0.0000 361.9980 0.0000 362.1000 0.0000 362.2980 0.0000 362.4000 0.0000 362.5980 0.0000 362.7000 0.0000 362.8980 0.0000 363.0000 0.0000 363.1980 0.0000 363.3000 0.0000 363.4980 0.0000 363.6000 0.0000 363.7980 0.0000 363.9000 0.0000 364.0980 0.0000 364.2000 0.0000 364.3980 0.0000 364.5000 0.0000 364.6980 0.0000 364.8000 0.0000 364.9980 0.0000 365.1000 0.0000 365.2980 0.0000 365.4000 0.0000 365.5980 0.0000 365.7000 0.0000 365.8980 0.0000 366.0000 0.0000 366.1980 0.0000 366.3000 0.0000 366.4980 0.0000 366.6000 0.0000 366.7980 0.0000 366.9000 0.0000 367.0980 0.0000 367.2000 1.0000 367.3980 1.0000 367.5000 1.0000 367.6980 1.0000 367.8000 1.0000 367.9980 1.0000 368.1000 1.0000 368.2980 1.0000 368.4000 1.0000 368.5980 1.0000 368.7000 1.0000 368.8980 1.0000 369.0000 1.0000 369.1980 1.0000 369.3000 1.0000 369.4980 1.0000 369.6000 1.0000 369.7980 1.0000 369.9000 1.0000 370.0980 1.0000 370.2000 1.0000 370.3980 1.0000 370.5000 1.0000 370.6980 1.0000 370.8000 1.0000 370.9980 1.0000 371.1000 1.0000 371.2980 1.0000 371.4000 1.0000 371.5980 1.0000 371.7000 1.0000 371.8980 1.0000 372.0000 1.0000 372.1980 1.0000 372.3000 1.0000 372.4980 1.0000 372.6000 1.0000 372.7980 1.0000 372.9000 1.0000 373.0980 1.0000 373.2000 1.0000 373.3980 1.0000 373.5000 1.0000 373.6980 1.0000 373.8000 1.0000 373.9980 1.0000 374.1000 1.0000 374.2980 1.0000 374.4000 0.0000 374.5980 0.0000 374.7000 0.0000 374.8980 0.0000 375.0000 0.0000 375.1980 0.0000 375.3000 0.0000 375.4980 0.0000 375.6000 0.0000 375.7980 0.0000 375.9000 0.0000 376.0980 0.0000 376.2000 0.0000 376.3980 0.0000 376.5000 0.0000 376.6980 0.0000 376.8000 0.0000 376.9980 0.0000 377.1000 0.0000 377.2980 0.0000 377.4000 0.0000 377.5980 0.0000 377.7000 0.0000 377.8980 0.0000 378.0000 0.0000 378.1980 0.0000 378.3000 0.0000 378.4980 0.0000 378.6000 0.0000 378.7980 0.0000 378.9000 0.0000 379.0980 0.0000 379.2000 0.0000 379.3980 0.0000 379.5000 0.0000 379.6980 0.0000 379.8000 0.0000 379.9980 0.0000 380.1000 0.0000 380.2980 0.0000 380.4000 0.0000 380.5980 0.0000 380.7000 0.0000 380.8980 0.0000 381.0000 0.0000 381.1980 0.0000 381.3000 0.0000 381.4980 0.0000 381.6000 0.0000 381.7980 0.0000 381.9000 0.0000 382.0980 0.0000 382.2000 0.0000 382.3980 0.0000 382.5000 0.0000 382.6980 0.0000 382.8000 0.0000 382.9980 0.0000 383.1000 0.0000 383.2980 0.0000 383.4000 0.0000 383.5980 0.0000 383.7000 0.0000 383.8980 0.0000 384.0000 0.0000 384.1980 0.0000 384.3000 0.0000 384.4980 0.0000 384.6000 0.0000 384.7980 0.0000 384.9000 0.0000 385.0980 0.0000 385.2000 0.0000 385.3980 0.0000 385.5000 0.0000 385.6980 0.0000 385.8000 0.0000 385.9980 0.0000 386.1000 0.0000 386.2980 0.0000 386.4000 0.0000 386.5980 0.0000 386.7000 0.0000 386.8980 0.0000 387.0000 0.0000 387.1980 0.0000 387.3000 0.0000 387.4980 0.0000 387.6000 0.0000 387.7980 0.0000 387.9000 0.0000 388.0980 0.0000 388.2000 0.0000 388.3980 0.0000 388.5000 0.0000 388.6980 0.0000 388.8000 1.0000 388.9980 1.0000 389.1000 1.0000 389.2980 1.0000 389.4000 1.0000 389.5980 1.0000 389.7000 1.0000 389.8980 1.0000 390.0000 1.0000 390.1980 1.0000 390.3000 1.0000 390.4980 1.0000 390.6000 1.0000 390.7980 1.0000 390.9000 1.0000 391.0980 1.0000 391.2000 1.0000 391.3980 1.0000 391.5000 1.0000 391.6980 1.0000 391.8000 1.0000 391.9980 1.0000 392.1000 1.0000 392.2980 1.0000 392.4000 1.0000 392.5980 1.0000 392.7000 1.0000 392.8980 1.0000 393.0000 1.0000 393.1980 1.0000 393.3000 1.0000 393.4980 1.0000 393.6000 1.0000 393.7980 1.0000 393.9000 1.0000 394.0980 1.0000 394.2000 1.0000 394.3980 1.0000 394.5000 1.0000 394.6980 1.0000 394.8000 1.0000 394.9980 1.0000 395.1000 1.0000 395.2980 1.0000 395.4000 1.0000 395.5980 1.0000 395.7000 1.0000 395.8980 1.0000 396.0000 0.0000 396.1980 0.0000 396.3000 0.0000 396.4980 0.0000 396.6000 0.0000 396.7980 0.0000 396.9000 0.0000 397.0980 0.0000 397.2000 0.0000 397.3980 0.0000 397.5000 0.0000 397.6980 0.0000 397.8000 0.0000 397.9980 0.0000 398.1000 0.0000 398.2980 0.0000 398.4000 0.0000 398.5980 0.0000 398.7000 0.0000 398.8980 0.0000 399.0000 0.0000 399.1980 0.0000 399.3000 0.0000 399.4980 0.0000 399.6000 0.0000 399.7980 0.0000 399.9000 0.0000 400.0980 0.0000 400.2000 0.0000 400.3980 0.0000 400.5000 0.0000 400.6980 0.0000 400.8000 0.0000 400.9980 0.0000 401.1000 0.0000 401.2980 0.0000 401.4000 0.0000 401.5980 0.0000 401.7000 0.0000 401.8980 0.0000 402.0000 0.0000 402.1980 0.0000 402.3000 0.0000 402.4980 0.0000 402.6000 0.0000 402.7980 0.0000 402.9000 0.0000 403.0980 0.0000 403.2000 0.0000 403.3980 0.0000 403.5000 0.0000 403.6980 0.0000 403.8000 0.0000 403.9980 0.0000 404.1000 0.0000 404.2980 0.0000 404.4000 0.0000 404.5980 0.0000 404.7000 0.0000 404.8980 0.0000 405.0000 0.0000 405.1980 0.0000 405.3000 0.0000 405.4980 0.0000 405.6000 0.0000 405.7980 0.0000 405.9000 0.0000 406.0980 0.0000 406.2000 0.0000 406.3980 0.0000 406.5000 0.0000 406.6980 0.0000 406.8000 0.0000 406.9980 0.0000 407.1000 0.0000 407.2980 0.0000 407.4000 0.0000 407.5980 0.0000 407.7000 0.0000 407.8980 0.0000 408.0000 0.0000 408.1980 0.0000 408.3000 0.0000 408.4980 0.0000 408.6000 0.0000 408.7980 0.0000 408.9000 0.0000 409.0980 0.0000 409.2000 0.0000 409.3980 0.0000 409.5000 0.0000 409.6980 0.0000 409.8000 0.0000 409.9980 0.0000 410.1000 0.0000 410.2980 0.0000 410.4000 1.0000 410.5980 1.0000 410.7000 1.0000 410.8980 1.0000 411.0000 1.0000 411.1980 1.0000 411.3000 1.0000 411.4980 1.0000 411.6000 1.0000 411.7980 1.0000 411.9000 1.0000 412.0980 1.0000 412.2000 1.0000 412.3980 1.0000 412.5000 1.0000 412.6980 1.0000 412.8000 1.0000 412.9980 1.0000 413.1000 1.0000 413.2980 1.0000 413.4000 1.0000 413.5980 1.0000 413.7000 1.0000 413.8980 1.0000 414.0000 1.0000 414.1980 1.0000 414.3000 1.0000 414.4980 1.0000 414.6000 1.0000 414.7980 1.0000 414.9000 1.0000 415.0980 1.0000 415.2000 1.0000 415.3980 1.0000 415.5000 1.0000 415.6980 1.0000 415.8000 1.0000 415.9980 1.0000 416.1000 1.0000 416.2980 1.0000 416.4000 1.0000 416.5980 1.0000 416.7000 1.0000 416.8980 1.0000 417.0000 1.0000 417.1980 1.0000 417.3000 1.0000 417.4980 1.0000 417.6000 0.0000 417.7980 0.0000 417.9000 0.0000 418.0980 0.0000 418.2000 0.0000 418.3980 0.0000 418.5000 0.0000 418.6980 0.0000 418.8000 0.0000 418.9980 0.0000 419.1000 0.0000 419.2980 0.0000 419.4000 0.0000 419.5980 0.0000 419.7000 0.0000 419.8980 0.0000 420.0000 0.0000 420.1980 0.0000 420.3000 0.0000 420.4980 0.0000 420.6000 0.0000 420.7980 0.0000 420.9000 0.0000 421.0980 0.0000 421.2000 0.0000 421.3980 0.0000 421.5000 0.0000 421.6980 0.0000 421.8000 0.0000 421.9980 0.0000 422.1000 0.0000 422.2980 0.0000 422.4000 0.0000 422.5980 0.0000 422.7000 0.0000 422.8980 0.0000 423.0000 0.0000 423.1980 0.0000 423.3000 0.0000 423.4980 0.0000 423.6000 0.0000 423.7980 0.0000 423.9000 0.0000 424.0980 0.0000 424.2000 0.0000 424.3980 0.0000 424.5000 0.0000 424.6980 0.0000 424.8000 0.0000 424.9980 0.0000 425.1000 0.0000 425.2980 0.0000 425.4000 0.0000 425.5980 0.0000 425.7000 0.0000 425.8980 0.0000 426.0000 0.0000 426.1980 0.0000 426.3000 0.0000 426.4980 0.0000 426.6000 0.0000 426.7980 0.0000 426.9000 0.0000 427.0980 0.0000 427.2000 0.0000 427.3980 0.0000 427.5000 0.0000 427.6980 0.0000 427.8000 0.0000 427.9980 0.0000 428.1000 0.0000 428.2980 0.0000 428.4000 0.0000 428.5980 0.0000 428.7000 0.0000 428.8980 0.0000 429.0000 0.0000 429.1980 0.0000 429.3000 0.0000 429.4980 0.0000 429.6000 0.0000 429.7980 0.0000 429.9000 0.0000 430.0980 0.0000 430.2000 0.0000 430.3980 0.0000 430.5000 0.0000 430.6980 0.0000 430.8000 0.0000 430.9980 0.0000 431.1000 0.0000 431.2980 0.0000 431.4000 0.0000 431.5980 0.0000 431.7000 0.0000 431.8980 0.0000 432.0000 1.0000 432.1980 1.0000 432.3000 1.0000 432.4980 1.0000 432.6000 1.0000 432.7980 1.0000 432.9000 1.0000 433.0980 1.0000 433.2000 1.0000 433.3980 1.0000 433.5000 1.0000 433.6980 1.0000 433.8000 1.0000 433.9980 1.0000 434.1000 1.0000 434.2980 1.0000 434.4000 1.0000 434.5980 1.0000 434.7000 1.0000 434.8980 1.0000 435.0000 1.0000 435.1980 1.0000 435.3000 1.0000 435.4980 1.0000 435.6000 1.0000 435.7980 1.0000 435.9000 1.0000 436.0980 1.0000 436.2000 1.0000 436.3980 1.0000 436.5000 1.0000 436.6980 1.0000 436.8000 1.0000 436.9980 1.0000 437.1000 1.0000 437.2980 1.0000 437.4000 1.0000 437.5980 1.0000 437.7000 1.0000 437.8980 1.0000 438.0000 1.0000 438.1980 1.0000 438.3000 1.0000 438.4980 1.0000 438.6000 1.0000 438.7980 1.0000 438.9000 1.0000 439.0980 1.0000 439.2000 0.0000 439.3980 0.0000 439.5000 0.0000 439.6980 0.0000 439.8000 0.0000 439.9980 0.0000 440.1000 0.0000 440.2980 0.0000 440.4000 0.0000 440.5980 0.0000 440.7000 0.0000 440.8980 0.0000 441.0000 0.0000 441.1980 0.0000 441.3000 0.0000 441.4980 0.0000 441.6000 0.0000 441.7980 0.0000 441.9000 0.0000 442.0980 0.0000 442.2000 0.0000 442.3980 0.0000 442.5000 0.0000 442.6980 0.0000 442.8000 0.0000 442.9980 0.0000 443.1000 0.0000 443.2980 0.0000 443.4000 0.0000 443.5980 0.0000 443.7000 0.0000 443.8980 0.0000 444.0000 0.0000 444.1980 0.0000 444.3000 0.0000 444.4980 0.0000 444.6000 0.0000 444.7980 0.0000 444.9000 0.0000 445.0980 0.0000 445.2000 0.0000 445.3980 0.0000 445.5000 0.0000 445.6980 0.0000 445.8000 0.0000 445.9980 0.0000 446.1000 0.0000 446.2980 0.0000 446.4000 0.0000 446.5980 0.0000 446.7000 0.0000 446.8980 0.0000 447.0000 0.0000 447.1980 0.0000 447.3000 0.0000 447.4980 0.0000 447.6000 0.0000 447.7980 0.0000 447.9000 0.0000 448.0980 0.0000 448.2000 0.0000 448.3980 0.0000 448.5000 0.0000 448.6980 0.0000 448.8000 0.0000 448.9980 0.0000 449.1000 0.0000 449.2980 0.0000 449.4000 0.0000 449.5980 0.0000 449.7000 0.0000 449.8980 0.0000 450.0000 0.0000 450.1980 0.0000 450.3000 0.0000 450.4980 0.0000 450.6000 0.0000 450.7980 0.0000 450.9000 0.0000 451.0980 0.0000 451.2000 0.0000 451.3980 0.0000 451.5000 0.0000 451.6980 0.0000 451.8000 0.0000 451.9980 0.0000 452.1000 0.0000 452.2980 0.0000 452.4000 0.0000 452.5980 0.0000 452.7000 0.0000 452.8980 0.0000 453.0000 0.0000 453.1980 0.0000 453.3000 0.0000 453.4980 0.0000 453.6000 1.0000 453.7980 1.0000 453.9000 1.0000 454.0980 1.0000 454.2000 1.0000 454.3980 1.0000 454.5000 1.0000 454.6980 1.0000 454.8000 1.0000 454.9980 1.0000 455.1000 1.0000 455.2980 1.0000 455.4000 1.0000 455.5980 1.0000 455.7000 1.0000 455.8980 1.0000 456.0000 1.0000 456.1980 1.0000 456.3000 1.0000 456.4980 1.0000 456.6000 1.0000 456.7980 1.0000 456.9000 1.0000 457.0980 1.0000 457.2000 1.0000 457.3980 1.0000 457.5000 1.0000 457.6980 1.0000 457.8000 1.0000 457.9980 1.0000 458.1000 1.0000 458.2980 1.0000 458.4000 1.0000 458.5980 1.0000 458.7000 1.0000 458.8980 1.0000 459.0000 1.0000 459.1980 1.0000 459.3000 1.0000 459.4980 1.0000 459.6000 1.0000 459.7980 1.0000 459.9000 1.0000 460.0980 1.0000 460.2000 1.0000 460.3980 1.0000 460.5000 1.0000 460.6980 1.0000 460.8000 0.0000 460.9980 0.0000 461.1000 0.0000 461.2980 0.0000 461.4000 0.0000 461.5980 0.0000 461.7000 0.0000 461.8980 0.0000 462.0000 0.0000 462.1980 0.0000 462.3000 0.0000 462.4980 0.0000 462.6000 0.0000 462.7980 0.0000 462.9000 0.0000 463.0980 0.0000 463.2000 0.0000 463.3980 0.0000 463.5000 0.0000 463.6980 0.0000 463.8000 0.0000 463.9980 0.0000 464.1000 0.0000 464.2980 0.0000 464.4000 0.0000 464.5980 0.0000 464.7000 0.0000 464.8980 0.0000 465.0000 0.0000 465.1980 0.0000 465.3000 0.0000 465.4980 0.0000 465.6000 0.0000 465.7980 0.0000 465.9000 0.0000 466.0980 0.0000 466.2000 0.0000 466.3980 0.0000 466.5000 0.0000 466.6980 0.0000 466.8000 0.0000 466.9980 0.0000 467.1000 0.0000 467.2980 0.0000 467.4000 0.0000 467.5980 0.0000 467.7000 0.0000 467.8980 0.0000 468.0000 0.0000 468.1980 0.0000 468.3000 0.0000 468.4980 0.0000 468.6000 0.0000 468.7980 0.0000 468.9000 0.0000 469.0980 0.0000 469.2000 0.0000 469.3980 0.0000 469.5000 0.0000 469.6980 0.0000 469.8000 0.0000 469.9980 0.0000 470.1000 0.0000 470.2980 0.0000 470.4000 0.0000 470.5980 0.0000 470.7000 0.0000 470.8980 0.0000 471.0000 0.0000 471.1980 0.0000 471.3000 0.0000 471.4980 0.0000 471.6000 0.0000 471.7980 0.0000 471.9000 0.0000 472.0980 0.0000 472.2000 0.0000 472.3980 0.0000 472.5000 0.0000 472.6980 0.0000 472.8000 0.0000 472.9980 0.0000 473.1000 0.0000 473.2980 0.0000 473.4000 0.0000 473.5980 0.0000 473.7000 0.0000 473.8980 0.0000 474.0000 0.0000 474.1980 0.0000 474.3000 0.0000 474.4980 0.0000 474.6000 0.0000 474.7980 0.0000 474.9000 0.0000 475.0980 0.0000 475.2000 1.0000 475.3980 1.0000 475.5000 1.0000 475.6980 1.0000 475.8000 1.0000 475.9980 1.0000 476.1000 1.0000 476.2980 1.0000 476.4000 1.0000 476.5980 1.0000 476.7000 1.0000 476.8980 1.0000 477.0000 1.0000 477.1980 1.0000 477.3000 1.0000 477.4980 1.0000 477.6000 1.0000 477.7980 1.0000 477.9000 1.0000 478.0980 1.0000 478.2000 1.0000 478.3980 1.0000 478.5000 1.0000 478.6980 1.0000 478.8000 1.0000 478.9980 1.0000 479.1000 1.0000 479.2980 1.0000 479.4000 1.0000 479.5980 1.0000 479.7000 1.0000 479.8980 1.0000 480.0000 1.0000 480.1980 1.0000 480.3000 1.0000 480.4980 1.0000 480.6000 1.0000 480.7980 1.0000 480.9000 1.0000 481.0980 1.0000 481.2000 1.0000 481.3980 1.0000 481.5000 1.0000 481.6980 1.0000 481.8000 1.0000 481.9980 1.0000 482.1000 1.0000 482.2980 1.0000 482.4000 0.0000 482.5980 0.0000 482.7000 0.0000 482.8980 0.0000 483.0000 0.0000 483.1980 0.0000 483.3000 0.0000 483.4980 0.0000 483.6000 0.0000 483.7980 0.0000 483.9000 0.0000 484.0980 0.0000 484.2000 0.0000 484.3980 0.0000 484.5000 0.0000 484.6980 0.0000 484.8000 0.0000 484.9980 0.0000 485.1000 0.0000 485.2980 0.0000 485.4000 0.0000 485.5980 0.0000 485.7000 0.0000 485.8980 0.0000 486.0000 0.0000 486.1980 0.0000 486.3000 0.0000 486.4980 0.0000 486.6000 0.0000 486.7980 0.0000 486.9000 0.0000 487.0980 0.0000 487.2000 0.0000 487.3980 0.0000 487.5000 0.0000 487.6980 0.0000 487.8000 0.0000 487.9980 0.0000 488.1000 0.0000 488.2980 0.0000 488.4000 0.0000 488.5980 0.0000 488.7000 0.0000 488.8980 0.0000 489.0000 0.0000 489.1980 0.0000 489.3000 0.0000 489.4980 0.0000 489.6000 0.0000 489.7980 0.0000 489.9000 0.0000 490.0980 0.0000 490.2000 0.0000 490.3980 0.0000 490.5000 0.0000 490.6980 0.0000 490.8000 0.0000 490.9980 0.0000 491.1000 0.0000 491.2980 0.0000 491.4000 0.0000 491.5980 0.0000 491.7000 0.0000 491.8980 0.0000 492.0000 0.0000 492.1980 0.0000 492.3000 0.0000 492.4980 0.0000 492.6000 0.0000 492.7980 0.0000 492.9000 0.0000 493.0980 0.0000 493.2000 0.0000 493.3980 0.0000 493.5000 0.0000 493.6980 0.0000 493.8000 0.0000 493.9980 0.0000 494.1000 0.0000 494.2980 0.0000 494.4000 0.0000 494.5980 0.0000 494.7000 0.0000 494.8980 0.0000 495.0000 0.0000 495.1980 0.0000 495.3000 0.0000 495.4980 0.0000 495.6000 0.0000 495.7980 0.0000 495.9000 0.0000 496.0980 0.0000 496.2000 0.0000 496.3980 0.0000 496.5000 0.0000 496.6980 0.0000 496.8000 1.0000 496.9980 1.0000 497.1000 1.0000 497.2980 1.0000 497.4000 1.0000 497.5980 1.0000 497.7000 1.0000 497.8980 1.0000 498.0000 1.0000 498.1980 1.0000 498.3000 1.0000 498.4980 1.0000 498.6000 1.0000 498.7980 1.0000 498.9000 1.0000 499.0980 1.0000 499.2000 1.0000 499.3980 1.0000 499.5000 1.0000 499.6980 1.0000 499.8000 1.0000 499.9980 1.0000 500.1000 1.0000 500.2980 1.0000 500.4000 1.0000 500.5980 1.0000 500.7000 1.0000 500.8980 1.0000 501.0000 1.0000 501.1980 1.0000 501.3000 1.0000 501.4980 1.0000 501.6000 1.0000 501.7980 1.0000 501.9000 1.0000 502.0980 1.0000 502.2000 1.0000 502.3980 1.0000 502.5000 1.0000 502.6980 1.0000 502.8000 1.0000 502.9980 1.0000 503.1000 1.0000 503.2980 1.0000 503.4000 1.0000 503.5980 1.0000 503.7000 1.0000 503.8980 1.0000 504.0000 0.0000 504.1980 0.0000 504.3000 0.0000 504.4980 0.0000 504.6000 0.0000 504.7980 0.0000 504.9000 0.0000 505.0980 0.0000 505.2000 0.0000 505.3980 0.0000 505.5000 0.0000 505.6980 0.0000 505.8000 0.0000 505.9980 0.0000 506.1000 0.0000 506.2980 0.0000 506.4000 0.0000 506.5980 0.0000 506.7000 0.0000 506.8980 0.0000 507.0000 0.0000 507.1980 0.0000 507.3000 0.0000 507.4980 0.0000 507.6000 0.0000 507.7980 0.0000 507.9000 0.0000 508.0980 0.0000 508.2000 0.0000 508.3980 0.0000 508.5000 0.0000 508.6980 0.0000 508.8000 0.0000 508.9980 0.0000 509.1000 0.0000 509.2980 0.0000 509.4000 0.0000 509.5980 0.0000 509.7000 0.0000 509.8980 0.0000 510.0000 0.0000 510.1980 0.0000 510.3000 0.0000 510.4980 0.0000 510.6000 0.0000 510.7980 0.0000 510.9000 0.0000 511.0980 0.0000 511.2000 0.0000 511.3980 0.0000 511.5000 0.0000 511.6980 0.0000 511.8000 0.0000 511.9980 0.0000 512.1000 0.0000 512.2980 0.0000 512.4000 0.0000 512.5980 0.0000 512.7000 0.0000 512.8980 0.0000 513.0000 0.0000 513.1980 0.0000 513.3000 0.0000 513.4980 0.0000 513.6000 0.0000 513.7980 0.0000 513.9000 0.0000 514.0980 0.0000 514.2000 0.0000 514.3980 0.0000 514.5000 0.0000 514.6980 0.0000 514.8000 0.0000 514.9980 0.0000 515.1000 0.0000 515.2980 0.0000 515.4000 0.0000 515.5980 0.0000 515.7000 0.0000 515.8980 0.0000 516.0000 0.0000 516.1980 0.0000 516.3000 0.0000 516.4980 0.0000 516.6000 0.0000 516.7980 0.0000 516.9000 0.0000 517.0980 0.0000 517.2000 0.0000 517.3980 0.0000 517.5000 0.0000 517.6980 0.0000 517.8000 0.0000 517.9980 0.0000 518.1000 0.0000 518.2980 0.0000 518.4000 1.0000 518.5980 1.0000 518.7000 1.0000 518.8980 1.0000 519.0000 1.0000 519.1980 1.0000 519.3000 1.0000 519.4980 1.0000 519.6000 1.0000 519.7980 1.0000 519.9000 1.0000 520.0980 1.0000 520.2000 1.0000 520.3980 1.0000 520.5000 1.0000 520.6980 1.0000 520.8000 1.0000 520.9980 1.0000 521.1000 1.0000 521.2980 1.0000 521.4000 1.0000 521.5980 1.0000 521.7000 1.0000 521.8980 1.0000 522.0000 1.0000 522.1980 1.0000 522.3000 1.0000 522.4980 1.0000 522.6000 1.0000 522.7980 1.0000 522.9000 1.0000 523.0980 1.0000 523.2000 1.0000 523.3980 1.0000 523.5000 1.0000 523.6980 1.0000 523.8000 1.0000 523.9980 1.0000 524.1000 1.0000 524.2980 1.0000 524.4000 1.0000 524.5980 1.0000 524.7000 1.0000 524.8980 1.0000 525.0000 1.0000 525.1980 1.0000 525.3000 1.0000 525.4980 1.0000 525.6000 0.0000 525.7980 0.0000 525.9000 0.0000 526.0980 0.0000 526.2000 0.0000 526.3980 0.0000 526.5000 0.0000 526.6980 0.0000 526.8000 0.0000 526.9980 0.0000 527.1000 0.0000 527.2980 0.0000 527.4000 0.0000 527.5980 0.0000 527.7000 0.0000 527.8980 0.0000 528.0000 0.0000 528.1980 0.0000 528.3000 0.0000 528.4980 0.0000 528.6000 0.0000 528.7980 0.0000 528.9000 0.0000 529.0980 0.0000 529.2000 0.0000 529.3980 0.0000 529.5000 0.0000 529.6980 0.0000 529.8000 0.0000 529.9980 0.0000 530.1000 0.0000 530.2980 0.0000 530.4000 0.0000 530.5980 0.0000 530.7000 0.0000 530.8980 0.0000 531.0000 0.0000 531.1980 0.0000 531.3000 0.0000 531.4980 0.0000 531.6000 0.0000 531.7980 0.0000 531.9000 0.0000 532.0980 0.0000 532.2000 0.0000 532.3980 0.0000 532.5000 0.0000 532.6980 0.0000 532.8000 0.0000 532.9980 0.0000 533.1000 0.0000 533.2980 0.0000 533.4000 0.0000 533.5980 0.0000 533.7000 0.0000 533.8980 0.0000 534.0000 0.0000 534.1980 0.0000 534.3000 0.0000 534.4980 0.0000 534.6000 0.0000 534.7980 0.0000 534.9000 0.0000 535.0980 0.0000 535.2000 0.0000 535.3980 0.0000 535.5000 0.0000 535.6980 0.0000 535.8000 0.0000 535.9980 0.0000 536.1000 0.0000 536.2980 0.0000 536.4000 0.0000 536.5980 0.0000 536.7000 0.0000 536.8980 0.0000 537.0000 0.0000 537.1980 0.0000 537.3000 0.0000 537.4980 0.0000 537.6000 0.0000 537.7980 0.0000 537.9000 0.0000 538.0980 0.0000 538.2000 0.0000 538.3980 0.0000 538.5000 0.0000 538.6980 0.0000 538.8000 0.0000 538.9980 0.0000 539.1000 0.0000 539.2980 0.0000 539.4000 0.0000 539.5980 0.0000 539.7000 0.0000 539.8980 0.0000 540.0000 1.0000 540.1980 1.0000 540.3000 1.0000 540.4980 1.0000 540.6000 1.0000 540.7980 1.0000 540.9000 1.0000 541.0980 1.0000 541.2000 1.0000 541.3980 1.0000 541.5000 1.0000 541.6980 1.0000 541.8000 1.0000 541.9980 1.0000 542.1000 1.0000 542.2980 1.0000 542.4000 1.0000 542.5980 1.0000 542.7000 1.0000 542.8980 1.0000 543.0000 1.0000 543.1980 1.0000 543.3000 1.0000 543.4980 1.0000 543.6000 1.0000 543.7980 1.0000 543.9000 1.0000 544.0980 1.0000 544.2000 1.0000 544.3980 1.0000 544.5000 1.0000 544.6980 1.0000 544.8000 1.0000 544.9980 1.0000 545.1000 1.0000 545.2980 1.0000 545.4000 1.0000 545.5980 1.0000 545.7000 1.0000 545.8980 1.0000 546.0000 1.0000 546.1980 1.0000 546.3000 1.0000 546.4980 1.0000 546.6000 1.0000 546.7980 1.0000 546.9000 1.0000 547.0980 1.0000 547.2000 0.0000 547.3980 0.0000 547.5000 0.0000 547.6980 0.0000 547.8000 0.0000 547.9980 0.0000 548.1000 0.0000 548.2980 0.0000 548.4000 0.0000 548.5980 0.0000 548.7000 0.0000 548.8980 0.0000 549.0000 0.0000 549.1980 0.0000 549.3000 0.0000 549.4980 0.0000 549.6000 0.0000 549.7980 0.0000 549.9000 0.0000 550.0980 0.0000 550.2000 0.0000 550.3980 0.0000 550.5000 0.0000 550.6980 0.0000 550.8000 0.0000 550.9980 0.0000 551.1000 0.0000 551.2980 0.0000 551.4000 0.0000 551.5980 0.0000 551.7000 0.0000 551.8980 0.0000 552.0000 0.0000 552.1980 0.0000 552.3000 0.0000 552.4980 0.0000 552.6000 0.0000 552.7980 0.0000 552.9000 0.0000 553.0980 0.0000 553.2000 0.0000 553.3980 0.0000 553.5000 0.0000 553.6980 0.0000 553.8000 0.0000 553.9980 0.0000 554.1000 0.0000 554.2980 0.0000 554.4000 0.0000 554.5980 0.0000 554.7000 0.0000 554.8980 0.0000 555.0000 0.0000 555.1980 0.0000 555.3000 0.0000 555.4980 0.0000 555.6000 0.0000 555.7980 0.0000 555.9000 0.0000 556.0980 0.0000 556.2000 0.0000 556.3980 0.0000 556.5000 0.0000 556.6980 0.0000 556.8000 0.0000 556.9980 0.0000 557.1000 0.0000 557.2980 0.0000 557.4000 0.0000 557.5980 0.0000 557.7000 0.0000 557.8980 0.0000 558.0000 0.0000 558.1980 0.0000 558.3000 0.0000 558.4980 0.0000 558.6000 0.0000 558.7980 0.0000 558.9000 0.0000 559.0980 0.0000 559.2000 0.0000 559.3980 0.0000 559.5000 0.0000 559.6980 0.0000 559.8000 0.0000 559.9980 0.0000 560.1000 0.0000 560.2980 0.0000 560.4000 0.0000 560.5980 0.0000 560.7000 0.0000 560.8980 0.0000 561.0000 0.0000 561.1980 0.0000 561.3000 0.0000 561.4980 0.0000 561.6000 1.0000 561.7980 1.0000 561.9000 1.0000 562.0980 1.0000 562.2000 1.0000 562.3980 1.0000 562.5000 1.0000 562.6980 1.0000 562.8000 1.0000 562.9980 1.0000 563.1000 1.0000 563.2980 1.0000 563.4000 1.0000 563.5980 1.0000 563.7000 1.0000 563.8980 1.0000 564.0000 1.0000 564.1980 1.0000 564.3000 1.0000 564.4980 1.0000 564.6000 1.0000 564.7980 1.0000 564.9000 1.0000 565.0980 1.0000 565.2000 1.0000 565.3980 1.0000 565.5000 1.0000 565.6980 1.0000 565.8000 1.0000 565.9980 1.0000 566.1000 1.0000 566.2980 1.0000 566.4000 1.0000 566.5980 1.0000 566.7000 1.0000 566.8980 1.0000 567.0000 1.0000 567.1980 1.0000 567.3000 1.0000 567.4980 1.0000 567.6000 1.0000 567.7980 1.0000 567.9000 1.0000 568.0980 1.0000 568.2000 1.0000 568.3980 1.0000 568.5000 1.0000 568.6980 1.0000 568.8000 0.0000 568.9980 0.0000 569.1000 0.0000 569.2980 0.0000 569.4000 0.0000 569.5980 0.0000 569.7000 0.0000 569.8980 0.0000 570.0000 0.0000 570.1980 0.0000 570.3000 0.0000 570.4980 0.0000 570.6000 0.0000 570.7980 0.0000 570.9000 0.0000 571.0980 0.0000 571.2000 0.0000 571.3980 0.0000 571.5000 0.0000 571.6980 0.0000 571.8000 0.0000 571.9980 0.0000 572.1000 0.0000 572.2980 0.0000 572.4000 0.0000 572.5980 0.0000 572.7000 0.0000 572.8980 0.0000 573.0000 0.0000 573.1980 0.0000 573.3000 0.0000 573.4980 0.0000 573.6000 0.0000 573.7980 0.0000 573.9000 0.0000 574.0980 0.0000 574.2000 0.0000 574.3980 0.0000 574.5000 0.0000 574.6980 0.0000 574.8000 0.0000 574.9980 0.0000 575.1000 0.0000 575.2980 0.0000 575.4000 0.0000 575.5980 0.0000 575.7000 0.0000 575.8980 0.0000 576.0000 0.0000 576.1980 0.0000 576.3000 0.0000 576.4980 0.0000 576.6000 0.0000 576.7980 0.0000 576.9000 0.0000 577.0980 0.0000 577.2000 0.0000 577.3980 0.0000 577.5000 0.0000 577.6980 0.0000 577.8000 0.0000 577.9980 0.0000 578.1000 0.0000 578.2980 0.0000 578.4000 0.0000 578.5980 0.0000 578.7000 0.0000 578.8980 0.0000 579.0000 0.0000 579.1980 0.0000 579.3000 0.0000 579.4980 0.0000 579.6000 0.0000 579.7980 0.0000 579.9000 0.0000 580.0980 0.0000 580.2000 0.0000 580.3980 0.0000 580.5000 0.0000 580.6980 0.0000 580.8000 0.0000 580.9980 0.0000 581.1000 0.0000 581.2980 0.0000 581.4000 0.0000 581.5980 0.0000 581.7000 0.0000 581.8980 0.0000 582.0000 0.0000 582.1980 0.0000 582.3000 0.0000 582.4980 0.0000 582.6000 0.0000 582.7980 0.0000 582.9000 0.0000 583.0980 0.0000 583.2000 1.0000 583.3980 1.0000 583.5000 1.0000 583.6980 1.0000 583.8000 1.0000 583.9980 1.0000 584.1000 1.0000 584.2980 1.0000 584.4000 1.0000 584.5980 1.0000 584.7000 1.0000 584.8980 1.0000 585.0000 1.0000 585.1980 1.0000 585.3000 1.0000 585.4980 1.0000 585.6000 1.0000 585.7980 1.0000 585.9000 1.0000 586.0980 1.0000 586.2000 1.0000 586.3980 1.0000 586.5000 1.0000 586.6980 1.0000 586.8000 1.0000 586.9980 1.0000 587.1000 1.0000 587.2980 1.0000 587.4000 1.0000 587.5980 1.0000 587.7000 1.0000 587.8980 1.0000 588.0000 1.0000 588.1980 1.0000 588.3000 1.0000 588.4980 1.0000 588.6000 1.0000 588.7980 1.0000 588.9000 1.0000 589.0980 1.0000 589.2000 1.0000 589.3980 1.0000 589.5000 1.0000 589.6980 1.0000 589.8000 1.0000 589.9980 1.0000 590.1000 1.0000 590.2980 1.0000 590.4000 0.0000 590.5980 0.0000 590.7000 0.0000 590.8980 0.0000 591.0000 0.0000 591.1980 0.0000 591.3000 0.0000 591.4980 0.0000 591.6000 0.0000 591.7980 0.0000 591.9000 0.0000 592.0980 0.0000 592.2000 0.0000 592.3980 0.0000 592.5000 0.0000 592.6980 0.0000 592.8000 0.0000 592.9980 0.0000 593.1000 0.0000 593.2980 0.0000 593.4000 0.0000 593.5980 0.0000 593.7000 0.0000 593.8980 0.0000 594.0000 0.0000 594.1980 0.0000 594.3000 0.0000 594.4980 0.0000 594.6000 0.0000 594.7980 0.0000 594.9000 0.0000 595.0980 0.0000 595.2000 0.0000 595.3980 0.0000 595.5000 0.0000 595.6980 0.0000 595.8000 0.0000 595.9980 0.0000 596.1000 0.0000 596.2980 0.0000 596.4000 0.0000 596.5980 0.0000 596.7000 0.0000 596.8980 0.0000 597.0000 0.0000 597.1980 0.0000 597.3000 0.0000 597.4980 0.0000 597.6000 0.0000 597.7980 0.0000 597.9000 0.0000 598.0980 0.0000 598.2000 0.0000 598.3980 0.0000 598.5000 0.0000 598.6980 0.0000 598.8000 0.0000 598.9980 0.0000 599.1000 0.0000 599.2980 0.0000 599.4000 0.0000 599.5980 0.0000 599.7000 0.0000 599.8980 0.0000 600.0000 0.0000)
Vtg1 tg1 0 PWL(0.0000 0.0000 0.1980 0.0000 0.3000 0.0000 0.4980 0.0000 0.6000 0.0000 0.7980 0.0000 0.9000 0.0000 1.0980 0.0000 1.2000 0.0000 1.3980 0.0000 1.5000 0.0000 1.6980 0.0000 1.8000 0.0000 1.9980 0.0000 2.1000 0.0000 2.2980 0.0000 2.4000 0.0000 2.5980 0.0000 2.7000 0.0000 2.8980 0.0000 3.0000 0.0000 3.1980 0.0000 3.3000 0.0000 3.4980 0.0000 3.6000 0.0000 3.7980 0.0000 3.9000 0.0000 4.0980 0.0000 4.2000 0.0000 4.3980 0.0000 4.5000 0.0000 4.6980 0.0000 4.8000 0.0000 4.9980 0.0000 5.1000 0.0000 5.2980 0.0000 5.4000 0.0000 5.5980 0.0000 5.7000 0.0000 5.8980 0.0000 6.0000 0.0000 6.1980 0.0000 6.3000 0.0000 6.4980 0.0000 6.6000 0.0000 6.7980 0.0000 6.9000 0.0000 7.0980 0.0000 7.2000 1.0000 7.3980 1.0000 7.5000 1.0000 7.6980 1.0000 7.8000 1.0000 7.9980 1.0000 8.1000 1.0000 8.2980 1.0000 8.4000 1.0000 8.5980 1.0000 8.7000 1.0000 8.8980 1.0000 9.0000 1.0000 9.1980 1.0000 9.3000 1.0000 9.4980 1.0000 9.6000 1.0000 9.7980 1.0000 9.9000 1.0000 10.0980 1.0000 10.2000 1.0000 10.3980 1.0000 10.5000 1.0000 10.6980 1.0000 10.8000 1.0000 10.9980 1.0000 11.1000 1.0000 11.2980 1.0000 11.4000 1.0000 11.5980 1.0000 11.7000 1.0000 11.8980 1.0000 12.0000 1.0000 12.1980 1.0000 12.3000 1.0000 12.4980 1.0000 12.6000 1.0000 12.7980 1.0000 12.9000 1.0000 13.0980 1.0000 13.2000 1.0000 13.3980 1.0000 13.5000 1.0000 13.6980 1.0000 13.8000 1.0000 13.9980 1.0000 14.1000 1.0000 14.2980 1.0000 14.4000 0.0000 14.5980 0.0000 14.7000 0.0000 14.8980 0.0000 15.0000 0.0000 15.1980 0.0000 15.3000 0.0000 15.4980 0.0000 15.6000 0.0000 15.7980 0.0000 15.9000 0.0000 16.0980 0.0000 16.2000 0.0000 16.3980 0.0000 16.5000 0.0000 16.6980 0.0000 16.8000 0.0000 16.9980 0.0000 17.1000 0.0000 17.2980 0.0000 17.4000 0.0000 17.5980 0.0000 17.7000 0.0000 17.8980 0.0000 18.0000 0.0000 18.1980 0.0000 18.3000 0.0000 18.4980 0.0000 18.6000 0.0000 18.7980 0.0000 18.9000 0.0000 19.0980 0.0000 19.2000 0.0000 19.3980 0.0000 19.5000 0.0000 19.6980 0.0000 19.8000 0.0000 19.9980 0.0000 20.1000 0.0000 20.2980 0.0000 20.4000 0.0000 20.5980 0.0000 20.7000 0.0000 20.8980 0.0000 21.0000 0.0000 21.1980 0.0000 21.3000 0.0000 21.4980 0.0000 21.6000 0.0000 21.7980 0.0000 21.9000 0.0000 22.0980 0.0000 22.2000 0.0000 22.3980 0.0000 22.5000 0.0000 22.6980 0.0000 22.8000 0.0000 22.9980 0.0000 23.1000 0.0000 23.2980 0.0000 23.4000 0.0000 23.5980 0.0000 23.7000 0.0000 23.8980 0.0000 24.0000 0.0000 24.1980 0.0000 24.3000 0.0000 24.4980 0.0000 24.6000 0.0000 24.7980 0.0000 24.9000 0.0000 25.0980 0.0000 25.2000 0.0000 25.3980 0.0000 25.5000 0.0000 25.6980 0.0000 25.8000 0.0000 25.9980 0.0000 26.1000 0.0000 26.2980 0.0000 26.4000 0.0000 26.5980 0.0000 26.7000 0.0000 26.8980 0.0000 27.0000 0.0000 27.1980 0.0000 27.3000 0.0000 27.4980 0.0000 27.6000 0.0000 27.7980 0.0000 27.9000 0.0000 28.0980 0.0000 28.2000 0.0000 28.3980 0.0000 28.5000 0.0000 28.6980 0.0000 28.8000 1.0000 28.9980 1.0000 29.1000 1.0000 29.2980 1.0000 29.4000 1.0000 29.5980 1.0000 29.7000 1.0000 29.8980 1.0000 30.0000 1.0000 30.1980 1.0000 30.3000 1.0000 30.4980 1.0000 30.6000 1.0000 30.7980 1.0000 30.9000 1.0000 31.0980 1.0000 31.2000 1.0000 31.3980 1.0000 31.5000 1.0000 31.6980 1.0000 31.8000 1.0000 31.9980 1.0000 32.1000 1.0000 32.2980 1.0000 32.4000 1.0000 32.5980 1.0000 32.7000 1.0000 32.8980 1.0000 33.0000 1.0000 33.1980 1.0000 33.3000 1.0000 33.4980 1.0000 33.6000 1.0000 33.7980 1.0000 33.9000 1.0000 34.0980 1.0000 34.2000 1.0000 34.3980 1.0000 34.5000 1.0000 34.6980 1.0000 34.8000 1.0000 34.9980 1.0000 35.1000 1.0000 35.2980 1.0000 35.4000 1.0000 35.5980 1.0000 35.7000 1.0000 35.8980 1.0000 36.0000 0.0000 36.1980 0.0000 36.3000 0.0000 36.4980 0.0000 36.6000 0.0000 36.7980 0.0000 36.9000 0.0000 37.0980 0.0000 37.2000 0.0000 37.3980 0.0000 37.5000 0.0000 37.6980 0.0000 37.8000 0.0000 37.9980 0.0000 38.1000 0.0000 38.2980 0.0000 38.4000 0.0000 38.5980 0.0000 38.7000 0.0000 38.8980 0.0000 39.0000 0.0000 39.1980 0.0000 39.3000 0.0000 39.4980 0.0000 39.6000 0.0000 39.7980 0.0000 39.9000 0.0000 40.0980 0.0000 40.2000 0.0000 40.3980 0.0000 40.5000 0.0000 40.6980 0.0000 40.8000 0.0000 40.9980 0.0000 41.1000 0.0000 41.2980 0.0000 41.4000 0.0000 41.5980 0.0000 41.7000 0.0000 41.8980 0.0000 42.0000 0.0000 42.1980 0.0000 42.3000 0.0000 42.4980 0.0000 42.6000 0.0000 42.7980 0.0000 42.9000 0.0000 43.0980 0.0000 43.2000 0.0000 43.3980 0.0000 43.5000 0.0000 43.6980 0.0000 43.8000 0.0000 43.9980 0.0000 44.1000 0.0000 44.2980 0.0000 44.4000 0.0000 44.5980 0.0000 44.7000 0.0000 44.8980 0.0000 45.0000 0.0000 45.1980 0.0000 45.3000 0.0000 45.4980 0.0000 45.6000 0.0000 45.7980 0.0000 45.9000 0.0000 46.0980 0.0000 46.2000 0.0000 46.3980 0.0000 46.5000 0.0000 46.6980 0.0000 46.8000 0.0000 46.9980 0.0000 47.1000 0.0000 47.2980 0.0000 47.4000 0.0000 47.5980 0.0000 47.7000 0.0000 47.8980 0.0000 48.0000 0.0000 48.1980 0.0000 48.3000 0.0000 48.4980 0.0000 48.6000 0.0000 48.7980 0.0000 48.9000 0.0000 49.0980 0.0000 49.2000 0.0000 49.3980 0.0000 49.5000 0.0000 49.6980 0.0000 49.8000 0.0000 49.9980 0.0000 50.1000 0.0000 50.2980 0.0000 50.4000 1.0000 50.5980 1.0000 50.7000 1.0000 50.8980 1.0000 51.0000 1.0000 51.1980 1.0000 51.3000 1.0000 51.4980 1.0000 51.6000 1.0000 51.7980 1.0000 51.9000 1.0000 52.0980 1.0000 52.2000 1.0000 52.3980 1.0000 52.5000 1.0000 52.6980 1.0000 52.8000 1.0000 52.9980 1.0000 53.1000 1.0000 53.2980 1.0000 53.4000 1.0000 53.5980 1.0000 53.7000 1.0000 53.8980 1.0000 54.0000 1.0000 54.1980 1.0000 54.3000 1.0000 54.4980 1.0000 54.6000 1.0000 54.7980 1.0000 54.9000 1.0000 55.0980 1.0000 55.2000 1.0000 55.3980 1.0000 55.5000 1.0000 55.6980 1.0000 55.8000 1.0000 55.9980 1.0000 56.1000 1.0000 56.2980 1.0000 56.4000 1.0000 56.5980 1.0000 56.7000 1.0000 56.8980 1.0000 57.0000 1.0000 57.1980 1.0000 57.3000 1.0000 57.4980 1.0000 57.6000 0.0000 57.7980 0.0000 57.9000 0.0000 58.0980 0.0000 58.2000 0.0000 58.3980 0.0000 58.5000 0.0000 58.6980 0.0000 58.8000 0.0000 58.9980 0.0000 59.1000 0.0000 59.2980 0.0000 59.4000 0.0000 59.5980 0.0000 59.7000 0.0000 59.8980 0.0000 60.0000 0.0000 60.1980 0.0000 60.3000 0.0000 60.4980 0.0000 60.6000 0.0000 60.7980 0.0000 60.9000 0.0000 61.0980 0.0000 61.2000 0.0000 61.3980 0.0000 61.5000 0.0000 61.6980 0.0000 61.8000 0.0000 61.9980 0.0000 62.1000 0.0000 62.2980 0.0000 62.4000 0.0000 62.5980 0.0000 62.7000 0.0000 62.8980 0.0000 63.0000 0.0000 63.1980 0.0000 63.3000 0.0000 63.4980 0.0000 63.6000 0.0000 63.7980 0.0000 63.9000 0.0000 64.0980 0.0000 64.2000 0.0000 64.3980 0.0000 64.5000 0.0000 64.6980 0.0000 64.8000 0.0000 64.9980 0.0000 65.1000 0.0000 65.2980 0.0000 65.4000 0.0000 65.5980 0.0000 65.7000 0.0000 65.8980 0.0000 66.0000 0.0000 66.1980 0.0000 66.3000 0.0000 66.4980 0.0000 66.6000 0.0000 66.7980 0.0000 66.9000 0.0000 67.0980 0.0000 67.2000 0.0000 67.3980 0.0000 67.5000 0.0000 67.6980 0.0000 67.8000 0.0000 67.9980 0.0000 68.1000 0.0000 68.2980 0.0000 68.4000 0.0000 68.5980 0.0000 68.7000 0.0000 68.8980 0.0000 69.0000 0.0000 69.1980 0.0000 69.3000 0.0000 69.4980 0.0000 69.6000 0.0000 69.7980 0.0000 69.9000 0.0000 70.0980 0.0000 70.2000 0.0000 70.3980 0.0000 70.5000 0.0000 70.6980 0.0000 70.8000 0.0000 70.9980 0.0000 71.1000 0.0000 71.2980 0.0000 71.4000 0.0000 71.5980 0.0000 71.7000 0.0000 71.8980 0.0000 72.0000 1.0000 72.1980 1.0000 72.3000 1.0000 72.4980 1.0000 72.6000 1.0000 72.7980 1.0000 72.9000 1.0000 73.0980 1.0000 73.2000 1.0000 73.3980 1.0000 73.5000 1.0000 73.6980 1.0000 73.8000 1.0000 73.9980 1.0000 74.1000 1.0000 74.2980 1.0000 74.4000 1.0000 74.5980 1.0000 74.7000 1.0000 74.8980 1.0000 75.0000 1.0000 75.1980 1.0000 75.3000 1.0000 75.4980 1.0000 75.6000 1.0000 75.7980 1.0000 75.9000 1.0000 76.0980 1.0000 76.2000 1.0000 76.3980 1.0000 76.5000 1.0000 76.6980 1.0000 76.8000 1.0000 76.9980 1.0000 77.1000 1.0000 77.2980 1.0000 77.4000 1.0000 77.5980 1.0000 77.7000 1.0000 77.8980 1.0000 78.0000 1.0000 78.1980 1.0000 78.3000 1.0000 78.4980 1.0000 78.6000 1.0000 78.7980 1.0000 78.9000 1.0000 79.0980 1.0000 79.2000 0.0000 79.3980 0.0000 79.5000 0.0000 79.6980 0.0000 79.8000 0.0000 79.9980 0.0000 80.1000 0.0000 80.2980 0.0000 80.4000 0.0000 80.5980 0.0000 80.7000 0.0000 80.8980 0.0000 81.0000 0.0000 81.1980 0.0000 81.3000 0.0000 81.4980 0.0000 81.6000 0.0000 81.7980 0.0000 81.9000 0.0000 82.0980 0.0000 82.2000 0.0000 82.3980 0.0000 82.5000 0.0000 82.6980 0.0000 82.8000 0.0000 82.9980 0.0000 83.1000 0.0000 83.2980 0.0000 83.4000 0.0000 83.5980 0.0000 83.7000 0.0000 83.8980 0.0000 84.0000 0.0000 84.1980 0.0000 84.3000 0.0000 84.4980 0.0000 84.6000 0.0000 84.7980 0.0000 84.9000 0.0000 85.0980 0.0000 85.2000 0.0000 85.3980 0.0000 85.5000 0.0000 85.6980 0.0000 85.8000 0.0000 85.9980 0.0000 86.1000 0.0000 86.2980 0.0000 86.4000 0.0000 86.5980 0.0000 86.7000 0.0000 86.8980 0.0000 87.0000 0.0000 87.1980 0.0000 87.3000 0.0000 87.4980 0.0000 87.6000 0.0000 87.7980 0.0000 87.9000 0.0000 88.0980 0.0000 88.2000 0.0000 88.3980 0.0000 88.5000 0.0000 88.6980 0.0000 88.8000 0.0000 88.9980 0.0000 89.1000 0.0000 89.2980 0.0000 89.4000 0.0000 89.5980 0.0000 89.7000 0.0000 89.8980 0.0000 90.0000 0.0000 90.1980 0.0000 90.3000 0.0000 90.4980 0.0000 90.6000 0.0000 90.7980 0.0000 90.9000 0.0000 91.0980 0.0000 91.2000 0.0000 91.3980 0.0000 91.5000 0.0000 91.6980 0.0000 91.8000 0.0000 91.9980 0.0000 92.1000 0.0000 92.2980 0.0000 92.4000 0.0000 92.5980 0.0000 92.7000 0.0000 92.8980 0.0000 93.0000 0.0000 93.1980 0.0000 93.3000 0.0000 93.4980 0.0000 93.6000 1.0000 93.7980 1.0000 93.9000 1.0000 94.0980 1.0000 94.2000 1.0000 94.3980 1.0000 94.5000 1.0000 94.6980 1.0000 94.8000 1.0000 94.9980 1.0000 95.1000 1.0000 95.2980 1.0000 95.4000 1.0000 95.5980 1.0000 95.7000 1.0000 95.8980 1.0000 96.0000 1.0000 96.1980 1.0000 96.3000 1.0000 96.4980 1.0000 96.6000 1.0000 96.7980 1.0000 96.9000 1.0000 97.0980 1.0000 97.2000 1.0000 97.3980 1.0000 97.5000 1.0000 97.6980 1.0000 97.8000 1.0000 97.9980 1.0000 98.1000 1.0000 98.2980 1.0000 98.4000 1.0000 98.5980 1.0000 98.7000 1.0000 98.8980 1.0000 99.0000 1.0000 99.1980 1.0000 99.3000 1.0000 99.4980 1.0000 99.6000 1.0000 99.7980 1.0000 99.9000 1.0000 100.0980 1.0000 100.2000 1.0000 100.3980 1.0000 100.5000 1.0000 100.6980 1.0000 100.8000 0.0000 100.9980 0.0000 101.1000 0.0000 101.2980 0.0000 101.4000 0.0000 101.5980 0.0000 101.7000 0.0000 101.8980 0.0000 102.0000 0.0000 102.1980 0.0000 102.3000 0.0000 102.4980 0.0000 102.6000 0.0000 102.7980 0.0000 102.9000 0.0000 103.0980 0.0000 103.2000 0.0000 103.3980 0.0000 103.5000 0.0000 103.6980 0.0000 103.8000 0.0000 103.9980 0.0000 104.1000 0.0000 104.2980 0.0000 104.4000 0.0000 104.5980 0.0000 104.7000 0.0000 104.8980 0.0000 105.0000 0.0000 105.1980 0.0000 105.3000 0.0000 105.4980 0.0000 105.6000 0.0000 105.7980 0.0000 105.9000 0.0000 106.0980 0.0000 106.2000 0.0000 106.3980 0.0000 106.5000 0.0000 106.6980 0.0000 106.8000 0.0000 106.9980 0.0000 107.1000 0.0000 107.2980 0.0000 107.4000 0.0000 107.5980 0.0000 107.7000 0.0000 107.8980 0.0000 108.0000 0.0000 108.1980 0.0000 108.3000 0.0000 108.4980 0.0000 108.6000 0.0000 108.7980 0.0000 108.9000 0.0000 109.0980 0.0000 109.2000 0.0000 109.3980 0.0000 109.5000 0.0000 109.6980 0.0000 109.8000 0.0000 109.9980 0.0000 110.1000 0.0000 110.2980 0.0000 110.4000 0.0000 110.5980 0.0000 110.7000 0.0000 110.8980 0.0000 111.0000 0.0000 111.1980 0.0000 111.3000 0.0000 111.4980 0.0000 111.6000 0.0000 111.7980 0.0000 111.9000 0.0000 112.0980 0.0000 112.2000 0.0000 112.3980 0.0000 112.5000 0.0000 112.6980 0.0000 112.8000 0.0000 112.9980 0.0000 113.1000 0.0000 113.2980 0.0000 113.4000 0.0000 113.5980 0.0000 113.7000 0.0000 113.8980 0.0000 114.0000 0.0000 114.1980 0.0000 114.3000 0.0000 114.4980 0.0000 114.6000 0.0000 114.7980 0.0000 114.9000 0.0000 115.0980 0.0000 115.2000 1.0000 115.3980 1.0000 115.5000 1.0000 115.6980 1.0000 115.8000 1.0000 115.9980 1.0000 116.1000 1.0000 116.2980 1.0000 116.4000 1.0000 116.5980 1.0000 116.7000 1.0000 116.8980 1.0000 117.0000 1.0000 117.1980 1.0000 117.3000 1.0000 117.4980 1.0000 117.6000 1.0000 117.7980 1.0000 117.9000 1.0000 118.0980 1.0000 118.2000 1.0000 118.3980 1.0000 118.5000 1.0000 118.6980 1.0000 118.8000 1.0000 118.9980 1.0000 119.1000 1.0000 119.2980 1.0000 119.4000 1.0000 119.5980 1.0000 119.7000 1.0000 119.8980 1.0000 120.0000 1.0000 120.1980 1.0000 120.3000 1.0000 120.4980 1.0000 120.6000 1.0000 120.7980 1.0000 120.9000 1.0000 121.0980 1.0000 121.2000 1.0000 121.3980 1.0000 121.5000 1.0000 121.6980 1.0000 121.8000 1.0000 121.9980 1.0000 122.1000 1.0000 122.2980 1.0000 122.4000 0.0000 122.5980 0.0000 122.7000 0.0000 122.8980 0.0000 123.0000 0.0000 123.1980 0.0000 123.3000 0.0000 123.4980 0.0000 123.6000 0.0000 123.7980 0.0000 123.9000 0.0000 124.0980 0.0000 124.2000 0.0000 124.3980 0.0000 124.5000 0.0000 124.6980 0.0000 124.8000 0.0000 124.9980 0.0000 125.1000 0.0000 125.2980 0.0000 125.4000 0.0000 125.5980 0.0000 125.7000 0.0000 125.8980 0.0000 126.0000 0.0000 126.1980 0.0000 126.3000 0.0000 126.4980 0.0000 126.6000 0.0000 126.7980 0.0000 126.9000 0.0000 127.0980 0.0000 127.2000 0.0000 127.3980 0.0000 127.5000 0.0000 127.6980 0.0000 127.8000 0.0000 127.9980 0.0000 128.1000 0.0000 128.2980 0.0000 128.4000 0.0000 128.5980 0.0000 128.7000 0.0000 128.8980 0.0000 129.0000 0.0000 129.1980 0.0000 129.3000 0.0000 129.4980 0.0000 129.6000 0.0000 129.7980 0.0000 129.9000 0.0000 130.0980 0.0000 130.2000 0.0000 130.3980 0.0000 130.5000 0.0000 130.6980 0.0000 130.8000 0.0000 130.9980 0.0000 131.1000 0.0000 131.2980 0.0000 131.4000 0.0000 131.5980 0.0000 131.7000 0.0000 131.8980 0.0000 132.0000 0.0000 132.1980 0.0000 132.3000 0.0000 132.4980 0.0000 132.6000 0.0000 132.7980 0.0000 132.9000 0.0000 133.0980 0.0000 133.2000 0.0000 133.3980 0.0000 133.5000 0.0000 133.6980 0.0000 133.8000 0.0000 133.9980 0.0000 134.1000 0.0000 134.2980 0.0000 134.4000 0.0000 134.5980 0.0000 134.7000 0.0000 134.8980 0.0000 135.0000 0.0000 135.1980 0.0000 135.3000 0.0000 135.4980 0.0000 135.6000 0.0000 135.7980 0.0000 135.9000 0.0000 136.0980 0.0000 136.2000 0.0000 136.3980 0.0000 136.5000 0.0000 136.6980 0.0000 136.8000 1.0000 136.9980 1.0000 137.1000 1.0000 137.2980 1.0000 137.4000 1.0000 137.5980 1.0000 137.7000 1.0000 137.8980 1.0000 138.0000 1.0000 138.1980 1.0000 138.3000 1.0000 138.4980 1.0000 138.6000 1.0000 138.7980 1.0000 138.9000 1.0000 139.0980 1.0000 139.2000 1.0000 139.3980 1.0000 139.5000 1.0000 139.6980 1.0000 139.8000 1.0000 139.9980 1.0000 140.1000 1.0000 140.2980 1.0000 140.4000 1.0000 140.5980 1.0000 140.7000 1.0000 140.8980 1.0000 141.0000 1.0000 141.1980 1.0000 141.3000 1.0000 141.4980 1.0000 141.6000 1.0000 141.7980 1.0000 141.9000 1.0000 142.0980 1.0000 142.2000 1.0000 142.3980 1.0000 142.5000 1.0000 142.6980 1.0000 142.8000 1.0000 142.9980 1.0000 143.1000 1.0000 143.2980 1.0000 143.4000 1.0000 143.5980 1.0000 143.7000 1.0000 143.8980 1.0000 144.0000 0.0000 144.1980 0.0000 144.3000 0.0000 144.4980 0.0000 144.6000 0.0000 144.7980 0.0000 144.9000 0.0000 145.0980 0.0000 145.2000 0.0000 145.3980 0.0000 145.5000 0.0000 145.6980 0.0000 145.8000 0.0000 145.9980 0.0000 146.1000 0.0000 146.2980 0.0000 146.4000 0.0000 146.5980 0.0000 146.7000 0.0000 146.8980 0.0000 147.0000 0.0000 147.1980 0.0000 147.3000 0.0000 147.4980 0.0000 147.6000 0.0000 147.7980 0.0000 147.9000 0.0000 148.0980 0.0000 148.2000 0.0000 148.3980 0.0000 148.5000 0.0000 148.6980 0.0000 148.8000 0.0000 148.9980 0.0000 149.1000 0.0000 149.2980 0.0000 149.4000 0.0000 149.5980 0.0000 149.7000 0.0000 149.8980 0.0000 150.0000 0.0000 150.1980 0.0000 150.3000 0.0000 150.4980 0.0000 150.6000 0.0000 150.7980 0.0000 150.9000 0.0000 151.0980 0.0000 151.2000 0.0000 151.3980 0.0000 151.5000 0.0000 151.6980 0.0000 151.8000 0.0000 151.9980 0.0000 152.1000 0.0000 152.2980 0.0000 152.4000 0.0000 152.5980 0.0000 152.7000 0.0000 152.8980 0.0000 153.0000 0.0000 153.1980 0.0000 153.3000 0.0000 153.4980 0.0000 153.6000 0.0000 153.7980 0.0000 153.9000 0.0000 154.0980 0.0000 154.2000 0.0000 154.3980 0.0000 154.5000 0.0000 154.6980 0.0000 154.8000 0.0000 154.9980 0.0000 155.1000 0.0000 155.2980 0.0000 155.4000 0.0000 155.5980 0.0000 155.7000 0.0000 155.8980 0.0000 156.0000 0.0000 156.1980 0.0000 156.3000 0.0000 156.4980 0.0000 156.6000 0.0000 156.7980 0.0000 156.9000 0.0000 157.0980 0.0000 157.2000 0.0000 157.3980 0.0000 157.5000 0.0000 157.6980 0.0000 157.8000 0.0000 157.9980 0.0000 158.1000 0.0000 158.2980 0.0000 158.4000 1.0000 158.5980 1.0000 158.7000 1.0000 158.8980 1.0000 159.0000 1.0000 159.1980 1.0000 159.3000 1.0000 159.4980 1.0000 159.6000 1.0000 159.7980 1.0000 159.9000 1.0000 160.0980 1.0000 160.2000 1.0000 160.3980 1.0000 160.5000 1.0000 160.6980 1.0000 160.8000 1.0000 160.9980 1.0000 161.1000 1.0000 161.2980 1.0000 161.4000 1.0000 161.5980 1.0000 161.7000 1.0000 161.8980 1.0000 162.0000 1.0000 162.1980 1.0000 162.3000 1.0000 162.4980 1.0000 162.6000 1.0000 162.7980 1.0000 162.9000 1.0000 163.0980 1.0000 163.2000 1.0000 163.3980 1.0000 163.5000 1.0000 163.6980 1.0000 163.8000 1.0000 163.9980 1.0000 164.1000 1.0000 164.2980 1.0000 164.4000 1.0000 164.5980 1.0000 164.7000 1.0000 164.8980 1.0000 165.0000 1.0000 165.1980 1.0000 165.3000 1.0000 165.4980 1.0000 165.6000 0.0000 165.7980 0.0000 165.9000 0.0000 166.0980 0.0000 166.2000 0.0000 166.3980 0.0000 166.5000 0.0000 166.6980 0.0000 166.8000 0.0000 166.9980 0.0000 167.1000 0.0000 167.2980 0.0000 167.4000 0.0000 167.5980 0.0000 167.7000 0.0000 167.8980 0.0000 168.0000 0.0000 168.1980 0.0000 168.3000 0.0000 168.4980 0.0000 168.6000 0.0000 168.7980 0.0000 168.9000 0.0000 169.0980 0.0000 169.2000 0.0000 169.3980 0.0000 169.5000 0.0000 169.6980 0.0000 169.8000 0.0000 169.9980 0.0000 170.1000 0.0000 170.2980 0.0000 170.4000 0.0000 170.5980 0.0000 170.7000 0.0000 170.8980 0.0000 171.0000 0.0000 171.1980 0.0000 171.3000 0.0000 171.4980 0.0000 171.6000 0.0000 171.7980 0.0000 171.9000 0.0000 172.0980 0.0000 172.2000 0.0000 172.3980 0.0000 172.5000 0.0000 172.6980 0.0000 172.8000 0.0000 172.9980 0.0000 173.1000 0.0000 173.2980 0.0000 173.4000 0.0000 173.5980 0.0000 173.7000 0.0000 173.8980 0.0000 174.0000 0.0000 174.1980 0.0000 174.3000 0.0000 174.4980 0.0000 174.6000 0.0000 174.7980 0.0000 174.9000 0.0000 175.0980 0.0000 175.2000 0.0000 175.3980 0.0000 175.5000 0.0000 175.6980 0.0000 175.8000 0.0000 175.9980 0.0000 176.1000 0.0000 176.2980 0.0000 176.4000 0.0000 176.5980 0.0000 176.7000 0.0000 176.8980 0.0000 177.0000 0.0000 177.1980 0.0000 177.3000 0.0000 177.4980 0.0000 177.6000 0.0000 177.7980 0.0000 177.9000 0.0000 178.0980 0.0000 178.2000 0.0000 178.3980 0.0000 178.5000 0.0000 178.6980 0.0000 178.8000 0.0000 178.9980 0.0000 179.1000 0.0000 179.2980 0.0000 179.4000 0.0000 179.5980 0.0000 179.7000 0.0000 179.8980 0.0000 180.0000 1.0000 180.1980 1.0000 180.3000 1.0000 180.4980 1.0000 180.6000 1.0000 180.7980 1.0000 180.9000 1.0000 181.0980 1.0000 181.2000 1.0000 181.3980 1.0000 181.5000 1.0000 181.6980 1.0000 181.8000 1.0000 181.9980 1.0000 182.1000 1.0000 182.2980 1.0000 182.4000 1.0000 182.5980 1.0000 182.7000 1.0000 182.8980 1.0000 183.0000 1.0000 183.1980 1.0000 183.3000 1.0000 183.4980 1.0000 183.6000 1.0000 183.7980 1.0000 183.9000 1.0000 184.0980 1.0000 184.2000 1.0000 184.3980 1.0000 184.5000 1.0000 184.6980 1.0000 184.8000 1.0000 184.9980 1.0000 185.1000 1.0000 185.2980 1.0000 185.4000 1.0000 185.5980 1.0000 185.7000 1.0000 185.8980 1.0000 186.0000 1.0000 186.1980 1.0000 186.3000 1.0000 186.4980 1.0000 186.6000 1.0000 186.7980 1.0000 186.9000 1.0000 187.0980 1.0000 187.2000 0.0000 187.3980 0.0000 187.5000 0.0000 187.6980 0.0000 187.8000 0.0000 187.9980 0.0000 188.1000 0.0000 188.2980 0.0000 188.4000 0.0000 188.5980 0.0000 188.7000 0.0000 188.8980 0.0000 189.0000 0.0000 189.1980 0.0000 189.3000 0.0000 189.4980 0.0000 189.6000 0.0000 189.7980 0.0000 189.9000 0.0000 190.0980 0.0000 190.2000 0.0000 190.3980 0.0000 190.5000 0.0000 190.6980 0.0000 190.8000 0.0000 190.9980 0.0000 191.1000 0.0000 191.2980 0.0000 191.4000 0.0000 191.5980 0.0000 191.7000 0.0000 191.8980 0.0000 192.0000 0.0000 192.1980 0.0000 192.3000 0.0000 192.4980 0.0000 192.6000 0.0000 192.7980 0.0000 192.9000 0.0000 193.0980 0.0000 193.2000 0.0000 193.3980 0.0000 193.5000 0.0000 193.6980 0.0000 193.8000 0.0000 193.9980 0.0000 194.1000 0.0000 194.2980 0.0000 194.4000 0.0000 194.5980 0.0000 194.7000 0.0000 194.8980 0.0000 195.0000 0.0000 195.1980 0.0000 195.3000 0.0000 195.4980 0.0000 195.6000 0.0000 195.7980 0.0000 195.9000 0.0000 196.0980 0.0000 196.2000 0.0000 196.3980 0.0000 196.5000 0.0000 196.6980 0.0000 196.8000 0.0000 196.9980 0.0000 197.1000 0.0000 197.2980 0.0000 197.4000 0.0000 197.5980 0.0000 197.7000 0.0000 197.8980 0.0000 198.0000 0.0000 198.1980 0.0000 198.3000 0.0000 198.4980 0.0000 198.6000 0.0000 198.7980 0.0000 198.9000 0.0000 199.0980 0.0000 199.2000 0.0000 199.3980 0.0000 199.5000 0.0000 199.6980 0.0000 199.8000 0.0000 199.9980 0.0000 200.1000 0.0000 200.2980 0.0000 200.4000 0.0000 200.5980 0.0000 200.7000 0.0000 200.8980 0.0000 201.0000 0.0000 201.1980 0.0000 201.3000 0.0000 201.4980 0.0000 201.6000 1.0000 201.7980 1.0000 201.9000 1.0000 202.0980 1.0000 202.2000 1.0000 202.3980 1.0000 202.5000 1.0000 202.6980 1.0000 202.8000 1.0000 202.9980 1.0000 203.1000 1.0000 203.2980 1.0000 203.4000 1.0000 203.5980 1.0000 203.7000 1.0000 203.8980 1.0000 204.0000 1.0000 204.1980 1.0000 204.3000 1.0000 204.4980 1.0000 204.6000 1.0000 204.7980 1.0000 204.9000 1.0000 205.0980 1.0000 205.2000 1.0000 205.3980 1.0000 205.5000 1.0000 205.6980 1.0000 205.8000 1.0000 205.9980 1.0000 206.1000 1.0000 206.2980 1.0000 206.4000 1.0000 206.5980 1.0000 206.7000 1.0000 206.8980 1.0000 207.0000 1.0000 207.1980 1.0000 207.3000 1.0000 207.4980 1.0000 207.6000 1.0000 207.7980 1.0000 207.9000 1.0000 208.0980 1.0000 208.2000 1.0000 208.3980 1.0000 208.5000 1.0000 208.6980 1.0000 208.8000 0.0000 208.9980 0.0000 209.1000 0.0000 209.2980 0.0000 209.4000 0.0000 209.5980 0.0000 209.7000 0.0000 209.8980 0.0000 210.0000 0.0000 210.1980 0.0000 210.3000 0.0000 210.4980 0.0000 210.6000 0.0000 210.7980 0.0000 210.9000 0.0000 211.0980 0.0000 211.2000 0.0000 211.3980 0.0000 211.5000 0.0000 211.6980 0.0000 211.8000 0.0000 211.9980 0.0000 212.1000 0.0000 212.2980 0.0000 212.4000 0.0000 212.5980 0.0000 212.7000 0.0000 212.8980 0.0000 213.0000 0.0000 213.1980 0.0000 213.3000 0.0000 213.4980 0.0000 213.6000 0.0000 213.7980 0.0000 213.9000 0.0000 214.0980 0.0000 214.2000 0.0000 214.3980 0.0000 214.5000 0.0000 214.6980 0.0000 214.8000 0.0000 214.9980 0.0000 215.1000 0.0000 215.2980 0.0000 215.4000 0.0000 215.5980 0.0000 215.7000 0.0000 215.8980 0.0000 216.0000 0.0000 216.1980 0.0000 216.3000 0.0000 216.4980 0.0000 216.6000 0.0000 216.7980 0.0000 216.9000 0.0000 217.0980 0.0000 217.2000 0.0000 217.3980 0.0000 217.5000 0.0000 217.6980 0.0000 217.8000 0.0000 217.9980 0.0000 218.1000 0.0000 218.2980 0.0000 218.4000 0.0000 218.5980 0.0000 218.7000 0.0000 218.8980 0.0000 219.0000 0.0000 219.1980 0.0000 219.3000 0.0000 219.4980 0.0000 219.6000 0.0000 219.7980 0.0000 219.9000 0.0000 220.0980 0.0000 220.2000 0.0000 220.3980 0.0000 220.5000 0.0000 220.6980 0.0000 220.8000 0.0000 220.9980 0.0000 221.1000 0.0000 221.2980 0.0000 221.4000 0.0000 221.5980 0.0000 221.7000 0.0000 221.8980 0.0000 222.0000 0.0000 222.1980 0.0000 222.3000 0.0000 222.4980 0.0000 222.6000 0.0000 222.7980 0.0000 222.9000 0.0000 223.0980 0.0000 223.2000 1.0000 223.3980 1.0000 223.5000 1.0000 223.6980 1.0000 223.8000 1.0000 223.9980 1.0000 224.1000 1.0000 224.2980 1.0000 224.4000 1.0000 224.5980 1.0000 224.7000 1.0000 224.8980 1.0000 225.0000 1.0000 225.1980 1.0000 225.3000 1.0000 225.4980 1.0000 225.6000 1.0000 225.7980 1.0000 225.9000 1.0000 226.0980 1.0000 226.2000 1.0000 226.3980 1.0000 226.5000 1.0000 226.6980 1.0000 226.8000 1.0000 226.9980 1.0000 227.1000 1.0000 227.2980 1.0000 227.4000 1.0000 227.5980 1.0000 227.7000 1.0000 227.8980 1.0000 228.0000 1.0000 228.1980 1.0000 228.3000 1.0000 228.4980 1.0000 228.6000 1.0000 228.7980 1.0000 228.9000 1.0000 229.0980 1.0000 229.2000 1.0000 229.3980 1.0000 229.5000 1.0000 229.6980 1.0000 229.8000 1.0000 229.9980 1.0000 230.1000 1.0000 230.2980 1.0000 230.4000 0.0000 230.5980 0.0000 230.7000 0.0000 230.8980 0.0000 231.0000 0.0000 231.1980 0.0000 231.3000 0.0000 231.4980 0.0000 231.6000 0.0000 231.7980 0.0000 231.9000 0.0000 232.0980 0.0000 232.2000 0.0000 232.3980 0.0000 232.5000 0.0000 232.6980 0.0000 232.8000 0.0000 232.9980 0.0000 233.1000 0.0000 233.2980 0.0000 233.4000 0.0000 233.5980 0.0000 233.7000 0.0000 233.8980 0.0000 234.0000 0.0000 234.1980 0.0000 234.3000 0.0000 234.4980 0.0000 234.6000 0.0000 234.7980 0.0000 234.9000 0.0000 235.0980 0.0000 235.2000 0.0000 235.3980 0.0000 235.5000 0.0000 235.6980 0.0000 235.8000 0.0000 235.9980 0.0000 236.1000 0.0000 236.2980 0.0000 236.4000 0.0000 236.5980 0.0000 236.7000 0.0000 236.8980 0.0000 237.0000 0.0000 237.1980 0.0000 237.3000 0.0000 237.4980 0.0000 237.6000 0.0000 237.7980 0.0000 237.9000 0.0000 238.0980 0.0000 238.2000 0.0000 238.3980 0.0000 238.5000 0.0000 238.6980 0.0000 238.8000 0.0000 238.9980 0.0000 239.1000 0.0000 239.2980 0.0000 239.4000 0.0000 239.5980 0.0000 239.7000 0.0000 239.8980 0.0000 240.0000 0.0000 240.1980 0.0000 240.3000 0.0000 240.4980 0.0000 240.6000 0.0000 240.7980 0.0000 240.9000 0.0000 241.0980 0.0000 241.2000 0.0000 241.3980 0.0000 241.5000 0.0000 241.6980 0.0000 241.8000 0.0000 241.9980 0.0000 242.1000 0.0000 242.2980 0.0000 242.4000 0.0000 242.5980 0.0000 242.7000 0.0000 242.8980 0.0000 243.0000 0.0000 243.1980 0.0000 243.3000 0.0000 243.4980 0.0000 243.6000 0.0000 243.7980 0.0000 243.9000 0.0000 244.0980 0.0000 244.2000 0.0000 244.3980 0.0000 244.5000 0.0000 244.6980 0.0000 244.8000 1.0000 244.9980 1.0000 245.1000 1.0000 245.2980 1.0000 245.4000 1.0000 245.5980 1.0000 245.7000 1.0000 245.8980 1.0000 246.0000 1.0000 246.1980 1.0000 246.3000 1.0000 246.4980 1.0000 246.6000 1.0000 246.7980 1.0000 246.9000 1.0000 247.0980 1.0000 247.2000 1.0000 247.3980 1.0000 247.5000 1.0000 247.6980 1.0000 247.8000 1.0000 247.9980 1.0000 248.1000 1.0000 248.2980 1.0000 248.4000 1.0000 248.5980 1.0000 248.7000 1.0000 248.8980 1.0000 249.0000 1.0000 249.1980 1.0000 249.3000 1.0000 249.4980 1.0000 249.6000 1.0000 249.7980 1.0000 249.9000 1.0000 250.0980 1.0000 250.2000 1.0000 250.3980 1.0000 250.5000 1.0000 250.6980 1.0000 250.8000 1.0000 250.9980 1.0000 251.1000 1.0000 251.2980 1.0000 251.4000 1.0000 251.5980 1.0000 251.7000 1.0000 251.8980 1.0000 252.0000 0.0000 252.1980 0.0000 252.3000 0.0000 252.4980 0.0000 252.6000 0.0000 252.7980 0.0000 252.9000 0.0000 253.0980 0.0000 253.2000 0.0000 253.3980 0.0000 253.5000 0.0000 253.6980 0.0000 253.8000 0.0000 253.9980 0.0000 254.1000 0.0000 254.2980 0.0000 254.4000 0.0000 254.5980 0.0000 254.7000 0.0000 254.8980 0.0000 255.0000 0.0000 255.1980 0.0000 255.3000 0.0000 255.4980 0.0000 255.6000 0.0000 255.7980 0.0000 255.9000 0.0000 256.0980 0.0000 256.2000 0.0000 256.3980 0.0000 256.5000 0.0000 256.6980 0.0000 256.8000 0.0000 256.9980 0.0000 257.1000 0.0000 257.2980 0.0000 257.4000 0.0000 257.5980 0.0000 257.7000 0.0000 257.8980 0.0000 258.0000 0.0000 258.1980 0.0000 258.3000 0.0000 258.4980 0.0000 258.6000 0.0000 258.7980 0.0000 258.9000 0.0000 259.0980 0.0000 259.2000 0.0000 259.3980 0.0000 259.5000 0.0000 259.6980 0.0000 259.8000 0.0000 259.9980 0.0000 260.1000 0.0000 260.2980 0.0000 260.4000 0.0000 260.5980 0.0000 260.7000 0.0000 260.8980 0.0000 261.0000 0.0000 261.1980 0.0000 261.3000 0.0000 261.4980 0.0000 261.6000 0.0000 261.7980 0.0000 261.9000 0.0000 262.0980 0.0000 262.2000 0.0000 262.3980 0.0000 262.5000 0.0000 262.6980 0.0000 262.8000 0.0000 262.9980 0.0000 263.1000 0.0000 263.2980 0.0000 263.4000 0.0000 263.5980 0.0000 263.7000 0.0000 263.8980 0.0000 264.0000 0.0000 264.1980 0.0000 264.3000 0.0000 264.4980 0.0000 264.6000 0.0000 264.7980 0.0000 264.9000 0.0000 265.0980 0.0000 265.2000 0.0000 265.3980 0.0000 265.5000 0.0000 265.6980 0.0000 265.8000 0.0000 265.9980 0.0000 266.1000 0.0000 266.2980 0.0000 266.4000 1.0000 266.5980 1.0000 266.7000 1.0000 266.8980 1.0000 267.0000 1.0000 267.1980 1.0000 267.3000 1.0000 267.4980 1.0000 267.6000 1.0000 267.7980 1.0000 267.9000 1.0000 268.0980 1.0000 268.2000 1.0000 268.3980 1.0000 268.5000 1.0000 268.6980 1.0000 268.8000 1.0000 268.9980 1.0000 269.1000 1.0000 269.2980 1.0000 269.4000 1.0000 269.5980 1.0000 269.7000 1.0000 269.8980 1.0000 270.0000 1.0000 270.1980 1.0000 270.3000 1.0000 270.4980 1.0000 270.6000 1.0000 270.7980 1.0000 270.9000 1.0000 271.0980 1.0000 271.2000 1.0000 271.3980 1.0000 271.5000 1.0000 271.6980 1.0000 271.8000 1.0000 271.9980 1.0000 272.1000 1.0000 272.2980 1.0000 272.4000 1.0000 272.5980 1.0000 272.7000 1.0000 272.8980 1.0000 273.0000 1.0000 273.1980 1.0000 273.3000 1.0000 273.4980 1.0000 273.6000 0.0000 273.7980 0.0000 273.9000 0.0000 274.0980 0.0000 274.2000 0.0000 274.3980 0.0000 274.5000 0.0000 274.6980 0.0000 274.8000 0.0000 274.9980 0.0000 275.1000 0.0000 275.2980 0.0000 275.4000 0.0000 275.5980 0.0000 275.7000 0.0000 275.8980 0.0000 276.0000 0.0000 276.1980 0.0000 276.3000 0.0000 276.4980 0.0000 276.6000 0.0000 276.7980 0.0000 276.9000 0.0000 277.0980 0.0000 277.2000 0.0000 277.3980 0.0000 277.5000 0.0000 277.6980 0.0000 277.8000 0.0000 277.9980 0.0000 278.1000 0.0000 278.2980 0.0000 278.4000 0.0000 278.5980 0.0000 278.7000 0.0000 278.8980 0.0000 279.0000 0.0000 279.1980 0.0000 279.3000 0.0000 279.4980 0.0000 279.6000 0.0000 279.7980 0.0000 279.9000 0.0000 280.0980 0.0000 280.2000 0.0000 280.3980 0.0000 280.5000 0.0000 280.6980 0.0000 280.8000 0.0000 280.9980 0.0000 281.1000 0.0000 281.2980 0.0000 281.4000 0.0000 281.5980 0.0000 281.7000 0.0000 281.8980 0.0000 282.0000 0.0000 282.1980 0.0000 282.3000 0.0000 282.4980 0.0000 282.6000 0.0000 282.7980 0.0000 282.9000 0.0000 283.0980 0.0000 283.2000 0.0000 283.3980 0.0000 283.5000 0.0000 283.6980 0.0000 283.8000 0.0000 283.9980 0.0000 284.1000 0.0000 284.2980 0.0000 284.4000 0.0000 284.5980 0.0000 284.7000 0.0000 284.8980 0.0000 285.0000 0.0000 285.1980 0.0000 285.3000 0.0000 285.4980 0.0000 285.6000 0.0000 285.7980 0.0000 285.9000 0.0000 286.0980 0.0000 286.2000 0.0000 286.3980 0.0000 286.5000 0.0000 286.6980 0.0000 286.8000 0.0000 286.9980 0.0000 287.1000 0.0000 287.2980 0.0000 287.4000 0.0000 287.5980 0.0000 287.7000 0.0000 287.8980 0.0000 288.0000 1.0000 288.1980 1.0000 288.3000 1.0000 288.4980 1.0000 288.6000 1.0000 288.7980 1.0000 288.9000 1.0000 289.0980 1.0000 289.2000 1.0000 289.3980 1.0000 289.5000 1.0000 289.6980 1.0000 289.8000 1.0000 289.9980 1.0000 290.1000 1.0000 290.2980 1.0000 290.4000 1.0000 290.5980 1.0000 290.7000 1.0000 290.8980 1.0000 291.0000 1.0000 291.1980 1.0000 291.3000 1.0000 291.4980 1.0000 291.6000 1.0000 291.7980 1.0000 291.9000 1.0000 292.0980 1.0000 292.2000 1.0000 292.3980 1.0000 292.5000 1.0000 292.6980 1.0000 292.8000 1.0000 292.9980 1.0000 293.1000 1.0000 293.2980 1.0000 293.4000 1.0000 293.5980 1.0000 293.7000 1.0000 293.8980 1.0000 294.0000 1.0000 294.1980 1.0000 294.3000 1.0000 294.4980 1.0000 294.6000 1.0000 294.7980 1.0000 294.9000 1.0000 295.0980 1.0000 295.2000 0.0000 295.3980 0.0000 295.5000 0.0000 295.6980 0.0000 295.8000 0.0000 295.9980 0.0000 296.1000 0.0000 296.2980 0.0000 296.4000 0.0000 296.5980 0.0000 296.7000 0.0000 296.8980 0.0000 297.0000 0.0000 297.1980 0.0000 297.3000 0.0000 297.4980 0.0000 297.6000 0.0000 297.7980 0.0000 297.9000 0.0000 298.0980 0.0000 298.2000 0.0000 298.3980 0.0000 298.5000 0.0000 298.6980 0.0000 298.8000 0.0000 298.9980 0.0000 299.1000 0.0000 299.2980 0.0000 299.4000 0.0000 299.5980 0.0000 299.7000 0.0000 299.8980 0.0000 300.0000 0.0000 300.1980 0.0000 300.3000 0.0000 300.4980 0.0000 300.6000 0.0000 300.7980 0.0000 300.9000 0.0000 301.0980 0.0000 301.2000 0.0000 301.3980 0.0000 301.5000 0.0000 301.6980 0.0000 301.8000 0.0000 301.9980 0.0000 302.1000 0.0000 302.2980 0.0000 302.4000 0.0000 302.5980 0.0000 302.7000 0.0000 302.8980 0.0000 303.0000 0.0000 303.1980 0.0000 303.3000 0.0000 303.4980 0.0000 303.6000 0.0000 303.7980 0.0000 303.9000 0.0000 304.0980 0.0000 304.2000 0.0000 304.3980 0.0000 304.5000 0.0000 304.6980 0.0000 304.8000 0.0000 304.9980 0.0000 305.1000 0.0000 305.2980 0.0000 305.4000 0.0000 305.5980 0.0000 305.7000 0.0000 305.8980 0.0000 306.0000 0.0000 306.1980 0.0000 306.3000 0.0000 306.4980 0.0000 306.6000 0.0000 306.7980 0.0000 306.9000 0.0000 307.0980 0.0000 307.2000 0.0000 307.3980 0.0000 307.5000 0.0000 307.6980 0.0000 307.8000 0.0000 307.9980 0.0000 308.1000 0.0000 308.2980 0.0000 308.4000 0.0000 308.5980 0.0000 308.7000 0.0000 308.8980 0.0000 309.0000 0.0000 309.1980 0.0000 309.3000 0.0000 309.4980 0.0000 309.6000 1.0000 309.7980 1.0000 309.9000 1.0000 310.0980 1.0000 310.2000 1.0000 310.3980 1.0000 310.5000 1.0000 310.6980 1.0000 310.8000 1.0000 310.9980 1.0000 311.1000 1.0000 311.2980 1.0000 311.4000 1.0000 311.5980 1.0000 311.7000 1.0000 311.8980 1.0000 312.0000 1.0000 312.1980 1.0000 312.3000 1.0000 312.4980 1.0000 312.6000 1.0000 312.7980 1.0000 312.9000 1.0000 313.0980 1.0000 313.2000 1.0000 313.3980 1.0000 313.5000 1.0000 313.6980 1.0000 313.8000 1.0000 313.9980 1.0000 314.1000 1.0000 314.2980 1.0000 314.4000 1.0000 314.5980 1.0000 314.7000 1.0000 314.8980 1.0000 315.0000 1.0000 315.1980 1.0000 315.3000 1.0000 315.4980 1.0000 315.6000 1.0000 315.7980 1.0000 315.9000 1.0000 316.0980 1.0000 316.2000 1.0000 316.3980 1.0000 316.5000 1.0000 316.6980 1.0000 316.8000 0.0000 316.9980 0.0000 317.1000 0.0000 317.2980 0.0000 317.4000 0.0000 317.5980 0.0000 317.7000 0.0000 317.8980 0.0000 318.0000 0.0000 318.1980 0.0000 318.3000 0.0000 318.4980 0.0000 318.6000 0.0000 318.7980 0.0000 318.9000 0.0000 319.0980 0.0000 319.2000 0.0000 319.3980 0.0000 319.5000 0.0000 319.6980 0.0000 319.8000 0.0000 319.9980 0.0000 320.1000 0.0000 320.2980 0.0000 320.4000 0.0000 320.5980 0.0000 320.7000 0.0000 320.8980 0.0000 321.0000 0.0000 321.1980 0.0000 321.3000 0.0000 321.4980 0.0000 321.6000 0.0000 321.7980 0.0000 321.9000 0.0000 322.0980 0.0000 322.2000 0.0000 322.3980 0.0000 322.5000 0.0000 322.6980 0.0000 322.8000 0.0000 322.9980 0.0000 323.1000 0.0000 323.2980 0.0000 323.4000 0.0000 323.5980 0.0000 323.7000 0.0000 323.8980 0.0000 324.0000 0.0000 324.1980 0.0000 324.3000 0.0000 324.4980 0.0000 324.6000 0.0000 324.7980 0.0000 324.9000 0.0000 325.0980 0.0000 325.2000 0.0000 325.3980 0.0000 325.5000 0.0000 325.6980 0.0000 325.8000 0.0000 325.9980 0.0000 326.1000 0.0000 326.2980 0.0000 326.4000 0.0000 326.5980 0.0000 326.7000 0.0000 326.8980 0.0000 327.0000 0.0000 327.1980 0.0000 327.3000 0.0000 327.4980 0.0000 327.6000 0.0000 327.7980 0.0000 327.9000 0.0000 328.0980 0.0000 328.2000 0.0000 328.3980 0.0000 328.5000 0.0000 328.6980 0.0000 328.8000 0.0000 328.9980 0.0000 329.1000 0.0000 329.2980 0.0000 329.4000 0.0000 329.5980 0.0000 329.7000 0.0000 329.8980 0.0000 330.0000 0.0000 330.1980 0.0000 330.3000 0.0000 330.4980 0.0000 330.6000 0.0000 330.7980 0.0000 330.9000 0.0000 331.0980 0.0000 331.2000 1.0000 331.3980 1.0000 331.5000 1.0000 331.6980 1.0000 331.8000 1.0000 331.9980 1.0000 332.1000 1.0000 332.2980 1.0000 332.4000 1.0000 332.5980 1.0000 332.7000 1.0000 332.8980 1.0000 333.0000 1.0000 333.1980 1.0000 333.3000 1.0000 333.4980 1.0000 333.6000 1.0000 333.7980 1.0000 333.9000 1.0000 334.0980 1.0000 334.2000 1.0000 334.3980 1.0000 334.5000 1.0000 334.6980 1.0000 334.8000 1.0000 334.9980 1.0000 335.1000 1.0000 335.2980 1.0000 335.4000 1.0000 335.5980 1.0000 335.7000 1.0000 335.8980 1.0000 336.0000 1.0000 336.1980 1.0000 336.3000 1.0000 336.4980 1.0000 336.6000 1.0000 336.7980 1.0000 336.9000 1.0000 337.0980 1.0000 337.2000 1.0000 337.3980 1.0000 337.5000 1.0000 337.6980 1.0000 337.8000 1.0000 337.9980 1.0000 338.1000 1.0000 338.2980 1.0000 338.4000 0.0000 338.5980 0.0000 338.7000 0.0000 338.8980 0.0000 339.0000 0.0000 339.1980 0.0000 339.3000 0.0000 339.4980 0.0000 339.6000 0.0000 339.7980 0.0000 339.9000 0.0000 340.0980 0.0000 340.2000 0.0000 340.3980 0.0000 340.5000 0.0000 340.6980 0.0000 340.8000 0.0000 340.9980 0.0000 341.1000 0.0000 341.2980 0.0000 341.4000 0.0000 341.5980 0.0000 341.7000 0.0000 341.8980 0.0000 342.0000 0.0000 342.1980 0.0000 342.3000 0.0000 342.4980 0.0000 342.6000 0.0000 342.7980 0.0000 342.9000 0.0000 343.0980 0.0000 343.2000 0.0000 343.3980 0.0000 343.5000 0.0000 343.6980 0.0000 343.8000 0.0000 343.9980 0.0000 344.1000 0.0000 344.2980 0.0000 344.4000 0.0000 344.5980 0.0000 344.7000 0.0000 344.8980 0.0000 345.0000 0.0000 345.1980 0.0000 345.3000 0.0000 345.4980 0.0000 345.6000 0.0000 345.7980 0.0000 345.9000 0.0000 346.0980 0.0000 346.2000 0.0000 346.3980 0.0000 346.5000 0.0000 346.6980 0.0000 346.8000 0.0000 346.9980 0.0000 347.1000 0.0000 347.2980 0.0000 347.4000 0.0000 347.5980 0.0000 347.7000 0.0000 347.8980 0.0000 348.0000 0.0000 348.1980 0.0000 348.3000 0.0000 348.4980 0.0000 348.6000 0.0000 348.7980 0.0000 348.9000 0.0000 349.0980 0.0000 349.2000 0.0000 349.3980 0.0000 349.5000 0.0000 349.6980 0.0000 349.8000 0.0000 349.9980 0.0000 350.1000 0.0000 350.2980 0.0000 350.4000 0.0000 350.5980 0.0000 350.7000 0.0000 350.8980 0.0000 351.0000 0.0000 351.1980 0.0000 351.3000 0.0000 351.4980 0.0000 351.6000 0.0000 351.7980 0.0000 351.9000 0.0000 352.0980 0.0000 352.2000 0.0000 352.3980 0.0000 352.5000 0.0000 352.6980 0.0000 352.8000 1.0000 352.9980 1.0000 353.1000 1.0000 353.2980 1.0000 353.4000 1.0000 353.5980 1.0000 353.7000 1.0000 353.8980 1.0000 354.0000 1.0000 354.1980 1.0000 354.3000 1.0000 354.4980 1.0000 354.6000 1.0000 354.7980 1.0000 354.9000 1.0000 355.0980 1.0000 355.2000 1.0000 355.3980 1.0000 355.5000 1.0000 355.6980 1.0000 355.8000 1.0000 355.9980 1.0000 356.1000 1.0000 356.2980 1.0000 356.4000 1.0000 356.5980 1.0000 356.7000 1.0000 356.8980 1.0000 357.0000 1.0000 357.1980 1.0000 357.3000 1.0000 357.4980 1.0000 357.6000 1.0000 357.7980 1.0000 357.9000 1.0000 358.0980 1.0000 358.2000 1.0000 358.3980 1.0000 358.5000 1.0000 358.6980 1.0000 358.8000 1.0000 358.9980 1.0000 359.1000 1.0000 359.2980 1.0000 359.4000 1.0000 359.5980 1.0000 359.7000 1.0000 359.8980 1.0000 360.0000 0.0000 360.1980 0.0000 360.3000 0.0000 360.4980 0.0000 360.6000 0.0000 360.7980 0.0000 360.9000 0.0000 361.0980 0.0000 361.2000 0.0000 361.3980 0.0000 361.5000 0.0000 361.6980 0.0000 361.8000 0.0000 361.9980 0.0000 362.1000 0.0000 362.2980 0.0000 362.4000 0.0000 362.5980 0.0000 362.7000 0.0000 362.8980 0.0000 363.0000 0.0000 363.1980 0.0000 363.3000 0.0000 363.4980 0.0000 363.6000 0.0000 363.7980 0.0000 363.9000 0.0000 364.0980 0.0000 364.2000 0.0000 364.3980 0.0000 364.5000 0.0000 364.6980 0.0000 364.8000 0.0000 364.9980 0.0000 365.1000 0.0000 365.2980 0.0000 365.4000 0.0000 365.5980 0.0000 365.7000 0.0000 365.8980 0.0000 366.0000 0.0000 366.1980 0.0000 366.3000 0.0000 366.4980 0.0000 366.6000 0.0000 366.7980 0.0000 366.9000 0.0000 367.0980 0.0000 367.2000 0.0000 367.3980 0.0000 367.5000 0.0000 367.6980 0.0000 367.8000 0.0000 367.9980 0.0000 368.1000 0.0000 368.2980 0.0000 368.4000 0.0000 368.5980 0.0000 368.7000 0.0000 368.8980 0.0000 369.0000 0.0000 369.1980 0.0000 369.3000 0.0000 369.4980 0.0000 369.6000 0.0000 369.7980 0.0000 369.9000 0.0000 370.0980 0.0000 370.2000 0.0000 370.3980 0.0000 370.5000 0.0000 370.6980 0.0000 370.8000 0.0000 370.9980 0.0000 371.1000 0.0000 371.2980 0.0000 371.4000 0.0000 371.5980 0.0000 371.7000 0.0000 371.8980 0.0000 372.0000 0.0000 372.1980 0.0000 372.3000 0.0000 372.4980 0.0000 372.6000 0.0000 372.7980 0.0000 372.9000 0.0000 373.0980 0.0000 373.2000 0.0000 373.3980 0.0000 373.5000 0.0000 373.6980 0.0000 373.8000 0.0000 373.9980 0.0000 374.1000 0.0000 374.2980 0.0000 374.4000 1.0000 374.5980 1.0000 374.7000 1.0000 374.8980 1.0000 375.0000 1.0000 375.1980 1.0000 375.3000 1.0000 375.4980 1.0000 375.6000 1.0000 375.7980 1.0000 375.9000 1.0000 376.0980 1.0000 376.2000 1.0000 376.3980 1.0000 376.5000 1.0000 376.6980 1.0000 376.8000 1.0000 376.9980 1.0000 377.1000 1.0000 377.2980 1.0000 377.4000 1.0000 377.5980 1.0000 377.7000 1.0000 377.8980 1.0000 378.0000 1.0000 378.1980 1.0000 378.3000 1.0000 378.4980 1.0000 378.6000 1.0000 378.7980 1.0000 378.9000 1.0000 379.0980 1.0000 379.2000 1.0000 379.3980 1.0000 379.5000 1.0000 379.6980 1.0000 379.8000 1.0000 379.9980 1.0000 380.1000 1.0000 380.2980 1.0000 380.4000 1.0000 380.5980 1.0000 380.7000 1.0000 380.8980 1.0000 381.0000 1.0000 381.1980 1.0000 381.3000 1.0000 381.4980 1.0000 381.6000 0.0000 381.7980 0.0000 381.9000 0.0000 382.0980 0.0000 382.2000 0.0000 382.3980 0.0000 382.5000 0.0000 382.6980 0.0000 382.8000 0.0000 382.9980 0.0000 383.1000 0.0000 383.2980 0.0000 383.4000 0.0000 383.5980 0.0000 383.7000 0.0000 383.8980 0.0000 384.0000 0.0000 384.1980 0.0000 384.3000 0.0000 384.4980 0.0000 384.6000 0.0000 384.7980 0.0000 384.9000 0.0000 385.0980 0.0000 385.2000 0.0000 385.3980 0.0000 385.5000 0.0000 385.6980 0.0000 385.8000 0.0000 385.9980 0.0000 386.1000 0.0000 386.2980 0.0000 386.4000 0.0000 386.5980 0.0000 386.7000 0.0000 386.8980 0.0000 387.0000 0.0000 387.1980 0.0000 387.3000 0.0000 387.4980 0.0000 387.6000 0.0000 387.7980 0.0000 387.9000 0.0000 388.0980 0.0000 388.2000 0.0000 388.3980 0.0000 388.5000 0.0000 388.6980 0.0000 388.8000 0.0000 388.9980 0.0000 389.1000 0.0000 389.2980 0.0000 389.4000 0.0000 389.5980 0.0000 389.7000 0.0000 389.8980 0.0000 390.0000 0.0000 390.1980 0.0000 390.3000 0.0000 390.4980 0.0000 390.6000 0.0000 390.7980 0.0000 390.9000 0.0000 391.0980 0.0000 391.2000 0.0000 391.3980 0.0000 391.5000 0.0000 391.6980 0.0000 391.8000 0.0000 391.9980 0.0000 392.1000 0.0000 392.2980 0.0000 392.4000 0.0000 392.5980 0.0000 392.7000 0.0000 392.8980 0.0000 393.0000 0.0000 393.1980 0.0000 393.3000 0.0000 393.4980 0.0000 393.6000 0.0000 393.7980 0.0000 393.9000 0.0000 394.0980 0.0000 394.2000 0.0000 394.3980 0.0000 394.5000 0.0000 394.6980 0.0000 394.8000 0.0000 394.9980 0.0000 395.1000 0.0000 395.2980 0.0000 395.4000 0.0000 395.5980 0.0000 395.7000 0.0000 395.8980 0.0000 396.0000 1.0000 396.1980 1.0000 396.3000 1.0000 396.4980 1.0000 396.6000 1.0000 396.7980 1.0000 396.9000 1.0000 397.0980 1.0000 397.2000 1.0000 397.3980 1.0000 397.5000 1.0000 397.6980 1.0000 397.8000 1.0000 397.9980 1.0000 398.1000 1.0000 398.2980 1.0000 398.4000 1.0000 398.5980 1.0000 398.7000 1.0000 398.8980 1.0000 399.0000 1.0000 399.1980 1.0000 399.3000 1.0000 399.4980 1.0000 399.6000 1.0000 399.7980 1.0000 399.9000 1.0000 400.0980 1.0000 400.2000 1.0000 400.3980 1.0000 400.5000 1.0000 400.6980 1.0000 400.8000 1.0000 400.9980 1.0000 401.1000 1.0000 401.2980 1.0000 401.4000 1.0000 401.5980 1.0000 401.7000 1.0000 401.8980 1.0000 402.0000 1.0000 402.1980 1.0000 402.3000 1.0000 402.4980 1.0000 402.6000 1.0000 402.7980 1.0000 402.9000 1.0000 403.0980 1.0000 403.2000 0.0000 403.3980 0.0000 403.5000 0.0000 403.6980 0.0000 403.8000 0.0000 403.9980 0.0000 404.1000 0.0000 404.2980 0.0000 404.4000 0.0000 404.5980 0.0000 404.7000 0.0000 404.8980 0.0000 405.0000 0.0000 405.1980 0.0000 405.3000 0.0000 405.4980 0.0000 405.6000 0.0000 405.7980 0.0000 405.9000 0.0000 406.0980 0.0000 406.2000 0.0000 406.3980 0.0000 406.5000 0.0000 406.6980 0.0000 406.8000 0.0000 406.9980 0.0000 407.1000 0.0000 407.2980 0.0000 407.4000 0.0000 407.5980 0.0000 407.7000 0.0000 407.8980 0.0000 408.0000 0.0000 408.1980 0.0000 408.3000 0.0000 408.4980 0.0000 408.6000 0.0000 408.7980 0.0000 408.9000 0.0000 409.0980 0.0000 409.2000 0.0000 409.3980 0.0000 409.5000 0.0000 409.6980 0.0000 409.8000 0.0000 409.9980 0.0000 410.1000 0.0000 410.2980 0.0000 410.4000 0.0000 410.5980 0.0000 410.7000 0.0000 410.8980 0.0000 411.0000 0.0000 411.1980 0.0000 411.3000 0.0000 411.4980 0.0000 411.6000 0.0000 411.7980 0.0000 411.9000 0.0000 412.0980 0.0000 412.2000 0.0000 412.3980 0.0000 412.5000 0.0000 412.6980 0.0000 412.8000 0.0000 412.9980 0.0000 413.1000 0.0000 413.2980 0.0000 413.4000 0.0000 413.5980 0.0000 413.7000 0.0000 413.8980 0.0000 414.0000 0.0000 414.1980 0.0000 414.3000 0.0000 414.4980 0.0000 414.6000 0.0000 414.7980 0.0000 414.9000 0.0000 415.0980 0.0000 415.2000 0.0000 415.3980 0.0000 415.5000 0.0000 415.6980 0.0000 415.8000 0.0000 415.9980 0.0000 416.1000 0.0000 416.2980 0.0000 416.4000 0.0000 416.5980 0.0000 416.7000 0.0000 416.8980 0.0000 417.0000 0.0000 417.1980 0.0000 417.3000 0.0000 417.4980 0.0000 417.6000 1.0000 417.7980 1.0000 417.9000 1.0000 418.0980 1.0000 418.2000 1.0000 418.3980 1.0000 418.5000 1.0000 418.6980 1.0000 418.8000 1.0000 418.9980 1.0000 419.1000 1.0000 419.2980 1.0000 419.4000 1.0000 419.5980 1.0000 419.7000 1.0000 419.8980 1.0000 420.0000 1.0000 420.1980 1.0000 420.3000 1.0000 420.4980 1.0000 420.6000 1.0000 420.7980 1.0000 420.9000 1.0000 421.0980 1.0000 421.2000 1.0000 421.3980 1.0000 421.5000 1.0000 421.6980 1.0000 421.8000 1.0000 421.9980 1.0000 422.1000 1.0000 422.2980 1.0000 422.4000 1.0000 422.5980 1.0000 422.7000 1.0000 422.8980 1.0000 423.0000 1.0000 423.1980 1.0000 423.3000 1.0000 423.4980 1.0000 423.6000 1.0000 423.7980 1.0000 423.9000 1.0000 424.0980 1.0000 424.2000 1.0000 424.3980 1.0000 424.5000 1.0000 424.6980 1.0000 424.8000 0.0000 424.9980 0.0000 425.1000 0.0000 425.2980 0.0000 425.4000 0.0000 425.5980 0.0000 425.7000 0.0000 425.8980 0.0000 426.0000 0.0000 426.1980 0.0000 426.3000 0.0000 426.4980 0.0000 426.6000 0.0000 426.7980 0.0000 426.9000 0.0000 427.0980 0.0000 427.2000 0.0000 427.3980 0.0000 427.5000 0.0000 427.6980 0.0000 427.8000 0.0000 427.9980 0.0000 428.1000 0.0000 428.2980 0.0000 428.4000 0.0000 428.5980 0.0000 428.7000 0.0000 428.8980 0.0000 429.0000 0.0000 429.1980 0.0000 429.3000 0.0000 429.4980 0.0000 429.6000 0.0000 429.7980 0.0000 429.9000 0.0000 430.0980 0.0000 430.2000 0.0000 430.3980 0.0000 430.5000 0.0000 430.6980 0.0000 430.8000 0.0000 430.9980 0.0000 431.1000 0.0000 431.2980 0.0000 431.4000 0.0000 431.5980 0.0000 431.7000 0.0000 431.8980 0.0000 432.0000 0.0000 432.1980 0.0000 432.3000 0.0000 432.4980 0.0000 432.6000 0.0000 432.7980 0.0000 432.9000 0.0000 433.0980 0.0000 433.2000 0.0000 433.3980 0.0000 433.5000 0.0000 433.6980 0.0000 433.8000 0.0000 433.9980 0.0000 434.1000 0.0000 434.2980 0.0000 434.4000 0.0000 434.5980 0.0000 434.7000 0.0000 434.8980 0.0000 435.0000 0.0000 435.1980 0.0000 435.3000 0.0000 435.4980 0.0000 435.6000 0.0000 435.7980 0.0000 435.9000 0.0000 436.0980 0.0000 436.2000 0.0000 436.3980 0.0000 436.5000 0.0000 436.6980 0.0000 436.8000 0.0000 436.9980 0.0000 437.1000 0.0000 437.2980 0.0000 437.4000 0.0000 437.5980 0.0000 437.7000 0.0000 437.8980 0.0000 438.0000 0.0000 438.1980 0.0000 438.3000 0.0000 438.4980 0.0000 438.6000 0.0000 438.7980 0.0000 438.9000 0.0000 439.0980 0.0000 439.2000 1.0000 439.3980 1.0000 439.5000 1.0000 439.6980 1.0000 439.8000 1.0000 439.9980 1.0000 440.1000 1.0000 440.2980 1.0000 440.4000 1.0000 440.5980 1.0000 440.7000 1.0000 440.8980 1.0000 441.0000 1.0000 441.1980 1.0000 441.3000 1.0000 441.4980 1.0000 441.6000 1.0000 441.7980 1.0000 441.9000 1.0000 442.0980 1.0000 442.2000 1.0000 442.3980 1.0000 442.5000 1.0000 442.6980 1.0000 442.8000 1.0000 442.9980 1.0000 443.1000 1.0000 443.2980 1.0000 443.4000 1.0000 443.5980 1.0000 443.7000 1.0000 443.8980 1.0000 444.0000 1.0000 444.1980 1.0000 444.3000 1.0000 444.4980 1.0000 444.6000 1.0000 444.7980 1.0000 444.9000 1.0000 445.0980 1.0000 445.2000 1.0000 445.3980 1.0000 445.5000 1.0000 445.6980 1.0000 445.8000 1.0000 445.9980 1.0000 446.1000 1.0000 446.2980 1.0000 446.4000 0.0000 446.5980 0.0000 446.7000 0.0000 446.8980 0.0000 447.0000 0.0000 447.1980 0.0000 447.3000 0.0000 447.4980 0.0000 447.6000 0.0000 447.7980 0.0000 447.9000 0.0000 448.0980 0.0000 448.2000 0.0000 448.3980 0.0000 448.5000 0.0000 448.6980 0.0000 448.8000 0.0000 448.9980 0.0000 449.1000 0.0000 449.2980 0.0000 449.4000 0.0000 449.5980 0.0000 449.7000 0.0000 449.8980 0.0000 450.0000 0.0000 450.1980 0.0000 450.3000 0.0000 450.4980 0.0000 450.6000 0.0000 450.7980 0.0000 450.9000 0.0000 451.0980 0.0000 451.2000 0.0000 451.3980 0.0000 451.5000 0.0000 451.6980 0.0000 451.8000 0.0000 451.9980 0.0000 452.1000 0.0000 452.2980 0.0000 452.4000 0.0000 452.5980 0.0000 452.7000 0.0000 452.8980 0.0000 453.0000 0.0000 453.1980 0.0000 453.3000 0.0000 453.4980 0.0000 453.6000 0.0000 453.7980 0.0000 453.9000 0.0000 454.0980 0.0000 454.2000 0.0000 454.3980 0.0000 454.5000 0.0000 454.6980 0.0000 454.8000 0.0000 454.9980 0.0000 455.1000 0.0000 455.2980 0.0000 455.4000 0.0000 455.5980 0.0000 455.7000 0.0000 455.8980 0.0000 456.0000 0.0000 456.1980 0.0000 456.3000 0.0000 456.4980 0.0000 456.6000 0.0000 456.7980 0.0000 456.9000 0.0000 457.0980 0.0000 457.2000 0.0000 457.3980 0.0000 457.5000 0.0000 457.6980 0.0000 457.8000 0.0000 457.9980 0.0000 458.1000 0.0000 458.2980 0.0000 458.4000 0.0000 458.5980 0.0000 458.7000 0.0000 458.8980 0.0000 459.0000 0.0000 459.1980 0.0000 459.3000 0.0000 459.4980 0.0000 459.6000 0.0000 459.7980 0.0000 459.9000 0.0000 460.0980 0.0000 460.2000 0.0000 460.3980 0.0000 460.5000 0.0000 460.6980 0.0000 460.8000 1.0000 460.9980 1.0000 461.1000 1.0000 461.2980 1.0000 461.4000 1.0000 461.5980 1.0000 461.7000 1.0000 461.8980 1.0000 462.0000 1.0000 462.1980 1.0000 462.3000 1.0000 462.4980 1.0000 462.6000 1.0000 462.7980 1.0000 462.9000 1.0000 463.0980 1.0000 463.2000 1.0000 463.3980 1.0000 463.5000 1.0000 463.6980 1.0000 463.8000 1.0000 463.9980 1.0000 464.1000 1.0000 464.2980 1.0000 464.4000 1.0000 464.5980 1.0000 464.7000 1.0000 464.8980 1.0000 465.0000 1.0000 465.1980 1.0000 465.3000 1.0000 465.4980 1.0000 465.6000 1.0000 465.7980 1.0000 465.9000 1.0000 466.0980 1.0000 466.2000 1.0000 466.3980 1.0000 466.5000 1.0000 466.6980 1.0000 466.8000 1.0000 466.9980 1.0000 467.1000 1.0000 467.2980 1.0000 467.4000 1.0000 467.5980 1.0000 467.7000 1.0000 467.8980 1.0000 468.0000 0.0000 468.1980 0.0000 468.3000 0.0000 468.4980 0.0000 468.6000 0.0000 468.7980 0.0000 468.9000 0.0000 469.0980 0.0000 469.2000 0.0000 469.3980 0.0000 469.5000 0.0000 469.6980 0.0000 469.8000 0.0000 469.9980 0.0000 470.1000 0.0000 470.2980 0.0000 470.4000 0.0000 470.5980 0.0000 470.7000 0.0000 470.8980 0.0000 471.0000 0.0000 471.1980 0.0000 471.3000 0.0000 471.4980 0.0000 471.6000 0.0000 471.7980 0.0000 471.9000 0.0000 472.0980 0.0000 472.2000 0.0000 472.3980 0.0000 472.5000 0.0000 472.6980 0.0000 472.8000 0.0000 472.9980 0.0000 473.1000 0.0000 473.2980 0.0000 473.4000 0.0000 473.5980 0.0000 473.7000 0.0000 473.8980 0.0000 474.0000 0.0000 474.1980 0.0000 474.3000 0.0000 474.4980 0.0000 474.6000 0.0000 474.7980 0.0000 474.9000 0.0000 475.0980 0.0000 475.2000 0.0000 475.3980 0.0000 475.5000 0.0000 475.6980 0.0000 475.8000 0.0000 475.9980 0.0000 476.1000 0.0000 476.2980 0.0000 476.4000 0.0000 476.5980 0.0000 476.7000 0.0000 476.8980 0.0000 477.0000 0.0000 477.1980 0.0000 477.3000 0.0000 477.4980 0.0000 477.6000 0.0000 477.7980 0.0000 477.9000 0.0000 478.0980 0.0000 478.2000 0.0000 478.3980 0.0000 478.5000 0.0000 478.6980 0.0000 478.8000 0.0000 478.9980 0.0000 479.1000 0.0000 479.2980 0.0000 479.4000 0.0000 479.5980 0.0000 479.7000 0.0000 479.8980 0.0000 480.0000 0.0000 480.1980 0.0000 480.3000 0.0000 480.4980 0.0000 480.6000 0.0000 480.7980 0.0000 480.9000 0.0000 481.0980 0.0000 481.2000 0.0000 481.3980 0.0000 481.5000 0.0000 481.6980 0.0000 481.8000 0.0000 481.9980 0.0000 482.1000 0.0000 482.2980 0.0000 482.4000 1.0000 482.5980 1.0000 482.7000 1.0000 482.8980 1.0000 483.0000 1.0000 483.1980 1.0000 483.3000 1.0000 483.4980 1.0000 483.6000 1.0000 483.7980 1.0000 483.9000 1.0000 484.0980 1.0000 484.2000 1.0000 484.3980 1.0000 484.5000 1.0000 484.6980 1.0000 484.8000 1.0000 484.9980 1.0000 485.1000 1.0000 485.2980 1.0000 485.4000 1.0000 485.5980 1.0000 485.7000 1.0000 485.8980 1.0000 486.0000 1.0000 486.1980 1.0000 486.3000 1.0000 486.4980 1.0000 486.6000 1.0000 486.7980 1.0000 486.9000 1.0000 487.0980 1.0000 487.2000 1.0000 487.3980 1.0000 487.5000 1.0000 487.6980 1.0000 487.8000 1.0000 487.9980 1.0000 488.1000 1.0000 488.2980 1.0000 488.4000 1.0000 488.5980 1.0000 488.7000 1.0000 488.8980 1.0000 489.0000 1.0000 489.1980 1.0000 489.3000 1.0000 489.4980 1.0000 489.6000 0.0000 489.7980 0.0000 489.9000 0.0000 490.0980 0.0000 490.2000 0.0000 490.3980 0.0000 490.5000 0.0000 490.6980 0.0000 490.8000 0.0000 490.9980 0.0000 491.1000 0.0000 491.2980 0.0000 491.4000 0.0000 491.5980 0.0000 491.7000 0.0000 491.8980 0.0000 492.0000 0.0000 492.1980 0.0000 492.3000 0.0000 492.4980 0.0000 492.6000 0.0000 492.7980 0.0000 492.9000 0.0000 493.0980 0.0000 493.2000 0.0000 493.3980 0.0000 493.5000 0.0000 493.6980 0.0000 493.8000 0.0000 493.9980 0.0000 494.1000 0.0000 494.2980 0.0000 494.4000 0.0000 494.5980 0.0000 494.7000 0.0000 494.8980 0.0000 495.0000 0.0000 495.1980 0.0000 495.3000 0.0000 495.4980 0.0000 495.6000 0.0000 495.7980 0.0000 495.9000 0.0000 496.0980 0.0000 496.2000 0.0000 496.3980 0.0000 496.5000 0.0000 496.6980 0.0000 496.8000 0.0000 496.9980 0.0000 497.1000 0.0000 497.2980 0.0000 497.4000 0.0000 497.5980 0.0000 497.7000 0.0000 497.8980 0.0000 498.0000 0.0000 498.1980 0.0000 498.3000 0.0000 498.4980 0.0000 498.6000 0.0000 498.7980 0.0000 498.9000 0.0000 499.0980 0.0000 499.2000 0.0000 499.3980 0.0000 499.5000 0.0000 499.6980 0.0000 499.8000 0.0000 499.9980 0.0000 500.1000 0.0000 500.2980 0.0000 500.4000 0.0000 500.5980 0.0000 500.7000 0.0000 500.8980 0.0000 501.0000 0.0000 501.1980 0.0000 501.3000 0.0000 501.4980 0.0000 501.6000 0.0000 501.7980 0.0000 501.9000 0.0000 502.0980 0.0000 502.2000 0.0000 502.3980 0.0000 502.5000 0.0000 502.6980 0.0000 502.8000 0.0000 502.9980 0.0000 503.1000 0.0000 503.2980 0.0000 503.4000 0.0000 503.5980 0.0000 503.7000 0.0000 503.8980 0.0000 504.0000 1.0000 504.1980 1.0000 504.3000 1.0000 504.4980 1.0000 504.6000 1.0000 504.7980 1.0000 504.9000 1.0000 505.0980 1.0000 505.2000 1.0000 505.3980 1.0000 505.5000 1.0000 505.6980 1.0000 505.8000 1.0000 505.9980 1.0000 506.1000 1.0000 506.2980 1.0000 506.4000 1.0000 506.5980 1.0000 506.7000 1.0000 506.8980 1.0000 507.0000 1.0000 507.1980 1.0000 507.3000 1.0000 507.4980 1.0000 507.6000 1.0000 507.7980 1.0000 507.9000 1.0000 508.0980 1.0000 508.2000 1.0000 508.3980 1.0000 508.5000 1.0000 508.6980 1.0000 508.8000 1.0000 508.9980 1.0000 509.1000 1.0000 509.2980 1.0000 509.4000 1.0000 509.5980 1.0000 509.7000 1.0000 509.8980 1.0000 510.0000 1.0000 510.1980 1.0000 510.3000 1.0000 510.4980 1.0000 510.6000 1.0000 510.7980 1.0000 510.9000 1.0000 511.0980 1.0000 511.2000 0.0000 511.3980 0.0000 511.5000 0.0000 511.6980 0.0000 511.8000 0.0000 511.9980 0.0000 512.1000 0.0000 512.2980 0.0000 512.4000 0.0000 512.5980 0.0000 512.7000 0.0000 512.8980 0.0000 513.0000 0.0000 513.1980 0.0000 513.3000 0.0000 513.4980 0.0000 513.6000 0.0000 513.7980 0.0000 513.9000 0.0000 514.0980 0.0000 514.2000 0.0000 514.3980 0.0000 514.5000 0.0000 514.6980 0.0000 514.8000 0.0000 514.9980 0.0000 515.1000 0.0000 515.2980 0.0000 515.4000 0.0000 515.5980 0.0000 515.7000 0.0000 515.8980 0.0000 516.0000 0.0000 516.1980 0.0000 516.3000 0.0000 516.4980 0.0000 516.6000 0.0000 516.7980 0.0000 516.9000 0.0000 517.0980 0.0000 517.2000 0.0000 517.3980 0.0000 517.5000 0.0000 517.6980 0.0000 517.8000 0.0000 517.9980 0.0000 518.1000 0.0000 518.2980 0.0000 518.4000 0.0000 518.5980 0.0000 518.7000 0.0000 518.8980 0.0000 519.0000 0.0000 519.1980 0.0000 519.3000 0.0000 519.4980 0.0000 519.6000 0.0000 519.7980 0.0000 519.9000 0.0000 520.0980 0.0000 520.2000 0.0000 520.3980 0.0000 520.5000 0.0000 520.6980 0.0000 520.8000 0.0000 520.9980 0.0000 521.1000 0.0000 521.2980 0.0000 521.4000 0.0000 521.5980 0.0000 521.7000 0.0000 521.8980 0.0000 522.0000 0.0000 522.1980 0.0000 522.3000 0.0000 522.4980 0.0000 522.6000 0.0000 522.7980 0.0000 522.9000 0.0000 523.0980 0.0000 523.2000 0.0000 523.3980 0.0000 523.5000 0.0000 523.6980 0.0000 523.8000 0.0000 523.9980 0.0000 524.1000 0.0000 524.2980 0.0000 524.4000 0.0000 524.5980 0.0000 524.7000 0.0000 524.8980 0.0000 525.0000 0.0000 525.1980 0.0000 525.3000 0.0000 525.4980 0.0000 525.6000 1.0000 525.7980 1.0000 525.9000 1.0000 526.0980 1.0000 526.2000 1.0000 526.3980 1.0000 526.5000 1.0000 526.6980 1.0000 526.8000 1.0000 526.9980 1.0000 527.1000 1.0000 527.2980 1.0000 527.4000 1.0000 527.5980 1.0000 527.7000 1.0000 527.8980 1.0000 528.0000 1.0000 528.1980 1.0000 528.3000 1.0000 528.4980 1.0000 528.6000 1.0000 528.7980 1.0000 528.9000 1.0000 529.0980 1.0000 529.2000 1.0000 529.3980 1.0000 529.5000 1.0000 529.6980 1.0000 529.8000 1.0000 529.9980 1.0000 530.1000 1.0000 530.2980 1.0000 530.4000 1.0000 530.5980 1.0000 530.7000 1.0000 530.8980 1.0000 531.0000 1.0000 531.1980 1.0000 531.3000 1.0000 531.4980 1.0000 531.6000 1.0000 531.7980 1.0000 531.9000 1.0000 532.0980 1.0000 532.2000 1.0000 532.3980 1.0000 532.5000 1.0000 532.6980 1.0000 532.8000 0.0000 532.9980 0.0000 533.1000 0.0000 533.2980 0.0000 533.4000 0.0000 533.5980 0.0000 533.7000 0.0000 533.8980 0.0000 534.0000 0.0000 534.1980 0.0000 534.3000 0.0000 534.4980 0.0000 534.6000 0.0000 534.7980 0.0000 534.9000 0.0000 535.0980 0.0000 535.2000 0.0000 535.3980 0.0000 535.5000 0.0000 535.6980 0.0000 535.8000 0.0000 535.9980 0.0000 536.1000 0.0000 536.2980 0.0000 536.4000 0.0000 536.5980 0.0000 536.7000 0.0000 536.8980 0.0000 537.0000 0.0000 537.1980 0.0000 537.3000 0.0000 537.4980 0.0000 537.6000 0.0000 537.7980 0.0000 537.9000 0.0000 538.0980 0.0000 538.2000 0.0000 538.3980 0.0000 538.5000 0.0000 538.6980 0.0000 538.8000 0.0000 538.9980 0.0000 539.1000 0.0000 539.2980 0.0000 539.4000 0.0000 539.5980 0.0000 539.7000 0.0000 539.8980 0.0000 540.0000 0.0000 540.1980 0.0000 540.3000 0.0000 540.4980 0.0000 540.6000 0.0000 540.7980 0.0000 540.9000 0.0000 541.0980 0.0000 541.2000 0.0000 541.3980 0.0000 541.5000 0.0000 541.6980 0.0000 541.8000 0.0000 541.9980 0.0000 542.1000 0.0000 542.2980 0.0000 542.4000 0.0000 542.5980 0.0000 542.7000 0.0000 542.8980 0.0000 543.0000 0.0000 543.1980 0.0000 543.3000 0.0000 543.4980 0.0000 543.6000 0.0000 543.7980 0.0000 543.9000 0.0000 544.0980 0.0000 544.2000 0.0000 544.3980 0.0000 544.5000 0.0000 544.6980 0.0000 544.8000 0.0000 544.9980 0.0000 545.1000 0.0000 545.2980 0.0000 545.4000 0.0000 545.5980 0.0000 545.7000 0.0000 545.8980 0.0000 546.0000 0.0000 546.1980 0.0000 546.3000 0.0000 546.4980 0.0000 546.6000 0.0000 546.7980 0.0000 546.9000 0.0000 547.0980 0.0000 547.2000 1.0000 547.3980 1.0000 547.5000 1.0000 547.6980 1.0000 547.8000 1.0000 547.9980 1.0000 548.1000 1.0000 548.2980 1.0000 548.4000 1.0000 548.5980 1.0000 548.7000 1.0000 548.8980 1.0000 549.0000 1.0000 549.1980 1.0000 549.3000 1.0000 549.4980 1.0000 549.6000 1.0000 549.7980 1.0000 549.9000 1.0000 550.0980 1.0000 550.2000 1.0000 550.3980 1.0000 550.5000 1.0000 550.6980 1.0000 550.8000 1.0000 550.9980 1.0000 551.1000 1.0000 551.2980 1.0000 551.4000 1.0000 551.5980 1.0000 551.7000 1.0000 551.8980 1.0000 552.0000 1.0000 552.1980 1.0000 552.3000 1.0000 552.4980 1.0000 552.6000 1.0000 552.7980 1.0000 552.9000 1.0000 553.0980 1.0000 553.2000 1.0000 553.3980 1.0000 553.5000 1.0000 553.6980 1.0000 553.8000 1.0000 553.9980 1.0000 554.1000 1.0000 554.2980 1.0000 554.4000 0.0000 554.5980 0.0000 554.7000 0.0000 554.8980 0.0000 555.0000 0.0000 555.1980 0.0000 555.3000 0.0000 555.4980 0.0000 555.6000 0.0000 555.7980 0.0000 555.9000 0.0000 556.0980 0.0000 556.2000 0.0000 556.3980 0.0000 556.5000 0.0000 556.6980 0.0000 556.8000 0.0000 556.9980 0.0000 557.1000 0.0000 557.2980 0.0000 557.4000 0.0000 557.5980 0.0000 557.7000 0.0000 557.8980 0.0000 558.0000 0.0000 558.1980 0.0000 558.3000 0.0000 558.4980 0.0000 558.6000 0.0000 558.7980 0.0000 558.9000 0.0000 559.0980 0.0000 559.2000 0.0000 559.3980 0.0000 559.5000 0.0000 559.6980 0.0000 559.8000 0.0000 559.9980 0.0000 560.1000 0.0000 560.2980 0.0000 560.4000 0.0000 560.5980 0.0000 560.7000 0.0000 560.8980 0.0000 561.0000 0.0000 561.1980 0.0000 561.3000 0.0000 561.4980 0.0000 561.6000 0.0000 561.7980 0.0000 561.9000 0.0000 562.0980 0.0000 562.2000 0.0000 562.3980 0.0000 562.5000 0.0000 562.6980 0.0000 562.8000 0.0000 562.9980 0.0000 563.1000 0.0000 563.2980 0.0000 563.4000 0.0000 563.5980 0.0000 563.7000 0.0000 563.8980 0.0000 564.0000 0.0000 564.1980 0.0000 564.3000 0.0000 564.4980 0.0000 564.6000 0.0000 564.7980 0.0000 564.9000 0.0000 565.0980 0.0000 565.2000 0.0000 565.3980 0.0000 565.5000 0.0000 565.6980 0.0000 565.8000 0.0000 565.9980 0.0000 566.1000 0.0000 566.2980 0.0000 566.4000 0.0000 566.5980 0.0000 566.7000 0.0000 566.8980 0.0000 567.0000 0.0000 567.1980 0.0000 567.3000 0.0000 567.4980 0.0000 567.6000 0.0000 567.7980 0.0000 567.9000 0.0000 568.0980 0.0000 568.2000 0.0000 568.3980 0.0000 568.5000 0.0000 568.6980 0.0000 568.8000 1.0000 568.9980 1.0000 569.1000 1.0000 569.2980 1.0000 569.4000 1.0000 569.5980 1.0000 569.7000 1.0000 569.8980 1.0000 570.0000 1.0000 570.1980 1.0000 570.3000 1.0000 570.4980 1.0000 570.6000 1.0000 570.7980 1.0000 570.9000 1.0000 571.0980 1.0000 571.2000 1.0000 571.3980 1.0000 571.5000 1.0000 571.6980 1.0000 571.8000 1.0000 571.9980 1.0000 572.1000 1.0000 572.2980 1.0000 572.4000 1.0000 572.5980 1.0000 572.7000 1.0000 572.8980 1.0000 573.0000 1.0000 573.1980 1.0000 573.3000 1.0000 573.4980 1.0000 573.6000 1.0000 573.7980 1.0000 573.9000 1.0000 574.0980 1.0000 574.2000 1.0000 574.3980 1.0000 574.5000 1.0000 574.6980 1.0000 574.8000 1.0000 574.9980 1.0000 575.1000 1.0000 575.2980 1.0000 575.4000 1.0000 575.5980 1.0000 575.7000 1.0000 575.8980 1.0000 576.0000 0.0000 576.1980 0.0000 576.3000 0.0000 576.4980 0.0000 576.6000 0.0000 576.7980 0.0000 576.9000 0.0000 577.0980 0.0000 577.2000 0.0000 577.3980 0.0000 577.5000 0.0000 577.6980 0.0000 577.8000 0.0000 577.9980 0.0000 578.1000 0.0000 578.2980 0.0000 578.4000 0.0000 578.5980 0.0000 578.7000 0.0000 578.8980 0.0000 579.0000 0.0000 579.1980 0.0000 579.3000 0.0000 579.4980 0.0000 579.6000 0.0000 579.7980 0.0000 579.9000 0.0000 580.0980 0.0000 580.2000 0.0000 580.3980 0.0000 580.5000 0.0000 580.6980 0.0000 580.8000 0.0000 580.9980 0.0000 581.1000 0.0000 581.2980 0.0000 581.4000 0.0000 581.5980 0.0000 581.7000 0.0000 581.8980 0.0000 582.0000 0.0000 582.1980 0.0000 582.3000 0.0000 582.4980 0.0000 582.6000 0.0000 582.7980 0.0000 582.9000 0.0000 583.0980 0.0000 583.2000 0.0000 583.3980 0.0000 583.5000 0.0000 583.6980 0.0000 583.8000 0.0000 583.9980 0.0000 584.1000 0.0000 584.2980 0.0000 584.4000 0.0000 584.5980 0.0000 584.7000 0.0000 584.8980 0.0000 585.0000 0.0000 585.1980 0.0000 585.3000 0.0000 585.4980 0.0000 585.6000 0.0000 585.7980 0.0000 585.9000 0.0000 586.0980 0.0000 586.2000 0.0000 586.3980 0.0000 586.5000 0.0000 586.6980 0.0000 586.8000 0.0000 586.9980 0.0000 587.1000 0.0000 587.2980 0.0000 587.4000 0.0000 587.5980 0.0000 587.7000 0.0000 587.8980 0.0000 588.0000 0.0000 588.1980 0.0000 588.3000 0.0000 588.4980 0.0000 588.6000 0.0000 588.7980 0.0000 588.9000 0.0000 589.0980 0.0000 589.2000 0.0000 589.3980 0.0000 589.5000 0.0000 589.6980 0.0000 589.8000 0.0000 589.9980 0.0000 590.1000 0.0000 590.2980 0.0000 590.4000 1.0000 590.5980 1.0000 590.7000 1.0000 590.8980 1.0000 591.0000 1.0000 591.1980 1.0000 591.3000 1.0000 591.4980 1.0000 591.6000 1.0000 591.7980 1.0000 591.9000 1.0000 592.0980 1.0000 592.2000 1.0000 592.3980 1.0000 592.5000 1.0000 592.6980 1.0000 592.8000 1.0000 592.9980 1.0000 593.1000 1.0000 593.2980 1.0000 593.4000 1.0000 593.5980 1.0000 593.7000 1.0000 593.8980 1.0000 594.0000 1.0000 594.1980 1.0000 594.3000 1.0000 594.4980 1.0000 594.6000 1.0000 594.7980 1.0000 594.9000 1.0000 595.0980 1.0000 595.2000 1.0000 595.3980 1.0000 595.5000 1.0000 595.6980 1.0000 595.8000 1.0000 595.9980 1.0000 596.1000 1.0000 596.2980 1.0000 596.4000 1.0000 596.5980 1.0000 596.7000 1.0000 596.8980 1.0000 597.0000 1.0000 597.1980 1.0000 597.3000 1.0000 597.4980 1.0000 597.6000 0.0000 597.7980 0.0000 597.9000 0.0000 598.0980 0.0000 598.2000 0.0000 598.3980 0.0000 598.5000 0.0000 598.6980 0.0000 598.8000 0.0000 598.9980 0.0000 599.1000 0.0000 599.2980 0.0000 599.4000 0.0000 599.5980 0.0000 599.7000 0.0000 599.8980 0.0000 600.0000 0.0000)
Vtg2 tg2 0 PWL(0.0000 0.0000 0.1980 0.0000 0.3000 0.0000 0.4980 0.0000 0.6000 0.0000 0.7980 0.0000 0.9000 0.0000 1.0980 0.0000 1.2000 0.0000 1.3980 0.0000 1.5000 0.0000 1.6980 0.0000 1.8000 0.0000 1.9980 0.0000 2.1000 0.0000 2.2980 0.0000 2.4000 0.0000 2.5980 0.0000 2.7000 0.0000 2.8980 0.0000 3.0000 0.0000 3.1980 0.0000 3.3000 0.0000 3.4980 0.0000 3.6000 0.0000 3.7980 0.0000 3.9000 0.0000 4.0980 0.0000 4.2000 0.0000 4.3980 0.0000 4.5000 0.0000 4.6980 0.0000 4.8000 0.0000 4.9980 0.0000 5.1000 0.0000 5.2980 0.0000 5.4000 0.0000 5.5980 0.0000 5.7000 0.0000 5.8980 0.0000 6.0000 0.0000 6.1980 0.0000 6.3000 0.0000 6.4980 0.0000 6.6000 0.0000 6.7980 0.0000 6.9000 0.0000 7.0980 0.0000 7.2000 0.0000 7.3980 0.0000 7.5000 0.0000 7.6980 0.0000 7.8000 0.0000 7.9980 0.0000 8.1000 0.0000 8.2980 0.0000 8.4000 0.0000 8.5980 0.0000 8.7000 0.0000 8.8980 0.0000 9.0000 0.0000 9.1980 0.0000 9.3000 0.0000 9.4980 0.0000 9.6000 0.0000 9.7980 0.0000 9.9000 0.0000 10.0980 0.0000 10.2000 0.0000 10.3980 0.0000 10.5000 0.0000 10.6980 0.0000 10.8000 0.0000 10.9980 0.0000 11.1000 0.0000 11.2980 0.0000 11.4000 0.0000 11.5980 0.0000 11.7000 0.0000 11.8980 0.0000 12.0000 0.0000 12.1980 0.0000 12.3000 0.0000 12.4980 0.0000 12.6000 0.0000 12.7980 0.0000 12.9000 0.0000 13.0980 0.0000 13.2000 0.0000 13.3980 0.0000 13.5000 0.0000 13.6980 0.0000 13.8000 0.0000 13.9980 0.0000 14.1000 0.0000 14.2980 0.0000 14.4000 1.0000 14.5980 1.0000 14.7000 1.0000 14.8980 1.0000 15.0000 1.0000 15.1980 1.0000 15.3000 1.0000 15.4980 1.0000 15.6000 1.0000 15.7980 1.0000 15.9000 1.0000 16.0980 1.0000 16.2000 1.0000 16.3980 1.0000 16.5000 1.0000 16.6980 1.0000 16.8000 1.0000 16.9980 1.0000 17.1000 1.0000 17.2980 1.0000 17.4000 1.0000 17.5980 1.0000 17.7000 1.0000 17.8980 1.0000 18.0000 1.0000 18.1980 1.0000 18.3000 1.0000 18.4980 1.0000 18.6000 1.0000 18.7980 1.0000 18.9000 1.0000 19.0980 1.0000 19.2000 1.0000 19.3980 1.0000 19.5000 1.0000 19.6980 1.0000 19.8000 1.0000 19.9980 1.0000 20.1000 1.0000 20.2980 1.0000 20.4000 1.0000 20.5980 1.0000 20.7000 1.0000 20.8980 1.0000 21.0000 1.0000 21.1980 1.0000 21.3000 1.0000 21.4980 1.0000 21.6000 0.0000 21.7980 0.0000 21.9000 0.0000 22.0980 0.0000 22.2000 0.0000 22.3980 0.0000 22.5000 0.0000 22.6980 0.0000 22.8000 0.0000 22.9980 0.0000 23.1000 0.0000 23.2980 0.0000 23.4000 0.0000 23.5980 0.0000 23.7000 0.0000 23.8980 0.0000 24.0000 0.0000 24.1980 0.0000 24.3000 0.0000 24.4980 0.0000 24.6000 0.0000 24.7980 0.0000 24.9000 0.0000 25.0980 0.0000 25.2000 0.0000 25.3980 0.0000 25.5000 0.0000 25.6980 0.0000 25.8000 0.0000 25.9980 0.0000 26.1000 0.0000 26.2980 0.0000 26.4000 0.0000 26.5980 0.0000 26.7000 0.0000 26.8980 0.0000 27.0000 0.0000 27.1980 0.0000 27.3000 0.0000 27.4980 0.0000 27.6000 0.0000 27.7980 0.0000 27.9000 0.0000 28.0980 0.0000 28.2000 0.0000 28.3980 0.0000 28.5000 0.0000 28.6980 0.0000 28.8000 0.0000 28.9980 0.0000 29.1000 0.0000 29.2980 0.0000 29.4000 0.0000 29.5980 0.0000 29.7000 0.0000 29.8980 0.0000 30.0000 0.0000 30.1980 0.0000 30.3000 0.0000 30.4980 0.0000 30.6000 0.0000 30.7980 0.0000 30.9000 0.0000 31.0980 0.0000 31.2000 0.0000 31.3980 0.0000 31.5000 0.0000 31.6980 0.0000 31.8000 0.0000 31.9980 0.0000 32.1000 0.0000 32.2980 0.0000 32.4000 0.0000 32.5980 0.0000 32.7000 0.0000 32.8980 0.0000 33.0000 0.0000 33.1980 0.0000 33.3000 0.0000 33.4980 0.0000 33.6000 0.0000 33.7980 0.0000 33.9000 0.0000 34.0980 0.0000 34.2000 0.0000 34.3980 0.0000 34.5000 0.0000 34.6980 0.0000 34.8000 0.0000 34.9980 0.0000 35.1000 0.0000 35.2980 0.0000 35.4000 0.0000 35.5980 0.0000 35.7000 0.0000 35.8980 0.0000 36.0000 1.0000 36.1980 1.0000 36.3000 1.0000 36.4980 1.0000 36.6000 1.0000 36.7980 1.0000 36.9000 1.0000 37.0980 1.0000 37.2000 1.0000 37.3980 1.0000 37.5000 1.0000 37.6980 1.0000 37.8000 1.0000 37.9980 1.0000 38.1000 1.0000 38.2980 1.0000 38.4000 1.0000 38.5980 1.0000 38.7000 1.0000 38.8980 1.0000 39.0000 1.0000 39.1980 1.0000 39.3000 1.0000 39.4980 1.0000 39.6000 1.0000 39.7980 1.0000 39.9000 1.0000 40.0980 1.0000 40.2000 1.0000 40.3980 1.0000 40.5000 1.0000 40.6980 1.0000 40.8000 1.0000 40.9980 1.0000 41.1000 1.0000 41.2980 1.0000 41.4000 1.0000 41.5980 1.0000 41.7000 1.0000 41.8980 1.0000 42.0000 1.0000 42.1980 1.0000 42.3000 1.0000 42.4980 1.0000 42.6000 1.0000 42.7980 1.0000 42.9000 1.0000 43.0980 1.0000 43.2000 0.0000 43.3980 0.0000 43.5000 0.0000 43.6980 0.0000 43.8000 0.0000 43.9980 0.0000 44.1000 0.0000 44.2980 0.0000 44.4000 0.0000 44.5980 0.0000 44.7000 0.0000 44.8980 0.0000 45.0000 0.0000 45.1980 0.0000 45.3000 0.0000 45.4980 0.0000 45.6000 0.0000 45.7980 0.0000 45.9000 0.0000 46.0980 0.0000 46.2000 0.0000 46.3980 0.0000 46.5000 0.0000 46.6980 0.0000 46.8000 0.0000 46.9980 0.0000 47.1000 0.0000 47.2980 0.0000 47.4000 0.0000 47.5980 0.0000 47.7000 0.0000 47.8980 0.0000 48.0000 0.0000 48.1980 0.0000 48.3000 0.0000 48.4980 0.0000 48.6000 0.0000 48.7980 0.0000 48.9000 0.0000 49.0980 0.0000 49.2000 0.0000 49.3980 0.0000 49.5000 0.0000 49.6980 0.0000 49.8000 0.0000 49.9980 0.0000 50.1000 0.0000 50.2980 0.0000 50.4000 0.0000 50.5980 0.0000 50.7000 0.0000 50.8980 0.0000 51.0000 0.0000 51.1980 0.0000 51.3000 0.0000 51.4980 0.0000 51.6000 0.0000 51.7980 0.0000 51.9000 0.0000 52.0980 0.0000 52.2000 0.0000 52.3980 0.0000 52.5000 0.0000 52.6980 0.0000 52.8000 0.0000 52.9980 0.0000 53.1000 0.0000 53.2980 0.0000 53.4000 0.0000 53.5980 0.0000 53.7000 0.0000 53.8980 0.0000 54.0000 0.0000 54.1980 0.0000 54.3000 0.0000 54.4980 0.0000 54.6000 0.0000 54.7980 0.0000 54.9000 0.0000 55.0980 0.0000 55.2000 0.0000 55.3980 0.0000 55.5000 0.0000 55.6980 0.0000 55.8000 0.0000 55.9980 0.0000 56.1000 0.0000 56.2980 0.0000 56.4000 0.0000 56.5980 0.0000 56.7000 0.0000 56.8980 0.0000 57.0000 0.0000 57.1980 0.0000 57.3000 0.0000 57.4980 0.0000 57.6000 1.0000 57.7980 1.0000 57.9000 1.0000 58.0980 1.0000 58.2000 1.0000 58.3980 1.0000 58.5000 1.0000 58.6980 1.0000 58.8000 1.0000 58.9980 1.0000 59.1000 1.0000 59.2980 1.0000 59.4000 1.0000 59.5980 1.0000 59.7000 1.0000 59.8980 1.0000 60.0000 1.0000 60.1980 1.0000 60.3000 1.0000 60.4980 1.0000 60.6000 1.0000 60.7980 1.0000 60.9000 1.0000 61.0980 1.0000 61.2000 1.0000 61.3980 1.0000 61.5000 1.0000 61.6980 1.0000 61.8000 1.0000 61.9980 1.0000 62.1000 1.0000 62.2980 1.0000 62.4000 1.0000 62.5980 1.0000 62.7000 1.0000 62.8980 1.0000 63.0000 1.0000 63.1980 1.0000 63.3000 1.0000 63.4980 1.0000 63.6000 1.0000 63.7980 1.0000 63.9000 1.0000 64.0980 1.0000 64.2000 1.0000 64.3980 1.0000 64.5000 1.0000 64.6980 1.0000 64.8000 0.0000 64.9980 0.0000 65.1000 0.0000 65.2980 0.0000 65.4000 0.0000 65.5980 0.0000 65.7000 0.0000 65.8980 0.0000 66.0000 0.0000 66.1980 0.0000 66.3000 0.0000 66.4980 0.0000 66.6000 0.0000 66.7980 0.0000 66.9000 0.0000 67.0980 0.0000 67.2000 0.0000 67.3980 0.0000 67.5000 0.0000 67.6980 0.0000 67.8000 0.0000 67.9980 0.0000 68.1000 0.0000 68.2980 0.0000 68.4000 0.0000 68.5980 0.0000 68.7000 0.0000 68.8980 0.0000 69.0000 0.0000 69.1980 0.0000 69.3000 0.0000 69.4980 0.0000 69.6000 0.0000 69.7980 0.0000 69.9000 0.0000 70.0980 0.0000 70.2000 0.0000 70.3980 0.0000 70.5000 0.0000 70.6980 0.0000 70.8000 0.0000 70.9980 0.0000 71.1000 0.0000 71.2980 0.0000 71.4000 0.0000 71.5980 0.0000 71.7000 0.0000 71.8980 0.0000 72.0000 0.0000 72.1980 0.0000 72.3000 0.0000 72.4980 0.0000 72.6000 0.0000 72.7980 0.0000 72.9000 0.0000 73.0980 0.0000 73.2000 0.0000 73.3980 0.0000 73.5000 0.0000 73.6980 0.0000 73.8000 0.0000 73.9980 0.0000 74.1000 0.0000 74.2980 0.0000 74.4000 0.0000 74.5980 0.0000 74.7000 0.0000 74.8980 0.0000 75.0000 0.0000 75.1980 0.0000 75.3000 0.0000 75.4980 0.0000 75.6000 0.0000 75.7980 0.0000 75.9000 0.0000 76.0980 0.0000 76.2000 0.0000 76.3980 0.0000 76.5000 0.0000 76.6980 0.0000 76.8000 0.0000 76.9980 0.0000 77.1000 0.0000 77.2980 0.0000 77.4000 0.0000 77.5980 0.0000 77.7000 0.0000 77.8980 0.0000 78.0000 0.0000 78.1980 0.0000 78.3000 0.0000 78.4980 0.0000 78.6000 0.0000 78.7980 0.0000 78.9000 0.0000 79.0980 0.0000 79.2000 1.0000 79.3980 1.0000 79.5000 1.0000 79.6980 1.0000 79.8000 1.0000 79.9980 1.0000 80.1000 1.0000 80.2980 1.0000 80.4000 1.0000 80.5980 1.0000 80.7000 1.0000 80.8980 1.0000 81.0000 1.0000 81.1980 1.0000 81.3000 1.0000 81.4980 1.0000 81.6000 1.0000 81.7980 1.0000 81.9000 1.0000 82.0980 1.0000 82.2000 1.0000 82.3980 1.0000 82.5000 1.0000 82.6980 1.0000 82.8000 1.0000 82.9980 1.0000 83.1000 1.0000 83.2980 1.0000 83.4000 1.0000 83.5980 1.0000 83.7000 1.0000 83.8980 1.0000 84.0000 1.0000 84.1980 1.0000 84.3000 1.0000 84.4980 1.0000 84.6000 1.0000 84.7980 1.0000 84.9000 1.0000 85.0980 1.0000 85.2000 1.0000 85.3980 1.0000 85.5000 1.0000 85.6980 1.0000 85.8000 1.0000 85.9980 1.0000 86.1000 1.0000 86.2980 1.0000 86.4000 0.0000 86.5980 0.0000 86.7000 0.0000 86.8980 0.0000 87.0000 0.0000 87.1980 0.0000 87.3000 0.0000 87.4980 0.0000 87.6000 0.0000 87.7980 0.0000 87.9000 0.0000 88.0980 0.0000 88.2000 0.0000 88.3980 0.0000 88.5000 0.0000 88.6980 0.0000 88.8000 0.0000 88.9980 0.0000 89.1000 0.0000 89.2980 0.0000 89.4000 0.0000 89.5980 0.0000 89.7000 0.0000 89.8980 0.0000 90.0000 0.0000 90.1980 0.0000 90.3000 0.0000 90.4980 0.0000 90.6000 0.0000 90.7980 0.0000 90.9000 0.0000 91.0980 0.0000 91.2000 0.0000 91.3980 0.0000 91.5000 0.0000 91.6980 0.0000 91.8000 0.0000 91.9980 0.0000 92.1000 0.0000 92.2980 0.0000 92.4000 0.0000 92.5980 0.0000 92.7000 0.0000 92.8980 0.0000 93.0000 0.0000 93.1980 0.0000 93.3000 0.0000 93.4980 0.0000 93.6000 0.0000 93.7980 0.0000 93.9000 0.0000 94.0980 0.0000 94.2000 0.0000 94.3980 0.0000 94.5000 0.0000 94.6980 0.0000 94.8000 0.0000 94.9980 0.0000 95.1000 0.0000 95.2980 0.0000 95.4000 0.0000 95.5980 0.0000 95.7000 0.0000 95.8980 0.0000 96.0000 0.0000 96.1980 0.0000 96.3000 0.0000 96.4980 0.0000 96.6000 0.0000 96.7980 0.0000 96.9000 0.0000 97.0980 0.0000 97.2000 0.0000 97.3980 0.0000 97.5000 0.0000 97.6980 0.0000 97.8000 0.0000 97.9980 0.0000 98.1000 0.0000 98.2980 0.0000 98.4000 0.0000 98.5980 0.0000 98.7000 0.0000 98.8980 0.0000 99.0000 0.0000 99.1980 0.0000 99.3000 0.0000 99.4980 0.0000 99.6000 0.0000 99.7980 0.0000 99.9000 0.0000 100.0980 0.0000 100.2000 0.0000 100.3980 0.0000 100.5000 0.0000 100.6980 0.0000 100.8000 1.0000 100.9980 1.0000 101.1000 1.0000 101.2980 1.0000 101.4000 1.0000 101.5980 1.0000 101.7000 1.0000 101.8980 1.0000 102.0000 1.0000 102.1980 1.0000 102.3000 1.0000 102.4980 1.0000 102.6000 1.0000 102.7980 1.0000 102.9000 1.0000 103.0980 1.0000 103.2000 1.0000 103.3980 1.0000 103.5000 1.0000 103.6980 1.0000 103.8000 1.0000 103.9980 1.0000 104.1000 1.0000 104.2980 1.0000 104.4000 1.0000 104.5980 1.0000 104.7000 1.0000 104.8980 1.0000 105.0000 1.0000 105.1980 1.0000 105.3000 1.0000 105.4980 1.0000 105.6000 1.0000 105.7980 1.0000 105.9000 1.0000 106.0980 1.0000 106.2000 1.0000 106.3980 1.0000 106.5000 1.0000 106.6980 1.0000 106.8000 1.0000 106.9980 1.0000 107.1000 1.0000 107.2980 1.0000 107.4000 1.0000 107.5980 1.0000 107.7000 1.0000 107.8980 1.0000 108.0000 0.0000 108.1980 0.0000 108.3000 0.0000 108.4980 0.0000 108.6000 0.0000 108.7980 0.0000 108.9000 0.0000 109.0980 0.0000 109.2000 0.0000 109.3980 0.0000 109.5000 0.0000 109.6980 0.0000 109.8000 0.0000 109.9980 0.0000 110.1000 0.0000 110.2980 0.0000 110.4000 0.0000 110.5980 0.0000 110.7000 0.0000 110.8980 0.0000 111.0000 0.0000 111.1980 0.0000 111.3000 0.0000 111.4980 0.0000 111.6000 0.0000 111.7980 0.0000 111.9000 0.0000 112.0980 0.0000 112.2000 0.0000 112.3980 0.0000 112.5000 0.0000 112.6980 0.0000 112.8000 0.0000 112.9980 0.0000 113.1000 0.0000 113.2980 0.0000 113.4000 0.0000 113.5980 0.0000 113.7000 0.0000 113.8980 0.0000 114.0000 0.0000 114.1980 0.0000 114.3000 0.0000 114.4980 0.0000 114.6000 0.0000 114.7980 0.0000 114.9000 0.0000 115.0980 0.0000 115.2000 0.0000 115.3980 0.0000 115.5000 0.0000 115.6980 0.0000 115.8000 0.0000 115.9980 0.0000 116.1000 0.0000 116.2980 0.0000 116.4000 0.0000 116.5980 0.0000 116.7000 0.0000 116.8980 0.0000 117.0000 0.0000 117.1980 0.0000 117.3000 0.0000 117.4980 0.0000 117.6000 0.0000 117.7980 0.0000 117.9000 0.0000 118.0980 0.0000 118.2000 0.0000 118.3980 0.0000 118.5000 0.0000 118.6980 0.0000 118.8000 0.0000 118.9980 0.0000 119.1000 0.0000 119.2980 0.0000 119.4000 0.0000 119.5980 0.0000 119.7000 0.0000 119.8980 0.0000 120.0000 0.0000 120.1980 0.0000 120.3000 0.0000 120.4980 0.0000 120.6000 0.0000 120.7980 0.0000 120.9000 0.0000 121.0980 0.0000 121.2000 0.0000 121.3980 0.0000 121.5000 0.0000 121.6980 0.0000 121.8000 0.0000 121.9980 0.0000 122.1000 0.0000 122.2980 0.0000 122.4000 1.0000 122.5980 1.0000 122.7000 1.0000 122.8980 1.0000 123.0000 1.0000 123.1980 1.0000 123.3000 1.0000 123.4980 1.0000 123.6000 1.0000 123.7980 1.0000 123.9000 1.0000 124.0980 1.0000 124.2000 1.0000 124.3980 1.0000 124.5000 1.0000 124.6980 1.0000 124.8000 1.0000 124.9980 1.0000 125.1000 1.0000 125.2980 1.0000 125.4000 1.0000 125.5980 1.0000 125.7000 1.0000 125.8980 1.0000 126.0000 1.0000 126.1980 1.0000 126.3000 1.0000 126.4980 1.0000 126.6000 1.0000 126.7980 1.0000 126.9000 1.0000 127.0980 1.0000 127.2000 1.0000 127.3980 1.0000 127.5000 1.0000 127.6980 1.0000 127.8000 1.0000 127.9980 1.0000 128.1000 1.0000 128.2980 1.0000 128.4000 1.0000 128.5980 1.0000 128.7000 1.0000 128.8980 1.0000 129.0000 1.0000 129.1980 1.0000 129.3000 1.0000 129.4980 1.0000 129.6000 0.0000 129.7980 0.0000 129.9000 0.0000 130.0980 0.0000 130.2000 0.0000 130.3980 0.0000 130.5000 0.0000 130.6980 0.0000 130.8000 0.0000 130.9980 0.0000 131.1000 0.0000 131.2980 0.0000 131.4000 0.0000 131.5980 0.0000 131.7000 0.0000 131.8980 0.0000 132.0000 0.0000 132.1980 0.0000 132.3000 0.0000 132.4980 0.0000 132.6000 0.0000 132.7980 0.0000 132.9000 0.0000 133.0980 0.0000 133.2000 0.0000 133.3980 0.0000 133.5000 0.0000 133.6980 0.0000 133.8000 0.0000 133.9980 0.0000 134.1000 0.0000 134.2980 0.0000 134.4000 0.0000 134.5980 0.0000 134.7000 0.0000 134.8980 0.0000 135.0000 0.0000 135.1980 0.0000 135.3000 0.0000 135.4980 0.0000 135.6000 0.0000 135.7980 0.0000 135.9000 0.0000 136.0980 0.0000 136.2000 0.0000 136.3980 0.0000 136.5000 0.0000 136.6980 0.0000 136.8000 0.0000 136.9980 0.0000 137.1000 0.0000 137.2980 0.0000 137.4000 0.0000 137.5980 0.0000 137.7000 0.0000 137.8980 0.0000 138.0000 0.0000 138.1980 0.0000 138.3000 0.0000 138.4980 0.0000 138.6000 0.0000 138.7980 0.0000 138.9000 0.0000 139.0980 0.0000 139.2000 0.0000 139.3980 0.0000 139.5000 0.0000 139.6980 0.0000 139.8000 0.0000 139.9980 0.0000 140.1000 0.0000 140.2980 0.0000 140.4000 0.0000 140.5980 0.0000 140.7000 0.0000 140.8980 0.0000 141.0000 0.0000 141.1980 0.0000 141.3000 0.0000 141.4980 0.0000 141.6000 0.0000 141.7980 0.0000 141.9000 0.0000 142.0980 0.0000 142.2000 0.0000 142.3980 0.0000 142.5000 0.0000 142.6980 0.0000 142.8000 0.0000 142.9980 0.0000 143.1000 0.0000 143.2980 0.0000 143.4000 0.0000 143.5980 0.0000 143.7000 0.0000 143.8980 0.0000 144.0000 1.0000 144.1980 1.0000 144.3000 1.0000 144.4980 1.0000 144.6000 1.0000 144.7980 1.0000 144.9000 1.0000 145.0980 1.0000 145.2000 1.0000 145.3980 1.0000 145.5000 1.0000 145.6980 1.0000 145.8000 1.0000 145.9980 1.0000 146.1000 1.0000 146.2980 1.0000 146.4000 1.0000 146.5980 1.0000 146.7000 1.0000 146.8980 1.0000 147.0000 1.0000 147.1980 1.0000 147.3000 1.0000 147.4980 1.0000 147.6000 1.0000 147.7980 1.0000 147.9000 1.0000 148.0980 1.0000 148.2000 1.0000 148.3980 1.0000 148.5000 1.0000 148.6980 1.0000 148.8000 1.0000 148.9980 1.0000 149.1000 1.0000 149.2980 1.0000 149.4000 1.0000 149.5980 1.0000 149.7000 1.0000 149.8980 1.0000 150.0000 1.0000 150.1980 1.0000 150.3000 1.0000 150.4980 1.0000 150.6000 1.0000 150.7980 1.0000 150.9000 1.0000 151.0980 1.0000 151.2000 0.0000 151.3980 0.0000 151.5000 0.0000 151.6980 0.0000 151.8000 0.0000 151.9980 0.0000 152.1000 0.0000 152.2980 0.0000 152.4000 0.0000 152.5980 0.0000 152.7000 0.0000 152.8980 0.0000 153.0000 0.0000 153.1980 0.0000 153.3000 0.0000 153.4980 0.0000 153.6000 0.0000 153.7980 0.0000 153.9000 0.0000 154.0980 0.0000 154.2000 0.0000 154.3980 0.0000 154.5000 0.0000 154.6980 0.0000 154.8000 0.0000 154.9980 0.0000 155.1000 0.0000 155.2980 0.0000 155.4000 0.0000 155.5980 0.0000 155.7000 0.0000 155.8980 0.0000 156.0000 0.0000 156.1980 0.0000 156.3000 0.0000 156.4980 0.0000 156.6000 0.0000 156.7980 0.0000 156.9000 0.0000 157.0980 0.0000 157.2000 0.0000 157.3980 0.0000 157.5000 0.0000 157.6980 0.0000 157.8000 0.0000 157.9980 0.0000 158.1000 0.0000 158.2980 0.0000 158.4000 0.0000 158.5980 0.0000 158.7000 0.0000 158.8980 0.0000 159.0000 0.0000 159.1980 0.0000 159.3000 0.0000 159.4980 0.0000 159.6000 0.0000 159.7980 0.0000 159.9000 0.0000 160.0980 0.0000 160.2000 0.0000 160.3980 0.0000 160.5000 0.0000 160.6980 0.0000 160.8000 0.0000 160.9980 0.0000 161.1000 0.0000 161.2980 0.0000 161.4000 0.0000 161.5980 0.0000 161.7000 0.0000 161.8980 0.0000 162.0000 0.0000 162.1980 0.0000 162.3000 0.0000 162.4980 0.0000 162.6000 0.0000 162.7980 0.0000 162.9000 0.0000 163.0980 0.0000 163.2000 0.0000 163.3980 0.0000 163.5000 0.0000 163.6980 0.0000 163.8000 0.0000 163.9980 0.0000 164.1000 0.0000 164.2980 0.0000 164.4000 0.0000 164.5980 0.0000 164.7000 0.0000 164.8980 0.0000 165.0000 0.0000 165.1980 0.0000 165.3000 0.0000 165.4980 0.0000 165.6000 1.0000 165.7980 1.0000 165.9000 1.0000 166.0980 1.0000 166.2000 1.0000 166.3980 1.0000 166.5000 1.0000 166.6980 1.0000 166.8000 1.0000 166.9980 1.0000 167.1000 1.0000 167.2980 1.0000 167.4000 1.0000 167.5980 1.0000 167.7000 1.0000 167.8980 1.0000 168.0000 1.0000 168.1980 1.0000 168.3000 1.0000 168.4980 1.0000 168.6000 1.0000 168.7980 1.0000 168.9000 1.0000 169.0980 1.0000 169.2000 1.0000 169.3980 1.0000 169.5000 1.0000 169.6980 1.0000 169.8000 1.0000 169.9980 1.0000 170.1000 1.0000 170.2980 1.0000 170.4000 1.0000 170.5980 1.0000 170.7000 1.0000 170.8980 1.0000 171.0000 1.0000 171.1980 1.0000 171.3000 1.0000 171.4980 1.0000 171.6000 1.0000 171.7980 1.0000 171.9000 1.0000 172.0980 1.0000 172.2000 1.0000 172.3980 1.0000 172.5000 1.0000 172.6980 1.0000 172.8000 0.0000 172.9980 0.0000 173.1000 0.0000 173.2980 0.0000 173.4000 0.0000 173.5980 0.0000 173.7000 0.0000 173.8980 0.0000 174.0000 0.0000 174.1980 0.0000 174.3000 0.0000 174.4980 0.0000 174.6000 0.0000 174.7980 0.0000 174.9000 0.0000 175.0980 0.0000 175.2000 0.0000 175.3980 0.0000 175.5000 0.0000 175.6980 0.0000 175.8000 0.0000 175.9980 0.0000 176.1000 0.0000 176.2980 0.0000 176.4000 0.0000 176.5980 0.0000 176.7000 0.0000 176.8980 0.0000 177.0000 0.0000 177.1980 0.0000 177.3000 0.0000 177.4980 0.0000 177.6000 0.0000 177.7980 0.0000 177.9000 0.0000 178.0980 0.0000 178.2000 0.0000 178.3980 0.0000 178.5000 0.0000 178.6980 0.0000 178.8000 0.0000 178.9980 0.0000 179.1000 0.0000 179.2980 0.0000 179.4000 0.0000 179.5980 0.0000 179.7000 0.0000 179.8980 0.0000 180.0000 0.0000 180.1980 0.0000 180.3000 0.0000 180.4980 0.0000 180.6000 0.0000 180.7980 0.0000 180.9000 0.0000 181.0980 0.0000 181.2000 0.0000 181.3980 0.0000 181.5000 0.0000 181.6980 0.0000 181.8000 0.0000 181.9980 0.0000 182.1000 0.0000 182.2980 0.0000 182.4000 0.0000 182.5980 0.0000 182.7000 0.0000 182.8980 0.0000 183.0000 0.0000 183.1980 0.0000 183.3000 0.0000 183.4980 0.0000 183.6000 0.0000 183.7980 0.0000 183.9000 0.0000 184.0980 0.0000 184.2000 0.0000 184.3980 0.0000 184.5000 0.0000 184.6980 0.0000 184.8000 0.0000 184.9980 0.0000 185.1000 0.0000 185.2980 0.0000 185.4000 0.0000 185.5980 0.0000 185.7000 0.0000 185.8980 0.0000 186.0000 0.0000 186.1980 0.0000 186.3000 0.0000 186.4980 0.0000 186.6000 0.0000 186.7980 0.0000 186.9000 0.0000 187.0980 0.0000 187.2000 1.0000 187.3980 1.0000 187.5000 1.0000 187.6980 1.0000 187.8000 1.0000 187.9980 1.0000 188.1000 1.0000 188.2980 1.0000 188.4000 1.0000 188.5980 1.0000 188.7000 1.0000 188.8980 1.0000 189.0000 1.0000 189.1980 1.0000 189.3000 1.0000 189.4980 1.0000 189.6000 1.0000 189.7980 1.0000 189.9000 1.0000 190.0980 1.0000 190.2000 1.0000 190.3980 1.0000 190.5000 1.0000 190.6980 1.0000 190.8000 1.0000 190.9980 1.0000 191.1000 1.0000 191.2980 1.0000 191.4000 1.0000 191.5980 1.0000 191.7000 1.0000 191.8980 1.0000 192.0000 1.0000 192.1980 1.0000 192.3000 1.0000 192.4980 1.0000 192.6000 1.0000 192.7980 1.0000 192.9000 1.0000 193.0980 1.0000 193.2000 1.0000 193.3980 1.0000 193.5000 1.0000 193.6980 1.0000 193.8000 1.0000 193.9980 1.0000 194.1000 1.0000 194.2980 1.0000 194.4000 0.0000 194.5980 0.0000 194.7000 0.0000 194.8980 0.0000 195.0000 0.0000 195.1980 0.0000 195.3000 0.0000 195.4980 0.0000 195.6000 0.0000 195.7980 0.0000 195.9000 0.0000 196.0980 0.0000 196.2000 0.0000 196.3980 0.0000 196.5000 0.0000 196.6980 0.0000 196.8000 0.0000 196.9980 0.0000 197.1000 0.0000 197.2980 0.0000 197.4000 0.0000 197.5980 0.0000 197.7000 0.0000 197.8980 0.0000 198.0000 0.0000 198.1980 0.0000 198.3000 0.0000 198.4980 0.0000 198.6000 0.0000 198.7980 0.0000 198.9000 0.0000 199.0980 0.0000 199.2000 0.0000 199.3980 0.0000 199.5000 0.0000 199.6980 0.0000 199.8000 0.0000 199.9980 0.0000 200.1000 0.0000 200.2980 0.0000 200.4000 0.0000 200.5980 0.0000 200.7000 0.0000 200.8980 0.0000 201.0000 0.0000 201.1980 0.0000 201.3000 0.0000 201.4980 0.0000 201.6000 0.0000 201.7980 0.0000 201.9000 0.0000 202.0980 0.0000 202.2000 0.0000 202.3980 0.0000 202.5000 0.0000 202.6980 0.0000 202.8000 0.0000 202.9980 0.0000 203.1000 0.0000 203.2980 0.0000 203.4000 0.0000 203.5980 0.0000 203.7000 0.0000 203.8980 0.0000 204.0000 0.0000 204.1980 0.0000 204.3000 0.0000 204.4980 0.0000 204.6000 0.0000 204.7980 0.0000 204.9000 0.0000 205.0980 0.0000 205.2000 0.0000 205.3980 0.0000 205.5000 0.0000 205.6980 0.0000 205.8000 0.0000 205.9980 0.0000 206.1000 0.0000 206.2980 0.0000 206.4000 0.0000 206.5980 0.0000 206.7000 0.0000 206.8980 0.0000 207.0000 0.0000 207.1980 0.0000 207.3000 0.0000 207.4980 0.0000 207.6000 0.0000 207.7980 0.0000 207.9000 0.0000 208.0980 0.0000 208.2000 0.0000 208.3980 0.0000 208.5000 0.0000 208.6980 0.0000 208.8000 1.0000 208.9980 1.0000 209.1000 1.0000 209.2980 1.0000 209.4000 1.0000 209.5980 1.0000 209.7000 1.0000 209.8980 1.0000 210.0000 1.0000 210.1980 1.0000 210.3000 1.0000 210.4980 1.0000 210.6000 1.0000 210.7980 1.0000 210.9000 1.0000 211.0980 1.0000 211.2000 1.0000 211.3980 1.0000 211.5000 1.0000 211.6980 1.0000 211.8000 1.0000 211.9980 1.0000 212.1000 1.0000 212.2980 1.0000 212.4000 1.0000 212.5980 1.0000 212.7000 1.0000 212.8980 1.0000 213.0000 1.0000 213.1980 1.0000 213.3000 1.0000 213.4980 1.0000 213.6000 1.0000 213.7980 1.0000 213.9000 1.0000 214.0980 1.0000 214.2000 1.0000 214.3980 1.0000 214.5000 1.0000 214.6980 1.0000 214.8000 1.0000 214.9980 1.0000 215.1000 1.0000 215.2980 1.0000 215.4000 1.0000 215.5980 1.0000 215.7000 1.0000 215.8980 1.0000 216.0000 0.0000 216.1980 0.0000 216.3000 0.0000 216.4980 0.0000 216.6000 0.0000 216.7980 0.0000 216.9000 0.0000 217.0980 0.0000 217.2000 0.0000 217.3980 0.0000 217.5000 0.0000 217.6980 0.0000 217.8000 0.0000 217.9980 0.0000 218.1000 0.0000 218.2980 0.0000 218.4000 0.0000 218.5980 0.0000 218.7000 0.0000 218.8980 0.0000 219.0000 0.0000 219.1980 0.0000 219.3000 0.0000 219.4980 0.0000 219.6000 0.0000 219.7980 0.0000 219.9000 0.0000 220.0980 0.0000 220.2000 0.0000 220.3980 0.0000 220.5000 0.0000 220.6980 0.0000 220.8000 0.0000 220.9980 0.0000 221.1000 0.0000 221.2980 0.0000 221.4000 0.0000 221.5980 0.0000 221.7000 0.0000 221.8980 0.0000 222.0000 0.0000 222.1980 0.0000 222.3000 0.0000 222.4980 0.0000 222.6000 0.0000 222.7980 0.0000 222.9000 0.0000 223.0980 0.0000 223.2000 0.0000 223.3980 0.0000 223.5000 0.0000 223.6980 0.0000 223.8000 0.0000 223.9980 0.0000 224.1000 0.0000 224.2980 0.0000 224.4000 0.0000 224.5980 0.0000 224.7000 0.0000 224.8980 0.0000 225.0000 0.0000 225.1980 0.0000 225.3000 0.0000 225.4980 0.0000 225.6000 0.0000 225.7980 0.0000 225.9000 0.0000 226.0980 0.0000 226.2000 0.0000 226.3980 0.0000 226.5000 0.0000 226.6980 0.0000 226.8000 0.0000 226.9980 0.0000 227.1000 0.0000 227.2980 0.0000 227.4000 0.0000 227.5980 0.0000 227.7000 0.0000 227.8980 0.0000 228.0000 0.0000 228.1980 0.0000 228.3000 0.0000 228.4980 0.0000 228.6000 0.0000 228.7980 0.0000 228.9000 0.0000 229.0980 0.0000 229.2000 0.0000 229.3980 0.0000 229.5000 0.0000 229.6980 0.0000 229.8000 0.0000 229.9980 0.0000 230.1000 0.0000 230.2980 0.0000 230.4000 1.0000 230.5980 1.0000 230.7000 1.0000 230.8980 1.0000 231.0000 1.0000 231.1980 1.0000 231.3000 1.0000 231.4980 1.0000 231.6000 1.0000 231.7980 1.0000 231.9000 1.0000 232.0980 1.0000 232.2000 1.0000 232.3980 1.0000 232.5000 1.0000 232.6980 1.0000 232.8000 1.0000 232.9980 1.0000 233.1000 1.0000 233.2980 1.0000 233.4000 1.0000 233.5980 1.0000 233.7000 1.0000 233.8980 1.0000 234.0000 1.0000 234.1980 1.0000 234.3000 1.0000 234.4980 1.0000 234.6000 1.0000 234.7980 1.0000 234.9000 1.0000 235.0980 1.0000 235.2000 1.0000 235.3980 1.0000 235.5000 1.0000 235.6980 1.0000 235.8000 1.0000 235.9980 1.0000 236.1000 1.0000 236.2980 1.0000 236.4000 1.0000 236.5980 1.0000 236.7000 1.0000 236.8980 1.0000 237.0000 1.0000 237.1980 1.0000 237.3000 1.0000 237.4980 1.0000 237.6000 0.0000 237.7980 0.0000 237.9000 0.0000 238.0980 0.0000 238.2000 0.0000 238.3980 0.0000 238.5000 0.0000 238.6980 0.0000 238.8000 0.0000 238.9980 0.0000 239.1000 0.0000 239.2980 0.0000 239.4000 0.0000 239.5980 0.0000 239.7000 0.0000 239.8980 0.0000 240.0000 0.0000 240.1980 0.0000 240.3000 0.0000 240.4980 0.0000 240.6000 0.0000 240.7980 0.0000 240.9000 0.0000 241.0980 0.0000 241.2000 0.0000 241.3980 0.0000 241.5000 0.0000 241.6980 0.0000 241.8000 0.0000 241.9980 0.0000 242.1000 0.0000 242.2980 0.0000 242.4000 0.0000 242.5980 0.0000 242.7000 0.0000 242.8980 0.0000 243.0000 0.0000 243.1980 0.0000 243.3000 0.0000 243.4980 0.0000 243.6000 0.0000 243.7980 0.0000 243.9000 0.0000 244.0980 0.0000 244.2000 0.0000 244.3980 0.0000 244.5000 0.0000 244.6980 0.0000 244.8000 0.0000 244.9980 0.0000 245.1000 0.0000 245.2980 0.0000 245.4000 0.0000 245.5980 0.0000 245.7000 0.0000 245.8980 0.0000 246.0000 0.0000 246.1980 0.0000 246.3000 0.0000 246.4980 0.0000 246.6000 0.0000 246.7980 0.0000 246.9000 0.0000 247.0980 0.0000 247.2000 0.0000 247.3980 0.0000 247.5000 0.0000 247.6980 0.0000 247.8000 0.0000 247.9980 0.0000 248.1000 0.0000 248.2980 0.0000 248.4000 0.0000 248.5980 0.0000 248.7000 0.0000 248.8980 0.0000 249.0000 0.0000 249.1980 0.0000 249.3000 0.0000 249.4980 0.0000 249.6000 0.0000 249.7980 0.0000 249.9000 0.0000 250.0980 0.0000 250.2000 0.0000 250.3980 0.0000 250.5000 0.0000 250.6980 0.0000 250.8000 0.0000 250.9980 0.0000 251.1000 0.0000 251.2980 0.0000 251.4000 0.0000 251.5980 0.0000 251.7000 0.0000 251.8980 0.0000 252.0000 1.0000 252.1980 1.0000 252.3000 1.0000 252.4980 1.0000 252.6000 1.0000 252.7980 1.0000 252.9000 1.0000 253.0980 1.0000 253.2000 1.0000 253.3980 1.0000 253.5000 1.0000 253.6980 1.0000 253.8000 1.0000 253.9980 1.0000 254.1000 1.0000 254.2980 1.0000 254.4000 1.0000 254.5980 1.0000 254.7000 1.0000 254.8980 1.0000 255.0000 1.0000 255.1980 1.0000 255.3000 1.0000 255.4980 1.0000 255.6000 1.0000 255.7980 1.0000 255.9000 1.0000 256.0980 1.0000 256.2000 1.0000 256.3980 1.0000 256.5000 1.0000 256.6980 1.0000 256.8000 1.0000 256.9980 1.0000 257.1000 1.0000 257.2980 1.0000 257.4000 1.0000 257.5980 1.0000 257.7000 1.0000 257.8980 1.0000 258.0000 1.0000 258.1980 1.0000 258.3000 1.0000 258.4980 1.0000 258.6000 1.0000 258.7980 1.0000 258.9000 1.0000 259.0980 1.0000 259.2000 0.0000 259.3980 0.0000 259.5000 0.0000 259.6980 0.0000 259.8000 0.0000 259.9980 0.0000 260.1000 0.0000 260.2980 0.0000 260.4000 0.0000 260.5980 0.0000 260.7000 0.0000 260.8980 0.0000 261.0000 0.0000 261.1980 0.0000 261.3000 0.0000 261.4980 0.0000 261.6000 0.0000 261.7980 0.0000 261.9000 0.0000 262.0980 0.0000 262.2000 0.0000 262.3980 0.0000 262.5000 0.0000 262.6980 0.0000 262.8000 0.0000 262.9980 0.0000 263.1000 0.0000 263.2980 0.0000 263.4000 0.0000 263.5980 0.0000 263.7000 0.0000 263.8980 0.0000 264.0000 0.0000 264.1980 0.0000 264.3000 0.0000 264.4980 0.0000 264.6000 0.0000 264.7980 0.0000 264.9000 0.0000 265.0980 0.0000 265.2000 0.0000 265.3980 0.0000 265.5000 0.0000 265.6980 0.0000 265.8000 0.0000 265.9980 0.0000 266.1000 0.0000 266.2980 0.0000 266.4000 0.0000 266.5980 0.0000 266.7000 0.0000 266.8980 0.0000 267.0000 0.0000 267.1980 0.0000 267.3000 0.0000 267.4980 0.0000 267.6000 0.0000 267.7980 0.0000 267.9000 0.0000 268.0980 0.0000 268.2000 0.0000 268.3980 0.0000 268.5000 0.0000 268.6980 0.0000 268.8000 0.0000 268.9980 0.0000 269.1000 0.0000 269.2980 0.0000 269.4000 0.0000 269.5980 0.0000 269.7000 0.0000 269.8980 0.0000 270.0000 0.0000 270.1980 0.0000 270.3000 0.0000 270.4980 0.0000 270.6000 0.0000 270.7980 0.0000 270.9000 0.0000 271.0980 0.0000 271.2000 0.0000 271.3980 0.0000 271.5000 0.0000 271.6980 0.0000 271.8000 0.0000 271.9980 0.0000 272.1000 0.0000 272.2980 0.0000 272.4000 0.0000 272.5980 0.0000 272.7000 0.0000 272.8980 0.0000 273.0000 0.0000 273.1980 0.0000 273.3000 0.0000 273.4980 0.0000 273.6000 1.0000 273.7980 1.0000 273.9000 1.0000 274.0980 1.0000 274.2000 1.0000 274.3980 1.0000 274.5000 1.0000 274.6980 1.0000 274.8000 1.0000 274.9980 1.0000 275.1000 1.0000 275.2980 1.0000 275.4000 1.0000 275.5980 1.0000 275.7000 1.0000 275.8980 1.0000 276.0000 1.0000 276.1980 1.0000 276.3000 1.0000 276.4980 1.0000 276.6000 1.0000 276.7980 1.0000 276.9000 1.0000 277.0980 1.0000 277.2000 1.0000 277.3980 1.0000 277.5000 1.0000 277.6980 1.0000 277.8000 1.0000 277.9980 1.0000 278.1000 1.0000 278.2980 1.0000 278.4000 1.0000 278.5980 1.0000 278.7000 1.0000 278.8980 1.0000 279.0000 1.0000 279.1980 1.0000 279.3000 1.0000 279.4980 1.0000 279.6000 1.0000 279.7980 1.0000 279.9000 1.0000 280.0980 1.0000 280.2000 1.0000 280.3980 1.0000 280.5000 1.0000 280.6980 1.0000 280.8000 0.0000 280.9980 0.0000 281.1000 0.0000 281.2980 0.0000 281.4000 0.0000 281.5980 0.0000 281.7000 0.0000 281.8980 0.0000 282.0000 0.0000 282.1980 0.0000 282.3000 0.0000 282.4980 0.0000 282.6000 0.0000 282.7980 0.0000 282.9000 0.0000 283.0980 0.0000 283.2000 0.0000 283.3980 0.0000 283.5000 0.0000 283.6980 0.0000 283.8000 0.0000 283.9980 0.0000 284.1000 0.0000 284.2980 0.0000 284.4000 0.0000 284.5980 0.0000 284.7000 0.0000 284.8980 0.0000 285.0000 0.0000 285.1980 0.0000 285.3000 0.0000 285.4980 0.0000 285.6000 0.0000 285.7980 0.0000 285.9000 0.0000 286.0980 0.0000 286.2000 0.0000 286.3980 0.0000 286.5000 0.0000 286.6980 0.0000 286.8000 0.0000 286.9980 0.0000 287.1000 0.0000 287.2980 0.0000 287.4000 0.0000 287.5980 0.0000 287.7000 0.0000 287.8980 0.0000 288.0000 0.0000 288.1980 0.0000 288.3000 0.0000 288.4980 0.0000 288.6000 0.0000 288.7980 0.0000 288.9000 0.0000 289.0980 0.0000 289.2000 0.0000 289.3980 0.0000 289.5000 0.0000 289.6980 0.0000 289.8000 0.0000 289.9980 0.0000 290.1000 0.0000 290.2980 0.0000 290.4000 0.0000 290.5980 0.0000 290.7000 0.0000 290.8980 0.0000 291.0000 0.0000 291.1980 0.0000 291.3000 0.0000 291.4980 0.0000 291.6000 0.0000 291.7980 0.0000 291.9000 0.0000 292.0980 0.0000 292.2000 0.0000 292.3980 0.0000 292.5000 0.0000 292.6980 0.0000 292.8000 0.0000 292.9980 0.0000 293.1000 0.0000 293.2980 0.0000 293.4000 0.0000 293.5980 0.0000 293.7000 0.0000 293.8980 0.0000 294.0000 0.0000 294.1980 0.0000 294.3000 0.0000 294.4980 0.0000 294.6000 0.0000 294.7980 0.0000 294.9000 0.0000 295.0980 0.0000 295.2000 1.0000 295.3980 1.0000 295.5000 1.0000 295.6980 1.0000 295.8000 1.0000 295.9980 1.0000 296.1000 1.0000 296.2980 1.0000 296.4000 1.0000 296.5980 1.0000 296.7000 1.0000 296.8980 1.0000 297.0000 1.0000 297.1980 1.0000 297.3000 1.0000 297.4980 1.0000 297.6000 1.0000 297.7980 1.0000 297.9000 1.0000 298.0980 1.0000 298.2000 1.0000 298.3980 1.0000 298.5000 1.0000 298.6980 1.0000 298.8000 1.0000 298.9980 1.0000 299.1000 1.0000 299.2980 1.0000 299.4000 1.0000 299.5980 1.0000 299.7000 1.0000 299.8980 1.0000 300.0000 1.0000 300.1980 1.0000 300.3000 1.0000 300.4980 1.0000 300.6000 1.0000 300.7980 1.0000 300.9000 1.0000 301.0980 1.0000 301.2000 1.0000 301.3980 1.0000 301.5000 1.0000 301.6980 1.0000 301.8000 1.0000 301.9980 1.0000 302.1000 1.0000 302.2980 1.0000 302.4000 0.0000 302.5980 0.0000 302.7000 0.0000 302.8980 0.0000 303.0000 0.0000 303.1980 0.0000 303.3000 0.0000 303.4980 0.0000 303.6000 0.0000 303.7980 0.0000 303.9000 0.0000 304.0980 0.0000 304.2000 0.0000 304.3980 0.0000 304.5000 0.0000 304.6980 0.0000 304.8000 0.0000 304.9980 0.0000 305.1000 0.0000 305.2980 0.0000 305.4000 0.0000 305.5980 0.0000 305.7000 0.0000 305.8980 0.0000 306.0000 0.0000 306.1980 0.0000 306.3000 0.0000 306.4980 0.0000 306.6000 0.0000 306.7980 0.0000 306.9000 0.0000 307.0980 0.0000 307.2000 0.0000 307.3980 0.0000 307.5000 0.0000 307.6980 0.0000 307.8000 0.0000 307.9980 0.0000 308.1000 0.0000 308.2980 0.0000 308.4000 0.0000 308.5980 0.0000 308.7000 0.0000 308.8980 0.0000 309.0000 0.0000 309.1980 0.0000 309.3000 0.0000 309.4980 0.0000 309.6000 0.0000 309.7980 0.0000 309.9000 0.0000 310.0980 0.0000 310.2000 0.0000 310.3980 0.0000 310.5000 0.0000 310.6980 0.0000 310.8000 0.0000 310.9980 0.0000 311.1000 0.0000 311.2980 0.0000 311.4000 0.0000 311.5980 0.0000 311.7000 0.0000 311.8980 0.0000 312.0000 0.0000 312.1980 0.0000 312.3000 0.0000 312.4980 0.0000 312.6000 0.0000 312.7980 0.0000 312.9000 0.0000 313.0980 0.0000 313.2000 0.0000 313.3980 0.0000 313.5000 0.0000 313.6980 0.0000 313.8000 0.0000 313.9980 0.0000 314.1000 0.0000 314.2980 0.0000 314.4000 0.0000 314.5980 0.0000 314.7000 0.0000 314.8980 0.0000 315.0000 0.0000 315.1980 0.0000 315.3000 0.0000 315.4980 0.0000 315.6000 0.0000 315.7980 0.0000 315.9000 0.0000 316.0980 0.0000 316.2000 0.0000 316.3980 0.0000 316.5000 0.0000 316.6980 0.0000 316.8000 1.0000 316.9980 1.0000 317.1000 1.0000 317.2980 1.0000 317.4000 1.0000 317.5980 1.0000 317.7000 1.0000 317.8980 1.0000 318.0000 1.0000 318.1980 1.0000 318.3000 1.0000 318.4980 1.0000 318.6000 1.0000 318.7980 1.0000 318.9000 1.0000 319.0980 1.0000 319.2000 1.0000 319.3980 1.0000 319.5000 1.0000 319.6980 1.0000 319.8000 1.0000 319.9980 1.0000 320.1000 1.0000 320.2980 1.0000 320.4000 1.0000 320.5980 1.0000 320.7000 1.0000 320.8980 1.0000 321.0000 1.0000 321.1980 1.0000 321.3000 1.0000 321.4980 1.0000 321.6000 1.0000 321.7980 1.0000 321.9000 1.0000 322.0980 1.0000 322.2000 1.0000 322.3980 1.0000 322.5000 1.0000 322.6980 1.0000 322.8000 1.0000 322.9980 1.0000 323.1000 1.0000 323.2980 1.0000 323.4000 1.0000 323.5980 1.0000 323.7000 1.0000 323.8980 1.0000 324.0000 0.0000 324.1980 0.0000 324.3000 0.0000 324.4980 0.0000 324.6000 0.0000 324.7980 0.0000 324.9000 0.0000 325.0980 0.0000 325.2000 0.0000 325.3980 0.0000 325.5000 0.0000 325.6980 0.0000 325.8000 0.0000 325.9980 0.0000 326.1000 0.0000 326.2980 0.0000 326.4000 0.0000 326.5980 0.0000 326.7000 0.0000 326.8980 0.0000 327.0000 0.0000 327.1980 0.0000 327.3000 0.0000 327.4980 0.0000 327.6000 0.0000 327.7980 0.0000 327.9000 0.0000 328.0980 0.0000 328.2000 0.0000 328.3980 0.0000 328.5000 0.0000 328.6980 0.0000 328.8000 0.0000 328.9980 0.0000 329.1000 0.0000 329.2980 0.0000 329.4000 0.0000 329.5980 0.0000 329.7000 0.0000 329.8980 0.0000 330.0000 0.0000 330.1980 0.0000 330.3000 0.0000 330.4980 0.0000 330.6000 0.0000 330.7980 0.0000 330.9000 0.0000 331.0980 0.0000 331.2000 0.0000 331.3980 0.0000 331.5000 0.0000 331.6980 0.0000 331.8000 0.0000 331.9980 0.0000 332.1000 0.0000 332.2980 0.0000 332.4000 0.0000 332.5980 0.0000 332.7000 0.0000 332.8980 0.0000 333.0000 0.0000 333.1980 0.0000 333.3000 0.0000 333.4980 0.0000 333.6000 0.0000 333.7980 0.0000 333.9000 0.0000 334.0980 0.0000 334.2000 0.0000 334.3980 0.0000 334.5000 0.0000 334.6980 0.0000 334.8000 0.0000 334.9980 0.0000 335.1000 0.0000 335.2980 0.0000 335.4000 0.0000 335.5980 0.0000 335.7000 0.0000 335.8980 0.0000 336.0000 0.0000 336.1980 0.0000 336.3000 0.0000 336.4980 0.0000 336.6000 0.0000 336.7980 0.0000 336.9000 0.0000 337.0980 0.0000 337.2000 0.0000 337.3980 0.0000 337.5000 0.0000 337.6980 0.0000 337.8000 0.0000 337.9980 0.0000 338.1000 0.0000 338.2980 0.0000 338.4000 1.0000 338.5980 1.0000 338.7000 1.0000 338.8980 1.0000 339.0000 1.0000 339.1980 1.0000 339.3000 1.0000 339.4980 1.0000 339.6000 1.0000 339.7980 1.0000 339.9000 1.0000 340.0980 1.0000 340.2000 1.0000 340.3980 1.0000 340.5000 1.0000 340.6980 1.0000 340.8000 1.0000 340.9980 1.0000 341.1000 1.0000 341.2980 1.0000 341.4000 1.0000 341.5980 1.0000 341.7000 1.0000 341.8980 1.0000 342.0000 1.0000 342.1980 1.0000 342.3000 1.0000 342.4980 1.0000 342.6000 1.0000 342.7980 1.0000 342.9000 1.0000 343.0980 1.0000 343.2000 1.0000 343.3980 1.0000 343.5000 1.0000 343.6980 1.0000 343.8000 1.0000 343.9980 1.0000 344.1000 1.0000 344.2980 1.0000 344.4000 1.0000 344.5980 1.0000 344.7000 1.0000 344.8980 1.0000 345.0000 1.0000 345.1980 1.0000 345.3000 1.0000 345.4980 1.0000 345.6000 0.0000 345.7980 0.0000 345.9000 0.0000 346.0980 0.0000 346.2000 0.0000 346.3980 0.0000 346.5000 0.0000 346.6980 0.0000 346.8000 0.0000 346.9980 0.0000 347.1000 0.0000 347.2980 0.0000 347.4000 0.0000 347.5980 0.0000 347.7000 0.0000 347.8980 0.0000 348.0000 0.0000 348.1980 0.0000 348.3000 0.0000 348.4980 0.0000 348.6000 0.0000 348.7980 0.0000 348.9000 0.0000 349.0980 0.0000 349.2000 0.0000 349.3980 0.0000 349.5000 0.0000 349.6980 0.0000 349.8000 0.0000 349.9980 0.0000 350.1000 0.0000 350.2980 0.0000 350.4000 0.0000 350.5980 0.0000 350.7000 0.0000 350.8980 0.0000 351.0000 0.0000 351.1980 0.0000 351.3000 0.0000 351.4980 0.0000 351.6000 0.0000 351.7980 0.0000 351.9000 0.0000 352.0980 0.0000 352.2000 0.0000 352.3980 0.0000 352.5000 0.0000 352.6980 0.0000 352.8000 0.0000 352.9980 0.0000 353.1000 0.0000 353.2980 0.0000 353.4000 0.0000 353.5980 0.0000 353.7000 0.0000 353.8980 0.0000 354.0000 0.0000 354.1980 0.0000 354.3000 0.0000 354.4980 0.0000 354.6000 0.0000 354.7980 0.0000 354.9000 0.0000 355.0980 0.0000 355.2000 0.0000 355.3980 0.0000 355.5000 0.0000 355.6980 0.0000 355.8000 0.0000 355.9980 0.0000 356.1000 0.0000 356.2980 0.0000 356.4000 0.0000 356.5980 0.0000 356.7000 0.0000 356.8980 0.0000 357.0000 0.0000 357.1980 0.0000 357.3000 0.0000 357.4980 0.0000 357.6000 0.0000 357.7980 0.0000 357.9000 0.0000 358.0980 0.0000 358.2000 0.0000 358.3980 0.0000 358.5000 0.0000 358.6980 0.0000 358.8000 0.0000 358.9980 0.0000 359.1000 0.0000 359.2980 0.0000 359.4000 0.0000 359.5980 0.0000 359.7000 0.0000 359.8980 0.0000 360.0000 1.0000 360.1980 1.0000 360.3000 1.0000 360.4980 1.0000 360.6000 1.0000 360.7980 1.0000 360.9000 1.0000 361.0980 1.0000 361.2000 1.0000 361.3980 1.0000 361.5000 1.0000 361.6980 1.0000 361.8000 1.0000 361.9980 1.0000 362.1000 1.0000 362.2980 1.0000 362.4000 1.0000 362.5980 1.0000 362.7000 1.0000 362.8980 1.0000 363.0000 1.0000 363.1980 1.0000 363.3000 1.0000 363.4980 1.0000 363.6000 1.0000 363.7980 1.0000 363.9000 1.0000 364.0980 1.0000 364.2000 1.0000 364.3980 1.0000 364.5000 1.0000 364.6980 1.0000 364.8000 1.0000 364.9980 1.0000 365.1000 1.0000 365.2980 1.0000 365.4000 1.0000 365.5980 1.0000 365.7000 1.0000 365.8980 1.0000 366.0000 1.0000 366.1980 1.0000 366.3000 1.0000 366.4980 1.0000 366.6000 1.0000 366.7980 1.0000 366.9000 1.0000 367.0980 1.0000 367.2000 0.0000 367.3980 0.0000 367.5000 0.0000 367.6980 0.0000 367.8000 0.0000 367.9980 0.0000 368.1000 0.0000 368.2980 0.0000 368.4000 0.0000 368.5980 0.0000 368.7000 0.0000 368.8980 0.0000 369.0000 0.0000 369.1980 0.0000 369.3000 0.0000 369.4980 0.0000 369.6000 0.0000 369.7980 0.0000 369.9000 0.0000 370.0980 0.0000 370.2000 0.0000 370.3980 0.0000 370.5000 0.0000 370.6980 0.0000 370.8000 0.0000 370.9980 0.0000 371.1000 0.0000 371.2980 0.0000 371.4000 0.0000 371.5980 0.0000 371.7000 0.0000 371.8980 0.0000 372.0000 0.0000 372.1980 0.0000 372.3000 0.0000 372.4980 0.0000 372.6000 0.0000 372.7980 0.0000 372.9000 0.0000 373.0980 0.0000 373.2000 0.0000 373.3980 0.0000 373.5000 0.0000 373.6980 0.0000 373.8000 0.0000 373.9980 0.0000 374.1000 0.0000 374.2980 0.0000 374.4000 0.0000 374.5980 0.0000 374.7000 0.0000 374.8980 0.0000 375.0000 0.0000 375.1980 0.0000 375.3000 0.0000 375.4980 0.0000 375.6000 0.0000 375.7980 0.0000 375.9000 0.0000 376.0980 0.0000 376.2000 0.0000 376.3980 0.0000 376.5000 0.0000 376.6980 0.0000 376.8000 0.0000 376.9980 0.0000 377.1000 0.0000 377.2980 0.0000 377.4000 0.0000 377.5980 0.0000 377.7000 0.0000 377.8980 0.0000 378.0000 0.0000 378.1980 0.0000 378.3000 0.0000 378.4980 0.0000 378.6000 0.0000 378.7980 0.0000 378.9000 0.0000 379.0980 0.0000 379.2000 0.0000 379.3980 0.0000 379.5000 0.0000 379.6980 0.0000 379.8000 0.0000 379.9980 0.0000 380.1000 0.0000 380.2980 0.0000 380.4000 0.0000 380.5980 0.0000 380.7000 0.0000 380.8980 0.0000 381.0000 0.0000 381.1980 0.0000 381.3000 0.0000 381.4980 0.0000 381.6000 1.0000 381.7980 1.0000 381.9000 1.0000 382.0980 1.0000 382.2000 1.0000 382.3980 1.0000 382.5000 1.0000 382.6980 1.0000 382.8000 1.0000 382.9980 1.0000 383.1000 1.0000 383.2980 1.0000 383.4000 1.0000 383.5980 1.0000 383.7000 1.0000 383.8980 1.0000 384.0000 1.0000 384.1980 1.0000 384.3000 1.0000 384.4980 1.0000 384.6000 1.0000 384.7980 1.0000 384.9000 1.0000 385.0980 1.0000 385.2000 1.0000 385.3980 1.0000 385.5000 1.0000 385.6980 1.0000 385.8000 1.0000 385.9980 1.0000 386.1000 1.0000 386.2980 1.0000 386.4000 1.0000 386.5980 1.0000 386.7000 1.0000 386.8980 1.0000 387.0000 1.0000 387.1980 1.0000 387.3000 1.0000 387.4980 1.0000 387.6000 1.0000 387.7980 1.0000 387.9000 1.0000 388.0980 1.0000 388.2000 1.0000 388.3980 1.0000 388.5000 1.0000 388.6980 1.0000 388.8000 0.0000 388.9980 0.0000 389.1000 0.0000 389.2980 0.0000 389.4000 0.0000 389.5980 0.0000 389.7000 0.0000 389.8980 0.0000 390.0000 0.0000 390.1980 0.0000 390.3000 0.0000 390.4980 0.0000 390.6000 0.0000 390.7980 0.0000 390.9000 0.0000 391.0980 0.0000 391.2000 0.0000 391.3980 0.0000 391.5000 0.0000 391.6980 0.0000 391.8000 0.0000 391.9980 0.0000 392.1000 0.0000 392.2980 0.0000 392.4000 0.0000 392.5980 0.0000 392.7000 0.0000 392.8980 0.0000 393.0000 0.0000 393.1980 0.0000 393.3000 0.0000 393.4980 0.0000 393.6000 0.0000 393.7980 0.0000 393.9000 0.0000 394.0980 0.0000 394.2000 0.0000 394.3980 0.0000 394.5000 0.0000 394.6980 0.0000 394.8000 0.0000 394.9980 0.0000 395.1000 0.0000 395.2980 0.0000 395.4000 0.0000 395.5980 0.0000 395.7000 0.0000 395.8980 0.0000 396.0000 0.0000 396.1980 0.0000 396.3000 0.0000 396.4980 0.0000 396.6000 0.0000 396.7980 0.0000 396.9000 0.0000 397.0980 0.0000 397.2000 0.0000 397.3980 0.0000 397.5000 0.0000 397.6980 0.0000 397.8000 0.0000 397.9980 0.0000 398.1000 0.0000 398.2980 0.0000 398.4000 0.0000 398.5980 0.0000 398.7000 0.0000 398.8980 0.0000 399.0000 0.0000 399.1980 0.0000 399.3000 0.0000 399.4980 0.0000 399.6000 0.0000 399.7980 0.0000 399.9000 0.0000 400.0980 0.0000 400.2000 0.0000 400.3980 0.0000 400.5000 0.0000 400.6980 0.0000 400.8000 0.0000 400.9980 0.0000 401.1000 0.0000 401.2980 0.0000 401.4000 0.0000 401.5980 0.0000 401.7000 0.0000 401.8980 0.0000 402.0000 0.0000 402.1980 0.0000 402.3000 0.0000 402.4980 0.0000 402.6000 0.0000 402.7980 0.0000 402.9000 0.0000 403.0980 0.0000 403.2000 1.0000 403.3980 1.0000 403.5000 1.0000 403.6980 1.0000 403.8000 1.0000 403.9980 1.0000 404.1000 1.0000 404.2980 1.0000 404.4000 1.0000 404.5980 1.0000 404.7000 1.0000 404.8980 1.0000 405.0000 1.0000 405.1980 1.0000 405.3000 1.0000 405.4980 1.0000 405.6000 1.0000 405.7980 1.0000 405.9000 1.0000 406.0980 1.0000 406.2000 1.0000 406.3980 1.0000 406.5000 1.0000 406.6980 1.0000 406.8000 1.0000 406.9980 1.0000 407.1000 1.0000 407.2980 1.0000 407.4000 1.0000 407.5980 1.0000 407.7000 1.0000 407.8980 1.0000 408.0000 1.0000 408.1980 1.0000 408.3000 1.0000 408.4980 1.0000 408.6000 1.0000 408.7980 1.0000 408.9000 1.0000 409.0980 1.0000 409.2000 1.0000 409.3980 1.0000 409.5000 1.0000 409.6980 1.0000 409.8000 1.0000 409.9980 1.0000 410.1000 1.0000 410.2980 1.0000 410.4000 0.0000 410.5980 0.0000 410.7000 0.0000 410.8980 0.0000 411.0000 0.0000 411.1980 0.0000 411.3000 0.0000 411.4980 0.0000 411.6000 0.0000 411.7980 0.0000 411.9000 0.0000 412.0980 0.0000 412.2000 0.0000 412.3980 0.0000 412.5000 0.0000 412.6980 0.0000 412.8000 0.0000 412.9980 0.0000 413.1000 0.0000 413.2980 0.0000 413.4000 0.0000 413.5980 0.0000 413.7000 0.0000 413.8980 0.0000 414.0000 0.0000 414.1980 0.0000 414.3000 0.0000 414.4980 0.0000 414.6000 0.0000 414.7980 0.0000 414.9000 0.0000 415.0980 0.0000 415.2000 0.0000 415.3980 0.0000 415.5000 0.0000 415.6980 0.0000 415.8000 0.0000 415.9980 0.0000 416.1000 0.0000 416.2980 0.0000 416.4000 0.0000 416.5980 0.0000 416.7000 0.0000 416.8980 0.0000 417.0000 0.0000 417.1980 0.0000 417.3000 0.0000 417.4980 0.0000 417.6000 0.0000 417.7980 0.0000 417.9000 0.0000 418.0980 0.0000 418.2000 0.0000 418.3980 0.0000 418.5000 0.0000 418.6980 0.0000 418.8000 0.0000 418.9980 0.0000 419.1000 0.0000 419.2980 0.0000 419.4000 0.0000 419.5980 0.0000 419.7000 0.0000 419.8980 0.0000 420.0000 0.0000 420.1980 0.0000 420.3000 0.0000 420.4980 0.0000 420.6000 0.0000 420.7980 0.0000 420.9000 0.0000 421.0980 0.0000 421.2000 0.0000 421.3980 0.0000 421.5000 0.0000 421.6980 0.0000 421.8000 0.0000 421.9980 0.0000 422.1000 0.0000 422.2980 0.0000 422.4000 0.0000 422.5980 0.0000 422.7000 0.0000 422.8980 0.0000 423.0000 0.0000 423.1980 0.0000 423.3000 0.0000 423.4980 0.0000 423.6000 0.0000 423.7980 0.0000 423.9000 0.0000 424.0980 0.0000 424.2000 0.0000 424.3980 0.0000 424.5000 0.0000 424.6980 0.0000 424.8000 1.0000 424.9980 1.0000 425.1000 1.0000 425.2980 1.0000 425.4000 1.0000 425.5980 1.0000 425.7000 1.0000 425.8980 1.0000 426.0000 1.0000 426.1980 1.0000 426.3000 1.0000 426.4980 1.0000 426.6000 1.0000 426.7980 1.0000 426.9000 1.0000 427.0980 1.0000 427.2000 1.0000 427.3980 1.0000 427.5000 1.0000 427.6980 1.0000 427.8000 1.0000 427.9980 1.0000 428.1000 1.0000 428.2980 1.0000 428.4000 1.0000 428.5980 1.0000 428.7000 1.0000 428.8980 1.0000 429.0000 1.0000 429.1980 1.0000 429.3000 1.0000 429.4980 1.0000 429.6000 1.0000 429.7980 1.0000 429.9000 1.0000 430.0980 1.0000 430.2000 1.0000 430.3980 1.0000 430.5000 1.0000 430.6980 1.0000 430.8000 1.0000 430.9980 1.0000 431.1000 1.0000 431.2980 1.0000 431.4000 1.0000 431.5980 1.0000 431.7000 1.0000 431.8980 1.0000 432.0000 0.0000 432.1980 0.0000 432.3000 0.0000 432.4980 0.0000 432.6000 0.0000 432.7980 0.0000 432.9000 0.0000 433.0980 0.0000 433.2000 0.0000 433.3980 0.0000 433.5000 0.0000 433.6980 0.0000 433.8000 0.0000 433.9980 0.0000 434.1000 0.0000 434.2980 0.0000 434.4000 0.0000 434.5980 0.0000 434.7000 0.0000 434.8980 0.0000 435.0000 0.0000 435.1980 0.0000 435.3000 0.0000 435.4980 0.0000 435.6000 0.0000 435.7980 0.0000 435.9000 0.0000 436.0980 0.0000 436.2000 0.0000 436.3980 0.0000 436.5000 0.0000 436.6980 0.0000 436.8000 0.0000 436.9980 0.0000 437.1000 0.0000 437.2980 0.0000 437.4000 0.0000 437.5980 0.0000 437.7000 0.0000 437.8980 0.0000 438.0000 0.0000 438.1980 0.0000 438.3000 0.0000 438.4980 0.0000 438.6000 0.0000 438.7980 0.0000 438.9000 0.0000 439.0980 0.0000 439.2000 0.0000 439.3980 0.0000 439.5000 0.0000 439.6980 0.0000 439.8000 0.0000 439.9980 0.0000 440.1000 0.0000 440.2980 0.0000 440.4000 0.0000 440.5980 0.0000 440.7000 0.0000 440.8980 0.0000 441.0000 0.0000 441.1980 0.0000 441.3000 0.0000 441.4980 0.0000 441.6000 0.0000 441.7980 0.0000 441.9000 0.0000 442.0980 0.0000 442.2000 0.0000 442.3980 0.0000 442.5000 0.0000 442.6980 0.0000 442.8000 0.0000 442.9980 0.0000 443.1000 0.0000 443.2980 0.0000 443.4000 0.0000 443.5980 0.0000 443.7000 0.0000 443.8980 0.0000 444.0000 0.0000 444.1980 0.0000 444.3000 0.0000 444.4980 0.0000 444.6000 0.0000 444.7980 0.0000 444.9000 0.0000 445.0980 0.0000 445.2000 0.0000 445.3980 0.0000 445.5000 0.0000 445.6980 0.0000 445.8000 0.0000 445.9980 0.0000 446.1000 0.0000 446.2980 0.0000 446.4000 1.0000 446.5980 1.0000 446.7000 1.0000 446.8980 1.0000 447.0000 1.0000 447.1980 1.0000 447.3000 1.0000 447.4980 1.0000 447.6000 1.0000 447.7980 1.0000 447.9000 1.0000 448.0980 1.0000 448.2000 1.0000 448.3980 1.0000 448.5000 1.0000 448.6980 1.0000 448.8000 1.0000 448.9980 1.0000 449.1000 1.0000 449.2980 1.0000 449.4000 1.0000 449.5980 1.0000 449.7000 1.0000 449.8980 1.0000 450.0000 1.0000 450.1980 1.0000 450.3000 1.0000 450.4980 1.0000 450.6000 1.0000 450.7980 1.0000 450.9000 1.0000 451.0980 1.0000 451.2000 1.0000 451.3980 1.0000 451.5000 1.0000 451.6980 1.0000 451.8000 1.0000 451.9980 1.0000 452.1000 1.0000 452.2980 1.0000 452.4000 1.0000 452.5980 1.0000 452.7000 1.0000 452.8980 1.0000 453.0000 1.0000 453.1980 1.0000 453.3000 1.0000 453.4980 1.0000 453.6000 0.0000 453.7980 0.0000 453.9000 0.0000 454.0980 0.0000 454.2000 0.0000 454.3980 0.0000 454.5000 0.0000 454.6980 0.0000 454.8000 0.0000 454.9980 0.0000 455.1000 0.0000 455.2980 0.0000 455.4000 0.0000 455.5980 0.0000 455.7000 0.0000 455.8980 0.0000 456.0000 0.0000 456.1980 0.0000 456.3000 0.0000 456.4980 0.0000 456.6000 0.0000 456.7980 0.0000 456.9000 0.0000 457.0980 0.0000 457.2000 0.0000 457.3980 0.0000 457.5000 0.0000 457.6980 0.0000 457.8000 0.0000 457.9980 0.0000 458.1000 0.0000 458.2980 0.0000 458.4000 0.0000 458.5980 0.0000 458.7000 0.0000 458.8980 0.0000 459.0000 0.0000 459.1980 0.0000 459.3000 0.0000 459.4980 0.0000 459.6000 0.0000 459.7980 0.0000 459.9000 0.0000 460.0980 0.0000 460.2000 0.0000 460.3980 0.0000 460.5000 0.0000 460.6980 0.0000 460.8000 0.0000 460.9980 0.0000 461.1000 0.0000 461.2980 0.0000 461.4000 0.0000 461.5980 0.0000 461.7000 0.0000 461.8980 0.0000 462.0000 0.0000 462.1980 0.0000 462.3000 0.0000 462.4980 0.0000 462.6000 0.0000 462.7980 0.0000 462.9000 0.0000 463.0980 0.0000 463.2000 0.0000 463.3980 0.0000 463.5000 0.0000 463.6980 0.0000 463.8000 0.0000 463.9980 0.0000 464.1000 0.0000 464.2980 0.0000 464.4000 0.0000 464.5980 0.0000 464.7000 0.0000 464.8980 0.0000 465.0000 0.0000 465.1980 0.0000 465.3000 0.0000 465.4980 0.0000 465.6000 0.0000 465.7980 0.0000 465.9000 0.0000 466.0980 0.0000 466.2000 0.0000 466.3980 0.0000 466.5000 0.0000 466.6980 0.0000 466.8000 0.0000 466.9980 0.0000 467.1000 0.0000 467.2980 0.0000 467.4000 0.0000 467.5980 0.0000 467.7000 0.0000 467.8980 0.0000 468.0000 1.0000 468.1980 1.0000 468.3000 1.0000 468.4980 1.0000 468.6000 1.0000 468.7980 1.0000 468.9000 1.0000 469.0980 1.0000 469.2000 1.0000 469.3980 1.0000 469.5000 1.0000 469.6980 1.0000 469.8000 1.0000 469.9980 1.0000 470.1000 1.0000 470.2980 1.0000 470.4000 1.0000 470.5980 1.0000 470.7000 1.0000 470.8980 1.0000 471.0000 1.0000 471.1980 1.0000 471.3000 1.0000 471.4980 1.0000 471.6000 1.0000 471.7980 1.0000 471.9000 1.0000 472.0980 1.0000 472.2000 1.0000 472.3980 1.0000 472.5000 1.0000 472.6980 1.0000 472.8000 1.0000 472.9980 1.0000 473.1000 1.0000 473.2980 1.0000 473.4000 1.0000 473.5980 1.0000 473.7000 1.0000 473.8980 1.0000 474.0000 1.0000 474.1980 1.0000 474.3000 1.0000 474.4980 1.0000 474.6000 1.0000 474.7980 1.0000 474.9000 1.0000 475.0980 1.0000 475.2000 0.0000 475.3980 0.0000 475.5000 0.0000 475.6980 0.0000 475.8000 0.0000 475.9980 0.0000 476.1000 0.0000 476.2980 0.0000 476.4000 0.0000 476.5980 0.0000 476.7000 0.0000 476.8980 0.0000 477.0000 0.0000 477.1980 0.0000 477.3000 0.0000 477.4980 0.0000 477.6000 0.0000 477.7980 0.0000 477.9000 0.0000 478.0980 0.0000 478.2000 0.0000 478.3980 0.0000 478.5000 0.0000 478.6980 0.0000 478.8000 0.0000 478.9980 0.0000 479.1000 0.0000 479.2980 0.0000 479.4000 0.0000 479.5980 0.0000 479.7000 0.0000 479.8980 0.0000 480.0000 0.0000 480.1980 0.0000 480.3000 0.0000 480.4980 0.0000 480.6000 0.0000 480.7980 0.0000 480.9000 0.0000 481.0980 0.0000 481.2000 0.0000 481.3980 0.0000 481.5000 0.0000 481.6980 0.0000 481.8000 0.0000 481.9980 0.0000 482.1000 0.0000 482.2980 0.0000 482.4000 0.0000 482.5980 0.0000 482.7000 0.0000 482.8980 0.0000 483.0000 0.0000 483.1980 0.0000 483.3000 0.0000 483.4980 0.0000 483.6000 0.0000 483.7980 0.0000 483.9000 0.0000 484.0980 0.0000 484.2000 0.0000 484.3980 0.0000 484.5000 0.0000 484.6980 0.0000 484.8000 0.0000 484.9980 0.0000 485.1000 0.0000 485.2980 0.0000 485.4000 0.0000 485.5980 0.0000 485.7000 0.0000 485.8980 0.0000 486.0000 0.0000 486.1980 0.0000 486.3000 0.0000 486.4980 0.0000 486.6000 0.0000 486.7980 0.0000 486.9000 0.0000 487.0980 0.0000 487.2000 0.0000 487.3980 0.0000 487.5000 0.0000 487.6980 0.0000 487.8000 0.0000 487.9980 0.0000 488.1000 0.0000 488.2980 0.0000 488.4000 0.0000 488.5980 0.0000 488.7000 0.0000 488.8980 0.0000 489.0000 0.0000 489.1980 0.0000 489.3000 0.0000 489.4980 0.0000 489.6000 1.0000 489.7980 1.0000 489.9000 1.0000 490.0980 1.0000 490.2000 1.0000 490.3980 1.0000 490.5000 1.0000 490.6980 1.0000 490.8000 1.0000 490.9980 1.0000 491.1000 1.0000 491.2980 1.0000 491.4000 1.0000 491.5980 1.0000 491.7000 1.0000 491.8980 1.0000 492.0000 1.0000 492.1980 1.0000 492.3000 1.0000 492.4980 1.0000 492.6000 1.0000 492.7980 1.0000 492.9000 1.0000 493.0980 1.0000 493.2000 1.0000 493.3980 1.0000 493.5000 1.0000 493.6980 1.0000 493.8000 1.0000 493.9980 1.0000 494.1000 1.0000 494.2980 1.0000 494.4000 1.0000 494.5980 1.0000 494.7000 1.0000 494.8980 1.0000 495.0000 1.0000 495.1980 1.0000 495.3000 1.0000 495.4980 1.0000 495.6000 1.0000 495.7980 1.0000 495.9000 1.0000 496.0980 1.0000 496.2000 1.0000 496.3980 1.0000 496.5000 1.0000 496.6980 1.0000 496.8000 0.0000 496.9980 0.0000 497.1000 0.0000 497.2980 0.0000 497.4000 0.0000 497.5980 0.0000 497.7000 0.0000 497.8980 0.0000 498.0000 0.0000 498.1980 0.0000 498.3000 0.0000 498.4980 0.0000 498.6000 0.0000 498.7980 0.0000 498.9000 0.0000 499.0980 0.0000 499.2000 0.0000 499.3980 0.0000 499.5000 0.0000 499.6980 0.0000 499.8000 0.0000 499.9980 0.0000 500.1000 0.0000 500.2980 0.0000 500.4000 0.0000 500.5980 0.0000 500.7000 0.0000 500.8980 0.0000 501.0000 0.0000 501.1980 0.0000 501.3000 0.0000 501.4980 0.0000 501.6000 0.0000 501.7980 0.0000 501.9000 0.0000 502.0980 0.0000 502.2000 0.0000 502.3980 0.0000 502.5000 0.0000 502.6980 0.0000 502.8000 0.0000 502.9980 0.0000 503.1000 0.0000 503.2980 0.0000 503.4000 0.0000 503.5980 0.0000 503.7000 0.0000 503.8980 0.0000 504.0000 0.0000 504.1980 0.0000 504.3000 0.0000 504.4980 0.0000 504.6000 0.0000 504.7980 0.0000 504.9000 0.0000 505.0980 0.0000 505.2000 0.0000 505.3980 0.0000 505.5000 0.0000 505.6980 0.0000 505.8000 0.0000 505.9980 0.0000 506.1000 0.0000 506.2980 0.0000 506.4000 0.0000 506.5980 0.0000 506.7000 0.0000 506.8980 0.0000 507.0000 0.0000 507.1980 0.0000 507.3000 0.0000 507.4980 0.0000 507.6000 0.0000 507.7980 0.0000 507.9000 0.0000 508.0980 0.0000 508.2000 0.0000 508.3980 0.0000 508.5000 0.0000 508.6980 0.0000 508.8000 0.0000 508.9980 0.0000 509.1000 0.0000 509.2980 0.0000 509.4000 0.0000 509.5980 0.0000 509.7000 0.0000 509.8980 0.0000 510.0000 0.0000 510.1980 0.0000 510.3000 0.0000 510.4980 0.0000 510.6000 0.0000 510.7980 0.0000 510.9000 0.0000 511.0980 0.0000 511.2000 1.0000 511.3980 1.0000 511.5000 1.0000 511.6980 1.0000 511.8000 1.0000 511.9980 1.0000 512.1000 1.0000 512.2980 1.0000 512.4000 1.0000 512.5980 1.0000 512.7000 1.0000 512.8980 1.0000 513.0000 1.0000 513.1980 1.0000 513.3000 1.0000 513.4980 1.0000 513.6000 1.0000 513.7980 1.0000 513.9000 1.0000 514.0980 1.0000 514.2000 1.0000 514.3980 1.0000 514.5000 1.0000 514.6980 1.0000 514.8000 1.0000 514.9980 1.0000 515.1000 1.0000 515.2980 1.0000 515.4000 1.0000 515.5980 1.0000 515.7000 1.0000 515.8980 1.0000 516.0000 1.0000 516.1980 1.0000 516.3000 1.0000 516.4980 1.0000 516.6000 1.0000 516.7980 1.0000 516.9000 1.0000 517.0980 1.0000 517.2000 1.0000 517.3980 1.0000 517.5000 1.0000 517.6980 1.0000 517.8000 1.0000 517.9980 1.0000 518.1000 1.0000 518.2980 1.0000 518.4000 0.0000 518.5980 0.0000 518.7000 0.0000 518.8980 0.0000 519.0000 0.0000 519.1980 0.0000 519.3000 0.0000 519.4980 0.0000 519.6000 0.0000 519.7980 0.0000 519.9000 0.0000 520.0980 0.0000 520.2000 0.0000 520.3980 0.0000 520.5000 0.0000 520.6980 0.0000 520.8000 0.0000 520.9980 0.0000 521.1000 0.0000 521.2980 0.0000 521.4000 0.0000 521.5980 0.0000 521.7000 0.0000 521.8980 0.0000 522.0000 0.0000 522.1980 0.0000 522.3000 0.0000 522.4980 0.0000 522.6000 0.0000 522.7980 0.0000 522.9000 0.0000 523.0980 0.0000 523.2000 0.0000 523.3980 0.0000 523.5000 0.0000 523.6980 0.0000 523.8000 0.0000 523.9980 0.0000 524.1000 0.0000 524.2980 0.0000 524.4000 0.0000 524.5980 0.0000 524.7000 0.0000 524.8980 0.0000 525.0000 0.0000 525.1980 0.0000 525.3000 0.0000 525.4980 0.0000 525.6000 0.0000 525.7980 0.0000 525.9000 0.0000 526.0980 0.0000 526.2000 0.0000 526.3980 0.0000 526.5000 0.0000 526.6980 0.0000 526.8000 0.0000 526.9980 0.0000 527.1000 0.0000 527.2980 0.0000 527.4000 0.0000 527.5980 0.0000 527.7000 0.0000 527.8980 0.0000 528.0000 0.0000 528.1980 0.0000 528.3000 0.0000 528.4980 0.0000 528.6000 0.0000 528.7980 0.0000 528.9000 0.0000 529.0980 0.0000 529.2000 0.0000 529.3980 0.0000 529.5000 0.0000 529.6980 0.0000 529.8000 0.0000 529.9980 0.0000 530.1000 0.0000 530.2980 0.0000 530.4000 0.0000 530.5980 0.0000 530.7000 0.0000 530.8980 0.0000 531.0000 0.0000 531.1980 0.0000 531.3000 0.0000 531.4980 0.0000 531.6000 0.0000 531.7980 0.0000 531.9000 0.0000 532.0980 0.0000 532.2000 0.0000 532.3980 0.0000 532.5000 0.0000 532.6980 0.0000 532.8000 1.0000 532.9980 1.0000 533.1000 1.0000 533.2980 1.0000 533.4000 1.0000 533.5980 1.0000 533.7000 1.0000 533.8980 1.0000 534.0000 1.0000 534.1980 1.0000 534.3000 1.0000 534.4980 1.0000 534.6000 1.0000 534.7980 1.0000 534.9000 1.0000 535.0980 1.0000 535.2000 1.0000 535.3980 1.0000 535.5000 1.0000 535.6980 1.0000 535.8000 1.0000 535.9980 1.0000 536.1000 1.0000 536.2980 1.0000 536.4000 1.0000 536.5980 1.0000 536.7000 1.0000 536.8980 1.0000 537.0000 1.0000 537.1980 1.0000 537.3000 1.0000 537.4980 1.0000 537.6000 1.0000 537.7980 1.0000 537.9000 1.0000 538.0980 1.0000 538.2000 1.0000 538.3980 1.0000 538.5000 1.0000 538.6980 1.0000 538.8000 1.0000 538.9980 1.0000 539.1000 1.0000 539.2980 1.0000 539.4000 1.0000 539.5980 1.0000 539.7000 1.0000 539.8980 1.0000 540.0000 0.0000 540.1980 0.0000 540.3000 0.0000 540.4980 0.0000 540.6000 0.0000 540.7980 0.0000 540.9000 0.0000 541.0980 0.0000 541.2000 0.0000 541.3980 0.0000 541.5000 0.0000 541.6980 0.0000 541.8000 0.0000 541.9980 0.0000 542.1000 0.0000 542.2980 0.0000 542.4000 0.0000 542.5980 0.0000 542.7000 0.0000 542.8980 0.0000 543.0000 0.0000 543.1980 0.0000 543.3000 0.0000 543.4980 0.0000 543.6000 0.0000 543.7980 0.0000 543.9000 0.0000 544.0980 0.0000 544.2000 0.0000 544.3980 0.0000 544.5000 0.0000 544.6980 0.0000 544.8000 0.0000 544.9980 0.0000 545.1000 0.0000 545.2980 0.0000 545.4000 0.0000 545.5980 0.0000 545.7000 0.0000 545.8980 0.0000 546.0000 0.0000 546.1980 0.0000 546.3000 0.0000 546.4980 0.0000 546.6000 0.0000 546.7980 0.0000 546.9000 0.0000 547.0980 0.0000 547.2000 0.0000 547.3980 0.0000 547.5000 0.0000 547.6980 0.0000 547.8000 0.0000 547.9980 0.0000 548.1000 0.0000 548.2980 0.0000 548.4000 0.0000 548.5980 0.0000 548.7000 0.0000 548.8980 0.0000 549.0000 0.0000 549.1980 0.0000 549.3000 0.0000 549.4980 0.0000 549.6000 0.0000 549.7980 0.0000 549.9000 0.0000 550.0980 0.0000 550.2000 0.0000 550.3980 0.0000 550.5000 0.0000 550.6980 0.0000 550.8000 0.0000 550.9980 0.0000 551.1000 0.0000 551.2980 0.0000 551.4000 0.0000 551.5980 0.0000 551.7000 0.0000 551.8980 0.0000 552.0000 0.0000 552.1980 0.0000 552.3000 0.0000 552.4980 0.0000 552.6000 0.0000 552.7980 0.0000 552.9000 0.0000 553.0980 0.0000 553.2000 0.0000 553.3980 0.0000 553.5000 0.0000 553.6980 0.0000 553.8000 0.0000 553.9980 0.0000 554.1000 0.0000 554.2980 0.0000 554.4000 1.0000 554.5980 1.0000 554.7000 1.0000 554.8980 1.0000 555.0000 1.0000 555.1980 1.0000 555.3000 1.0000 555.4980 1.0000 555.6000 1.0000 555.7980 1.0000 555.9000 1.0000 556.0980 1.0000 556.2000 1.0000 556.3980 1.0000 556.5000 1.0000 556.6980 1.0000 556.8000 1.0000 556.9980 1.0000 557.1000 1.0000 557.2980 1.0000 557.4000 1.0000 557.5980 1.0000 557.7000 1.0000 557.8980 1.0000 558.0000 1.0000 558.1980 1.0000 558.3000 1.0000 558.4980 1.0000 558.6000 1.0000 558.7980 1.0000 558.9000 1.0000 559.0980 1.0000 559.2000 1.0000 559.3980 1.0000 559.5000 1.0000 559.6980 1.0000 559.8000 1.0000 559.9980 1.0000 560.1000 1.0000 560.2980 1.0000 560.4000 1.0000 560.5980 1.0000 560.7000 1.0000 560.8980 1.0000 561.0000 1.0000 561.1980 1.0000 561.3000 1.0000 561.4980 1.0000 561.6000 0.0000 561.7980 0.0000 561.9000 0.0000 562.0980 0.0000 562.2000 0.0000 562.3980 0.0000 562.5000 0.0000 562.6980 0.0000 562.8000 0.0000 562.9980 0.0000 563.1000 0.0000 563.2980 0.0000 563.4000 0.0000 563.5980 0.0000 563.7000 0.0000 563.8980 0.0000 564.0000 0.0000 564.1980 0.0000 564.3000 0.0000 564.4980 0.0000 564.6000 0.0000 564.7980 0.0000 564.9000 0.0000 565.0980 0.0000 565.2000 0.0000 565.3980 0.0000 565.5000 0.0000 565.6980 0.0000 565.8000 0.0000 565.9980 0.0000 566.1000 0.0000 566.2980 0.0000 566.4000 0.0000 566.5980 0.0000 566.7000 0.0000 566.8980 0.0000 567.0000 0.0000 567.1980 0.0000 567.3000 0.0000 567.4980 0.0000 567.6000 0.0000 567.7980 0.0000 567.9000 0.0000 568.0980 0.0000 568.2000 0.0000 568.3980 0.0000 568.5000 0.0000 568.6980 0.0000 568.8000 0.0000 568.9980 0.0000 569.1000 0.0000 569.2980 0.0000 569.4000 0.0000 569.5980 0.0000 569.7000 0.0000 569.8980 0.0000 570.0000 0.0000 570.1980 0.0000 570.3000 0.0000 570.4980 0.0000 570.6000 0.0000 570.7980 0.0000 570.9000 0.0000 571.0980 0.0000 571.2000 0.0000 571.3980 0.0000 571.5000 0.0000 571.6980 0.0000 571.8000 0.0000 571.9980 0.0000 572.1000 0.0000 572.2980 0.0000 572.4000 0.0000 572.5980 0.0000 572.7000 0.0000 572.8980 0.0000 573.0000 0.0000 573.1980 0.0000 573.3000 0.0000 573.4980 0.0000 573.6000 0.0000 573.7980 0.0000 573.9000 0.0000 574.0980 0.0000 574.2000 0.0000 574.3980 0.0000 574.5000 0.0000 574.6980 0.0000 574.8000 0.0000 574.9980 0.0000 575.1000 0.0000 575.2980 0.0000 575.4000 0.0000 575.5980 0.0000 575.7000 0.0000 575.8980 0.0000 576.0000 1.0000 576.1980 1.0000 576.3000 1.0000 576.4980 1.0000 576.6000 1.0000 576.7980 1.0000 576.9000 1.0000 577.0980 1.0000 577.2000 1.0000 577.3980 1.0000 577.5000 1.0000 577.6980 1.0000 577.8000 1.0000 577.9980 1.0000 578.1000 1.0000 578.2980 1.0000 578.4000 1.0000 578.5980 1.0000 578.7000 1.0000 578.8980 1.0000 579.0000 1.0000 579.1980 1.0000 579.3000 1.0000 579.4980 1.0000 579.6000 1.0000 579.7980 1.0000 579.9000 1.0000 580.0980 1.0000 580.2000 1.0000 580.3980 1.0000 580.5000 1.0000 580.6980 1.0000 580.8000 1.0000 580.9980 1.0000 581.1000 1.0000 581.2980 1.0000 581.4000 1.0000 581.5980 1.0000 581.7000 1.0000 581.8980 1.0000 582.0000 1.0000 582.1980 1.0000 582.3000 1.0000 582.4980 1.0000 582.6000 1.0000 582.7980 1.0000 582.9000 1.0000 583.0980 1.0000 583.2000 0.0000 583.3980 0.0000 583.5000 0.0000 583.6980 0.0000 583.8000 0.0000 583.9980 0.0000 584.1000 0.0000 584.2980 0.0000 584.4000 0.0000 584.5980 0.0000 584.7000 0.0000 584.8980 0.0000 585.0000 0.0000 585.1980 0.0000 585.3000 0.0000 585.4980 0.0000 585.6000 0.0000 585.7980 0.0000 585.9000 0.0000 586.0980 0.0000 586.2000 0.0000 586.3980 0.0000 586.5000 0.0000 586.6980 0.0000 586.8000 0.0000 586.9980 0.0000 587.1000 0.0000 587.2980 0.0000 587.4000 0.0000 587.5980 0.0000 587.7000 0.0000 587.8980 0.0000 588.0000 0.0000 588.1980 0.0000 588.3000 0.0000 588.4980 0.0000 588.6000 0.0000 588.7980 0.0000 588.9000 0.0000 589.0980 0.0000 589.2000 0.0000 589.3980 0.0000 589.5000 0.0000 589.6980 0.0000 589.8000 0.0000 589.9980 0.0000 590.1000 0.0000 590.2980 0.0000 590.4000 0.0000 590.5980 0.0000 590.7000 0.0000 590.8980 0.0000 591.0000 0.0000 591.1980 0.0000 591.3000 0.0000 591.4980 0.0000 591.6000 0.0000 591.7980 0.0000 591.9000 0.0000 592.0980 0.0000 592.2000 0.0000 592.3980 0.0000 592.5000 0.0000 592.6980 0.0000 592.8000 0.0000 592.9980 0.0000 593.1000 0.0000 593.2980 0.0000 593.4000 0.0000 593.5980 0.0000 593.7000 0.0000 593.8980 0.0000 594.0000 0.0000 594.1980 0.0000 594.3000 0.0000 594.4980 0.0000 594.6000 0.0000 594.7980 0.0000 594.9000 0.0000 595.0980 0.0000 595.2000 0.0000 595.3980 0.0000 595.5000 0.0000 595.6980 0.0000 595.8000 0.0000 595.9980 0.0000 596.1000 0.0000 596.2980 0.0000 596.4000 0.0000 596.5980 0.0000 596.7000 0.0000 596.8980 0.0000 597.0000 0.0000 597.1980 0.0000 597.3000 0.0000 597.4980 0.0000 597.6000 1.0000 597.7980 1.0000 597.9000 1.0000 598.0980 1.0000 598.2000 1.0000 598.3980 1.0000 598.5000 1.0000 598.6980 1.0000 598.8000 1.0000 598.9980 1.0000 599.1000 1.0000 599.2980 1.0000 599.4000 1.0000 599.5980 1.0000 599.7000 1.0000 599.8980 1.0000 600.0000 1.0000)
C_gp_1_0_0 gp_1_0_0 0 {Cg}
Mp_1_0_0 a4 gp_1_0_0 colp_L1_0 0 NSYN W=10u L=1u
Mn_1_0_0 a4 vcn coln_L1_0 0 NSYN W=10u L=1u
C_gp_1_0_1 gp_1_0_1 0 {Cg}
Mp_1_0_1 a0 gp_1_0_1 colp_L1_0 0 NSYN W=10u L=1u
Mn_1_0_1 a0 vcn coln_L1_0 0 NSYN W=10u L=1u
C_gp_1_0_2 gp_1_0_2 0 {Cg}
Mp_1_0_2 a5 gp_1_0_2 colp_L1_0 0 NSYN W=10u L=1u
Mn_1_0_2 a5 vcn coln_L1_0 0 NSYN W=10u L=1u
C_gp_1_0_3 gp_1_0_3 0 {Cg}
Mp_1_0_3 a1 gp_1_0_3 colp_L1_0 0 NSYN W=10u L=1u
Mn_1_0_3 a1 vcn coln_L1_0 0 NSYN W=10u L=1u
C_gp_1_0_b gp_1_0_b 0 {Cg}
Mp_1_0_b bx gp_1_0_b colp_L1_0 0 NSYN W=10u L=1u
Mn_1_0_b bx vcn coln_L1_0 0 NSYN W=10u L=1u
Msa_h_L1_0 coln_L1_0 coln_L1_0 0 0 NMIR W=20u L=1u
Msb_h_L1_0 z_L1_0 coln_L1_0 0 0 NMIR W=20u L=1u
Msc_h_L1_0 colp_L1_0 colp_L1_0 0 0 NMIR W=20u L=1u
Msd_h_L1_0 dpf_h_L1_0 colp_L1_0 0 0 NMIR W=20u L=1u
Mse_h_L1_0 dpf_h_L1_0 dpf_h_L1_0 vdd vdd PMIR W=60u L=1u
Msf_h_L1_0 z_L1_0 dpf_h_L1_0 vdd vdd PMIR W=60u L=1u
R_h_L1_0 z_L1_0 vrefh 8000.0
Mr_L1_0  hdd_L1_0 z_L1_0 tail_L1_0 0 NREL W=12u L=1u
Mr2_L1_0 dmp_L1_0  vmid  tail_L1_0 0 NREL W=12u L=1u
Mtl_L1_0 tail_L1_0 vtb 0 0 NREL W=32.0u L=1u
Mdm_L1_0 dmp_L1_0 dmp_L1_0 vdd vdd PMIR W=40u L=1u
Mrp1_L1_0 hdd_L1_0 hdd_L1_0 vdd vdd PMIR W=40u L=1u
Mrp2_L1_0 hv_L1_0 hdd_L1_0 vdd vdd PMIR W=40u L=1u
Rhv_L1_0 hv_L1_0 vg0 8000.0
C_gp_1_1_0 gp_1_1_0 0 {Cg}
Mp_1_1_0 a0 gp_1_1_0 colp_L1_1 0 NSYN W=10u L=1u
Mn_1_1_0 a0 vcn coln_L1_1 0 NSYN W=10u L=1u
C_gp_1_1_1 gp_1_1_1 0 {Cg}
Mp_1_1_1 a5 gp_1_1_1 colp_L1_1 0 NSYN W=10u L=1u
Mn_1_1_1 a5 vcn coln_L1_1 0 NSYN W=10u L=1u
C_gp_1_1_2 gp_1_1_2 0 {Cg}
Mp_1_1_2 a1 gp_1_1_2 colp_L1_1 0 NSYN W=10u L=1u
Mn_1_1_2 a1 vcn coln_L1_1 0 NSYN W=10u L=1u
C_gp_1_1_3 gp_1_1_3 0 {Cg}
Mp_1_1_3 a4 gp_1_1_3 colp_L1_1 0 NSYN W=10u L=1u
Mn_1_1_3 a4 vcn coln_L1_1 0 NSYN W=10u L=1u
C_gp_1_1_b gp_1_1_b 0 {Cg}
Mp_1_1_b bx gp_1_1_b colp_L1_1 0 NSYN W=10u L=1u
Mn_1_1_b bx vcn coln_L1_1 0 NSYN W=10u L=1u
Msa_h_L1_1 coln_L1_1 coln_L1_1 0 0 NMIR W=20u L=1u
Msb_h_L1_1 z_L1_1 coln_L1_1 0 0 NMIR W=20u L=1u
Msc_h_L1_1 colp_L1_1 colp_L1_1 0 0 NMIR W=20u L=1u
Msd_h_L1_1 dpf_h_L1_1 colp_L1_1 0 0 NMIR W=20u L=1u
Mse_h_L1_1 dpf_h_L1_1 dpf_h_L1_1 vdd vdd PMIR W=60u L=1u
Msf_h_L1_1 z_L1_1 dpf_h_L1_1 vdd vdd PMIR W=60u L=1u
R_h_L1_1 z_L1_1 vrefh 8000.0
Mr_L1_1  hdd_L1_1 z_L1_1 tail_L1_1 0 NREL W=12u L=1u
Mr2_L1_1 dmp_L1_1  vmid  tail_L1_1 0 NREL W=12u L=1u
Mtl_L1_1 tail_L1_1 vtb 0 0 NREL W=32.0u L=1u
Mdm_L1_1 dmp_L1_1 dmp_L1_1 vdd vdd PMIR W=40u L=1u
Mrp1_L1_1 hdd_L1_1 hdd_L1_1 vdd vdd PMIR W=40u L=1u
Mrp2_L1_1 hv_L1_1 hdd_L1_1 vdd vdd PMIR W=40u L=1u
Rhv_L1_1 hv_L1_1 vg0 8000.0
C_gp_1_2_0 gp_1_2_0 0 {Cg}
Mp_1_2_0 a1 gp_1_2_0 colp_L1_2 0 NSYN W=10u L=1u
Mn_1_2_0 a1 vcn coln_L1_2 0 NSYN W=10u L=1u
C_gp_1_2_1 gp_1_2_1 0 {Cg}
Mp_1_2_1 a5 gp_1_2_1 colp_L1_2 0 NSYN W=10u L=1u
Mn_1_2_1 a5 vcn coln_L1_2 0 NSYN W=10u L=1u
C_gp_1_2_2 gp_1_2_2 0 {Cg}
Mp_1_2_2 a0 gp_1_2_2 colp_L1_2 0 NSYN W=10u L=1u
Mn_1_2_2 a0 vcn coln_L1_2 0 NSYN W=10u L=1u
C_gp_1_2_3 gp_1_2_3 0 {Cg}
Mp_1_2_3 a4 gp_1_2_3 colp_L1_2 0 NSYN W=10u L=1u
Mn_1_2_3 a4 vcn coln_L1_2 0 NSYN W=10u L=1u
C_gp_1_2_b gp_1_2_b 0 {Cg}
Mp_1_2_b bx gp_1_2_b colp_L1_2 0 NSYN W=10u L=1u
Mn_1_2_b bx vcn coln_L1_2 0 NSYN W=10u L=1u
Msa_h_L1_2 coln_L1_2 coln_L1_2 0 0 NMIR W=20u L=1u
Msb_h_L1_2 z_L1_2 coln_L1_2 0 0 NMIR W=20u L=1u
Msc_h_L1_2 colp_L1_2 colp_L1_2 0 0 NMIR W=20u L=1u
Msd_h_L1_2 dpf_h_L1_2 colp_L1_2 0 0 NMIR W=20u L=1u
Mse_h_L1_2 dpf_h_L1_2 dpf_h_L1_2 vdd vdd PMIR W=60u L=1u
Msf_h_L1_2 z_L1_2 dpf_h_L1_2 vdd vdd PMIR W=60u L=1u
R_h_L1_2 z_L1_2 vrefh 8000.0
Mr_L1_2  hdd_L1_2 z_L1_2 tail_L1_2 0 NREL W=12u L=1u
Mr2_L1_2 dmp_L1_2  vmid  tail_L1_2 0 NREL W=12u L=1u
Mtl_L1_2 tail_L1_2 vtb 0 0 NREL W=32.0u L=1u
Mdm_L1_2 dmp_L1_2 dmp_L1_2 vdd vdd PMIR W=40u L=1u
Mrp1_L1_2 hdd_L1_2 hdd_L1_2 vdd vdd PMIR W=40u L=1u
Mrp2_L1_2 hv_L1_2 hdd_L1_2 vdd vdd PMIR W=40u L=1u
Rhv_L1_2 hv_L1_2 vg0 8000.0
C_gp_1_3_0 gp_1_3_0 0 {Cg}
Mp_1_3_0 a4 gp_1_3_0 colp_L1_3 0 NSYN W=10u L=1u
Mn_1_3_0 a4 vcn coln_L1_3 0 NSYN W=10u L=1u
C_gp_1_3_1 gp_1_3_1 0 {Cg}
Mp_1_3_1 a0 gp_1_3_1 colp_L1_3 0 NSYN W=10u L=1u
Mn_1_3_1 a0 vcn coln_L1_3 0 NSYN W=10u L=1u
C_gp_1_3_2 gp_1_3_2 0 {Cg}
Mp_1_3_2 a5 gp_1_3_2 colp_L1_3 0 NSYN W=10u L=1u
Mn_1_3_2 a5 vcn coln_L1_3 0 NSYN W=10u L=1u
C_gp_1_3_3 gp_1_3_3 0 {Cg}
Mp_1_3_3 a1 gp_1_3_3 colp_L1_3 0 NSYN W=10u L=1u
Mn_1_3_3 a1 vcn coln_L1_3 0 NSYN W=10u L=1u
C_gp_1_3_b gp_1_3_b 0 {Cg}
Mp_1_3_b bx gp_1_3_b colp_L1_3 0 NSYN W=10u L=1u
Mn_1_3_b bx vcn coln_L1_3 0 NSYN W=10u L=1u
Msa_h_L1_3 coln_L1_3 coln_L1_3 0 0 NMIR W=20u L=1u
Msb_h_L1_3 z_L1_3 coln_L1_3 0 0 NMIR W=20u L=1u
Msc_h_L1_3 colp_L1_3 colp_L1_3 0 0 NMIR W=20u L=1u
Msd_h_L1_3 dpf_h_L1_3 colp_L1_3 0 0 NMIR W=20u L=1u
Mse_h_L1_3 dpf_h_L1_3 dpf_h_L1_3 vdd vdd PMIR W=60u L=1u
Msf_h_L1_3 z_L1_3 dpf_h_L1_3 vdd vdd PMIR W=60u L=1u
R_h_L1_3 z_L1_3 vrefh 8000.0
Mr_L1_3  hdd_L1_3 z_L1_3 tail_L1_3 0 NREL W=12u L=1u
Mr2_L1_3 dmp_L1_3  vmid  tail_L1_3 0 NREL W=12u L=1u
Mtl_L1_3 tail_L1_3 vtb 0 0 NREL W=32.0u L=1u
Mdm_L1_3 dmp_L1_3 dmp_L1_3 vdd vdd PMIR W=40u L=1u
Mrp1_L1_3 hdd_L1_3 hdd_L1_3 vdd vdd PMIR W=40u L=1u
Mrp2_L1_3 hv_L1_3 hdd_L1_3 vdd vdd PMIR W=40u L=1u
Rhv_L1_3 hv_L1_3 vg0 8000.0
C_gp_1_4_0 gp_1_4_0 0 {Cg}
Mp_1_4_0 a2 gp_1_4_0 colp_L1_4 0 NSYN W=10u L=1u
Mn_1_4_0 a2 vcn coln_L1_4 0 NSYN W=10u L=1u
C_gp_1_4_1 gp_1_4_1 0 {Cg}
Mp_1_4_1 a6 gp_1_4_1 colp_L1_4 0 NSYN W=10u L=1u
Mn_1_4_1 a6 vcn coln_L1_4 0 NSYN W=10u L=1u
C_gp_1_4_2 gp_1_4_2 0 {Cg}
Mp_1_4_2 a7 gp_1_4_2 colp_L1_4 0 NSYN W=10u L=1u
Mn_1_4_2 a7 vcn coln_L1_4 0 NSYN W=10u L=1u
C_gp_1_4_3 gp_1_4_3 0 {Cg}
Mp_1_4_3 a3 gp_1_4_3 colp_L1_4 0 NSYN W=10u L=1u
Mn_1_4_3 a3 vcn coln_L1_4 0 NSYN W=10u L=1u
C_gp_1_4_b gp_1_4_b 0 {Cg}
Mp_1_4_b bx gp_1_4_b colp_L1_4 0 NSYN W=10u L=1u
Mn_1_4_b bx vcn coln_L1_4 0 NSYN W=10u L=1u
Msa_h_L1_4 coln_L1_4 coln_L1_4 0 0 NMIR W=20u L=1u
Msb_h_L1_4 z_L1_4 coln_L1_4 0 0 NMIR W=20u L=1u
Msc_h_L1_4 colp_L1_4 colp_L1_4 0 0 NMIR W=20u L=1u
Msd_h_L1_4 dpf_h_L1_4 colp_L1_4 0 0 NMIR W=20u L=1u
Mse_h_L1_4 dpf_h_L1_4 dpf_h_L1_4 vdd vdd PMIR W=60u L=1u
Msf_h_L1_4 z_L1_4 dpf_h_L1_4 vdd vdd PMIR W=60u L=1u
R_h_L1_4 z_L1_4 vrefh 8000.0
Mr_L1_4  hdd_L1_4 z_L1_4 tail_L1_4 0 NREL W=12u L=1u
Mr2_L1_4 dmp_L1_4  vmid  tail_L1_4 0 NREL W=12u L=1u
Mtl_L1_4 tail_L1_4 vtb 0 0 NREL W=32.0u L=1u
Mdm_L1_4 dmp_L1_4 dmp_L1_4 vdd vdd PMIR W=40u L=1u
Mrp1_L1_4 hdd_L1_4 hdd_L1_4 vdd vdd PMIR W=40u L=1u
Mrp2_L1_4 hv_L1_4 hdd_L1_4 vdd vdd PMIR W=40u L=1u
Rhv_L1_4 hv_L1_4 vg0 8000.0
C_gp_1_5_0 gp_1_5_0 0 {Cg}
Mp_1_5_0 a3 gp_1_5_0 colp_L1_5 0 NSYN W=10u L=1u
Mn_1_5_0 a3 vcn coln_L1_5 0 NSYN W=10u L=1u
C_gp_1_5_1 gp_1_5_1 0 {Cg}
Mp_1_5_1 a6 gp_1_5_1 colp_L1_5 0 NSYN W=10u L=1u
Mn_1_5_1 a6 vcn coln_L1_5 0 NSYN W=10u L=1u
C_gp_1_5_2 gp_1_5_2 0 {Cg}
Mp_1_5_2 a2 gp_1_5_2 colp_L1_5 0 NSYN W=10u L=1u
Mn_1_5_2 a2 vcn coln_L1_5 0 NSYN W=10u L=1u
C_gp_1_5_3 gp_1_5_3 0 {Cg}
Mp_1_5_3 a7 gp_1_5_3 colp_L1_5 0 NSYN W=10u L=1u
Mn_1_5_3 a7 vcn coln_L1_5 0 NSYN W=10u L=1u
C_gp_1_5_b gp_1_5_b 0 {Cg}
Mp_1_5_b bx gp_1_5_b colp_L1_5 0 NSYN W=10u L=1u
Mn_1_5_b bx vcn coln_L1_5 0 NSYN W=10u L=1u
Msa_h_L1_5 coln_L1_5 coln_L1_5 0 0 NMIR W=20u L=1u
Msb_h_L1_5 z_L1_5 coln_L1_5 0 0 NMIR W=20u L=1u
Msc_h_L1_5 colp_L1_5 colp_L1_5 0 0 NMIR W=20u L=1u
Msd_h_L1_5 dpf_h_L1_5 colp_L1_5 0 0 NMIR W=20u L=1u
Mse_h_L1_5 dpf_h_L1_5 dpf_h_L1_5 vdd vdd PMIR W=60u L=1u
Msf_h_L1_5 z_L1_5 dpf_h_L1_5 vdd vdd PMIR W=60u L=1u
R_h_L1_5 z_L1_5 vrefh 8000.0
Mr_L1_5  hdd_L1_5 z_L1_5 tail_L1_5 0 NREL W=12u L=1u
Mr2_L1_5 dmp_L1_5  vmid  tail_L1_5 0 NREL W=12u L=1u
Mtl_L1_5 tail_L1_5 vtb 0 0 NREL W=32.0u L=1u
Mdm_L1_5 dmp_L1_5 dmp_L1_5 vdd vdd PMIR W=40u L=1u
Mrp1_L1_5 hdd_L1_5 hdd_L1_5 vdd vdd PMIR W=40u L=1u
Mrp2_L1_5 hv_L1_5 hdd_L1_5 vdd vdd PMIR W=40u L=1u
Rhv_L1_5 hv_L1_5 vg0 8000.0
C_gp_1_6_0 gp_1_6_0 0 {Cg}
Mp_1_6_0 a7 gp_1_6_0 colp_L1_6 0 NSYN W=10u L=1u
Mn_1_6_0 a7 vcn coln_L1_6 0 NSYN W=10u L=1u
C_gp_1_6_1 gp_1_6_1 0 {Cg}
Mp_1_6_1 a6 gp_1_6_1 colp_L1_6 0 NSYN W=10u L=1u
Mn_1_6_1 a6 vcn coln_L1_6 0 NSYN W=10u L=1u
C_gp_1_6_2 gp_1_6_2 0 {Cg}
Mp_1_6_2 a3 gp_1_6_2 colp_L1_6 0 NSYN W=10u L=1u
Mn_1_6_2 a3 vcn coln_L1_6 0 NSYN W=10u L=1u
C_gp_1_6_3 gp_1_6_3 0 {Cg}
Mp_1_6_3 a2 gp_1_6_3 colp_L1_6 0 NSYN W=10u L=1u
Mn_1_6_3 a2 vcn coln_L1_6 0 NSYN W=10u L=1u
C_gp_1_6_b gp_1_6_b 0 {Cg}
Mp_1_6_b bx gp_1_6_b colp_L1_6 0 NSYN W=10u L=1u
Mn_1_6_b bx vcn coln_L1_6 0 NSYN W=10u L=1u
Msa_h_L1_6 coln_L1_6 coln_L1_6 0 0 NMIR W=20u L=1u
Msb_h_L1_6 z_L1_6 coln_L1_6 0 0 NMIR W=20u L=1u
Msc_h_L1_6 colp_L1_6 colp_L1_6 0 0 NMIR W=20u L=1u
Msd_h_L1_6 dpf_h_L1_6 colp_L1_6 0 0 NMIR W=20u L=1u
Mse_h_L1_6 dpf_h_L1_6 dpf_h_L1_6 vdd vdd PMIR W=60u L=1u
Msf_h_L1_6 z_L1_6 dpf_h_L1_6 vdd vdd PMIR W=60u L=1u
R_h_L1_6 z_L1_6 vrefh 8000.0
Mr_L1_6  hdd_L1_6 z_L1_6 tail_L1_6 0 NREL W=12u L=1u
Mr2_L1_6 dmp_L1_6  vmid  tail_L1_6 0 NREL W=12u L=1u
Mtl_L1_6 tail_L1_6 vtb 0 0 NREL W=32.0u L=1u
Mdm_L1_6 dmp_L1_6 dmp_L1_6 vdd vdd PMIR W=40u L=1u
Mrp1_L1_6 hdd_L1_6 hdd_L1_6 vdd vdd PMIR W=40u L=1u
Mrp2_L1_6 hv_L1_6 hdd_L1_6 vdd vdd PMIR W=40u L=1u
Rhv_L1_6 hv_L1_6 vg0 8000.0
C_gp_1_7_0 gp_1_7_0 0 {Cg}
Mp_1_7_0 a7 gp_1_7_0 colp_L1_7 0 NSYN W=10u L=1u
Mn_1_7_0 a7 vcn coln_L1_7 0 NSYN W=10u L=1u
C_gp_1_7_1 gp_1_7_1 0 {Cg}
Mp_1_7_1 a2 gp_1_7_1 colp_L1_7 0 NSYN W=10u L=1u
Mn_1_7_1 a2 vcn coln_L1_7 0 NSYN W=10u L=1u
C_gp_1_7_2 gp_1_7_2 0 {Cg}
Mp_1_7_2 a6 gp_1_7_2 colp_L1_7 0 NSYN W=10u L=1u
Mn_1_7_2 a6 vcn coln_L1_7 0 NSYN W=10u L=1u
C_gp_1_7_3 gp_1_7_3 0 {Cg}
Mp_1_7_3 a3 gp_1_7_3 colp_L1_7 0 NSYN W=10u L=1u
Mn_1_7_3 a3 vcn coln_L1_7 0 NSYN W=10u L=1u
C_gp_1_7_b gp_1_7_b 0 {Cg}
Mp_1_7_b bx gp_1_7_b colp_L1_7 0 NSYN W=10u L=1u
Mn_1_7_b bx vcn coln_L1_7 0 NSYN W=10u L=1u
Msa_h_L1_7 coln_L1_7 coln_L1_7 0 0 NMIR W=20u L=1u
Msb_h_L1_7 z_L1_7 coln_L1_7 0 0 NMIR W=20u L=1u
Msc_h_L1_7 colp_L1_7 colp_L1_7 0 0 NMIR W=20u L=1u
Msd_h_L1_7 dpf_h_L1_7 colp_L1_7 0 0 NMIR W=20u L=1u
Mse_h_L1_7 dpf_h_L1_7 dpf_h_L1_7 vdd vdd PMIR W=60u L=1u
Msf_h_L1_7 z_L1_7 dpf_h_L1_7 vdd vdd PMIR W=60u L=1u
R_h_L1_7 z_L1_7 vrefh 8000.0
Mr_L1_7  hdd_L1_7 z_L1_7 tail_L1_7 0 NREL W=12u L=1u
Mr2_L1_7 dmp_L1_7  vmid  tail_L1_7 0 NREL W=12u L=1u
Mtl_L1_7 tail_L1_7 vtb 0 0 NREL W=32.0u L=1u
Mdm_L1_7 dmp_L1_7 dmp_L1_7 vdd vdd PMIR W=40u L=1u
Mrp1_L1_7 hdd_L1_7 hdd_L1_7 vdd vdd PMIR W=40u L=1u
Mrp2_L1_7 hv_L1_7 hdd_L1_7 vdd vdd PMIR W=40u L=1u
Rhv_L1_7 hv_L1_7 vg0 8000.0
C_gp_1_8_0 gp_1_8_0 0 {Cg}
Mp_1_8_0 a12 gp_1_8_0 colp_L1_8 0 NSYN W=10u L=1u
Mn_1_8_0 a12 vcn coln_L1_8 0 NSYN W=10u L=1u
C_gp_1_8_1 gp_1_8_1 0 {Cg}
Mp_1_8_1 a8 gp_1_8_1 colp_L1_8 0 NSYN W=10u L=1u
Mn_1_8_1 a8 vcn coln_L1_8 0 NSYN W=10u L=1u
C_gp_1_8_2 gp_1_8_2 0 {Cg}
Mp_1_8_2 a9 gp_1_8_2 colp_L1_8 0 NSYN W=10u L=1u
Mn_1_8_2 a9 vcn coln_L1_8 0 NSYN W=10u L=1u
C_gp_1_8_3 gp_1_8_3 0 {Cg}
Mp_1_8_3 a13 gp_1_8_3 colp_L1_8 0 NSYN W=10u L=1u
Mn_1_8_3 a13 vcn coln_L1_8 0 NSYN W=10u L=1u
C_gp_1_8_b gp_1_8_b 0 {Cg}
Mp_1_8_b bx gp_1_8_b colp_L1_8 0 NSYN W=10u L=1u
Mn_1_8_b bx vcn coln_L1_8 0 NSYN W=10u L=1u
Msa_h_L1_8 coln_L1_8 coln_L1_8 0 0 NMIR W=20u L=1u
Msb_h_L1_8 z_L1_8 coln_L1_8 0 0 NMIR W=20u L=1u
Msc_h_L1_8 colp_L1_8 colp_L1_8 0 0 NMIR W=20u L=1u
Msd_h_L1_8 dpf_h_L1_8 colp_L1_8 0 0 NMIR W=20u L=1u
Mse_h_L1_8 dpf_h_L1_8 dpf_h_L1_8 vdd vdd PMIR W=60u L=1u
Msf_h_L1_8 z_L1_8 dpf_h_L1_8 vdd vdd PMIR W=60u L=1u
R_h_L1_8 z_L1_8 vrefh 8000.0
Mr_L1_8  hdd_L1_8 z_L1_8 tail_L1_8 0 NREL W=12u L=1u
Mr2_L1_8 dmp_L1_8  vmid  tail_L1_8 0 NREL W=12u L=1u
Mtl_L1_8 tail_L1_8 vtb 0 0 NREL W=32.0u L=1u
Mdm_L1_8 dmp_L1_8 dmp_L1_8 vdd vdd PMIR W=40u L=1u
Mrp1_L1_8 hdd_L1_8 hdd_L1_8 vdd vdd PMIR W=40u L=1u
Mrp2_L1_8 hv_L1_8 hdd_L1_8 vdd vdd PMIR W=40u L=1u
Rhv_L1_8 hv_L1_8 vg0 8000.0
C_gp_1_9_0 gp_1_9_0 0 {Cg}
Mp_1_9_0 a8 gp_1_9_0 colp_L1_9 0 NSYN W=10u L=1u
Mn_1_9_0 a8 vcn coln_L1_9 0 NSYN W=10u L=1u
C_gp_1_9_1 gp_1_9_1 0 {Cg}
Mp_1_9_1 a13 gp_1_9_1 colp_L1_9 0 NSYN W=10u L=1u
Mn_1_9_1 a13 vcn coln_L1_9 0 NSYN W=10u L=1u
C_gp_1_9_2 gp_1_9_2 0 {Cg}
Mp_1_9_2 a12 gp_1_9_2 colp_L1_9 0 NSYN W=10u L=1u
Mn_1_9_2 a12 vcn coln_L1_9 0 NSYN W=10u L=1u
C_gp_1_9_3 gp_1_9_3 0 {Cg}
Mp_1_9_3 a9 gp_1_9_3 colp_L1_9 0 NSYN W=10u L=1u
Mn_1_9_3 a9 vcn coln_L1_9 0 NSYN W=10u L=1u
C_gp_1_9_b gp_1_9_b 0 {Cg}
Mp_1_9_b bx gp_1_9_b colp_L1_9 0 NSYN W=10u L=1u
Mn_1_9_b bx vcn coln_L1_9 0 NSYN W=10u L=1u
Msa_h_L1_9 coln_L1_9 coln_L1_9 0 0 NMIR W=20u L=1u
Msb_h_L1_9 z_L1_9 coln_L1_9 0 0 NMIR W=20u L=1u
Msc_h_L1_9 colp_L1_9 colp_L1_9 0 0 NMIR W=20u L=1u
Msd_h_L1_9 dpf_h_L1_9 colp_L1_9 0 0 NMIR W=20u L=1u
Mse_h_L1_9 dpf_h_L1_9 dpf_h_L1_9 vdd vdd PMIR W=60u L=1u
Msf_h_L1_9 z_L1_9 dpf_h_L1_9 vdd vdd PMIR W=60u L=1u
R_h_L1_9 z_L1_9 vrefh 8000.0
Mr_L1_9  hdd_L1_9 z_L1_9 tail_L1_9 0 NREL W=12u L=1u
Mr2_L1_9 dmp_L1_9  vmid  tail_L1_9 0 NREL W=12u L=1u
Mtl_L1_9 tail_L1_9 vtb 0 0 NREL W=32.0u L=1u
Mdm_L1_9 dmp_L1_9 dmp_L1_9 vdd vdd PMIR W=40u L=1u
Mrp1_L1_9 hdd_L1_9 hdd_L1_9 vdd vdd PMIR W=40u L=1u
Mrp2_L1_9 hv_L1_9 hdd_L1_9 vdd vdd PMIR W=40u L=1u
Rhv_L1_9 hv_L1_9 vg0 8000.0
C_gp_1_10_0 gp_1_10_0 0 {Cg}
Mp_1_10_0 a13 gp_1_10_0 colp_L1_10 0 NSYN W=10u L=1u
Mn_1_10_0 a13 vcn coln_L1_10 0 NSYN W=10u L=1u
C_gp_1_10_1 gp_1_10_1 0 {Cg}
Mp_1_10_1 a12 gp_1_10_1 colp_L1_10 0 NSYN W=10u L=1u
Mn_1_10_1 a12 vcn coln_L1_10 0 NSYN W=10u L=1u
C_gp_1_10_2 gp_1_10_2 0 {Cg}
Mp_1_10_2 a8 gp_1_10_2 colp_L1_10 0 NSYN W=10u L=1u
Mn_1_10_2 a8 vcn coln_L1_10 0 NSYN W=10u L=1u
C_gp_1_10_3 gp_1_10_3 0 {Cg}
Mp_1_10_3 a9 gp_1_10_3 colp_L1_10 0 NSYN W=10u L=1u
Mn_1_10_3 a9 vcn coln_L1_10 0 NSYN W=10u L=1u
C_gp_1_10_b gp_1_10_b 0 {Cg}
Mp_1_10_b bx gp_1_10_b colp_L1_10 0 NSYN W=10u L=1u
Mn_1_10_b bx vcn coln_L1_10 0 NSYN W=10u L=1u
Msa_h_L1_10 coln_L1_10 coln_L1_10 0 0 NMIR W=20u L=1u
Msb_h_L1_10 z_L1_10 coln_L1_10 0 0 NMIR W=20u L=1u
Msc_h_L1_10 colp_L1_10 colp_L1_10 0 0 NMIR W=20u L=1u
Msd_h_L1_10 dpf_h_L1_10 colp_L1_10 0 0 NMIR W=20u L=1u
Mse_h_L1_10 dpf_h_L1_10 dpf_h_L1_10 vdd vdd PMIR W=60u L=1u
Msf_h_L1_10 z_L1_10 dpf_h_L1_10 vdd vdd PMIR W=60u L=1u
R_h_L1_10 z_L1_10 vrefh 8000.0
Mr_L1_10  hdd_L1_10 z_L1_10 tail_L1_10 0 NREL W=12u L=1u
Mr2_L1_10 dmp_L1_10  vmid  tail_L1_10 0 NREL W=12u L=1u
Mtl_L1_10 tail_L1_10 vtb 0 0 NREL W=32.0u L=1u
Mdm_L1_10 dmp_L1_10 dmp_L1_10 vdd vdd PMIR W=40u L=1u
Mrp1_L1_10 hdd_L1_10 hdd_L1_10 vdd vdd PMIR W=40u L=1u
Mrp2_L1_10 hv_L1_10 hdd_L1_10 vdd vdd PMIR W=40u L=1u
Rhv_L1_10 hv_L1_10 vg0 8000.0
C_gp_1_11_0 gp_1_11_0 0 {Cg}
Mp_1_11_0 a9 gp_1_11_0 colp_L1_11 0 NSYN W=10u L=1u
Mn_1_11_0 a9 vcn coln_L1_11 0 NSYN W=10u L=1u
C_gp_1_11_1 gp_1_11_1 0 {Cg}
Mp_1_11_1 a12 gp_1_11_1 colp_L1_11 0 NSYN W=10u L=1u
Mn_1_11_1 a12 vcn coln_L1_11 0 NSYN W=10u L=1u
C_gp_1_11_2 gp_1_11_2 0 {Cg}
Mp_1_11_2 a13 gp_1_11_2 colp_L1_11 0 NSYN W=10u L=1u
Mn_1_11_2 a13 vcn coln_L1_11 0 NSYN W=10u L=1u
C_gp_1_11_3 gp_1_11_3 0 {Cg}
Mp_1_11_3 a8 gp_1_11_3 colp_L1_11 0 NSYN W=10u L=1u
Mn_1_11_3 a8 vcn coln_L1_11 0 NSYN W=10u L=1u
C_gp_1_11_b gp_1_11_b 0 {Cg}
Mp_1_11_b bx gp_1_11_b colp_L1_11 0 NSYN W=10u L=1u
Mn_1_11_b bx vcn coln_L1_11 0 NSYN W=10u L=1u
Msa_h_L1_11 coln_L1_11 coln_L1_11 0 0 NMIR W=20u L=1u
Msb_h_L1_11 z_L1_11 coln_L1_11 0 0 NMIR W=20u L=1u
Msc_h_L1_11 colp_L1_11 colp_L1_11 0 0 NMIR W=20u L=1u
Msd_h_L1_11 dpf_h_L1_11 colp_L1_11 0 0 NMIR W=20u L=1u
Mse_h_L1_11 dpf_h_L1_11 dpf_h_L1_11 vdd vdd PMIR W=60u L=1u
Msf_h_L1_11 z_L1_11 dpf_h_L1_11 vdd vdd PMIR W=60u L=1u
R_h_L1_11 z_L1_11 vrefh 8000.0
Mr_L1_11  hdd_L1_11 z_L1_11 tail_L1_11 0 NREL W=12u L=1u
Mr2_L1_11 dmp_L1_11  vmid  tail_L1_11 0 NREL W=12u L=1u
Mtl_L1_11 tail_L1_11 vtb 0 0 NREL W=32.0u L=1u
Mdm_L1_11 dmp_L1_11 dmp_L1_11 vdd vdd PMIR W=40u L=1u
Mrp1_L1_11 hdd_L1_11 hdd_L1_11 vdd vdd PMIR W=40u L=1u
Mrp2_L1_11 hv_L1_11 hdd_L1_11 vdd vdd PMIR W=40u L=1u
Rhv_L1_11 hv_L1_11 vg0 8000.0
C_gp_1_12_0 gp_1_12_0 0 {Cg}
Mp_1_12_0 a10 gp_1_12_0 colp_L1_12 0 NSYN W=10u L=1u
Mn_1_12_0 a10 vcn coln_L1_12 0 NSYN W=10u L=1u
C_gp_1_12_1 gp_1_12_1 0 {Cg}
Mp_1_12_1 a14 gp_1_12_1 colp_L1_12 0 NSYN W=10u L=1u
Mn_1_12_1 a14 vcn coln_L1_12 0 NSYN W=10u L=1u
C_gp_1_12_2 gp_1_12_2 0 {Cg}
Mp_1_12_2 a15 gp_1_12_2 colp_L1_12 0 NSYN W=10u L=1u
Mn_1_12_2 a15 vcn coln_L1_12 0 NSYN W=10u L=1u
C_gp_1_12_3 gp_1_12_3 0 {Cg}
Mp_1_12_3 a11 gp_1_12_3 colp_L1_12 0 NSYN W=10u L=1u
Mn_1_12_3 a11 vcn coln_L1_12 0 NSYN W=10u L=1u
C_gp_1_12_b gp_1_12_b 0 {Cg}
Mp_1_12_b bx gp_1_12_b colp_L1_12 0 NSYN W=10u L=1u
Mn_1_12_b bx vcn coln_L1_12 0 NSYN W=10u L=1u
Msa_h_L1_12 coln_L1_12 coln_L1_12 0 0 NMIR W=20u L=1u
Msb_h_L1_12 z_L1_12 coln_L1_12 0 0 NMIR W=20u L=1u
Msc_h_L1_12 colp_L1_12 colp_L1_12 0 0 NMIR W=20u L=1u
Msd_h_L1_12 dpf_h_L1_12 colp_L1_12 0 0 NMIR W=20u L=1u
Mse_h_L1_12 dpf_h_L1_12 dpf_h_L1_12 vdd vdd PMIR W=60u L=1u
Msf_h_L1_12 z_L1_12 dpf_h_L1_12 vdd vdd PMIR W=60u L=1u
R_h_L1_12 z_L1_12 vrefh 8000.0
Mr_L1_12  hdd_L1_12 z_L1_12 tail_L1_12 0 NREL W=12u L=1u
Mr2_L1_12 dmp_L1_12  vmid  tail_L1_12 0 NREL W=12u L=1u
Mtl_L1_12 tail_L1_12 vtb 0 0 NREL W=32.0u L=1u
Mdm_L1_12 dmp_L1_12 dmp_L1_12 vdd vdd PMIR W=40u L=1u
Mrp1_L1_12 hdd_L1_12 hdd_L1_12 vdd vdd PMIR W=40u L=1u
Mrp2_L1_12 hv_L1_12 hdd_L1_12 vdd vdd PMIR W=40u L=1u
Rhv_L1_12 hv_L1_12 vg0 8000.0
C_gp_1_13_0 gp_1_13_0 0 {Cg}
Mp_1_13_0 a15 gp_1_13_0 colp_L1_13 0 NSYN W=10u L=1u
Mn_1_13_0 a15 vcn coln_L1_13 0 NSYN W=10u L=1u
C_gp_1_13_1 gp_1_13_1 0 {Cg}
Mp_1_13_1 a14 gp_1_13_1 colp_L1_13 0 NSYN W=10u L=1u
Mn_1_13_1 a14 vcn coln_L1_13 0 NSYN W=10u L=1u
C_gp_1_13_2 gp_1_13_2 0 {Cg}
Mp_1_13_2 a10 gp_1_13_2 colp_L1_13 0 NSYN W=10u L=1u
Mn_1_13_2 a10 vcn coln_L1_13 0 NSYN W=10u L=1u
C_gp_1_13_3 gp_1_13_3 0 {Cg}
Mp_1_13_3 a11 gp_1_13_3 colp_L1_13 0 NSYN W=10u L=1u
Mn_1_13_3 a11 vcn coln_L1_13 0 NSYN W=10u L=1u
C_gp_1_13_b gp_1_13_b 0 {Cg}
Mp_1_13_b bx gp_1_13_b colp_L1_13 0 NSYN W=10u L=1u
Mn_1_13_b bx vcn coln_L1_13 0 NSYN W=10u L=1u
Msa_h_L1_13 coln_L1_13 coln_L1_13 0 0 NMIR W=20u L=1u
Msb_h_L1_13 z_L1_13 coln_L1_13 0 0 NMIR W=20u L=1u
Msc_h_L1_13 colp_L1_13 colp_L1_13 0 0 NMIR W=20u L=1u
Msd_h_L1_13 dpf_h_L1_13 colp_L1_13 0 0 NMIR W=20u L=1u
Mse_h_L1_13 dpf_h_L1_13 dpf_h_L1_13 vdd vdd PMIR W=60u L=1u
Msf_h_L1_13 z_L1_13 dpf_h_L1_13 vdd vdd PMIR W=60u L=1u
R_h_L1_13 z_L1_13 vrefh 8000.0
Mr_L1_13  hdd_L1_13 z_L1_13 tail_L1_13 0 NREL W=12u L=1u
Mr2_L1_13 dmp_L1_13  vmid  tail_L1_13 0 NREL W=12u L=1u
Mtl_L1_13 tail_L1_13 vtb 0 0 NREL W=32.0u L=1u
Mdm_L1_13 dmp_L1_13 dmp_L1_13 vdd vdd PMIR W=40u L=1u
Mrp1_L1_13 hdd_L1_13 hdd_L1_13 vdd vdd PMIR W=40u L=1u
Mrp2_L1_13 hv_L1_13 hdd_L1_13 vdd vdd PMIR W=40u L=1u
Rhv_L1_13 hv_L1_13 vg0 8000.0
C_gp_1_14_0 gp_1_14_0 0 {Cg}
Mp_1_14_0 a15 gp_1_14_0 colp_L1_14 0 NSYN W=10u L=1u
Mn_1_14_0 a15 vcn coln_L1_14 0 NSYN W=10u L=1u
C_gp_1_14_1 gp_1_14_1 0 {Cg}
Mp_1_14_1 a10 gp_1_14_1 colp_L1_14 0 NSYN W=10u L=1u
Mn_1_14_1 a10 vcn coln_L1_14 0 NSYN W=10u L=1u
C_gp_1_14_2 gp_1_14_2 0 {Cg}
Mp_1_14_2 a11 gp_1_14_2 colp_L1_14 0 NSYN W=10u L=1u
Mn_1_14_2 a11 vcn coln_L1_14 0 NSYN W=10u L=1u
C_gp_1_14_3 gp_1_14_3 0 {Cg}
Mp_1_14_3 a14 gp_1_14_3 colp_L1_14 0 NSYN W=10u L=1u
Mn_1_14_3 a14 vcn coln_L1_14 0 NSYN W=10u L=1u
C_gp_1_14_b gp_1_14_b 0 {Cg}
Mp_1_14_b bx gp_1_14_b colp_L1_14 0 NSYN W=10u L=1u
Mn_1_14_b bx vcn coln_L1_14 0 NSYN W=10u L=1u
Msa_h_L1_14 coln_L1_14 coln_L1_14 0 0 NMIR W=20u L=1u
Msb_h_L1_14 z_L1_14 coln_L1_14 0 0 NMIR W=20u L=1u
Msc_h_L1_14 colp_L1_14 colp_L1_14 0 0 NMIR W=20u L=1u
Msd_h_L1_14 dpf_h_L1_14 colp_L1_14 0 0 NMIR W=20u L=1u
Mse_h_L1_14 dpf_h_L1_14 dpf_h_L1_14 vdd vdd PMIR W=60u L=1u
Msf_h_L1_14 z_L1_14 dpf_h_L1_14 vdd vdd PMIR W=60u L=1u
R_h_L1_14 z_L1_14 vrefh 8000.0
Mr_L1_14  hdd_L1_14 z_L1_14 tail_L1_14 0 NREL W=12u L=1u
Mr2_L1_14 dmp_L1_14  vmid  tail_L1_14 0 NREL W=12u L=1u
Mtl_L1_14 tail_L1_14 vtb 0 0 NREL W=32.0u L=1u
Mdm_L1_14 dmp_L1_14 dmp_L1_14 vdd vdd PMIR W=40u L=1u
Mrp1_L1_14 hdd_L1_14 hdd_L1_14 vdd vdd PMIR W=40u L=1u
Mrp2_L1_14 hv_L1_14 hdd_L1_14 vdd vdd PMIR W=40u L=1u
Rhv_L1_14 hv_L1_14 vg0 8000.0
C_gp_1_15_0 gp_1_15_0 0 {Cg}
Mp_1_15_0 a11 gp_1_15_0 colp_L1_15 0 NSYN W=10u L=1u
Mn_1_15_0 a11 vcn coln_L1_15 0 NSYN W=10u L=1u
C_gp_1_15_1 gp_1_15_1 0 {Cg}
Mp_1_15_1 a10 gp_1_15_1 colp_L1_15 0 NSYN W=10u L=1u
Mn_1_15_1 a10 vcn coln_L1_15 0 NSYN W=10u L=1u
C_gp_1_15_2 gp_1_15_2 0 {Cg}
Mp_1_15_2 a14 gp_1_15_2 colp_L1_15 0 NSYN W=10u L=1u
Mn_1_15_2 a14 vcn coln_L1_15 0 NSYN W=10u L=1u
C_gp_1_15_3 gp_1_15_3 0 {Cg}
Mp_1_15_3 a15 gp_1_15_3 colp_L1_15 0 NSYN W=10u L=1u
Mn_1_15_3 a15 vcn coln_L1_15 0 NSYN W=10u L=1u
C_gp_1_15_b gp_1_15_b 0 {Cg}
Mp_1_15_b bx gp_1_15_b colp_L1_15 0 NSYN W=10u L=1u
Mn_1_15_b bx vcn coln_L1_15 0 NSYN W=10u L=1u
Msa_h_L1_15 coln_L1_15 coln_L1_15 0 0 NMIR W=20u L=1u
Msb_h_L1_15 z_L1_15 coln_L1_15 0 0 NMIR W=20u L=1u
Msc_h_L1_15 colp_L1_15 colp_L1_15 0 0 NMIR W=20u L=1u
Msd_h_L1_15 dpf_h_L1_15 colp_L1_15 0 0 NMIR W=20u L=1u
Mse_h_L1_15 dpf_h_L1_15 dpf_h_L1_15 vdd vdd PMIR W=60u L=1u
Msf_h_L1_15 z_L1_15 dpf_h_L1_15 vdd vdd PMIR W=60u L=1u
R_h_L1_15 z_L1_15 vrefh 8000.0
Mr_L1_15  hdd_L1_15 z_L1_15 tail_L1_15 0 NREL W=12u L=1u
Mr2_L1_15 dmp_L1_15  vmid  tail_L1_15 0 NREL W=12u L=1u
Mtl_L1_15 tail_L1_15 vtb 0 0 NREL W=32.0u L=1u
Mdm_L1_15 dmp_L1_15 dmp_L1_15 vdd vdd PMIR W=40u L=1u
Mrp1_L1_15 hdd_L1_15 hdd_L1_15 vdd vdd PMIR W=40u L=1u
Mrp2_L1_15 hv_L1_15 hdd_L1_15 vdd vdd PMIR W=40u L=1u
Rhv_L1_15 hv_L1_15 vg0 8000.0
C_gp_2_0_0 gp_2_0_0 0 {Cg}
Mp_2_0_0 hv_L1_7 gp_2_0_0 colp_L2_0 0 NSYN W=10u L=1u
Mn_2_0_0 hv_L1_7 vcn coln_L2_0 0 NSYN W=10u L=1u
C_gp_2_0_1 gp_2_0_1 0 {Cg}
Mp_2_0_1 hv_L1_3 gp_2_0_1 colp_L2_0 0 NSYN W=10u L=1u
Mn_2_0_1 hv_L1_3 vcn coln_L2_0 0 NSYN W=10u L=1u
C_gp_2_0_2 gp_2_0_2 0 {Cg}
Mp_2_0_2 hv_L1_11 gp_2_0_2 colp_L2_0 0 NSYN W=10u L=1u
Mn_2_0_2 hv_L1_11 vcn coln_L2_0 0 NSYN W=10u L=1u
C_gp_2_0_3 gp_2_0_3 0 {Cg}
Mp_2_0_3 hv_L1_6 gp_2_0_3 colp_L2_0 0 NSYN W=10u L=1u
Mn_2_0_3 hv_L1_6 vcn coln_L2_0 0 NSYN W=10u L=1u
C_gp_2_0_b gp_2_0_b 0 {Cg}
Mp_2_0_b bx gp_2_0_b colp_L2_0 0 NSYN W=10u L=1u
Mn_2_0_b bx vcn coln_L2_0 0 NSYN W=10u L=1u
Msa_h_L2_0 coln_L2_0 coln_L2_0 0 0 NMIR W=20u L=1u
Msb_h_L2_0 z_L2_0 coln_L2_0 0 0 NMIR W=20u L=1u
Msc_h_L2_0 colp_L2_0 colp_L2_0 0 0 NMIR W=20u L=1u
Msd_h_L2_0 dpf_h_L2_0 colp_L2_0 0 0 NMIR W=20u L=1u
Mse_h_L2_0 dpf_h_L2_0 dpf_h_L2_0 vdd vdd PMIR W=60u L=1u
Msf_h_L2_0 z_L2_0 dpf_h_L2_0 vdd vdd PMIR W=60u L=1u
R_h_L2_0 z_L2_0 vrefh 8000.0
Mr_L2_0  hdd_L2_0 z_L2_0 tail_L2_0 0 NREL W=12u L=1u
Mr2_L2_0 dmp_L2_0  vmid  tail_L2_0 0 NREL W=12u L=1u
Mtl_L2_0 tail_L2_0 vtb 0 0 NREL W=32.0u L=1u
Mdm_L2_0 dmp_L2_0 dmp_L2_0 vdd vdd PMIR W=40u L=1u
Mrp1_L2_0 hdd_L2_0 hdd_L2_0 vdd vdd PMIR W=40u L=1u
Mrp2_L2_0 hv_L2_0 hdd_L2_0 vdd vdd PMIR W=40u L=1u
Rhv_L2_0 hv_L2_0 vg0 8000.0
C_gp_2_1_0 gp_2_1_0 0 {Cg}
Mp_2_1_0 hv_L1_13 gp_2_1_0 colp_L2_1 0 NSYN W=10u L=1u
Mn_2_1_0 hv_L1_13 vcn coln_L2_1 0 NSYN W=10u L=1u
C_gp_2_1_1 gp_2_1_1 0 {Cg}
Mp_2_1_1 hv_L1_12 gp_2_1_1 colp_L2_1 0 NSYN W=10u L=1u
Mn_2_1_1 hv_L1_12 vcn coln_L2_1 0 NSYN W=10u L=1u
C_gp_2_1_2 gp_2_1_2 0 {Cg}
Mp_2_1_2 hv_L1_14 gp_2_1_2 colp_L2_1 0 NSYN W=10u L=1u
Mn_2_1_2 hv_L1_14 vcn coln_L2_1 0 NSYN W=10u L=1u
C_gp_2_1_3 gp_2_1_3 0 {Cg}
Mp_2_1_3 hv_L1_8 gp_2_1_3 colp_L2_1 0 NSYN W=10u L=1u
Mn_2_1_3 hv_L1_8 vcn coln_L2_1 0 NSYN W=10u L=1u
C_gp_2_1_b gp_2_1_b 0 {Cg}
Mp_2_1_b bx gp_2_1_b colp_L2_1 0 NSYN W=10u L=1u
Mn_2_1_b bx vcn coln_L2_1 0 NSYN W=10u L=1u
Msa_h_L2_1 coln_L2_1 coln_L2_1 0 0 NMIR W=20u L=1u
Msb_h_L2_1 z_L2_1 coln_L2_1 0 0 NMIR W=20u L=1u
Msc_h_L2_1 colp_L2_1 colp_L2_1 0 0 NMIR W=20u L=1u
Msd_h_L2_1 dpf_h_L2_1 colp_L2_1 0 0 NMIR W=20u L=1u
Mse_h_L2_1 dpf_h_L2_1 dpf_h_L2_1 vdd vdd PMIR W=60u L=1u
Msf_h_L2_1 z_L2_1 dpf_h_L2_1 vdd vdd PMIR W=60u L=1u
R_h_L2_1 z_L2_1 vrefh 8000.0
Mr_L2_1  hdd_L2_1 z_L2_1 tail_L2_1 0 NREL W=12u L=1u
Mr2_L2_1 dmp_L2_1  vmid  tail_L2_1 0 NREL W=12u L=1u
Mtl_L2_1 tail_L2_1 vtb 0 0 NREL W=32.0u L=1u
Mdm_L2_1 dmp_L2_1 dmp_L2_1 vdd vdd PMIR W=40u L=1u
Mrp1_L2_1 hdd_L2_1 hdd_L2_1 vdd vdd PMIR W=40u L=1u
Mrp2_L2_1 hv_L2_1 hdd_L2_1 vdd vdd PMIR W=40u L=1u
Rhv_L2_1 hv_L2_1 vg0 8000.0
C_gp_2_2_0 gp_2_2_0 0 {Cg}
Mp_2_2_0 hv_L1_15 gp_2_2_0 colp_L2_2 0 NSYN W=10u L=1u
Mn_2_2_0 hv_L1_15 vcn coln_L2_2 0 NSYN W=10u L=1u
C_gp_2_2_1 gp_2_2_1 0 {Cg}
Mp_2_2_1 hv_L1_4 gp_2_2_1 colp_L2_2 0 NSYN W=10u L=1u
Mn_2_2_1 hv_L1_4 vcn coln_L2_2 0 NSYN W=10u L=1u
C_gp_2_2_2 gp_2_2_2 0 {Cg}
Mp_2_2_2 hv_L1_5 gp_2_2_2 colp_L2_2 0 NSYN W=10u L=1u
Mn_2_2_2 hv_L1_5 vcn coln_L2_2 0 NSYN W=10u L=1u
C_gp_2_2_3 gp_2_2_3 0 {Cg}
Mp_2_2_3 hv_L1_9 gp_2_2_3 colp_L2_2 0 NSYN W=10u L=1u
Mn_2_2_3 hv_L1_9 vcn coln_L2_2 0 NSYN W=10u L=1u
C_gp_2_2_b gp_2_2_b 0 {Cg}
Mp_2_2_b bx gp_2_2_b colp_L2_2 0 NSYN W=10u L=1u
Mn_2_2_b bx vcn coln_L2_2 0 NSYN W=10u L=1u
Msa_h_L2_2 coln_L2_2 coln_L2_2 0 0 NMIR W=20u L=1u
Msb_h_L2_2 z_L2_2 coln_L2_2 0 0 NMIR W=20u L=1u
Msc_h_L2_2 colp_L2_2 colp_L2_2 0 0 NMIR W=20u L=1u
Msd_h_L2_2 dpf_h_L2_2 colp_L2_2 0 0 NMIR W=20u L=1u
Mse_h_L2_2 dpf_h_L2_2 dpf_h_L2_2 vdd vdd PMIR W=60u L=1u
Msf_h_L2_2 z_L2_2 dpf_h_L2_2 vdd vdd PMIR W=60u L=1u
R_h_L2_2 z_L2_2 vrefh 8000.0
Mr_L2_2  hdd_L2_2 z_L2_2 tail_L2_2 0 NREL W=12u L=1u
Mr2_L2_2 dmp_L2_2  vmid  tail_L2_2 0 NREL W=12u L=1u
Mtl_L2_2 tail_L2_2 vtb 0 0 NREL W=32.0u L=1u
Mdm_L2_2 dmp_L2_2 dmp_L2_2 vdd vdd PMIR W=40u L=1u
Mrp1_L2_2 hdd_L2_2 hdd_L2_2 vdd vdd PMIR W=40u L=1u
Mrp2_L2_2 hv_L2_2 hdd_L2_2 vdd vdd PMIR W=40u L=1u
Rhv_L2_2 hv_L2_2 vg0 8000.0
C_gp_2_3_0 gp_2_3_0 0 {Cg}
Mp_2_3_0 hv_L1_1 gp_2_3_0 colp_L2_3 0 NSYN W=10u L=1u
Mn_2_3_0 hv_L1_1 vcn coln_L2_3 0 NSYN W=10u L=1u
C_gp_2_3_1 gp_2_3_1 0 {Cg}
Mp_2_3_1 hv_L1_0 gp_2_3_1 colp_L2_3 0 NSYN W=10u L=1u
Mn_2_3_1 hv_L1_0 vcn coln_L2_3 0 NSYN W=10u L=1u
C_gp_2_3_2 gp_2_3_2 0 {Cg}
Mp_2_3_2 hv_L1_10 gp_2_3_2 colp_L2_3 0 NSYN W=10u L=1u
Mn_2_3_2 hv_L1_10 vcn coln_L2_3 0 NSYN W=10u L=1u
C_gp_2_3_3 gp_2_3_3 0 {Cg}
Mp_2_3_3 hv_L1_2 gp_2_3_3 colp_L2_3 0 NSYN W=10u L=1u
Mn_2_3_3 hv_L1_2 vcn coln_L2_3 0 NSYN W=10u L=1u
C_gp_2_3_b gp_2_3_b 0 {Cg}
Mp_2_3_b bx gp_2_3_b colp_L2_3 0 NSYN W=10u L=1u
Mn_2_3_b bx vcn coln_L2_3 0 NSYN W=10u L=1u
Msa_h_L2_3 coln_L2_3 coln_L2_3 0 0 NMIR W=20u L=1u
Msb_h_L2_3 z_L2_3 coln_L2_3 0 0 NMIR W=20u L=1u
Msc_h_L2_3 colp_L2_3 colp_L2_3 0 0 NMIR W=20u L=1u
Msd_h_L2_3 dpf_h_L2_3 colp_L2_3 0 0 NMIR W=20u L=1u
Mse_h_L2_3 dpf_h_L2_3 dpf_h_L2_3 vdd vdd PMIR W=60u L=1u
Msf_h_L2_3 z_L2_3 dpf_h_L2_3 vdd vdd PMIR W=60u L=1u
R_h_L2_3 z_L2_3 vrefh 8000.0
Mr_L2_3  hdd_L2_3 z_L2_3 tail_L2_3 0 NREL W=12u L=1u
Mr2_L2_3 dmp_L2_3  vmid  tail_L2_3 0 NREL W=12u L=1u
Mtl_L2_3 tail_L2_3 vtb 0 0 NREL W=32.0u L=1u
Mdm_L2_3 dmp_L2_3 dmp_L2_3 vdd vdd PMIR W=40u L=1u
Mrp1_L2_3 hdd_L2_3 hdd_L2_3 vdd vdd PMIR W=40u L=1u
Mrp2_L2_3 hv_L2_3 hdd_L2_3 vdd vdd PMIR W=40u L=1u
Rhv_L2_3 hv_L2_3 vg0 8000.0
C_gp_2_4_0 gp_2_4_0 0 {Cg}
Mp_2_4_0 hv_L1_0 gp_2_4_0 colp_L2_4 0 NSYN W=10u L=1u
Mn_2_4_0 hv_L1_0 vcn coln_L2_4 0 NSYN W=10u L=1u
C_gp_2_4_1 gp_2_4_1 0 {Cg}
Mp_2_4_1 hv_L1_2 gp_2_4_1 colp_L2_4 0 NSYN W=10u L=1u
Mn_2_4_1 hv_L1_2 vcn coln_L2_4 0 NSYN W=10u L=1u
C_gp_2_4_2 gp_2_4_2 0 {Cg}
Mp_2_4_2 hv_L1_13 gp_2_4_2 colp_L2_4 0 NSYN W=10u L=1u
Mn_2_4_2 hv_L1_13 vcn coln_L2_4 0 NSYN W=10u L=1u
C_gp_2_4_3 gp_2_4_3 0 {Cg}
Mp_2_4_3 hv_L1_3 gp_2_4_3 colp_L2_4 0 NSYN W=10u L=1u
Mn_2_4_3 hv_L1_3 vcn coln_L2_4 0 NSYN W=10u L=1u
C_gp_2_4_b gp_2_4_b 0 {Cg}
Mp_2_4_b bx gp_2_4_b colp_L2_4 0 NSYN W=10u L=1u
Mn_2_4_b bx vcn coln_L2_4 0 NSYN W=10u L=1u
Msa_h_L2_4 coln_L2_4 coln_L2_4 0 0 NMIR W=20u L=1u
Msb_h_L2_4 z_L2_4 coln_L2_4 0 0 NMIR W=20u L=1u
Msc_h_L2_4 colp_L2_4 colp_L2_4 0 0 NMIR W=20u L=1u
Msd_h_L2_4 dpf_h_L2_4 colp_L2_4 0 0 NMIR W=20u L=1u
Mse_h_L2_4 dpf_h_L2_4 dpf_h_L2_4 vdd vdd PMIR W=60u L=1u
Msf_h_L2_4 z_L2_4 dpf_h_L2_4 vdd vdd PMIR W=60u L=1u
R_h_L2_4 z_L2_4 vrefh 8000.0
Mr_L2_4  hdd_L2_4 z_L2_4 tail_L2_4 0 NREL W=12u L=1u
Mr2_L2_4 dmp_L2_4  vmid  tail_L2_4 0 NREL W=12u L=1u
Mtl_L2_4 tail_L2_4 vtb 0 0 NREL W=32.0u L=1u
Mdm_L2_4 dmp_L2_4 dmp_L2_4 vdd vdd PMIR W=40u L=1u
Mrp1_L2_4 hdd_L2_4 hdd_L2_4 vdd vdd PMIR W=40u L=1u
Mrp2_L2_4 hv_L2_4 hdd_L2_4 vdd vdd PMIR W=40u L=1u
Rhv_L2_4 hv_L2_4 vg0 8000.0
C_gp_2_5_0 gp_2_5_0 0 {Cg}
Mp_2_5_0 hv_L1_6 gp_2_5_0 colp_L2_5 0 NSYN W=10u L=1u
Mn_2_5_0 hv_L1_6 vcn coln_L2_5 0 NSYN W=10u L=1u
C_gp_2_5_1 gp_2_5_1 0 {Cg}
Mp_2_5_1 hv_L1_4 gp_2_5_1 colp_L2_5 0 NSYN W=10u L=1u
Mn_2_5_1 hv_L1_4 vcn coln_L2_5 0 NSYN W=10u L=1u
C_gp_2_5_2 gp_2_5_2 0 {Cg}
Mp_2_5_2 hv_L1_9 gp_2_5_2 colp_L2_5 0 NSYN W=10u L=1u
Mn_2_5_2 hv_L1_9 vcn coln_L2_5 0 NSYN W=10u L=1u
C_gp_2_5_3 gp_2_5_3 0 {Cg}
Mp_2_5_3 hv_L1_8 gp_2_5_3 colp_L2_5 0 NSYN W=10u L=1u
Mn_2_5_3 hv_L1_8 vcn coln_L2_5 0 NSYN W=10u L=1u
C_gp_2_5_b gp_2_5_b 0 {Cg}
Mp_2_5_b bx gp_2_5_b colp_L2_5 0 NSYN W=10u L=1u
Mn_2_5_b bx vcn coln_L2_5 0 NSYN W=10u L=1u
Msa_h_L2_5 coln_L2_5 coln_L2_5 0 0 NMIR W=20u L=1u
Msb_h_L2_5 z_L2_5 coln_L2_5 0 0 NMIR W=20u L=1u
Msc_h_L2_5 colp_L2_5 colp_L2_5 0 0 NMIR W=20u L=1u
Msd_h_L2_5 dpf_h_L2_5 colp_L2_5 0 0 NMIR W=20u L=1u
Mse_h_L2_5 dpf_h_L2_5 dpf_h_L2_5 vdd vdd PMIR W=60u L=1u
Msf_h_L2_5 z_L2_5 dpf_h_L2_5 vdd vdd PMIR W=60u L=1u
R_h_L2_5 z_L2_5 vrefh 8000.0
Mr_L2_5  hdd_L2_5 z_L2_5 tail_L2_5 0 NREL W=12u L=1u
Mr2_L2_5 dmp_L2_5  vmid  tail_L2_5 0 NREL W=12u L=1u
Mtl_L2_5 tail_L2_5 vtb 0 0 NREL W=32.0u L=1u
Mdm_L2_5 dmp_L2_5 dmp_L2_5 vdd vdd PMIR W=40u L=1u
Mrp1_L2_5 hdd_L2_5 hdd_L2_5 vdd vdd PMIR W=40u L=1u
Mrp2_L2_5 hv_L2_5 hdd_L2_5 vdd vdd PMIR W=40u L=1u
Rhv_L2_5 hv_L2_5 vg0 8000.0
C_gp_2_6_0 gp_2_6_0 0 {Cg}
Mp_2_6_0 hv_L1_1 gp_2_6_0 colp_L2_6 0 NSYN W=10u L=1u
Mn_2_6_0 hv_L1_1 vcn coln_L2_6 0 NSYN W=10u L=1u
C_gp_2_6_1 gp_2_6_1 0 {Cg}
Mp_2_6_1 hv_L1_10 gp_2_6_1 colp_L2_6 0 NSYN W=10u L=1u
Mn_2_6_1 hv_L1_10 vcn coln_L2_6 0 NSYN W=10u L=1u
C_gp_2_6_2 gp_2_6_2 0 {Cg}
Mp_2_6_2 hv_L1_14 gp_2_6_2 colp_L2_6 0 NSYN W=10u L=1u
Mn_2_6_2 hv_L1_14 vcn coln_L2_6 0 NSYN W=10u L=1u
C_gp_2_6_3 gp_2_6_3 0 {Cg}
Mp_2_6_3 hv_L1_15 gp_2_6_3 colp_L2_6 0 NSYN W=10u L=1u
Mn_2_6_3 hv_L1_15 vcn coln_L2_6 0 NSYN W=10u L=1u
C_gp_2_6_b gp_2_6_b 0 {Cg}
Mp_2_6_b bx gp_2_6_b colp_L2_6 0 NSYN W=10u L=1u
Mn_2_6_b bx vcn coln_L2_6 0 NSYN W=10u L=1u
Msa_h_L2_6 coln_L2_6 coln_L2_6 0 0 NMIR W=20u L=1u
Msb_h_L2_6 z_L2_6 coln_L2_6 0 0 NMIR W=20u L=1u
Msc_h_L2_6 colp_L2_6 colp_L2_6 0 0 NMIR W=20u L=1u
Msd_h_L2_6 dpf_h_L2_6 colp_L2_6 0 0 NMIR W=20u L=1u
Mse_h_L2_6 dpf_h_L2_6 dpf_h_L2_6 vdd vdd PMIR W=60u L=1u
Msf_h_L2_6 z_L2_6 dpf_h_L2_6 vdd vdd PMIR W=60u L=1u
R_h_L2_6 z_L2_6 vrefh 8000.0
Mr_L2_6  hdd_L2_6 z_L2_6 tail_L2_6 0 NREL W=12u L=1u
Mr2_L2_6 dmp_L2_6  vmid  tail_L2_6 0 NREL W=12u L=1u
Mtl_L2_6 tail_L2_6 vtb 0 0 NREL W=32.0u L=1u
Mdm_L2_6 dmp_L2_6 dmp_L2_6 vdd vdd PMIR W=40u L=1u
Mrp1_L2_6 hdd_L2_6 hdd_L2_6 vdd vdd PMIR W=40u L=1u
Mrp2_L2_6 hv_L2_6 hdd_L2_6 vdd vdd PMIR W=40u L=1u
Rhv_L2_6 hv_L2_6 vg0 8000.0
C_gp_2_7_0 gp_2_7_0 0 {Cg}
Mp_2_7_0 hv_L1_5 gp_2_7_0 colp_L2_7 0 NSYN W=10u L=1u
Mn_2_7_0 hv_L1_5 vcn coln_L2_7 0 NSYN W=10u L=1u
C_gp_2_7_1 gp_2_7_1 0 {Cg}
Mp_2_7_1 hv_L1_11 gp_2_7_1 colp_L2_7 0 NSYN W=10u L=1u
Mn_2_7_1 hv_L1_11 vcn coln_L2_7 0 NSYN W=10u L=1u
C_gp_2_7_2 gp_2_7_2 0 {Cg}
Mp_2_7_2 hv_L1_12 gp_2_7_2 colp_L2_7 0 NSYN W=10u L=1u
Mn_2_7_2 hv_L1_12 vcn coln_L2_7 0 NSYN W=10u L=1u
C_gp_2_7_3 gp_2_7_3 0 {Cg}
Mp_2_7_3 hv_L1_7 gp_2_7_3 colp_L2_7 0 NSYN W=10u L=1u
Mn_2_7_3 hv_L1_7 vcn coln_L2_7 0 NSYN W=10u L=1u
C_gp_2_7_b gp_2_7_b 0 {Cg}
Mp_2_7_b bx gp_2_7_b colp_L2_7 0 NSYN W=10u L=1u
Mn_2_7_b bx vcn coln_L2_7 0 NSYN W=10u L=1u
Msa_h_L2_7 coln_L2_7 coln_L2_7 0 0 NMIR W=20u L=1u
Msb_h_L2_7 z_L2_7 coln_L2_7 0 0 NMIR W=20u L=1u
Msc_h_L2_7 colp_L2_7 colp_L2_7 0 0 NMIR W=20u L=1u
Msd_h_L2_7 dpf_h_L2_7 colp_L2_7 0 0 NMIR W=20u L=1u
Mse_h_L2_7 dpf_h_L2_7 dpf_h_L2_7 vdd vdd PMIR W=60u L=1u
Msf_h_L2_7 z_L2_7 dpf_h_L2_7 vdd vdd PMIR W=60u L=1u
R_h_L2_7 z_L2_7 vrefh 8000.0
Mr_L2_7  hdd_L2_7 z_L2_7 tail_L2_7 0 NREL W=12u L=1u
Mr2_L2_7 dmp_L2_7  vmid  tail_L2_7 0 NREL W=12u L=1u
Mtl_L2_7 tail_L2_7 vtb 0 0 NREL W=32.0u L=1u
Mdm_L2_7 dmp_L2_7 dmp_L2_7 vdd vdd PMIR W=40u L=1u
Mrp1_L2_7 hdd_L2_7 hdd_L2_7 vdd vdd PMIR W=40u L=1u
Mrp2_L2_7 hv_L2_7 hdd_L2_7 vdd vdd PMIR W=40u L=1u
Rhv_L2_7 hv_L2_7 vg0 8000.0
C_gp_2_8_0 gp_2_8_0 0 {Cg}
Mp_2_8_0 hv_L1_13 gp_2_8_0 colp_L2_8 0 NSYN W=10u L=1u
Mn_2_8_0 hv_L1_13 vcn coln_L2_8 0 NSYN W=10u L=1u
C_gp_2_8_1 gp_2_8_1 0 {Cg}
Mp_2_8_1 hv_L1_5 gp_2_8_1 colp_L2_8 0 NSYN W=10u L=1u
Mn_2_8_1 hv_L1_5 vcn coln_L2_8 0 NSYN W=10u L=1u
C_gp_2_8_2 gp_2_8_2 0 {Cg}
Mp_2_8_2 hv_L1_12 gp_2_8_2 colp_L2_8 0 NSYN W=10u L=1u
Mn_2_8_2 hv_L1_12 vcn coln_L2_8 0 NSYN W=10u L=1u
C_gp_2_8_3 gp_2_8_3 0 {Cg}
Mp_2_8_3 hv_L1_9 gp_2_8_3 colp_L2_8 0 NSYN W=10u L=1u
Mn_2_8_3 hv_L1_9 vcn coln_L2_8 0 NSYN W=10u L=1u
C_gp_2_8_b gp_2_8_b 0 {Cg}
Mp_2_8_b bx gp_2_8_b colp_L2_8 0 NSYN W=10u L=1u
Mn_2_8_b bx vcn coln_L2_8 0 NSYN W=10u L=1u
Msa_h_L2_8 coln_L2_8 coln_L2_8 0 0 NMIR W=20u L=1u
Msb_h_L2_8 z_L2_8 coln_L2_8 0 0 NMIR W=20u L=1u
Msc_h_L2_8 colp_L2_8 colp_L2_8 0 0 NMIR W=20u L=1u
Msd_h_L2_8 dpf_h_L2_8 colp_L2_8 0 0 NMIR W=20u L=1u
Mse_h_L2_8 dpf_h_L2_8 dpf_h_L2_8 vdd vdd PMIR W=60u L=1u
Msf_h_L2_8 z_L2_8 dpf_h_L2_8 vdd vdd PMIR W=60u L=1u
R_h_L2_8 z_L2_8 vrefh 8000.0
Mr_L2_8  hdd_L2_8 z_L2_8 tail_L2_8 0 NREL W=12u L=1u
Mr2_L2_8 dmp_L2_8  vmid  tail_L2_8 0 NREL W=12u L=1u
Mtl_L2_8 tail_L2_8 vtb 0 0 NREL W=32.0u L=1u
Mdm_L2_8 dmp_L2_8 dmp_L2_8 vdd vdd PMIR W=40u L=1u
Mrp1_L2_8 hdd_L2_8 hdd_L2_8 vdd vdd PMIR W=40u L=1u
Mrp2_L2_8 hv_L2_8 hdd_L2_8 vdd vdd PMIR W=40u L=1u
Rhv_L2_8 hv_L2_8 vg0 8000.0
C_gp_2_9_0 gp_2_9_0 0 {Cg}
Mp_2_9_0 hv_L1_11 gp_2_9_0 colp_L2_9 0 NSYN W=10u L=1u
Mn_2_9_0 hv_L1_11 vcn coln_L2_9 0 NSYN W=10u L=1u
C_gp_2_9_1 gp_2_9_1 0 {Cg}
Mp_2_9_1 hv_L1_4 gp_2_9_1 colp_L2_9 0 NSYN W=10u L=1u
Mn_2_9_1 hv_L1_4 vcn coln_L2_9 0 NSYN W=10u L=1u
C_gp_2_9_2 gp_2_9_2 0 {Cg}
Mp_2_9_2 hv_L1_0 gp_2_9_2 colp_L2_9 0 NSYN W=10u L=1u
Mn_2_9_2 hv_L1_0 vcn coln_L2_9 0 NSYN W=10u L=1u
C_gp_2_9_3 gp_2_9_3 0 {Cg}
Mp_2_9_3 hv_L1_7 gp_2_9_3 colp_L2_9 0 NSYN W=10u L=1u
Mn_2_9_3 hv_L1_7 vcn coln_L2_9 0 NSYN W=10u L=1u
C_gp_2_9_b gp_2_9_b 0 {Cg}
Mp_2_9_b bx gp_2_9_b colp_L2_9 0 NSYN W=10u L=1u
Mn_2_9_b bx vcn coln_L2_9 0 NSYN W=10u L=1u
Msa_h_L2_9 coln_L2_9 coln_L2_9 0 0 NMIR W=20u L=1u
Msb_h_L2_9 z_L2_9 coln_L2_9 0 0 NMIR W=20u L=1u
Msc_h_L2_9 colp_L2_9 colp_L2_9 0 0 NMIR W=20u L=1u
Msd_h_L2_9 dpf_h_L2_9 colp_L2_9 0 0 NMIR W=20u L=1u
Mse_h_L2_9 dpf_h_L2_9 dpf_h_L2_9 vdd vdd PMIR W=60u L=1u
Msf_h_L2_9 z_L2_9 dpf_h_L2_9 vdd vdd PMIR W=60u L=1u
R_h_L2_9 z_L2_9 vrefh 8000.0
Mr_L2_9  hdd_L2_9 z_L2_9 tail_L2_9 0 NREL W=12u L=1u
Mr2_L2_9 dmp_L2_9  vmid  tail_L2_9 0 NREL W=12u L=1u
Mtl_L2_9 tail_L2_9 vtb 0 0 NREL W=32.0u L=1u
Mdm_L2_9 dmp_L2_9 dmp_L2_9 vdd vdd PMIR W=40u L=1u
Mrp1_L2_9 hdd_L2_9 hdd_L2_9 vdd vdd PMIR W=40u L=1u
Mrp2_L2_9 hv_L2_9 hdd_L2_9 vdd vdd PMIR W=40u L=1u
Rhv_L2_9 hv_L2_9 vg0 8000.0
C_gp_2_10_0 gp_2_10_0 0 {Cg}
Mp_2_10_0 hv_L1_2 gp_2_10_0 colp_L2_10 0 NSYN W=10u L=1u
Mn_2_10_0 hv_L1_2 vcn coln_L2_10 0 NSYN W=10u L=1u
C_gp_2_10_1 gp_2_10_1 0 {Cg}
Mp_2_10_1 hv_L1_15 gp_2_10_1 colp_L2_10 0 NSYN W=10u L=1u
Mn_2_10_1 hv_L1_15 vcn coln_L2_10 0 NSYN W=10u L=1u
C_gp_2_10_2 gp_2_10_2 0 {Cg}
Mp_2_10_2 hv_L1_1 gp_2_10_2 colp_L2_10 0 NSYN W=10u L=1u
Mn_2_10_2 hv_L1_1 vcn coln_L2_10 0 NSYN W=10u L=1u
C_gp_2_10_3 gp_2_10_3 0 {Cg}
Mp_2_10_3 hv_L1_10 gp_2_10_3 colp_L2_10 0 NSYN W=10u L=1u
Mn_2_10_3 hv_L1_10 vcn coln_L2_10 0 NSYN W=10u L=1u
C_gp_2_10_b gp_2_10_b 0 {Cg}
Mp_2_10_b bx gp_2_10_b colp_L2_10 0 NSYN W=10u L=1u
Mn_2_10_b bx vcn coln_L2_10 0 NSYN W=10u L=1u
Msa_h_L2_10 coln_L2_10 coln_L2_10 0 0 NMIR W=20u L=1u
Msb_h_L2_10 z_L2_10 coln_L2_10 0 0 NMIR W=20u L=1u
Msc_h_L2_10 colp_L2_10 colp_L2_10 0 0 NMIR W=20u L=1u
Msd_h_L2_10 dpf_h_L2_10 colp_L2_10 0 0 NMIR W=20u L=1u
Mse_h_L2_10 dpf_h_L2_10 dpf_h_L2_10 vdd vdd PMIR W=60u L=1u
Msf_h_L2_10 z_L2_10 dpf_h_L2_10 vdd vdd PMIR W=60u L=1u
R_h_L2_10 z_L2_10 vrefh 8000.0
Mr_L2_10  hdd_L2_10 z_L2_10 tail_L2_10 0 NREL W=12u L=1u
Mr2_L2_10 dmp_L2_10  vmid  tail_L2_10 0 NREL W=12u L=1u
Mtl_L2_10 tail_L2_10 vtb 0 0 NREL W=32.0u L=1u
Mdm_L2_10 dmp_L2_10 dmp_L2_10 vdd vdd PMIR W=40u L=1u
Mrp1_L2_10 hdd_L2_10 hdd_L2_10 vdd vdd PMIR W=40u L=1u
Mrp2_L2_10 hv_L2_10 hdd_L2_10 vdd vdd PMIR W=40u L=1u
Rhv_L2_10 hv_L2_10 vg0 8000.0
C_gp_2_11_0 gp_2_11_0 0 {Cg}
Mp_2_11_0 hv_L1_8 gp_2_11_0 colp_L2_11 0 NSYN W=10u L=1u
Mn_2_11_0 hv_L1_8 vcn coln_L2_11 0 NSYN W=10u L=1u
C_gp_2_11_1 gp_2_11_1 0 {Cg}
Mp_2_11_1 hv_L1_6 gp_2_11_1 colp_L2_11 0 NSYN W=10u L=1u
Mn_2_11_1 hv_L1_6 vcn coln_L2_11 0 NSYN W=10u L=1u
C_gp_2_11_2 gp_2_11_2 0 {Cg}
Mp_2_11_2 hv_L1_14 gp_2_11_2 colp_L2_11 0 NSYN W=10u L=1u
Mn_2_11_2 hv_L1_14 vcn coln_L2_11 0 NSYN W=10u L=1u
C_gp_2_11_3 gp_2_11_3 0 {Cg}
Mp_2_11_3 hv_L1_3 gp_2_11_3 colp_L2_11 0 NSYN W=10u L=1u
Mn_2_11_3 hv_L1_3 vcn coln_L2_11 0 NSYN W=10u L=1u
C_gp_2_11_b gp_2_11_b 0 {Cg}
Mp_2_11_b bx gp_2_11_b colp_L2_11 0 NSYN W=10u L=1u
Mn_2_11_b bx vcn coln_L2_11 0 NSYN W=10u L=1u
Msa_h_L2_11 coln_L2_11 coln_L2_11 0 0 NMIR W=20u L=1u
Msb_h_L2_11 z_L2_11 coln_L2_11 0 0 NMIR W=20u L=1u
Msc_h_L2_11 colp_L2_11 colp_L2_11 0 0 NMIR W=20u L=1u
Msd_h_L2_11 dpf_h_L2_11 colp_L2_11 0 0 NMIR W=20u L=1u
Mse_h_L2_11 dpf_h_L2_11 dpf_h_L2_11 vdd vdd PMIR W=60u L=1u
Msf_h_L2_11 z_L2_11 dpf_h_L2_11 vdd vdd PMIR W=60u L=1u
R_h_L2_11 z_L2_11 vrefh 8000.0
Mr_L2_11  hdd_L2_11 z_L2_11 tail_L2_11 0 NREL W=12u L=1u
Mr2_L2_11 dmp_L2_11  vmid  tail_L2_11 0 NREL W=12u L=1u
Mtl_L2_11 tail_L2_11 vtb 0 0 NREL W=32.0u L=1u
Mdm_L2_11 dmp_L2_11 dmp_L2_11 vdd vdd PMIR W=40u L=1u
Mrp1_L2_11 hdd_L2_11 hdd_L2_11 vdd vdd PMIR W=40u L=1u
Mrp2_L2_11 hv_L2_11 hdd_L2_11 vdd vdd PMIR W=40u L=1u
Rhv_L2_11 hv_L2_11 vg0 8000.0
C_gp_2_12_0 gp_2_12_0 0 {Cg}
Mp_2_12_0 hv_L1_4 gp_2_12_0 colp_L2_12 0 NSYN W=10u L=1u
Mn_2_12_0 hv_L1_4 vcn coln_L2_12 0 NSYN W=10u L=1u
C_gp_2_12_1 gp_2_12_1 0 {Cg}
Mp_2_12_1 hv_L1_2 gp_2_12_1 colp_L2_12 0 NSYN W=10u L=1u
Mn_2_12_1 hv_L1_2 vcn coln_L2_12 0 NSYN W=10u L=1u
C_gp_2_12_2 gp_2_12_2 0 {Cg}
Mp_2_12_2 hv_L1_14 gp_2_12_2 colp_L2_12 0 NSYN W=10u L=1u
Mn_2_12_2 hv_L1_14 vcn coln_L2_12 0 NSYN W=10u L=1u
C_gp_2_12_3 gp_2_12_3 0 {Cg}
Mp_2_12_3 hv_L1_12 gp_2_12_3 colp_L2_12 0 NSYN W=10u L=1u
Mn_2_12_3 hv_L1_12 vcn coln_L2_12 0 NSYN W=10u L=1u
C_gp_2_12_b gp_2_12_b 0 {Cg}
Mp_2_12_b bx gp_2_12_b colp_L2_12 0 NSYN W=10u L=1u
Mn_2_12_b bx vcn coln_L2_12 0 NSYN W=10u L=1u
Msa_h_L2_12 coln_L2_12 coln_L2_12 0 0 NMIR W=20u L=1u
Msb_h_L2_12 z_L2_12 coln_L2_12 0 0 NMIR W=20u L=1u
Msc_h_L2_12 colp_L2_12 colp_L2_12 0 0 NMIR W=20u L=1u
Msd_h_L2_12 dpf_h_L2_12 colp_L2_12 0 0 NMIR W=20u L=1u
Mse_h_L2_12 dpf_h_L2_12 dpf_h_L2_12 vdd vdd PMIR W=60u L=1u
Msf_h_L2_12 z_L2_12 dpf_h_L2_12 vdd vdd PMIR W=60u L=1u
R_h_L2_12 z_L2_12 vrefh 8000.0
Mr_L2_12  hdd_L2_12 z_L2_12 tail_L2_12 0 NREL W=12u L=1u
Mr2_L2_12 dmp_L2_12  vmid  tail_L2_12 0 NREL W=12u L=1u
Mtl_L2_12 tail_L2_12 vtb 0 0 NREL W=32.0u L=1u
Mdm_L2_12 dmp_L2_12 dmp_L2_12 vdd vdd PMIR W=40u L=1u
Mrp1_L2_12 hdd_L2_12 hdd_L2_12 vdd vdd PMIR W=40u L=1u
Mrp2_L2_12 hv_L2_12 hdd_L2_12 vdd vdd PMIR W=40u L=1u
Rhv_L2_12 hv_L2_12 vg0 8000.0
C_gp_2_13_0 gp_2_13_0 0 {Cg}
Mp_2_13_0 hv_L1_7 gp_2_13_0 colp_L2_13 0 NSYN W=10u L=1u
Mn_2_13_0 hv_L1_7 vcn coln_L2_13 0 NSYN W=10u L=1u
C_gp_2_13_1 gp_2_13_1 0 {Cg}
Mp_2_13_1 hv_L1_11 gp_2_13_1 colp_L2_13 0 NSYN W=10u L=1u
Mn_2_13_1 hv_L1_11 vcn coln_L2_13 0 NSYN W=10u L=1u
C_gp_2_13_2 gp_2_13_2 0 {Cg}
Mp_2_13_2 hv_L1_10 gp_2_13_2 colp_L2_13 0 NSYN W=10u L=1u
Mn_2_13_2 hv_L1_10 vcn coln_L2_13 0 NSYN W=10u L=1u
C_gp_2_13_3 gp_2_13_3 0 {Cg}
Mp_2_13_3 hv_L1_6 gp_2_13_3 colp_L2_13 0 NSYN W=10u L=1u
Mn_2_13_3 hv_L1_6 vcn coln_L2_13 0 NSYN W=10u L=1u
C_gp_2_13_b gp_2_13_b 0 {Cg}
Mp_2_13_b bx gp_2_13_b colp_L2_13 0 NSYN W=10u L=1u
Mn_2_13_b bx vcn coln_L2_13 0 NSYN W=10u L=1u
Msa_h_L2_13 coln_L2_13 coln_L2_13 0 0 NMIR W=20u L=1u
Msb_h_L2_13 z_L2_13 coln_L2_13 0 0 NMIR W=20u L=1u
Msc_h_L2_13 colp_L2_13 colp_L2_13 0 0 NMIR W=20u L=1u
Msd_h_L2_13 dpf_h_L2_13 colp_L2_13 0 0 NMIR W=20u L=1u
Mse_h_L2_13 dpf_h_L2_13 dpf_h_L2_13 vdd vdd PMIR W=60u L=1u
Msf_h_L2_13 z_L2_13 dpf_h_L2_13 vdd vdd PMIR W=60u L=1u
R_h_L2_13 z_L2_13 vrefh 8000.0
Mr_L2_13  hdd_L2_13 z_L2_13 tail_L2_13 0 NREL W=12u L=1u
Mr2_L2_13 dmp_L2_13  vmid  tail_L2_13 0 NREL W=12u L=1u
Mtl_L2_13 tail_L2_13 vtb 0 0 NREL W=32.0u L=1u
Mdm_L2_13 dmp_L2_13 dmp_L2_13 vdd vdd PMIR W=40u L=1u
Mrp1_L2_13 hdd_L2_13 hdd_L2_13 vdd vdd PMIR W=40u L=1u
Mrp2_L2_13 hv_L2_13 hdd_L2_13 vdd vdd PMIR W=40u L=1u
Rhv_L2_13 hv_L2_13 vg0 8000.0
C_gp_2_14_0 gp_2_14_0 0 {Cg}
Mp_2_14_0 hv_L1_5 gp_2_14_0 colp_L2_14 0 NSYN W=10u L=1u
Mn_2_14_0 hv_L1_5 vcn coln_L2_14 0 NSYN W=10u L=1u
C_gp_2_14_1 gp_2_14_1 0 {Cg}
Mp_2_14_1 hv_L1_8 gp_2_14_1 colp_L2_14 0 NSYN W=10u L=1u
Mn_2_14_1 hv_L1_8 vcn coln_L2_14 0 NSYN W=10u L=1u
C_gp_2_14_2 gp_2_14_2 0 {Cg}
Mp_2_14_2 hv_L1_9 gp_2_14_2 colp_L2_14 0 NSYN W=10u L=1u
Mn_2_14_2 hv_L1_9 vcn coln_L2_14 0 NSYN W=10u L=1u
C_gp_2_14_3 gp_2_14_3 0 {Cg}
Mp_2_14_3 hv_L1_13 gp_2_14_3 colp_L2_14 0 NSYN W=10u L=1u
Mn_2_14_3 hv_L1_13 vcn coln_L2_14 0 NSYN W=10u L=1u
C_gp_2_14_b gp_2_14_b 0 {Cg}
Mp_2_14_b bx gp_2_14_b colp_L2_14 0 NSYN W=10u L=1u
Mn_2_14_b bx vcn coln_L2_14 0 NSYN W=10u L=1u
Msa_h_L2_14 coln_L2_14 coln_L2_14 0 0 NMIR W=20u L=1u
Msb_h_L2_14 z_L2_14 coln_L2_14 0 0 NMIR W=20u L=1u
Msc_h_L2_14 colp_L2_14 colp_L2_14 0 0 NMIR W=20u L=1u
Msd_h_L2_14 dpf_h_L2_14 colp_L2_14 0 0 NMIR W=20u L=1u
Mse_h_L2_14 dpf_h_L2_14 dpf_h_L2_14 vdd vdd PMIR W=60u L=1u
Msf_h_L2_14 z_L2_14 dpf_h_L2_14 vdd vdd PMIR W=60u L=1u
R_h_L2_14 z_L2_14 vrefh 8000.0
Mr_L2_14  hdd_L2_14 z_L2_14 tail_L2_14 0 NREL W=12u L=1u
Mr2_L2_14 dmp_L2_14  vmid  tail_L2_14 0 NREL W=12u L=1u
Mtl_L2_14 tail_L2_14 vtb 0 0 NREL W=32.0u L=1u
Mdm_L2_14 dmp_L2_14 dmp_L2_14 vdd vdd PMIR W=40u L=1u
Mrp1_L2_14 hdd_L2_14 hdd_L2_14 vdd vdd PMIR W=40u L=1u
Mrp2_L2_14 hv_L2_14 hdd_L2_14 vdd vdd PMIR W=40u L=1u
Rhv_L2_14 hv_L2_14 vg0 8000.0
C_gp_2_15_0 gp_2_15_0 0 {Cg}
Mp_2_15_0 hv_L1_15 gp_2_15_0 colp_L2_15 0 NSYN W=10u L=1u
Mn_2_15_0 hv_L1_15 vcn coln_L2_15 0 NSYN W=10u L=1u
C_gp_2_15_1 gp_2_15_1 0 {Cg}
Mp_2_15_1 hv_L1_3 gp_2_15_1 colp_L2_15 0 NSYN W=10u L=1u
Mn_2_15_1 hv_L1_3 vcn coln_L2_15 0 NSYN W=10u L=1u
C_gp_2_15_2 gp_2_15_2 0 {Cg}
Mp_2_15_2 hv_L1_0 gp_2_15_2 colp_L2_15 0 NSYN W=10u L=1u
Mn_2_15_2 hv_L1_0 vcn coln_L2_15 0 NSYN W=10u L=1u
C_gp_2_15_3 gp_2_15_3 0 {Cg}
Mp_2_15_3 hv_L1_1 gp_2_15_3 colp_L2_15 0 NSYN W=10u L=1u
Mn_2_15_3 hv_L1_1 vcn coln_L2_15 0 NSYN W=10u L=1u
C_gp_2_15_b gp_2_15_b 0 {Cg}
Mp_2_15_b bx gp_2_15_b colp_L2_15 0 NSYN W=10u L=1u
Mn_2_15_b bx vcn coln_L2_15 0 NSYN W=10u L=1u
Msa_h_L2_15 coln_L2_15 coln_L2_15 0 0 NMIR W=20u L=1u
Msb_h_L2_15 z_L2_15 coln_L2_15 0 0 NMIR W=20u L=1u
Msc_h_L2_15 colp_L2_15 colp_L2_15 0 0 NMIR W=20u L=1u
Msd_h_L2_15 dpf_h_L2_15 colp_L2_15 0 0 NMIR W=20u L=1u
Mse_h_L2_15 dpf_h_L2_15 dpf_h_L2_15 vdd vdd PMIR W=60u L=1u
Msf_h_L2_15 z_L2_15 dpf_h_L2_15 vdd vdd PMIR W=60u L=1u
R_h_L2_15 z_L2_15 vrefh 8000.0
Mr_L2_15  hdd_L2_15 z_L2_15 tail_L2_15 0 NREL W=12u L=1u
Mr2_L2_15 dmp_L2_15  vmid  tail_L2_15 0 NREL W=12u L=1u
Mtl_L2_15 tail_L2_15 vtb 0 0 NREL W=32.0u L=1u
Mdm_L2_15 dmp_L2_15 dmp_L2_15 vdd vdd PMIR W=40u L=1u
Mrp1_L2_15 hdd_L2_15 hdd_L2_15 vdd vdd PMIR W=40u L=1u
Mrp2_L2_15 hv_L2_15 hdd_L2_15 vdd vdd PMIR W=40u L=1u
Rhv_L2_15 hv_L2_15 vg0 8000.0
C_gp_o_0_0 gp_o_0_0 0 {Cg}
Mp_o_0_0 hv_L2_9 gp_o_0_0 colpo0 0 NSYN W=10u L=1u
Mn_o_0_0 hv_L2_9 vcn colno0 0 NSYN W=10u L=1u
C_gp_o_0_1 gp_o_0_1 0 {Cg}
Mp_o_0_1 hv_L2_11 gp_o_0_1 colpo0 0 NSYN W=10u L=1u
Mn_o_0_1 hv_L2_11 vcn colno0 0 NSYN W=10u L=1u
C_gp_o_0_2 gp_o_0_2 0 {Cg}
Mp_o_0_2 hv_L2_7 gp_o_0_2 colpo0 0 NSYN W=10u L=1u
Mn_o_0_2 hv_L2_7 vcn colno0 0 NSYN W=10u L=1u
C_gp_o_0_3 gp_o_0_3 0 {Cg}
Mp_o_0_3 hv_L2_12 gp_o_0_3 colpo0 0 NSYN W=10u L=1u
Mn_o_0_3 hv_L2_12 vcn colno0 0 NSYN W=10u L=1u
C_gp_o_0_b gp_o_0_b 0 {Cg}
Mp_o_0_b bx gp_o_0_b colpo0 0 NSYN W=10u L=1u
Mn_o_0_b bx vcn colno0 0 NSYN W=10u L=1u
Msa_o0 colno0 colno0 0 0 NMIR W=20u L=1u
Msb_o0 y_0 colno0 0 0 NMIR W=20u L=1u
Msc_o0 colpo0 colpo0 0 0 NMIR W=20u L=1u
Msd_o0 dpf_o0 colpo0 0 0 NMIR W=20u L=1u
Mse_o0 dpf_o0 dpf_o0 vdd vdd PMIR W=60u L=1u
Msf_o0 y_0 dpf_o0 vdd vdd PMIR W=60u L=1u
R_o0 y_0 vrefo 7000.0
C_gp_o_1_0 gp_o_1_0 0 {Cg}
Mp_o_1_0 hv_L2_5 gp_o_1_0 colpo1 0 NSYN W=10u L=1u
Mn_o_1_0 hv_L2_5 vcn colno1 0 NSYN W=10u L=1u
C_gp_o_1_1 gp_o_1_1 0 {Cg}
Mp_o_1_1 hv_L2_12 gp_o_1_1 colpo1 0 NSYN W=10u L=1u
Mn_o_1_1 hv_L2_12 vcn colno1 0 NSYN W=10u L=1u
C_gp_o_1_2 gp_o_1_2 0 {Cg}
Mp_o_1_2 hv_L2_13 gp_o_1_2 colpo1 0 NSYN W=10u L=1u
Mn_o_1_2 hv_L2_13 vcn colno1 0 NSYN W=10u L=1u
C_gp_o_1_3 gp_o_1_3 0 {Cg}
Mp_o_1_3 hv_L2_9 gp_o_1_3 colpo1 0 NSYN W=10u L=1u
Mn_o_1_3 hv_L2_9 vcn colno1 0 NSYN W=10u L=1u
C_gp_o_1_b gp_o_1_b 0 {Cg}
Mp_o_1_b bx gp_o_1_b colpo1 0 NSYN W=10u L=1u
Mn_o_1_b bx vcn colno1 0 NSYN W=10u L=1u
Msa_o1 colno1 colno1 0 0 NMIR W=20u L=1u
Msb_o1 y_1 colno1 0 0 NMIR W=20u L=1u
Msc_o1 colpo1 colpo1 0 0 NMIR W=20u L=1u
Msd_o1 dpf_o1 colpo1 0 0 NMIR W=20u L=1u
Mse_o1 dpf_o1 dpf_o1 vdd vdd PMIR W=60u L=1u
Msf_o1 y_1 dpf_o1 vdd vdd PMIR W=60u L=1u
R_o1 y_1 vrefo 7000.0
C_gp_o_2_0 gp_o_2_0 0 {Cg}
Mp_o_2_0 hv_L2_5 gp_o_2_0 colpo2 0 NSYN W=10u L=1u
Mn_o_2_0 hv_L2_5 vcn colno2 0 NSYN W=10u L=1u
C_gp_o_2_1 gp_o_2_1 0 {Cg}
Mp_o_2_1 hv_L2_15 gp_o_2_1 colpo2 0 NSYN W=10u L=1u
Mn_o_2_1 hv_L2_15 vcn colno2 0 NSYN W=10u L=1u
C_gp_o_2_2 gp_o_2_2 0 {Cg}
Mp_o_2_2 hv_L2_7 gp_o_2_2 colpo2 0 NSYN W=10u L=1u
Mn_o_2_2 hv_L2_7 vcn colno2 0 NSYN W=10u L=1u
C_gp_o_2_3 gp_o_2_3 0 {Cg}
Mp_o_2_3 hv_L2_12 gp_o_2_3 colpo2 0 NSYN W=10u L=1u
Mn_o_2_3 hv_L2_12 vcn colno2 0 NSYN W=10u L=1u
C_gp_o_2_b gp_o_2_b 0 {Cg}
Mp_o_2_b bx gp_o_2_b colpo2 0 NSYN W=10u L=1u
Mn_o_2_b bx vcn colno2 0 NSYN W=10u L=1u
Msa_o2 colno2 colno2 0 0 NMIR W=20u L=1u
Msb_o2 y_2 colno2 0 0 NMIR W=20u L=1u
Msc_o2 colpo2 colpo2 0 0 NMIR W=20u L=1u
Msd_o2 dpf_o2 colpo2 0 0 NMIR W=20u L=1u
Mse_o2 dpf_o2 dpf_o2 vdd vdd PMIR W=60u L=1u
Msf_o2 y_2 dpf_o2 vdd vdd PMIR W=60u L=1u
R_o2 y_2 vrefo 7000.0
Rocm_0 d2e_0 d2ebar 10000.0
Rocm_1 d2e_1 d2ebar 10000.0
Rocm_2 d2e_2 d2ebar 10000.0
Cocm d2ebar 0 50f
Msf2_0 d2e_0 dpf_o0 vdd vdd PMIR W=60u L=1u
Msb2_0 d2e_0 colno0 0 0 NMIR W=20u L=1u
Moff_0 d2e_0 boff vdd vdd PMIR W=10u L=1u
Mtge_0 d2e_0 tg0 0 0 NMIR W=10u L=1u
Rde_0 d2e_0 vrefd 7000.0
Mqa_0 d2en_ps_0 colno0 0 0 NMIR W=20u L=1u
Mqb_0 d2en_ps_0 tg0 0 0 NMIR W=10u L=1u
Mpd_0 d2en_ps_0 d2en_ps_0 vdd vdd PMIR W=60u L=1u
Mpm_0 d2e_n_0 d2en_ps_0 vdd vdd PMIR W=60u L=1u
Mqc_0 d2en_ns_0 dpf_o0 vdd vdd PMIR W=60u L=1u
Mqd_0 d2en_ns_0 boff vdd vdd PMIR W=10u L=1u
Mnd_0 d2en_ns_0 d2en_ns_0 0 0 NMIR W=20u L=1u
Mnm_0 d2e_n_0 d2en_ns_0 0 0 NMIR W=20u L=1u
Rden_0 d2e_n_0 vrefd 7000.0
Mbep_0 vdd d2e_0 d2e_pb_0 0 NSYN W=200u L=1u
Rbep_0 d2e_pb_0 0 20e3
Mben_0 vdd d2e_n_0 d2e_nb_0 0 NSYN W=200u L=1u
Rben_0 d2e_nb_0 0 20e3
Msf2_1 d2e_1 dpf_o1 vdd vdd PMIR W=60u L=1u
Msb2_1 d2e_1 colno1 0 0 NMIR W=20u L=1u
Moff_1 d2e_1 boff vdd vdd PMIR W=10u L=1u
Mtge_1 d2e_1 tg1 0 0 NMIR W=10u L=1u
Rde_1 d2e_1 vrefd 7000.0
Mqa_1 d2en_ps_1 colno1 0 0 NMIR W=20u L=1u
Mqb_1 d2en_ps_1 tg1 0 0 NMIR W=10u L=1u
Mpd_1 d2en_ps_1 d2en_ps_1 vdd vdd PMIR W=60u L=1u
Mpm_1 d2e_n_1 d2en_ps_1 vdd vdd PMIR W=60u L=1u
Mqc_1 d2en_ns_1 dpf_o1 vdd vdd PMIR W=60u L=1u
Mqd_1 d2en_ns_1 boff vdd vdd PMIR W=10u L=1u
Mnd_1 d2en_ns_1 d2en_ns_1 0 0 NMIR W=20u L=1u
Mnm_1 d2e_n_1 d2en_ns_1 0 0 NMIR W=20u L=1u
Rden_1 d2e_n_1 vrefd 7000.0
Mbep_1 vdd d2e_1 d2e_pb_1 0 NSYN W=200u L=1u
Rbep_1 d2e_pb_1 0 20e3
Mben_1 vdd d2e_n_1 d2e_nb_1 0 NSYN W=200u L=1u
Rben_1 d2e_nb_1 0 20e3
Msf2_2 d2e_2 dpf_o2 vdd vdd PMIR W=60u L=1u
Msb2_2 d2e_2 colno2 0 0 NMIR W=20u L=1u
Moff_2 d2e_2 boff vdd vdd PMIR W=10u L=1u
Mtge_2 d2e_2 tg2 0 0 NMIR W=10u L=1u
Rde_2 d2e_2 vrefd 7000.0
Mqa_2 d2en_ps_2 colno2 0 0 NMIR W=20u L=1u
Mqb_2 d2en_ps_2 tg2 0 0 NMIR W=10u L=1u
Mpd_2 d2en_ps_2 d2en_ps_2 vdd vdd PMIR W=60u L=1u
Mpm_2 d2e_n_2 d2en_ps_2 vdd vdd PMIR W=60u L=1u
Mqc_2 d2en_ns_2 dpf_o2 vdd vdd PMIR W=60u L=1u
Mqd_2 d2en_ns_2 boff vdd vdd PMIR W=10u L=1u
Mnd_2 d2en_ns_2 d2en_ns_2 0 0 NMIR W=20u L=1u
Mnm_2 d2e_n_2 d2en_ns_2 0 0 NMIR W=20u L=1u
Rden_2 d2e_n_2 vrefd 7000.0
Mbep_2 vdd d2e_2 d2e_pb_2 0 NSYN W=200u L=1u
Rbep_2 d2e_pb_2 0 20e3
Mben_2 vdd d2e_n_2 d2e_nb_2 0 NSYN W=200u L=1u
Rben_2 d2e_nb_2 0 20e3
Mt_oU_0_0 ts_oU_0_0 hv_L2_9 0 0 NMIR W=20.0u L=1u
Mo1_oU_0_0 da_oU_0_0 d2ebar ts_oU_0_0 0 NMIR W=20u L=1u
Mo2_oU_0_0 gp_o_0_0 d2e_0 ts_oU_0_0 0 NMIR W=20u L=1u
Mo3_oU_0_0 da_oU_0_0 da_oU_0_0 vdd vdd PMIR W=60u L=1u
Mo4_oU_0_0 gp_o_0_0 da_oU_0_0 vdd vdd PMIR W=60u L=1u
Mt_oU_0_1 ts_oU_0_1 hv_L2_11 0 0 NMIR W=20.0u L=1u
Mo1_oU_0_1 da_oU_0_1 d2ebar ts_oU_0_1 0 NMIR W=20u L=1u
Mo2_oU_0_1 gp_o_0_1 d2e_0 ts_oU_0_1 0 NMIR W=20u L=1u
Mo3_oU_0_1 da_oU_0_1 da_oU_0_1 vdd vdd PMIR W=60u L=1u
Mo4_oU_0_1 gp_o_0_1 da_oU_0_1 vdd vdd PMIR W=60u L=1u
Mt_oU_0_2 ts_oU_0_2 hv_L2_7 0 0 NMIR W=20.0u L=1u
Mo1_oU_0_2 da_oU_0_2 d2ebar ts_oU_0_2 0 NMIR W=20u L=1u
Mo2_oU_0_2 gp_o_0_2 d2e_0 ts_oU_0_2 0 NMIR W=20u L=1u
Mo3_oU_0_2 da_oU_0_2 da_oU_0_2 vdd vdd PMIR W=60u L=1u
Mo4_oU_0_2 gp_o_0_2 da_oU_0_2 vdd vdd PMIR W=60u L=1u
Mt_oU_0_3 ts_oU_0_3 hv_L2_12 0 0 NMIR W=20.0u L=1u
Mo1_oU_0_3 da_oU_0_3 d2ebar ts_oU_0_3 0 NMIR W=20u L=1u
Mo2_oU_0_3 gp_o_0_3 d2e_0 ts_oU_0_3 0 NMIR W=20u L=1u
Mo3_oU_0_3 da_oU_0_3 da_oU_0_3 vdd vdd PMIR W=60u L=1u
Mo4_oU_0_3 gp_o_0_3 da_oU_0_3 vdd vdd PMIR W=60u L=1u
Mt_oU_1_0 ts_oU_1_0 hv_L2_5 0 0 NMIR W=20.0u L=1u
Mo1_oU_1_0 da_oU_1_0 d2ebar ts_oU_1_0 0 NMIR W=20u L=1u
Mo2_oU_1_0 gp_o_1_0 d2e_1 ts_oU_1_0 0 NMIR W=20u L=1u
Mo3_oU_1_0 da_oU_1_0 da_oU_1_0 vdd vdd PMIR W=60u L=1u
Mo4_oU_1_0 gp_o_1_0 da_oU_1_0 vdd vdd PMIR W=60u L=1u
Mt_oU_1_1 ts_oU_1_1 hv_L2_12 0 0 NMIR W=20.0u L=1u
Mo1_oU_1_1 da_oU_1_1 d2ebar ts_oU_1_1 0 NMIR W=20u L=1u
Mo2_oU_1_1 gp_o_1_1 d2e_1 ts_oU_1_1 0 NMIR W=20u L=1u
Mo3_oU_1_1 da_oU_1_1 da_oU_1_1 vdd vdd PMIR W=60u L=1u
Mo4_oU_1_1 gp_o_1_1 da_oU_1_1 vdd vdd PMIR W=60u L=1u
Mt_oU_1_2 ts_oU_1_2 hv_L2_13 0 0 NMIR W=20.0u L=1u
Mo1_oU_1_2 da_oU_1_2 d2ebar ts_oU_1_2 0 NMIR W=20u L=1u
Mo2_oU_1_2 gp_o_1_2 d2e_1 ts_oU_1_2 0 NMIR W=20u L=1u
Mo3_oU_1_2 da_oU_1_2 da_oU_1_2 vdd vdd PMIR W=60u L=1u
Mo4_oU_1_2 gp_o_1_2 da_oU_1_2 vdd vdd PMIR W=60u L=1u
Mt_oU_1_3 ts_oU_1_3 hv_L2_9 0 0 NMIR W=20.0u L=1u
Mo1_oU_1_3 da_oU_1_3 d2ebar ts_oU_1_3 0 NMIR W=20u L=1u
Mo2_oU_1_3 gp_o_1_3 d2e_1 ts_oU_1_3 0 NMIR W=20u L=1u
Mo3_oU_1_3 da_oU_1_3 da_oU_1_3 vdd vdd PMIR W=60u L=1u
Mo4_oU_1_3 gp_o_1_3 da_oU_1_3 vdd vdd PMIR W=60u L=1u
Mt_oU_2_0 ts_oU_2_0 hv_L2_5 0 0 NMIR W=20.0u L=1u
Mo1_oU_2_0 da_oU_2_0 d2ebar ts_oU_2_0 0 NMIR W=20u L=1u
Mo2_oU_2_0 gp_o_2_0 d2e_2 ts_oU_2_0 0 NMIR W=20u L=1u
Mo3_oU_2_0 da_oU_2_0 da_oU_2_0 vdd vdd PMIR W=60u L=1u
Mo4_oU_2_0 gp_o_2_0 da_oU_2_0 vdd vdd PMIR W=60u L=1u
Mt_oU_2_1 ts_oU_2_1 hv_L2_15 0 0 NMIR W=20.0u L=1u
Mo1_oU_2_1 da_oU_2_1 d2ebar ts_oU_2_1 0 NMIR W=20u L=1u
Mo2_oU_2_1 gp_o_2_1 d2e_2 ts_oU_2_1 0 NMIR W=20u L=1u
Mo3_oU_2_1 da_oU_2_1 da_oU_2_1 vdd vdd PMIR W=60u L=1u
Mo4_oU_2_1 gp_o_2_1 da_oU_2_1 vdd vdd PMIR W=60u L=1u
Mt_oU_2_2 ts_oU_2_2 hv_L2_7 0 0 NMIR W=20.0u L=1u
Mo1_oU_2_2 da_oU_2_2 d2ebar ts_oU_2_2 0 NMIR W=20u L=1u
Mo2_oU_2_2 gp_o_2_2 d2e_2 ts_oU_2_2 0 NMIR W=20u L=1u
Mo3_oU_2_2 da_oU_2_2 da_oU_2_2 vdd vdd PMIR W=60u L=1u
Mo4_oU_2_2 gp_o_2_2 da_oU_2_2 vdd vdd PMIR W=60u L=1u
Mt_oU_2_3 ts_oU_2_3 hv_L2_12 0 0 NMIR W=20.0u L=1u
Mo1_oU_2_3 da_oU_2_3 d2ebar ts_oU_2_3 0 NMIR W=20u L=1u
Mo2_oU_2_3 gp_o_2_3 d2e_2 ts_oU_2_3 0 NMIR W=20u L=1u
Mo3_oU_2_3 da_oU_2_3 da_oU_2_3 vdd vdd PMIR W=60u L=1u
Mo4_oU_2_3 gp_o_2_3 da_oU_2_3 vdd vdd PMIR W=60u L=1u
Rno_L2_0 dpre_L2_0 vrefd 1e3
Rno_L2_1 dpre_L2_1 vrefd 1e3
Rno_L2_2 dpre_L2_2 vrefd 1e3
Rno_L2_3 dpre_L2_3 vrefd 1e3
Rno_L2_4 dpre_L2_4 vrefd 1e3
MpTa_L2_5_0 d2e_pb_1 gp_o_1_0 ctp_L2_5 0 NSYN W=10u L=1u
MnTb_L2_5_0 d2e_nb_1 vcn ctp_L2_5 0 NSYN W=10u L=1u
MnTa_L2_5_0 d2e_pb_1 vcn ctn_L2_5 0 NSYN W=10u L=1u
MpTb_L2_5_0 d2e_nb_1 gp_o_1_0 ctn_L2_5 0 NSYN W=10u L=1u
MpTa_L2_5_1 d2e_pb_2 gp_o_2_0 ctp_L2_5 0 NSYN W=10u L=1u
MnTb_L2_5_1 d2e_nb_2 vcn ctp_L2_5 0 NSYN W=10u L=1u
MnTa_L2_5_1 d2e_pb_2 vcn ctn_L2_5 0 NSYN W=10u L=1u
MpTb_L2_5_1 d2e_nb_2 gp_o_2_0 ctn_L2_5 0 NSYN W=10u L=1u
Msa_bk_L2_5 ctn_L2_5 ctn_L2_5 0 0 NMIR W=20u L=1u
Msb_bk_L2_5 dpre_L2_5 ctn_L2_5 0 0 NMIR W=20u L=1u
Msc_bk_L2_5 ctp_L2_5 ctp_L2_5 0 0 NMIR W=20u L=1u
Msd_bk_L2_5 dpf_bk_L2_5 ctp_L2_5 0 0 NMIR W=20u L=1u
Mse_bk_L2_5 dpf_bk_L2_5 dpf_bk_L2_5 vdd vdd PMIR W=60u L=1u
Msf_bk_L2_5 dpre_L2_5 dpf_bk_L2_5 vdd vdd PMIR W=60u L=1u
R_bk_L2_5 dpre_L2_5 vrefd 16000.0
Rno_L2_6 dpre_L2_6 vrefd 1e3
MpTa_L2_7_0 d2e_pb_0 gp_o_0_2 ctp_L2_7 0 NSYN W=10u L=1u
MnTb_L2_7_0 d2e_nb_0 vcn ctp_L2_7 0 NSYN W=10u L=1u
MnTa_L2_7_0 d2e_pb_0 vcn ctn_L2_7 0 NSYN W=10u L=1u
MpTb_L2_7_0 d2e_nb_0 gp_o_0_2 ctn_L2_7 0 NSYN W=10u L=1u
MpTa_L2_7_1 d2e_pb_2 gp_o_2_2 ctp_L2_7 0 NSYN W=10u L=1u
MnTb_L2_7_1 d2e_nb_2 vcn ctp_L2_7 0 NSYN W=10u L=1u
MnTa_L2_7_1 d2e_pb_2 vcn ctn_L2_7 0 NSYN W=10u L=1u
MpTb_L2_7_1 d2e_nb_2 gp_o_2_2 ctn_L2_7 0 NSYN W=10u L=1u
Msa_bk_L2_7 ctn_L2_7 ctn_L2_7 0 0 NMIR W=20u L=1u
Msb_bk_L2_7 dpre_L2_7 ctn_L2_7 0 0 NMIR W=20u L=1u
Msc_bk_L2_7 ctp_L2_7 ctp_L2_7 0 0 NMIR W=20u L=1u
Msd_bk_L2_7 dpf_bk_L2_7 ctp_L2_7 0 0 NMIR W=20u L=1u
Mse_bk_L2_7 dpf_bk_L2_7 dpf_bk_L2_7 vdd vdd PMIR W=60u L=1u
Msf_bk_L2_7 dpre_L2_7 dpf_bk_L2_7 vdd vdd PMIR W=60u L=1u
R_bk_L2_7 dpre_L2_7 vrefd 16000.0
Rno_L2_8 dpre_L2_8 vrefd 1e3
MpTa_L2_9_0 d2e_pb_0 gp_o_0_0 ctp_L2_9 0 NSYN W=10u L=1u
MnTb_L2_9_0 d2e_nb_0 vcn ctp_L2_9 0 NSYN W=10u L=1u
MnTa_L2_9_0 d2e_pb_0 vcn ctn_L2_9 0 NSYN W=10u L=1u
MpTb_L2_9_0 d2e_nb_0 gp_o_0_0 ctn_L2_9 0 NSYN W=10u L=1u
MpTa_L2_9_1 d2e_pb_1 gp_o_1_3 ctp_L2_9 0 NSYN W=10u L=1u
MnTb_L2_9_1 d2e_nb_1 vcn ctp_L2_9 0 NSYN W=10u L=1u
MnTa_L2_9_1 d2e_pb_1 vcn ctn_L2_9 0 NSYN W=10u L=1u
MpTb_L2_9_1 d2e_nb_1 gp_o_1_3 ctn_L2_9 0 NSYN W=10u L=1u
Msa_bk_L2_9 ctn_L2_9 ctn_L2_9 0 0 NMIR W=20u L=1u
Msb_bk_L2_9 dpre_L2_9 ctn_L2_9 0 0 NMIR W=20u L=1u
Msc_bk_L2_9 ctp_L2_9 ctp_L2_9 0 0 NMIR W=20u L=1u
Msd_bk_L2_9 dpf_bk_L2_9 ctp_L2_9 0 0 NMIR W=20u L=1u
Mse_bk_L2_9 dpf_bk_L2_9 dpf_bk_L2_9 vdd vdd PMIR W=60u L=1u
Msf_bk_L2_9 dpre_L2_9 dpf_bk_L2_9 vdd vdd PMIR W=60u L=1u
R_bk_L2_9 dpre_L2_9 vrefd 16000.0
Rno_L2_10 dpre_L2_10 vrefd 1e3
MpTa_L2_11_0 d2e_pb_0 gp_o_0_1 ctp_L2_11 0 NSYN W=10u L=1u
MnTb_L2_11_0 d2e_nb_0 vcn ctp_L2_11 0 NSYN W=10u L=1u
MnTa_L2_11_0 d2e_pb_0 vcn ctn_L2_11 0 NSYN W=10u L=1u
MpTb_L2_11_0 d2e_nb_0 gp_o_0_1 ctn_L2_11 0 NSYN W=10u L=1u
Msa_bk_L2_11 ctn_L2_11 ctn_L2_11 0 0 NMIR W=20u L=1u
Msb_bk_L2_11 dpre_L2_11 ctn_L2_11 0 0 NMIR W=20u L=1u
Msc_bk_L2_11 ctp_L2_11 ctp_L2_11 0 0 NMIR W=20u L=1u
Msd_bk_L2_11 dpf_bk_L2_11 ctp_L2_11 0 0 NMIR W=20u L=1u
Mse_bk_L2_11 dpf_bk_L2_11 dpf_bk_L2_11 vdd vdd PMIR W=60u L=1u
Msf_bk_L2_11 dpre_L2_11 dpf_bk_L2_11 vdd vdd PMIR W=60u L=1u
R_bk_L2_11 dpre_L2_11 vrefd 16000.0
MpTa_L2_12_0 d2e_pb_0 gp_o_0_3 ctp_L2_12 0 NSYN W=10u L=1u
MnTb_L2_12_0 d2e_nb_0 vcn ctp_L2_12 0 NSYN W=10u L=1u
MnTa_L2_12_0 d2e_pb_0 vcn ctn_L2_12 0 NSYN W=10u L=1u
MpTb_L2_12_0 d2e_nb_0 gp_o_0_3 ctn_L2_12 0 NSYN W=10u L=1u
MpTa_L2_12_1 d2e_pb_1 gp_o_1_1 ctp_L2_12 0 NSYN W=10u L=1u
MnTb_L2_12_1 d2e_nb_1 vcn ctp_L2_12 0 NSYN W=10u L=1u
MnTa_L2_12_1 d2e_pb_1 vcn ctn_L2_12 0 NSYN W=10u L=1u
MpTb_L2_12_1 d2e_nb_1 gp_o_1_1 ctn_L2_12 0 NSYN W=10u L=1u
MpTa_L2_12_2 d2e_pb_2 gp_o_2_3 ctp_L2_12 0 NSYN W=10u L=1u
MnTb_L2_12_2 d2e_nb_2 vcn ctp_L2_12 0 NSYN W=10u L=1u
MnTa_L2_12_2 d2e_pb_2 vcn ctn_L2_12 0 NSYN W=10u L=1u
MpTb_L2_12_2 d2e_nb_2 gp_o_2_3 ctn_L2_12 0 NSYN W=10u L=1u
Msa_bk_L2_12 ctn_L2_12 ctn_L2_12 0 0 NMIR W=20u L=1u
Msb_bk_L2_12 dpre_L2_12 ctn_L2_12 0 0 NMIR W=20u L=1u
Msc_bk_L2_12 ctp_L2_12 ctp_L2_12 0 0 NMIR W=20u L=1u
Msd_bk_L2_12 dpf_bk_L2_12 ctp_L2_12 0 0 NMIR W=20u L=1u
Mse_bk_L2_12 dpf_bk_L2_12 dpf_bk_L2_12 vdd vdd PMIR W=60u L=1u
Msf_bk_L2_12 dpre_L2_12 dpf_bk_L2_12 vdd vdd PMIR W=60u L=1u
R_bk_L2_12 dpre_L2_12 vrefd 16000.0
MpTa_L2_13_0 d2e_pb_1 gp_o_1_2 ctp_L2_13 0 NSYN W=10u L=1u
MnTb_L2_13_0 d2e_nb_1 vcn ctp_L2_13 0 NSYN W=10u L=1u
MnTa_L2_13_0 d2e_pb_1 vcn ctn_L2_13 0 NSYN W=10u L=1u
MpTb_L2_13_0 d2e_nb_1 gp_o_1_2 ctn_L2_13 0 NSYN W=10u L=1u
Msa_bk_L2_13 ctn_L2_13 ctn_L2_13 0 0 NMIR W=20u L=1u
Msb_bk_L2_13 dpre_L2_13 ctn_L2_13 0 0 NMIR W=20u L=1u
Msc_bk_L2_13 ctp_L2_13 ctp_L2_13 0 0 NMIR W=20u L=1u
Msd_bk_L2_13 dpf_bk_L2_13 ctp_L2_13 0 0 NMIR W=20u L=1u
Mse_bk_L2_13 dpf_bk_L2_13 dpf_bk_L2_13 vdd vdd PMIR W=60u L=1u
Msf_bk_L2_13 dpre_L2_13 dpf_bk_L2_13 vdd vdd PMIR W=60u L=1u
R_bk_L2_13 dpre_L2_13 vrefd 16000.0
Rno_L2_14 dpre_L2_14 vrefd 1e3
MpTa_L2_15_0 d2e_pb_2 gp_o_2_1 ctp_L2_15 0 NSYN W=10u L=1u
MnTb_L2_15_0 d2e_nb_2 vcn ctp_L2_15 0 NSYN W=10u L=1u
MnTa_L2_15_0 d2e_pb_2 vcn ctn_L2_15 0 NSYN W=10u L=1u
MpTb_L2_15_0 d2e_nb_2 gp_o_2_1 ctn_L2_15 0 NSYN W=10u L=1u
Msa_bk_L2_15 ctn_L2_15 ctn_L2_15 0 0 NMIR W=20u L=1u
Msb_bk_L2_15 dpre_L2_15 ctn_L2_15 0 0 NMIR W=20u L=1u
Msc_bk_L2_15 ctp_L2_15 ctp_L2_15 0 0 NMIR W=20u L=1u
Msd_bk_L2_15 dpf_bk_L2_15 ctp_L2_15 0 0 NMIR W=20u L=1u
Mse_bk_L2_15 dpf_bk_L2_15 dpf_bk_L2_15 vdd vdd PMIR W=60u L=1u
Msf_bk_L2_15 dpre_L2_15 dpf_bk_L2_15 vdd vdd PMIR W=60u L=1u
R_bk_L2_15 dpre_L2_15 vrefd 16000.0
Rcm_L2_0 dpre_L2_0 d1bar_L2 10000.0
Rcm_L2_1 dpre_L2_1 d1bar_L2 10000.0
Rcm_L2_2 dpre_L2_2 d1bar_L2 10000.0
Rcm_L2_3 dpre_L2_3 d1bar_L2 10000.0
Rcm_L2_4 dpre_L2_4 d1bar_L2 10000.0
Rcm_L2_5 dpre_L2_5 d1bar_L2 10000.0
Rcm_L2_6 dpre_L2_6 d1bar_L2 10000.0
Rcm_L2_7 dpre_L2_7 d1bar_L2 10000.0
Rcm_L2_8 dpre_L2_8 d1bar_L2 10000.0
Rcm_L2_9 dpre_L2_9 d1bar_L2 10000.0
Rcm_L2_10 dpre_L2_10 d1bar_L2 10000.0
Rcm_L2_11 dpre_L2_11 d1bar_L2 10000.0
Rcm_L2_12 dpre_L2_12 d1bar_L2 10000.0
Rcm_L2_13 dpre_L2_13 d1bar_L2 10000.0
Rcm_L2_14 dpre_L2_14 d1bar_L2 10000.0
Rcm_L2_15 dpre_L2_15 d1bar_L2 10000.0
Ccm_L2 d1bar_L2 0 50f
Mct_L2_0 ctail_L2_0 vcbias 0 0 NMIR W=10u L=1u
Mca_L2_0 cna_L2_0 z_L2_0 ctail_L2_0 0 NSYN W=20u L=1u
Mcb_L2_0 uon_L2_0 vthr ctail_L2_0 0 NSYN W=20u L=1u
Mcp1_L2_0 cna_L2_0 cna_L2_0 vdd vdd PMIR W=40u L=1u
Mcp2_L2_0 uon_L2_0 cna_L2_0 vdd vdd PMIR W=40u L=1u
Rulk_L2_0 uon_L2_0 vulk 60000.0
Mt_uU_L2_0_0 ts_uU_L2_0_0 hv_L1_7 0 0 NMIR W=48.0u L=1u
Mo1_uU_L2_0_0 da_uU_L2_0_0 d1bar_L2 ts_uU_L2_0_0 0 NMIR W=20u L=1u
Mo2_uU_L2_0_0 gp_2_0_0 dpre_L2_0 ts_uU_L2_0_0 0 NMIR W=20u L=1u
Mo3_uU_L2_0_0 da_uU_L2_0_0 da_uU_L2_0_0 vdd vdd PMIR W=60u L=1u
Mo4_uU_L2_0_0 gp_2_0_0 da_uU_L2_0_0 vdd vdd PMIR W=60u L=1u
Mt_uU_L2_0_1 ts_uU_L2_0_1 hv_L1_3 0 0 NMIR W=48.0u L=1u
Mo1_uU_L2_0_1 da_uU_L2_0_1 d1bar_L2 ts_uU_L2_0_1 0 NMIR W=20u L=1u
Mo2_uU_L2_0_1 gp_2_0_1 dpre_L2_0 ts_uU_L2_0_1 0 NMIR W=20u L=1u
Mo3_uU_L2_0_1 da_uU_L2_0_1 da_uU_L2_0_1 vdd vdd PMIR W=60u L=1u
Mo4_uU_L2_0_1 gp_2_0_1 da_uU_L2_0_1 vdd vdd PMIR W=60u L=1u
Mt_uU_L2_0_2 ts_uU_L2_0_2 hv_L1_11 0 0 NMIR W=48.0u L=1u
Mo1_uU_L2_0_2 da_uU_L2_0_2 d1bar_L2 ts_uU_L2_0_2 0 NMIR W=20u L=1u
Mo2_uU_L2_0_2 gp_2_0_2 dpre_L2_0 ts_uU_L2_0_2 0 NMIR W=20u L=1u
Mo3_uU_L2_0_2 da_uU_L2_0_2 da_uU_L2_0_2 vdd vdd PMIR W=60u L=1u
Mo4_uU_L2_0_2 gp_2_0_2 da_uU_L2_0_2 vdd vdd PMIR W=60u L=1u
Mt_uU_L2_0_3 ts_uU_L2_0_3 hv_L1_6 0 0 NMIR W=48.0u L=1u
Mo1_uU_L2_0_3 da_uU_L2_0_3 d1bar_L2 ts_uU_L2_0_3 0 NMIR W=20u L=1u
Mo2_uU_L2_0_3 gp_2_0_3 dpre_L2_0 ts_uU_L2_0_3 0 NMIR W=20u L=1u
Mo3_uU_L2_0_3 da_uU_L2_0_3 da_uU_L2_0_3 vdd vdd PMIR W=60u L=1u
Mo4_uU_L2_0_3 gp_2_0_3 da_uU_L2_0_3 vdd vdd PMIR W=60u L=1u
Mct_L2_1 ctail_L2_1 vcbias 0 0 NMIR W=10u L=1u
Mca_L2_1 cna_L2_1 z_L2_1 ctail_L2_1 0 NSYN W=20u L=1u
Mcb_L2_1 uon_L2_1 vthr ctail_L2_1 0 NSYN W=20u L=1u
Mcp1_L2_1 cna_L2_1 cna_L2_1 vdd vdd PMIR W=40u L=1u
Mcp2_L2_1 uon_L2_1 cna_L2_1 vdd vdd PMIR W=40u L=1u
Rulk_L2_1 uon_L2_1 vulk 60000.0
Mt_uU_L2_1_0 ts_uU_L2_1_0 hv_L1_13 0 0 NMIR W=48.0u L=1u
Mo1_uU_L2_1_0 da_uU_L2_1_0 d1bar_L2 ts_uU_L2_1_0 0 NMIR W=20u L=1u
Mo2_uU_L2_1_0 gp_2_1_0 dpre_L2_1 ts_uU_L2_1_0 0 NMIR W=20u L=1u
Mo3_uU_L2_1_0 da_uU_L2_1_0 da_uU_L2_1_0 vdd vdd PMIR W=60u L=1u
Mo4_uU_L2_1_0 gp_2_1_0 da_uU_L2_1_0 vdd vdd PMIR W=60u L=1u
Mt_uU_L2_1_1 ts_uU_L2_1_1 hv_L1_12 0 0 NMIR W=48.0u L=1u
Mo1_uU_L2_1_1 da_uU_L2_1_1 d1bar_L2 ts_uU_L2_1_1 0 NMIR W=20u L=1u
Mo2_uU_L2_1_1 gp_2_1_1 dpre_L2_1 ts_uU_L2_1_1 0 NMIR W=20u L=1u
Mo3_uU_L2_1_1 da_uU_L2_1_1 da_uU_L2_1_1 vdd vdd PMIR W=60u L=1u
Mo4_uU_L2_1_1 gp_2_1_1 da_uU_L2_1_1 vdd vdd PMIR W=60u L=1u
Mt_uU_L2_1_2 ts_uU_L2_1_2 hv_L1_14 0 0 NMIR W=48.0u L=1u
Mo1_uU_L2_1_2 da_uU_L2_1_2 d1bar_L2 ts_uU_L2_1_2 0 NMIR W=20u L=1u
Mo2_uU_L2_1_2 gp_2_1_2 dpre_L2_1 ts_uU_L2_1_2 0 NMIR W=20u L=1u
Mo3_uU_L2_1_2 da_uU_L2_1_2 da_uU_L2_1_2 vdd vdd PMIR W=60u L=1u
Mo4_uU_L2_1_2 gp_2_1_2 da_uU_L2_1_2 vdd vdd PMIR W=60u L=1u
Mt_uU_L2_1_3 ts_uU_L2_1_3 hv_L1_8 0 0 NMIR W=48.0u L=1u
Mo1_uU_L2_1_3 da_uU_L2_1_3 d1bar_L2 ts_uU_L2_1_3 0 NMIR W=20u L=1u
Mo2_uU_L2_1_3 gp_2_1_3 dpre_L2_1 ts_uU_L2_1_3 0 NMIR W=20u L=1u
Mo3_uU_L2_1_3 da_uU_L2_1_3 da_uU_L2_1_3 vdd vdd PMIR W=60u L=1u
Mo4_uU_L2_1_3 gp_2_1_3 da_uU_L2_1_3 vdd vdd PMIR W=60u L=1u
Mct_L2_2 ctail_L2_2 vcbias 0 0 NMIR W=10u L=1u
Mca_L2_2 cna_L2_2 z_L2_2 ctail_L2_2 0 NSYN W=20u L=1u
Mcb_L2_2 uon_L2_2 vthr ctail_L2_2 0 NSYN W=20u L=1u
Mcp1_L2_2 cna_L2_2 cna_L2_2 vdd vdd PMIR W=40u L=1u
Mcp2_L2_2 uon_L2_2 cna_L2_2 vdd vdd PMIR W=40u L=1u
Rulk_L2_2 uon_L2_2 vulk 60000.0
Mt_uU_L2_2_0 ts_uU_L2_2_0 hv_L1_15 0 0 NMIR W=48.0u L=1u
Mo1_uU_L2_2_0 da_uU_L2_2_0 d1bar_L2 ts_uU_L2_2_0 0 NMIR W=20u L=1u
Mo2_uU_L2_2_0 gp_2_2_0 dpre_L2_2 ts_uU_L2_2_0 0 NMIR W=20u L=1u
Mo3_uU_L2_2_0 da_uU_L2_2_0 da_uU_L2_2_0 vdd vdd PMIR W=60u L=1u
Mo4_uU_L2_2_0 gp_2_2_0 da_uU_L2_2_0 vdd vdd PMIR W=60u L=1u
Mt_uU_L2_2_1 ts_uU_L2_2_1 hv_L1_4 0 0 NMIR W=48.0u L=1u
Mo1_uU_L2_2_1 da_uU_L2_2_1 d1bar_L2 ts_uU_L2_2_1 0 NMIR W=20u L=1u
Mo2_uU_L2_2_1 gp_2_2_1 dpre_L2_2 ts_uU_L2_2_1 0 NMIR W=20u L=1u
Mo3_uU_L2_2_1 da_uU_L2_2_1 da_uU_L2_2_1 vdd vdd PMIR W=60u L=1u
Mo4_uU_L2_2_1 gp_2_2_1 da_uU_L2_2_1 vdd vdd PMIR W=60u L=1u
Mt_uU_L2_2_2 ts_uU_L2_2_2 hv_L1_5 0 0 NMIR W=48.0u L=1u
Mo1_uU_L2_2_2 da_uU_L2_2_2 d1bar_L2 ts_uU_L2_2_2 0 NMIR W=20u L=1u
Mo2_uU_L2_2_2 gp_2_2_2 dpre_L2_2 ts_uU_L2_2_2 0 NMIR W=20u L=1u
Mo3_uU_L2_2_2 da_uU_L2_2_2 da_uU_L2_2_2 vdd vdd PMIR W=60u L=1u
Mo4_uU_L2_2_2 gp_2_2_2 da_uU_L2_2_2 vdd vdd PMIR W=60u L=1u
Mt_uU_L2_2_3 ts_uU_L2_2_3 hv_L1_9 0 0 NMIR W=48.0u L=1u
Mo1_uU_L2_2_3 da_uU_L2_2_3 d1bar_L2 ts_uU_L2_2_3 0 NMIR W=20u L=1u
Mo2_uU_L2_2_3 gp_2_2_3 dpre_L2_2 ts_uU_L2_2_3 0 NMIR W=20u L=1u
Mo3_uU_L2_2_3 da_uU_L2_2_3 da_uU_L2_2_3 vdd vdd PMIR W=60u L=1u
Mo4_uU_L2_2_3 gp_2_2_3 da_uU_L2_2_3 vdd vdd PMIR W=60u L=1u
Mct_L2_3 ctail_L2_3 vcbias 0 0 NMIR W=10u L=1u
Mca_L2_3 cna_L2_3 z_L2_3 ctail_L2_3 0 NSYN W=20u L=1u
Mcb_L2_3 uon_L2_3 vthr ctail_L2_3 0 NSYN W=20u L=1u
Mcp1_L2_3 cna_L2_3 cna_L2_3 vdd vdd PMIR W=40u L=1u
Mcp2_L2_3 uon_L2_3 cna_L2_3 vdd vdd PMIR W=40u L=1u
Rulk_L2_3 uon_L2_3 vulk 60000.0
Mt_uU_L2_3_0 ts_uU_L2_3_0 hv_L1_1 0 0 NMIR W=48.0u L=1u
Mo1_uU_L2_3_0 da_uU_L2_3_0 d1bar_L2 ts_uU_L2_3_0 0 NMIR W=20u L=1u
Mo2_uU_L2_3_0 gp_2_3_0 dpre_L2_3 ts_uU_L2_3_0 0 NMIR W=20u L=1u
Mo3_uU_L2_3_0 da_uU_L2_3_0 da_uU_L2_3_0 vdd vdd PMIR W=60u L=1u
Mo4_uU_L2_3_0 gp_2_3_0 da_uU_L2_3_0 vdd vdd PMIR W=60u L=1u
Mt_uU_L2_3_1 ts_uU_L2_3_1 hv_L1_0 0 0 NMIR W=48.0u L=1u
Mo1_uU_L2_3_1 da_uU_L2_3_1 d1bar_L2 ts_uU_L2_3_1 0 NMIR W=20u L=1u
Mo2_uU_L2_3_1 gp_2_3_1 dpre_L2_3 ts_uU_L2_3_1 0 NMIR W=20u L=1u
Mo3_uU_L2_3_1 da_uU_L2_3_1 da_uU_L2_3_1 vdd vdd PMIR W=60u L=1u
Mo4_uU_L2_3_1 gp_2_3_1 da_uU_L2_3_1 vdd vdd PMIR W=60u L=1u
Mt_uU_L2_3_2 ts_uU_L2_3_2 hv_L1_10 0 0 NMIR W=48.0u L=1u
Mo1_uU_L2_3_2 da_uU_L2_3_2 d1bar_L2 ts_uU_L2_3_2 0 NMIR W=20u L=1u
Mo2_uU_L2_3_2 gp_2_3_2 dpre_L2_3 ts_uU_L2_3_2 0 NMIR W=20u L=1u
Mo3_uU_L2_3_2 da_uU_L2_3_2 da_uU_L2_3_2 vdd vdd PMIR W=60u L=1u
Mo4_uU_L2_3_2 gp_2_3_2 da_uU_L2_3_2 vdd vdd PMIR W=60u L=1u
Mt_uU_L2_3_3 ts_uU_L2_3_3 hv_L1_2 0 0 NMIR W=48.0u L=1u
Mo1_uU_L2_3_3 da_uU_L2_3_3 d1bar_L2 ts_uU_L2_3_3 0 NMIR W=20u L=1u
Mo2_uU_L2_3_3 gp_2_3_3 dpre_L2_3 ts_uU_L2_3_3 0 NMIR W=20u L=1u
Mo3_uU_L2_3_3 da_uU_L2_3_3 da_uU_L2_3_3 vdd vdd PMIR W=60u L=1u
Mo4_uU_L2_3_3 gp_2_3_3 da_uU_L2_3_3 vdd vdd PMIR W=60u L=1u
Mct_L2_4 ctail_L2_4 vcbias 0 0 NMIR W=10u L=1u
Mca_L2_4 cna_L2_4 z_L2_4 ctail_L2_4 0 NSYN W=20u L=1u
Mcb_L2_4 uon_L2_4 vthr ctail_L2_4 0 NSYN W=20u L=1u
Mcp1_L2_4 cna_L2_4 cna_L2_4 vdd vdd PMIR W=40u L=1u
Mcp2_L2_4 uon_L2_4 cna_L2_4 vdd vdd PMIR W=40u L=1u
Rulk_L2_4 uon_L2_4 vulk 60000.0
Mt_uU_L2_4_0 ts_uU_L2_4_0 hv_L1_0 0 0 NMIR W=48.0u L=1u
Mo1_uU_L2_4_0 da_uU_L2_4_0 d1bar_L2 ts_uU_L2_4_0 0 NMIR W=20u L=1u
Mo2_uU_L2_4_0 gp_2_4_0 dpre_L2_4 ts_uU_L2_4_0 0 NMIR W=20u L=1u
Mo3_uU_L2_4_0 da_uU_L2_4_0 da_uU_L2_4_0 vdd vdd PMIR W=60u L=1u
Mo4_uU_L2_4_0 gp_2_4_0 da_uU_L2_4_0 vdd vdd PMIR W=60u L=1u
Mt_uU_L2_4_1 ts_uU_L2_4_1 hv_L1_2 0 0 NMIR W=48.0u L=1u
Mo1_uU_L2_4_1 da_uU_L2_4_1 d1bar_L2 ts_uU_L2_4_1 0 NMIR W=20u L=1u
Mo2_uU_L2_4_1 gp_2_4_1 dpre_L2_4 ts_uU_L2_4_1 0 NMIR W=20u L=1u
Mo3_uU_L2_4_1 da_uU_L2_4_1 da_uU_L2_4_1 vdd vdd PMIR W=60u L=1u
Mo4_uU_L2_4_1 gp_2_4_1 da_uU_L2_4_1 vdd vdd PMIR W=60u L=1u
Mt_uU_L2_4_2 ts_uU_L2_4_2 hv_L1_13 0 0 NMIR W=48.0u L=1u
Mo1_uU_L2_4_2 da_uU_L2_4_2 d1bar_L2 ts_uU_L2_4_2 0 NMIR W=20u L=1u
Mo2_uU_L2_4_2 gp_2_4_2 dpre_L2_4 ts_uU_L2_4_2 0 NMIR W=20u L=1u
Mo3_uU_L2_4_2 da_uU_L2_4_2 da_uU_L2_4_2 vdd vdd PMIR W=60u L=1u
Mo4_uU_L2_4_2 gp_2_4_2 da_uU_L2_4_2 vdd vdd PMIR W=60u L=1u
Mt_uU_L2_4_3 ts_uU_L2_4_3 hv_L1_3 0 0 NMIR W=48.0u L=1u
Mo1_uU_L2_4_3 da_uU_L2_4_3 d1bar_L2 ts_uU_L2_4_3 0 NMIR W=20u L=1u
Mo2_uU_L2_4_3 gp_2_4_3 dpre_L2_4 ts_uU_L2_4_3 0 NMIR W=20u L=1u
Mo3_uU_L2_4_3 da_uU_L2_4_3 da_uU_L2_4_3 vdd vdd PMIR W=60u L=1u
Mo4_uU_L2_4_3 gp_2_4_3 da_uU_L2_4_3 vdd vdd PMIR W=60u L=1u
Mct_L2_5 ctail_L2_5 vcbias 0 0 NMIR W=10u L=1u
Mca_L2_5 cna_L2_5 z_L2_5 ctail_L2_5 0 NSYN W=20u L=1u
Mcb_L2_5 uon_L2_5 vthr ctail_L2_5 0 NSYN W=20u L=1u
Mcp1_L2_5 cna_L2_5 cna_L2_5 vdd vdd PMIR W=40u L=1u
Mcp2_L2_5 uon_L2_5 cna_L2_5 vdd vdd PMIR W=40u L=1u
Rulk_L2_5 uon_L2_5 vulk 60000.0
Mt_uU_L2_5_0 ts_uU_L2_5_0 hv_L1_6 0 0 NMIR W=48.0u L=1u
Mo1_uU_L2_5_0 da_uU_L2_5_0 d1bar_L2 ts_uU_L2_5_0 0 NMIR W=20u L=1u
Mo2_uU_L2_5_0 gp_2_5_0 dpre_L2_5 ts_uU_L2_5_0 0 NMIR W=20u L=1u
Mo3_uU_L2_5_0 da_uU_L2_5_0 da_uU_L2_5_0 vdd vdd PMIR W=60u L=1u
Mo4_uU_L2_5_0 gp_2_5_0 da_uU_L2_5_0 vdd vdd PMIR W=60u L=1u
Mt_uU_L2_5_1 ts_uU_L2_5_1 hv_L1_4 0 0 NMIR W=48.0u L=1u
Mo1_uU_L2_5_1 da_uU_L2_5_1 d1bar_L2 ts_uU_L2_5_1 0 NMIR W=20u L=1u
Mo2_uU_L2_5_1 gp_2_5_1 dpre_L2_5 ts_uU_L2_5_1 0 NMIR W=20u L=1u
Mo3_uU_L2_5_1 da_uU_L2_5_1 da_uU_L2_5_1 vdd vdd PMIR W=60u L=1u
Mo4_uU_L2_5_1 gp_2_5_1 da_uU_L2_5_1 vdd vdd PMIR W=60u L=1u
Mt_uU_L2_5_2 ts_uU_L2_5_2 hv_L1_9 0 0 NMIR W=48.0u L=1u
Mo1_uU_L2_5_2 da_uU_L2_5_2 d1bar_L2 ts_uU_L2_5_2 0 NMIR W=20u L=1u
Mo2_uU_L2_5_2 gp_2_5_2 dpre_L2_5 ts_uU_L2_5_2 0 NMIR W=20u L=1u
Mo3_uU_L2_5_2 da_uU_L2_5_2 da_uU_L2_5_2 vdd vdd PMIR W=60u L=1u
Mo4_uU_L2_5_2 gp_2_5_2 da_uU_L2_5_2 vdd vdd PMIR W=60u L=1u
Mt_uU_L2_5_3 ts_uU_L2_5_3 hv_L1_8 0 0 NMIR W=48.0u L=1u
Mo1_uU_L2_5_3 da_uU_L2_5_3 d1bar_L2 ts_uU_L2_5_3 0 NMIR W=20u L=1u
Mo2_uU_L2_5_3 gp_2_5_3 dpre_L2_5 ts_uU_L2_5_3 0 NMIR W=20u L=1u
Mo3_uU_L2_5_3 da_uU_L2_5_3 da_uU_L2_5_3 vdd vdd PMIR W=60u L=1u
Mo4_uU_L2_5_3 gp_2_5_3 da_uU_L2_5_3 vdd vdd PMIR W=60u L=1u
Mct_L2_6 ctail_L2_6 vcbias 0 0 NMIR W=10u L=1u
Mca_L2_6 cna_L2_6 z_L2_6 ctail_L2_6 0 NSYN W=20u L=1u
Mcb_L2_6 uon_L2_6 vthr ctail_L2_6 0 NSYN W=20u L=1u
Mcp1_L2_6 cna_L2_6 cna_L2_6 vdd vdd PMIR W=40u L=1u
Mcp2_L2_6 uon_L2_6 cna_L2_6 vdd vdd PMIR W=40u L=1u
Rulk_L2_6 uon_L2_6 vulk 60000.0
Mt_uU_L2_6_0 ts_uU_L2_6_0 hv_L1_1 0 0 NMIR W=48.0u L=1u
Mo1_uU_L2_6_0 da_uU_L2_6_0 d1bar_L2 ts_uU_L2_6_0 0 NMIR W=20u L=1u
Mo2_uU_L2_6_0 gp_2_6_0 dpre_L2_6 ts_uU_L2_6_0 0 NMIR W=20u L=1u
Mo3_uU_L2_6_0 da_uU_L2_6_0 da_uU_L2_6_0 vdd vdd PMIR W=60u L=1u
Mo4_uU_L2_6_0 gp_2_6_0 da_uU_L2_6_0 vdd vdd PMIR W=60u L=1u
Mt_uU_L2_6_1 ts_uU_L2_6_1 hv_L1_10 0 0 NMIR W=48.0u L=1u
Mo1_uU_L2_6_1 da_uU_L2_6_1 d1bar_L2 ts_uU_L2_6_1 0 NMIR W=20u L=1u
Mo2_uU_L2_6_1 gp_2_6_1 dpre_L2_6 ts_uU_L2_6_1 0 NMIR W=20u L=1u
Mo3_uU_L2_6_1 da_uU_L2_6_1 da_uU_L2_6_1 vdd vdd PMIR W=60u L=1u
Mo4_uU_L2_6_1 gp_2_6_1 da_uU_L2_6_1 vdd vdd PMIR W=60u L=1u
Mt_uU_L2_6_2 ts_uU_L2_6_2 hv_L1_14 0 0 NMIR W=48.0u L=1u
Mo1_uU_L2_6_2 da_uU_L2_6_2 d1bar_L2 ts_uU_L2_6_2 0 NMIR W=20u L=1u
Mo2_uU_L2_6_2 gp_2_6_2 dpre_L2_6 ts_uU_L2_6_2 0 NMIR W=20u L=1u
Mo3_uU_L2_6_2 da_uU_L2_6_2 da_uU_L2_6_2 vdd vdd PMIR W=60u L=1u
Mo4_uU_L2_6_2 gp_2_6_2 da_uU_L2_6_2 vdd vdd PMIR W=60u L=1u
Mt_uU_L2_6_3 ts_uU_L2_6_3 hv_L1_15 0 0 NMIR W=48.0u L=1u
Mo1_uU_L2_6_3 da_uU_L2_6_3 d1bar_L2 ts_uU_L2_6_3 0 NMIR W=20u L=1u
Mo2_uU_L2_6_3 gp_2_6_3 dpre_L2_6 ts_uU_L2_6_3 0 NMIR W=20u L=1u
Mo3_uU_L2_6_3 da_uU_L2_6_3 da_uU_L2_6_3 vdd vdd PMIR W=60u L=1u
Mo4_uU_L2_6_3 gp_2_6_3 da_uU_L2_6_3 vdd vdd PMIR W=60u L=1u
Mct_L2_7 ctail_L2_7 vcbias 0 0 NMIR W=10u L=1u
Mca_L2_7 cna_L2_7 z_L2_7 ctail_L2_7 0 NSYN W=20u L=1u
Mcb_L2_7 uon_L2_7 vthr ctail_L2_7 0 NSYN W=20u L=1u
Mcp1_L2_7 cna_L2_7 cna_L2_7 vdd vdd PMIR W=40u L=1u
Mcp2_L2_7 uon_L2_7 cna_L2_7 vdd vdd PMIR W=40u L=1u
Rulk_L2_7 uon_L2_7 vulk 60000.0
Mt_uU_L2_7_0 ts_uU_L2_7_0 hv_L1_5 0 0 NMIR W=48.0u L=1u
Mo1_uU_L2_7_0 da_uU_L2_7_0 d1bar_L2 ts_uU_L2_7_0 0 NMIR W=20u L=1u
Mo2_uU_L2_7_0 gp_2_7_0 dpre_L2_7 ts_uU_L2_7_0 0 NMIR W=20u L=1u
Mo3_uU_L2_7_0 da_uU_L2_7_0 da_uU_L2_7_0 vdd vdd PMIR W=60u L=1u
Mo4_uU_L2_7_0 gp_2_7_0 da_uU_L2_7_0 vdd vdd PMIR W=60u L=1u
Mt_uU_L2_7_1 ts_uU_L2_7_1 hv_L1_11 0 0 NMIR W=48.0u L=1u
Mo1_uU_L2_7_1 da_uU_L2_7_1 d1bar_L2 ts_uU_L2_7_1 0 NMIR W=20u L=1u
Mo2_uU_L2_7_1 gp_2_7_1 dpre_L2_7 ts_uU_L2_7_1 0 NMIR W=20u L=1u
Mo3_uU_L2_7_1 da_uU_L2_7_1 da_uU_L2_7_1 vdd vdd PMIR W=60u L=1u
Mo4_uU_L2_7_1 gp_2_7_1 da_uU_L2_7_1 vdd vdd PMIR W=60u L=1u
Mt_uU_L2_7_2 ts_uU_L2_7_2 hv_L1_12 0 0 NMIR W=48.0u L=1u
Mo1_uU_L2_7_2 da_uU_L2_7_2 d1bar_L2 ts_uU_L2_7_2 0 NMIR W=20u L=1u
Mo2_uU_L2_7_2 gp_2_7_2 dpre_L2_7 ts_uU_L2_7_2 0 NMIR W=20u L=1u
Mo3_uU_L2_7_2 da_uU_L2_7_2 da_uU_L2_7_2 vdd vdd PMIR W=60u L=1u
Mo4_uU_L2_7_2 gp_2_7_2 da_uU_L2_7_2 vdd vdd PMIR W=60u L=1u
Mt_uU_L2_7_3 ts_uU_L2_7_3 hv_L1_7 0 0 NMIR W=48.0u L=1u
Mo1_uU_L2_7_3 da_uU_L2_7_3 d1bar_L2 ts_uU_L2_7_3 0 NMIR W=20u L=1u
Mo2_uU_L2_7_3 gp_2_7_3 dpre_L2_7 ts_uU_L2_7_3 0 NMIR W=20u L=1u
Mo3_uU_L2_7_3 da_uU_L2_7_3 da_uU_L2_7_3 vdd vdd PMIR W=60u L=1u
Mo4_uU_L2_7_3 gp_2_7_3 da_uU_L2_7_3 vdd vdd PMIR W=60u L=1u
Mct_L2_8 ctail_L2_8 vcbias 0 0 NMIR W=10u L=1u
Mca_L2_8 cna_L2_8 z_L2_8 ctail_L2_8 0 NSYN W=20u L=1u
Mcb_L2_8 uon_L2_8 vthr ctail_L2_8 0 NSYN W=20u L=1u
Mcp1_L2_8 cna_L2_8 cna_L2_8 vdd vdd PMIR W=40u L=1u
Mcp2_L2_8 uon_L2_8 cna_L2_8 vdd vdd PMIR W=40u L=1u
Rulk_L2_8 uon_L2_8 vulk 60000.0
Mt_uU_L2_8_0 ts_uU_L2_8_0 hv_L1_13 0 0 NMIR W=48.0u L=1u
Mo1_uU_L2_8_0 da_uU_L2_8_0 d1bar_L2 ts_uU_L2_8_0 0 NMIR W=20u L=1u
Mo2_uU_L2_8_0 gp_2_8_0 dpre_L2_8 ts_uU_L2_8_0 0 NMIR W=20u L=1u
Mo3_uU_L2_8_0 da_uU_L2_8_0 da_uU_L2_8_0 vdd vdd PMIR W=60u L=1u
Mo4_uU_L2_8_0 gp_2_8_0 da_uU_L2_8_0 vdd vdd PMIR W=60u L=1u
Mt_uU_L2_8_1 ts_uU_L2_8_1 hv_L1_5 0 0 NMIR W=48.0u L=1u
Mo1_uU_L2_8_1 da_uU_L2_8_1 d1bar_L2 ts_uU_L2_8_1 0 NMIR W=20u L=1u
Mo2_uU_L2_8_1 gp_2_8_1 dpre_L2_8 ts_uU_L2_8_1 0 NMIR W=20u L=1u
Mo3_uU_L2_8_1 da_uU_L2_8_1 da_uU_L2_8_1 vdd vdd PMIR W=60u L=1u
Mo4_uU_L2_8_1 gp_2_8_1 da_uU_L2_8_1 vdd vdd PMIR W=60u L=1u
Mt_uU_L2_8_2 ts_uU_L2_8_2 hv_L1_12 0 0 NMIR W=48.0u L=1u
Mo1_uU_L2_8_2 da_uU_L2_8_2 d1bar_L2 ts_uU_L2_8_2 0 NMIR W=20u L=1u
Mo2_uU_L2_8_2 gp_2_8_2 dpre_L2_8 ts_uU_L2_8_2 0 NMIR W=20u L=1u
Mo3_uU_L2_8_2 da_uU_L2_8_2 da_uU_L2_8_2 vdd vdd PMIR W=60u L=1u
Mo4_uU_L2_8_2 gp_2_8_2 da_uU_L2_8_2 vdd vdd PMIR W=60u L=1u
Mt_uU_L2_8_3 ts_uU_L2_8_3 hv_L1_9 0 0 NMIR W=48.0u L=1u
Mo1_uU_L2_8_3 da_uU_L2_8_3 d1bar_L2 ts_uU_L2_8_3 0 NMIR W=20u L=1u
Mo2_uU_L2_8_3 gp_2_8_3 dpre_L2_8 ts_uU_L2_8_3 0 NMIR W=20u L=1u
Mo3_uU_L2_8_3 da_uU_L2_8_3 da_uU_L2_8_3 vdd vdd PMIR W=60u L=1u
Mo4_uU_L2_8_3 gp_2_8_3 da_uU_L2_8_3 vdd vdd PMIR W=60u L=1u
Mct_L2_9 ctail_L2_9 vcbias 0 0 NMIR W=10u L=1u
Mca_L2_9 cna_L2_9 z_L2_9 ctail_L2_9 0 NSYN W=20u L=1u
Mcb_L2_9 uon_L2_9 vthr ctail_L2_9 0 NSYN W=20u L=1u
Mcp1_L2_9 cna_L2_9 cna_L2_9 vdd vdd PMIR W=40u L=1u
Mcp2_L2_9 uon_L2_9 cna_L2_9 vdd vdd PMIR W=40u L=1u
Rulk_L2_9 uon_L2_9 vulk 60000.0
Mt_uU_L2_9_0 ts_uU_L2_9_0 hv_L1_11 0 0 NMIR W=48.0u L=1u
Mo1_uU_L2_9_0 da_uU_L2_9_0 d1bar_L2 ts_uU_L2_9_0 0 NMIR W=20u L=1u
Mo2_uU_L2_9_0 gp_2_9_0 dpre_L2_9 ts_uU_L2_9_0 0 NMIR W=20u L=1u
Mo3_uU_L2_9_0 da_uU_L2_9_0 da_uU_L2_9_0 vdd vdd PMIR W=60u L=1u
Mo4_uU_L2_9_0 gp_2_9_0 da_uU_L2_9_0 vdd vdd PMIR W=60u L=1u
Mt_uU_L2_9_1 ts_uU_L2_9_1 hv_L1_4 0 0 NMIR W=48.0u L=1u
Mo1_uU_L2_9_1 da_uU_L2_9_1 d1bar_L2 ts_uU_L2_9_1 0 NMIR W=20u L=1u
Mo2_uU_L2_9_1 gp_2_9_1 dpre_L2_9 ts_uU_L2_9_1 0 NMIR W=20u L=1u
Mo3_uU_L2_9_1 da_uU_L2_9_1 da_uU_L2_9_1 vdd vdd PMIR W=60u L=1u
Mo4_uU_L2_9_1 gp_2_9_1 da_uU_L2_9_1 vdd vdd PMIR W=60u L=1u
Mt_uU_L2_9_2 ts_uU_L2_9_2 hv_L1_0 0 0 NMIR W=48.0u L=1u
Mo1_uU_L2_9_2 da_uU_L2_9_2 d1bar_L2 ts_uU_L2_9_2 0 NMIR W=20u L=1u
Mo2_uU_L2_9_2 gp_2_9_2 dpre_L2_9 ts_uU_L2_9_2 0 NMIR W=20u L=1u
Mo3_uU_L2_9_2 da_uU_L2_9_2 da_uU_L2_9_2 vdd vdd PMIR W=60u L=1u
Mo4_uU_L2_9_2 gp_2_9_2 da_uU_L2_9_2 vdd vdd PMIR W=60u L=1u
Mt_uU_L2_9_3 ts_uU_L2_9_3 hv_L1_7 0 0 NMIR W=48.0u L=1u
Mo1_uU_L2_9_3 da_uU_L2_9_3 d1bar_L2 ts_uU_L2_9_3 0 NMIR W=20u L=1u
Mo2_uU_L2_9_3 gp_2_9_3 dpre_L2_9 ts_uU_L2_9_3 0 NMIR W=20u L=1u
Mo3_uU_L2_9_3 da_uU_L2_9_3 da_uU_L2_9_3 vdd vdd PMIR W=60u L=1u
Mo4_uU_L2_9_3 gp_2_9_3 da_uU_L2_9_3 vdd vdd PMIR W=60u L=1u
Mct_L2_10 ctail_L2_10 vcbias 0 0 NMIR W=10u L=1u
Mca_L2_10 cna_L2_10 z_L2_10 ctail_L2_10 0 NSYN W=20u L=1u
Mcb_L2_10 uon_L2_10 vthr ctail_L2_10 0 NSYN W=20u L=1u
Mcp1_L2_10 cna_L2_10 cna_L2_10 vdd vdd PMIR W=40u L=1u
Mcp2_L2_10 uon_L2_10 cna_L2_10 vdd vdd PMIR W=40u L=1u
Rulk_L2_10 uon_L2_10 vulk 60000.0
Mt_uU_L2_10_0 ts_uU_L2_10_0 hv_L1_2 0 0 NMIR W=48.0u L=1u
Mo1_uU_L2_10_0 da_uU_L2_10_0 d1bar_L2 ts_uU_L2_10_0 0 NMIR W=20u L=1u
Mo2_uU_L2_10_0 gp_2_10_0 dpre_L2_10 ts_uU_L2_10_0 0 NMIR W=20u L=1u
Mo3_uU_L2_10_0 da_uU_L2_10_0 da_uU_L2_10_0 vdd vdd PMIR W=60u L=1u
Mo4_uU_L2_10_0 gp_2_10_0 da_uU_L2_10_0 vdd vdd PMIR W=60u L=1u
Mt_uU_L2_10_1 ts_uU_L2_10_1 hv_L1_15 0 0 NMIR W=48.0u L=1u
Mo1_uU_L2_10_1 da_uU_L2_10_1 d1bar_L2 ts_uU_L2_10_1 0 NMIR W=20u L=1u
Mo2_uU_L2_10_1 gp_2_10_1 dpre_L2_10 ts_uU_L2_10_1 0 NMIR W=20u L=1u
Mo3_uU_L2_10_1 da_uU_L2_10_1 da_uU_L2_10_1 vdd vdd PMIR W=60u L=1u
Mo4_uU_L2_10_1 gp_2_10_1 da_uU_L2_10_1 vdd vdd PMIR W=60u L=1u
Mt_uU_L2_10_2 ts_uU_L2_10_2 hv_L1_1 0 0 NMIR W=48.0u L=1u
Mo1_uU_L2_10_2 da_uU_L2_10_2 d1bar_L2 ts_uU_L2_10_2 0 NMIR W=20u L=1u
Mo2_uU_L2_10_2 gp_2_10_2 dpre_L2_10 ts_uU_L2_10_2 0 NMIR W=20u L=1u
Mo3_uU_L2_10_2 da_uU_L2_10_2 da_uU_L2_10_2 vdd vdd PMIR W=60u L=1u
Mo4_uU_L2_10_2 gp_2_10_2 da_uU_L2_10_2 vdd vdd PMIR W=60u L=1u
Mt_uU_L2_10_3 ts_uU_L2_10_3 hv_L1_10 0 0 NMIR W=48.0u L=1u
Mo1_uU_L2_10_3 da_uU_L2_10_3 d1bar_L2 ts_uU_L2_10_3 0 NMIR W=20u L=1u
Mo2_uU_L2_10_3 gp_2_10_3 dpre_L2_10 ts_uU_L2_10_3 0 NMIR W=20u L=1u
Mo3_uU_L2_10_3 da_uU_L2_10_3 da_uU_L2_10_3 vdd vdd PMIR W=60u L=1u
Mo4_uU_L2_10_3 gp_2_10_3 da_uU_L2_10_3 vdd vdd PMIR W=60u L=1u
Mct_L2_11 ctail_L2_11 vcbias 0 0 NMIR W=10u L=1u
Mca_L2_11 cna_L2_11 z_L2_11 ctail_L2_11 0 NSYN W=20u L=1u
Mcb_L2_11 uon_L2_11 vthr ctail_L2_11 0 NSYN W=20u L=1u
Mcp1_L2_11 cna_L2_11 cna_L2_11 vdd vdd PMIR W=40u L=1u
Mcp2_L2_11 uon_L2_11 cna_L2_11 vdd vdd PMIR W=40u L=1u
Rulk_L2_11 uon_L2_11 vulk 60000.0
Mt_uU_L2_11_0 ts_uU_L2_11_0 hv_L1_8 0 0 NMIR W=48.0u L=1u
Mo1_uU_L2_11_0 da_uU_L2_11_0 d1bar_L2 ts_uU_L2_11_0 0 NMIR W=20u L=1u
Mo2_uU_L2_11_0 gp_2_11_0 dpre_L2_11 ts_uU_L2_11_0 0 NMIR W=20u L=1u
Mo3_uU_L2_11_0 da_uU_L2_11_0 da_uU_L2_11_0 vdd vdd PMIR W=60u L=1u
Mo4_uU_L2_11_0 gp_2_11_0 da_uU_L2_11_0 vdd vdd PMIR W=60u L=1u
Mt_uU_L2_11_1 ts_uU_L2_11_1 hv_L1_6 0 0 NMIR W=48.0u L=1u
Mo1_uU_L2_11_1 da_uU_L2_11_1 d1bar_L2 ts_uU_L2_11_1 0 NMIR W=20u L=1u
Mo2_uU_L2_11_1 gp_2_11_1 dpre_L2_11 ts_uU_L2_11_1 0 NMIR W=20u L=1u
Mo3_uU_L2_11_1 da_uU_L2_11_1 da_uU_L2_11_1 vdd vdd PMIR W=60u L=1u
Mo4_uU_L2_11_1 gp_2_11_1 da_uU_L2_11_1 vdd vdd PMIR W=60u L=1u
Mt_uU_L2_11_2 ts_uU_L2_11_2 hv_L1_14 0 0 NMIR W=48.0u L=1u
Mo1_uU_L2_11_2 da_uU_L2_11_2 d1bar_L2 ts_uU_L2_11_2 0 NMIR W=20u L=1u
Mo2_uU_L2_11_2 gp_2_11_2 dpre_L2_11 ts_uU_L2_11_2 0 NMIR W=20u L=1u
Mo3_uU_L2_11_2 da_uU_L2_11_2 da_uU_L2_11_2 vdd vdd PMIR W=60u L=1u
Mo4_uU_L2_11_2 gp_2_11_2 da_uU_L2_11_2 vdd vdd PMIR W=60u L=1u
Mt_uU_L2_11_3 ts_uU_L2_11_3 hv_L1_3 0 0 NMIR W=48.0u L=1u
Mo1_uU_L2_11_3 da_uU_L2_11_3 d1bar_L2 ts_uU_L2_11_3 0 NMIR W=20u L=1u
Mo2_uU_L2_11_3 gp_2_11_3 dpre_L2_11 ts_uU_L2_11_3 0 NMIR W=20u L=1u
Mo3_uU_L2_11_3 da_uU_L2_11_3 da_uU_L2_11_3 vdd vdd PMIR W=60u L=1u
Mo4_uU_L2_11_3 gp_2_11_3 da_uU_L2_11_3 vdd vdd PMIR W=60u L=1u
Mct_L2_12 ctail_L2_12 vcbias 0 0 NMIR W=10u L=1u
Mca_L2_12 cna_L2_12 z_L2_12 ctail_L2_12 0 NSYN W=20u L=1u
Mcb_L2_12 uon_L2_12 vthr ctail_L2_12 0 NSYN W=20u L=1u
Mcp1_L2_12 cna_L2_12 cna_L2_12 vdd vdd PMIR W=40u L=1u
Mcp2_L2_12 uon_L2_12 cna_L2_12 vdd vdd PMIR W=40u L=1u
Rulk_L2_12 uon_L2_12 vulk 60000.0
Mt_uU_L2_12_0 ts_uU_L2_12_0 hv_L1_4 0 0 NMIR W=48.0u L=1u
Mo1_uU_L2_12_0 da_uU_L2_12_0 d1bar_L2 ts_uU_L2_12_0 0 NMIR W=20u L=1u
Mo2_uU_L2_12_0 gp_2_12_0 dpre_L2_12 ts_uU_L2_12_0 0 NMIR W=20u L=1u
Mo3_uU_L2_12_0 da_uU_L2_12_0 da_uU_L2_12_0 vdd vdd PMIR W=60u L=1u
Mo4_uU_L2_12_0 gp_2_12_0 da_uU_L2_12_0 vdd vdd PMIR W=60u L=1u
Mt_uU_L2_12_1 ts_uU_L2_12_1 hv_L1_2 0 0 NMIR W=48.0u L=1u
Mo1_uU_L2_12_1 da_uU_L2_12_1 d1bar_L2 ts_uU_L2_12_1 0 NMIR W=20u L=1u
Mo2_uU_L2_12_1 gp_2_12_1 dpre_L2_12 ts_uU_L2_12_1 0 NMIR W=20u L=1u
Mo3_uU_L2_12_1 da_uU_L2_12_1 da_uU_L2_12_1 vdd vdd PMIR W=60u L=1u
Mo4_uU_L2_12_1 gp_2_12_1 da_uU_L2_12_1 vdd vdd PMIR W=60u L=1u
Mt_uU_L2_12_2 ts_uU_L2_12_2 hv_L1_14 0 0 NMIR W=48.0u L=1u
Mo1_uU_L2_12_2 da_uU_L2_12_2 d1bar_L2 ts_uU_L2_12_2 0 NMIR W=20u L=1u
Mo2_uU_L2_12_2 gp_2_12_2 dpre_L2_12 ts_uU_L2_12_2 0 NMIR W=20u L=1u
Mo3_uU_L2_12_2 da_uU_L2_12_2 da_uU_L2_12_2 vdd vdd PMIR W=60u L=1u
Mo4_uU_L2_12_2 gp_2_12_2 da_uU_L2_12_2 vdd vdd PMIR W=60u L=1u
Mt_uU_L2_12_3 ts_uU_L2_12_3 hv_L1_12 0 0 NMIR W=48.0u L=1u
Mo1_uU_L2_12_3 da_uU_L2_12_3 d1bar_L2 ts_uU_L2_12_3 0 NMIR W=20u L=1u
Mo2_uU_L2_12_3 gp_2_12_3 dpre_L2_12 ts_uU_L2_12_3 0 NMIR W=20u L=1u
Mo3_uU_L2_12_3 da_uU_L2_12_3 da_uU_L2_12_3 vdd vdd PMIR W=60u L=1u
Mo4_uU_L2_12_3 gp_2_12_3 da_uU_L2_12_3 vdd vdd PMIR W=60u L=1u
Mct_L2_13 ctail_L2_13 vcbias 0 0 NMIR W=10u L=1u
Mca_L2_13 cna_L2_13 z_L2_13 ctail_L2_13 0 NSYN W=20u L=1u
Mcb_L2_13 uon_L2_13 vthr ctail_L2_13 0 NSYN W=20u L=1u
Mcp1_L2_13 cna_L2_13 cna_L2_13 vdd vdd PMIR W=40u L=1u
Mcp2_L2_13 uon_L2_13 cna_L2_13 vdd vdd PMIR W=40u L=1u
Rulk_L2_13 uon_L2_13 vulk 60000.0
Mt_uU_L2_13_0 ts_uU_L2_13_0 hv_L1_7 0 0 NMIR W=48.0u L=1u
Mo1_uU_L2_13_0 da_uU_L2_13_0 d1bar_L2 ts_uU_L2_13_0 0 NMIR W=20u L=1u
Mo2_uU_L2_13_0 gp_2_13_0 dpre_L2_13 ts_uU_L2_13_0 0 NMIR W=20u L=1u
Mo3_uU_L2_13_0 da_uU_L2_13_0 da_uU_L2_13_0 vdd vdd PMIR W=60u L=1u
Mo4_uU_L2_13_0 gp_2_13_0 da_uU_L2_13_0 vdd vdd PMIR W=60u L=1u
Mt_uU_L2_13_1 ts_uU_L2_13_1 hv_L1_11 0 0 NMIR W=48.0u L=1u
Mo1_uU_L2_13_1 da_uU_L2_13_1 d1bar_L2 ts_uU_L2_13_1 0 NMIR W=20u L=1u
Mo2_uU_L2_13_1 gp_2_13_1 dpre_L2_13 ts_uU_L2_13_1 0 NMIR W=20u L=1u
Mo3_uU_L2_13_1 da_uU_L2_13_1 da_uU_L2_13_1 vdd vdd PMIR W=60u L=1u
Mo4_uU_L2_13_1 gp_2_13_1 da_uU_L2_13_1 vdd vdd PMIR W=60u L=1u
Mt_uU_L2_13_2 ts_uU_L2_13_2 hv_L1_10 0 0 NMIR W=48.0u L=1u
Mo1_uU_L2_13_2 da_uU_L2_13_2 d1bar_L2 ts_uU_L2_13_2 0 NMIR W=20u L=1u
Mo2_uU_L2_13_2 gp_2_13_2 dpre_L2_13 ts_uU_L2_13_2 0 NMIR W=20u L=1u
Mo3_uU_L2_13_2 da_uU_L2_13_2 da_uU_L2_13_2 vdd vdd PMIR W=60u L=1u
Mo4_uU_L2_13_2 gp_2_13_2 da_uU_L2_13_2 vdd vdd PMIR W=60u L=1u
Mt_uU_L2_13_3 ts_uU_L2_13_3 hv_L1_6 0 0 NMIR W=48.0u L=1u
Mo1_uU_L2_13_3 da_uU_L2_13_3 d1bar_L2 ts_uU_L2_13_3 0 NMIR W=20u L=1u
Mo2_uU_L2_13_3 gp_2_13_3 dpre_L2_13 ts_uU_L2_13_3 0 NMIR W=20u L=1u
Mo3_uU_L2_13_3 da_uU_L2_13_3 da_uU_L2_13_3 vdd vdd PMIR W=60u L=1u
Mo4_uU_L2_13_3 gp_2_13_3 da_uU_L2_13_3 vdd vdd PMIR W=60u L=1u
Mct_L2_14 ctail_L2_14 vcbias 0 0 NMIR W=10u L=1u
Mca_L2_14 cna_L2_14 z_L2_14 ctail_L2_14 0 NSYN W=20u L=1u
Mcb_L2_14 uon_L2_14 vthr ctail_L2_14 0 NSYN W=20u L=1u
Mcp1_L2_14 cna_L2_14 cna_L2_14 vdd vdd PMIR W=40u L=1u
Mcp2_L2_14 uon_L2_14 cna_L2_14 vdd vdd PMIR W=40u L=1u
Rulk_L2_14 uon_L2_14 vulk 60000.0
Mt_uU_L2_14_0 ts_uU_L2_14_0 hv_L1_5 0 0 NMIR W=48.0u L=1u
Mo1_uU_L2_14_0 da_uU_L2_14_0 d1bar_L2 ts_uU_L2_14_0 0 NMIR W=20u L=1u
Mo2_uU_L2_14_0 gp_2_14_0 dpre_L2_14 ts_uU_L2_14_0 0 NMIR W=20u L=1u
Mo3_uU_L2_14_0 da_uU_L2_14_0 da_uU_L2_14_0 vdd vdd PMIR W=60u L=1u
Mo4_uU_L2_14_0 gp_2_14_0 da_uU_L2_14_0 vdd vdd PMIR W=60u L=1u
Mt_uU_L2_14_1 ts_uU_L2_14_1 hv_L1_8 0 0 NMIR W=48.0u L=1u
Mo1_uU_L2_14_1 da_uU_L2_14_1 d1bar_L2 ts_uU_L2_14_1 0 NMIR W=20u L=1u
Mo2_uU_L2_14_1 gp_2_14_1 dpre_L2_14 ts_uU_L2_14_1 0 NMIR W=20u L=1u
Mo3_uU_L2_14_1 da_uU_L2_14_1 da_uU_L2_14_1 vdd vdd PMIR W=60u L=1u
Mo4_uU_L2_14_1 gp_2_14_1 da_uU_L2_14_1 vdd vdd PMIR W=60u L=1u
Mt_uU_L2_14_2 ts_uU_L2_14_2 hv_L1_9 0 0 NMIR W=48.0u L=1u
Mo1_uU_L2_14_2 da_uU_L2_14_2 d1bar_L2 ts_uU_L2_14_2 0 NMIR W=20u L=1u
Mo2_uU_L2_14_2 gp_2_14_2 dpre_L2_14 ts_uU_L2_14_2 0 NMIR W=20u L=1u
Mo3_uU_L2_14_2 da_uU_L2_14_2 da_uU_L2_14_2 vdd vdd PMIR W=60u L=1u
Mo4_uU_L2_14_2 gp_2_14_2 da_uU_L2_14_2 vdd vdd PMIR W=60u L=1u
Mt_uU_L2_14_3 ts_uU_L2_14_3 hv_L1_13 0 0 NMIR W=48.0u L=1u
Mo1_uU_L2_14_3 da_uU_L2_14_3 d1bar_L2 ts_uU_L2_14_3 0 NMIR W=20u L=1u
Mo2_uU_L2_14_3 gp_2_14_3 dpre_L2_14 ts_uU_L2_14_3 0 NMIR W=20u L=1u
Mo3_uU_L2_14_3 da_uU_L2_14_3 da_uU_L2_14_3 vdd vdd PMIR W=60u L=1u
Mo4_uU_L2_14_3 gp_2_14_3 da_uU_L2_14_3 vdd vdd PMIR W=60u L=1u
Mct_L2_15 ctail_L2_15 vcbias 0 0 NMIR W=10u L=1u
Mca_L2_15 cna_L2_15 z_L2_15 ctail_L2_15 0 NSYN W=20u L=1u
Mcb_L2_15 uon_L2_15 vthr ctail_L2_15 0 NSYN W=20u L=1u
Mcp1_L2_15 cna_L2_15 cna_L2_15 vdd vdd PMIR W=40u L=1u
Mcp2_L2_15 uon_L2_15 cna_L2_15 vdd vdd PMIR W=40u L=1u
Rulk_L2_15 uon_L2_15 vulk 60000.0
Mt_uU_L2_15_0 ts_uU_L2_15_0 hv_L1_15 0 0 NMIR W=48.0u L=1u
Mo1_uU_L2_15_0 da_uU_L2_15_0 d1bar_L2 ts_uU_L2_15_0 0 NMIR W=20u L=1u
Mo2_uU_L2_15_0 gp_2_15_0 dpre_L2_15 ts_uU_L2_15_0 0 NMIR W=20u L=1u
Mo3_uU_L2_15_0 da_uU_L2_15_0 da_uU_L2_15_0 vdd vdd PMIR W=60u L=1u
Mo4_uU_L2_15_0 gp_2_15_0 da_uU_L2_15_0 vdd vdd PMIR W=60u L=1u
Mt_uU_L2_15_1 ts_uU_L2_15_1 hv_L1_3 0 0 NMIR W=48.0u L=1u
Mo1_uU_L2_15_1 da_uU_L2_15_1 d1bar_L2 ts_uU_L2_15_1 0 NMIR W=20u L=1u
Mo2_uU_L2_15_1 gp_2_15_1 dpre_L2_15 ts_uU_L2_15_1 0 NMIR W=20u L=1u
Mo3_uU_L2_15_1 da_uU_L2_15_1 da_uU_L2_15_1 vdd vdd PMIR W=60u L=1u
Mo4_uU_L2_15_1 gp_2_15_1 da_uU_L2_15_1 vdd vdd PMIR W=60u L=1u
Mt_uU_L2_15_2 ts_uU_L2_15_2 hv_L1_0 0 0 NMIR W=48.0u L=1u
Mo1_uU_L2_15_2 da_uU_L2_15_2 d1bar_L2 ts_uU_L2_15_2 0 NMIR W=20u L=1u
Mo2_uU_L2_15_2 gp_2_15_2 dpre_L2_15 ts_uU_L2_15_2 0 NMIR W=20u L=1u
Mo3_uU_L2_15_2 da_uU_L2_15_2 da_uU_L2_15_2 vdd vdd PMIR W=60u L=1u
Mo4_uU_L2_15_2 gp_2_15_2 da_uU_L2_15_2 vdd vdd PMIR W=60u L=1u
Mt_uU_L2_15_3 ts_uU_L2_15_3 hv_L1_1 0 0 NMIR W=48.0u L=1u
Mo1_uU_L2_15_3 da_uU_L2_15_3 d1bar_L2 ts_uU_L2_15_3 0 NMIR W=20u L=1u
Mo2_uU_L2_15_3 gp_2_15_3 dpre_L2_15 ts_uU_L2_15_3 0 NMIR W=20u L=1u
Mo3_uU_L2_15_3 da_uU_L2_15_3 da_uU_L2_15_3 vdd vdd PMIR W=60u L=1u
Mo4_uU_L2_15_3 gp_2_15_3 da_uU_L2_15_3 vdd vdd PMIR W=60u L=1u
MpTa_L1_0_0 dpre_L2_3 gp_2_3_1 ctp_L1_0 0 NSYN W=10u L=1u
MnTb_L1_0_0 vrefd vcn ctp_L1_0 0 NSYN W=10u L=1u
MnTa_L1_0_0 dpre_L2_3 vcn ctn_L1_0 0 NSYN W=10u L=1u
MpTb_L1_0_0 vrefd gp_2_3_1 ctn_L1_0 0 NSYN W=10u L=1u
MpTa_L1_0_1 dpre_L2_4 gp_2_4_0 ctp_L1_0 0 NSYN W=10u L=1u
MnTb_L1_0_1 vrefd vcn ctp_L1_0 0 NSYN W=10u L=1u
MnTa_L1_0_1 dpre_L2_4 vcn ctn_L1_0 0 NSYN W=10u L=1u
MpTb_L1_0_1 vrefd gp_2_4_0 ctn_L1_0 0 NSYN W=10u L=1u
MpTa_L1_0_2 dpre_L2_9 gp_2_9_2 ctp_L1_0 0 NSYN W=10u L=1u
MnTb_L1_0_2 vrefd vcn ctp_L1_0 0 NSYN W=10u L=1u
MnTa_L1_0_2 dpre_L2_9 vcn ctn_L1_0 0 NSYN W=10u L=1u
MpTb_L1_0_2 vrefd gp_2_9_2 ctn_L1_0 0 NSYN W=10u L=1u
MpTa_L1_0_3 dpre_L2_15 gp_2_15_2 ctp_L1_0 0 NSYN W=10u L=1u
MnTb_L1_0_3 vrefd vcn ctp_L1_0 0 NSYN W=10u L=1u
MnTa_L1_0_3 dpre_L2_15 vcn ctn_L1_0 0 NSYN W=10u L=1u
MpTb_L1_0_3 vrefd gp_2_15_2 ctn_L1_0 0 NSYN W=10u L=1u
Msa_bk_L1_0 ctn_L1_0 ctn_L1_0 0 0 NMIR W=20u L=1u
Msb_bk_L1_0 dpre_L1_0 ctn_L1_0 0 0 NMIR W=20u L=1u
Msc_bk_L1_0 ctp_L1_0 ctp_L1_0 0 0 NMIR W=20u L=1u
Msd_bk_L1_0 dpf_bk_L1_0 ctp_L1_0 0 0 NMIR W=20u L=1u
Mse_bk_L1_0 dpf_bk_L1_0 dpf_bk_L1_0 vdd vdd PMIR W=60u L=1u
Msf_bk_L1_0 dpre_L1_0 dpf_bk_L1_0 vdd vdd PMIR W=60u L=1u
R_bk_L1_0 dpre_L1_0 vrefd 16000.0
MpTa_L1_1_0 dpre_L2_3 gp_2_3_0 ctp_L1_1 0 NSYN W=10u L=1u
MnTb_L1_1_0 vrefd vcn ctp_L1_1 0 NSYN W=10u L=1u
MnTa_L1_1_0 dpre_L2_3 vcn ctn_L1_1 0 NSYN W=10u L=1u
MpTb_L1_1_0 vrefd gp_2_3_0 ctn_L1_1 0 NSYN W=10u L=1u
MpTa_L1_1_1 dpre_L2_6 gp_2_6_0 ctp_L1_1 0 NSYN W=10u L=1u
MnTb_L1_1_1 vrefd vcn ctp_L1_1 0 NSYN W=10u L=1u
MnTa_L1_1_1 dpre_L2_6 vcn ctn_L1_1 0 NSYN W=10u L=1u
MpTb_L1_1_1 vrefd gp_2_6_0 ctn_L1_1 0 NSYN W=10u L=1u
MpTa_L1_1_2 dpre_L2_10 gp_2_10_2 ctp_L1_1 0 NSYN W=10u L=1u
MnTb_L1_1_2 vrefd vcn ctp_L1_1 0 NSYN W=10u L=1u
MnTa_L1_1_2 dpre_L2_10 vcn ctn_L1_1 0 NSYN W=10u L=1u
MpTb_L1_1_2 vrefd gp_2_10_2 ctn_L1_1 0 NSYN W=10u L=1u
MpTa_L1_1_3 dpre_L2_15 gp_2_15_3 ctp_L1_1 0 NSYN W=10u L=1u
MnTb_L1_1_3 vrefd vcn ctp_L1_1 0 NSYN W=10u L=1u
MnTa_L1_1_3 dpre_L2_15 vcn ctn_L1_1 0 NSYN W=10u L=1u
MpTb_L1_1_3 vrefd gp_2_15_3 ctn_L1_1 0 NSYN W=10u L=1u
Msa_bk_L1_1 ctn_L1_1 ctn_L1_1 0 0 NMIR W=20u L=1u
Msb_bk_L1_1 dpre_L1_1 ctn_L1_1 0 0 NMIR W=20u L=1u
Msc_bk_L1_1 ctp_L1_1 ctp_L1_1 0 0 NMIR W=20u L=1u
Msd_bk_L1_1 dpf_bk_L1_1 ctp_L1_1 0 0 NMIR W=20u L=1u
Mse_bk_L1_1 dpf_bk_L1_1 dpf_bk_L1_1 vdd vdd PMIR W=60u L=1u
Msf_bk_L1_1 dpre_L1_1 dpf_bk_L1_1 vdd vdd PMIR W=60u L=1u
R_bk_L1_1 dpre_L1_1 vrefd 16000.0
MpTa_L1_2_0 dpre_L2_3 gp_2_3_3 ctp_L1_2 0 NSYN W=10u L=1u
MnTb_L1_2_0 vrefd vcn ctp_L1_2 0 NSYN W=10u L=1u
MnTa_L1_2_0 dpre_L2_3 vcn ctn_L1_2 0 NSYN W=10u L=1u
MpTb_L1_2_0 vrefd gp_2_3_3 ctn_L1_2 0 NSYN W=10u L=1u
MpTa_L1_2_1 dpre_L2_4 gp_2_4_1 ctp_L1_2 0 NSYN W=10u L=1u
MnTb_L1_2_1 vrefd vcn ctp_L1_2 0 NSYN W=10u L=1u
MnTa_L1_2_1 dpre_L2_4 vcn ctn_L1_2 0 NSYN W=10u L=1u
MpTb_L1_2_1 vrefd gp_2_4_1 ctn_L1_2 0 NSYN W=10u L=1u
MpTa_L1_2_2 dpre_L2_10 gp_2_10_0 ctp_L1_2 0 NSYN W=10u L=1u
MnTb_L1_2_2 vrefd vcn ctp_L1_2 0 NSYN W=10u L=1u
MnTa_L1_2_2 dpre_L2_10 vcn ctn_L1_2 0 NSYN W=10u L=1u
MpTb_L1_2_2 vrefd gp_2_10_0 ctn_L1_2 0 NSYN W=10u L=1u
MpTa_L1_2_3 dpre_L2_12 gp_2_12_1 ctp_L1_2 0 NSYN W=10u L=1u
MnTb_L1_2_3 vrefd vcn ctp_L1_2 0 NSYN W=10u L=1u
MnTa_L1_2_3 dpre_L2_12 vcn ctn_L1_2 0 NSYN W=10u L=1u
MpTb_L1_2_3 vrefd gp_2_12_1 ctn_L1_2 0 NSYN W=10u L=1u
Msa_bk_L1_2 ctn_L1_2 ctn_L1_2 0 0 NMIR W=20u L=1u
Msb_bk_L1_2 dpre_L1_2 ctn_L1_2 0 0 NMIR W=20u L=1u
Msc_bk_L1_2 ctp_L1_2 ctp_L1_2 0 0 NMIR W=20u L=1u
Msd_bk_L1_2 dpf_bk_L1_2 ctp_L1_2 0 0 NMIR W=20u L=1u
Mse_bk_L1_2 dpf_bk_L1_2 dpf_bk_L1_2 vdd vdd PMIR W=60u L=1u
Msf_bk_L1_2 dpre_L1_2 dpf_bk_L1_2 vdd vdd PMIR W=60u L=1u
R_bk_L1_2 dpre_L1_2 vrefd 16000.0
MpTa_L1_3_0 dpre_L2_0 gp_2_0_1 ctp_L1_3 0 NSYN W=10u L=1u
MnTb_L1_3_0 vrefd vcn ctp_L1_3 0 NSYN W=10u L=1u
MnTa_L1_3_0 dpre_L2_0 vcn ctn_L1_3 0 NSYN W=10u L=1u
MpTb_L1_3_0 vrefd gp_2_0_1 ctn_L1_3 0 NSYN W=10u L=1u
MpTa_L1_3_1 dpre_L2_4 gp_2_4_3 ctp_L1_3 0 NSYN W=10u L=1u
MnTb_L1_3_1 vrefd vcn ctp_L1_3 0 NSYN W=10u L=1u
MnTa_L1_3_1 dpre_L2_4 vcn ctn_L1_3 0 NSYN W=10u L=1u
MpTb_L1_3_1 vrefd gp_2_4_3 ctn_L1_3 0 NSYN W=10u L=1u
MpTa_L1_3_2 dpre_L2_11 gp_2_11_3 ctp_L1_3 0 NSYN W=10u L=1u
MnTb_L1_3_2 vrefd vcn ctp_L1_3 0 NSYN W=10u L=1u
MnTa_L1_3_2 dpre_L2_11 vcn ctn_L1_3 0 NSYN W=10u L=1u
MpTb_L1_3_2 vrefd gp_2_11_3 ctn_L1_3 0 NSYN W=10u L=1u
MpTa_L1_3_3 dpre_L2_15 gp_2_15_1 ctp_L1_3 0 NSYN W=10u L=1u
MnTb_L1_3_3 vrefd vcn ctp_L1_3 0 NSYN W=10u L=1u
MnTa_L1_3_3 dpre_L2_15 vcn ctn_L1_3 0 NSYN W=10u L=1u
MpTb_L1_3_3 vrefd gp_2_15_1 ctn_L1_3 0 NSYN W=10u L=1u
Msa_bk_L1_3 ctn_L1_3 ctn_L1_3 0 0 NMIR W=20u L=1u
Msb_bk_L1_3 dpre_L1_3 ctn_L1_3 0 0 NMIR W=20u L=1u
Msc_bk_L1_3 ctp_L1_3 ctp_L1_3 0 0 NMIR W=20u L=1u
Msd_bk_L1_3 dpf_bk_L1_3 ctp_L1_3 0 0 NMIR W=20u L=1u
Mse_bk_L1_3 dpf_bk_L1_3 dpf_bk_L1_3 vdd vdd PMIR W=60u L=1u
Msf_bk_L1_3 dpre_L1_3 dpf_bk_L1_3 vdd vdd PMIR W=60u L=1u
R_bk_L1_3 dpre_L1_3 vrefd 16000.0
MpTa_L1_4_0 dpre_L2_2 gp_2_2_1 ctp_L1_4 0 NSYN W=10u L=1u
MnTb_L1_4_0 vrefd vcn ctp_L1_4 0 NSYN W=10u L=1u
MnTa_L1_4_0 dpre_L2_2 vcn ctn_L1_4 0 NSYN W=10u L=1u
MpTb_L1_4_0 vrefd gp_2_2_1 ctn_L1_4 0 NSYN W=10u L=1u
MpTa_L1_4_1 dpre_L2_5 gp_2_5_1 ctp_L1_4 0 NSYN W=10u L=1u
MnTb_L1_4_1 vrefd vcn ctp_L1_4 0 NSYN W=10u L=1u
MnTa_L1_4_1 dpre_L2_5 vcn ctn_L1_4 0 NSYN W=10u L=1u
MpTb_L1_4_1 vrefd gp_2_5_1 ctn_L1_4 0 NSYN W=10u L=1u
MpTa_L1_4_2 dpre_L2_9 gp_2_9_1 ctp_L1_4 0 NSYN W=10u L=1u
MnTb_L1_4_2 vrefd vcn ctp_L1_4 0 NSYN W=10u L=1u
MnTa_L1_4_2 dpre_L2_9 vcn ctn_L1_4 0 NSYN W=10u L=1u
MpTb_L1_4_2 vrefd gp_2_9_1 ctn_L1_4 0 NSYN W=10u L=1u
MpTa_L1_4_3 dpre_L2_12 gp_2_12_0 ctp_L1_4 0 NSYN W=10u L=1u
MnTb_L1_4_3 vrefd vcn ctp_L1_4 0 NSYN W=10u L=1u
MnTa_L1_4_3 dpre_L2_12 vcn ctn_L1_4 0 NSYN W=10u L=1u
MpTb_L1_4_3 vrefd gp_2_12_0 ctn_L1_4 0 NSYN W=10u L=1u
Msa_bk_L1_4 ctn_L1_4 ctn_L1_4 0 0 NMIR W=20u L=1u
Msb_bk_L1_4 dpre_L1_4 ctn_L1_4 0 0 NMIR W=20u L=1u
Msc_bk_L1_4 ctp_L1_4 ctp_L1_4 0 0 NMIR W=20u L=1u
Msd_bk_L1_4 dpf_bk_L1_4 ctp_L1_4 0 0 NMIR W=20u L=1u
Mse_bk_L1_4 dpf_bk_L1_4 dpf_bk_L1_4 vdd vdd PMIR W=60u L=1u
Msf_bk_L1_4 dpre_L1_4 dpf_bk_L1_4 vdd vdd PMIR W=60u L=1u
R_bk_L1_4 dpre_L1_4 vrefd 16000.0
MpTa_L1_5_0 dpre_L2_2 gp_2_2_2 ctp_L1_5 0 NSYN W=10u L=1u
MnTb_L1_5_0 vrefd vcn ctp_L1_5 0 NSYN W=10u L=1u
MnTa_L1_5_0 dpre_L2_2 vcn ctn_L1_5 0 NSYN W=10u L=1u
MpTb_L1_5_0 vrefd gp_2_2_2 ctn_L1_5 0 NSYN W=10u L=1u
MpTa_L1_5_1 dpre_L2_7 gp_2_7_0 ctp_L1_5 0 NSYN W=10u L=1u
MnTb_L1_5_1 vrefd vcn ctp_L1_5 0 NSYN W=10u L=1u
MnTa_L1_5_1 dpre_L2_7 vcn ctn_L1_5 0 NSYN W=10u L=1u
MpTb_L1_5_1 vrefd gp_2_7_0 ctn_L1_5 0 NSYN W=10u L=1u
MpTa_L1_5_2 dpre_L2_8 gp_2_8_1 ctp_L1_5 0 NSYN W=10u L=1u
MnTb_L1_5_2 vrefd vcn ctp_L1_5 0 NSYN W=10u L=1u
MnTa_L1_5_2 dpre_L2_8 vcn ctn_L1_5 0 NSYN W=10u L=1u
MpTb_L1_5_2 vrefd gp_2_8_1 ctn_L1_5 0 NSYN W=10u L=1u
MpTa_L1_5_3 dpre_L2_14 gp_2_14_0 ctp_L1_5 0 NSYN W=10u L=1u
MnTb_L1_5_3 vrefd vcn ctp_L1_5 0 NSYN W=10u L=1u
MnTa_L1_5_3 dpre_L2_14 vcn ctn_L1_5 0 NSYN W=10u L=1u
MpTb_L1_5_3 vrefd gp_2_14_0 ctn_L1_5 0 NSYN W=10u L=1u
Msa_bk_L1_5 ctn_L1_5 ctn_L1_5 0 0 NMIR W=20u L=1u
Msb_bk_L1_5 dpre_L1_5 ctn_L1_5 0 0 NMIR W=20u L=1u
Msc_bk_L1_5 ctp_L1_5 ctp_L1_5 0 0 NMIR W=20u L=1u
Msd_bk_L1_5 dpf_bk_L1_5 ctp_L1_5 0 0 NMIR W=20u L=1u
Mse_bk_L1_5 dpf_bk_L1_5 dpf_bk_L1_5 vdd vdd PMIR W=60u L=1u
Msf_bk_L1_5 dpre_L1_5 dpf_bk_L1_5 vdd vdd PMIR W=60u L=1u
R_bk_L1_5 dpre_L1_5 vrefd 16000.0
MpTa_L1_6_0 dpre_L2_0 gp_2_0_3 ctp_L1_6 0 NSYN W=10u L=1u
MnTb_L1_6_0 vrefd vcn ctp_L1_6 0 NSYN W=10u L=1u
MnTa_L1_6_0 dpre_L2_0 vcn ctn_L1_6 0 NSYN W=10u L=1u
MpTb_L1_6_0 vrefd gp_2_0_3 ctn_L1_6 0 NSYN W=10u L=1u
MpTa_L1_6_1 dpre_L2_5 gp_2_5_0 ctp_L1_6 0 NSYN W=10u L=1u
MnTb_L1_6_1 vrefd vcn ctp_L1_6 0 NSYN W=10u L=1u
MnTa_L1_6_1 dpre_L2_5 vcn ctn_L1_6 0 NSYN W=10u L=1u
MpTb_L1_6_1 vrefd gp_2_5_0 ctn_L1_6 0 NSYN W=10u L=1u
MpTa_L1_6_2 dpre_L2_11 gp_2_11_1 ctp_L1_6 0 NSYN W=10u L=1u
MnTb_L1_6_2 vrefd vcn ctp_L1_6 0 NSYN W=10u L=1u
MnTa_L1_6_2 dpre_L2_11 vcn ctn_L1_6 0 NSYN W=10u L=1u
MpTb_L1_6_2 vrefd gp_2_11_1 ctn_L1_6 0 NSYN W=10u L=1u
MpTa_L1_6_3 dpre_L2_13 gp_2_13_3 ctp_L1_6 0 NSYN W=10u L=1u
MnTb_L1_6_3 vrefd vcn ctp_L1_6 0 NSYN W=10u L=1u
MnTa_L1_6_3 dpre_L2_13 vcn ctn_L1_6 0 NSYN W=10u L=1u
MpTb_L1_6_3 vrefd gp_2_13_3 ctn_L1_6 0 NSYN W=10u L=1u
Msa_bk_L1_6 ctn_L1_6 ctn_L1_6 0 0 NMIR W=20u L=1u
Msb_bk_L1_6 dpre_L1_6 ctn_L1_6 0 0 NMIR W=20u L=1u
Msc_bk_L1_6 ctp_L1_6 ctp_L1_6 0 0 NMIR W=20u L=1u
Msd_bk_L1_6 dpf_bk_L1_6 ctp_L1_6 0 0 NMIR W=20u L=1u
Mse_bk_L1_6 dpf_bk_L1_6 dpf_bk_L1_6 vdd vdd PMIR W=60u L=1u
Msf_bk_L1_6 dpre_L1_6 dpf_bk_L1_6 vdd vdd PMIR W=60u L=1u
R_bk_L1_6 dpre_L1_6 vrefd 16000.0
MpTa_L1_7_0 dpre_L2_0 gp_2_0_0 ctp_L1_7 0 NSYN W=10u L=1u
MnTb_L1_7_0 vrefd vcn ctp_L1_7 0 NSYN W=10u L=1u
MnTa_L1_7_0 dpre_L2_0 vcn ctn_L1_7 0 NSYN W=10u L=1u
MpTb_L1_7_0 vrefd gp_2_0_0 ctn_L1_7 0 NSYN W=10u L=1u
MpTa_L1_7_1 dpre_L2_7 gp_2_7_3 ctp_L1_7 0 NSYN W=10u L=1u
MnTb_L1_7_1 vrefd vcn ctp_L1_7 0 NSYN W=10u L=1u
MnTa_L1_7_1 dpre_L2_7 vcn ctn_L1_7 0 NSYN W=10u L=1u
MpTb_L1_7_1 vrefd gp_2_7_3 ctn_L1_7 0 NSYN W=10u L=1u
MpTa_L1_7_2 dpre_L2_9 gp_2_9_3 ctp_L1_7 0 NSYN W=10u L=1u
MnTb_L1_7_2 vrefd vcn ctp_L1_7 0 NSYN W=10u L=1u
MnTa_L1_7_2 dpre_L2_9 vcn ctn_L1_7 0 NSYN W=10u L=1u
MpTb_L1_7_2 vrefd gp_2_9_3 ctn_L1_7 0 NSYN W=10u L=1u
MpTa_L1_7_3 dpre_L2_13 gp_2_13_0 ctp_L1_7 0 NSYN W=10u L=1u
MnTb_L1_7_3 vrefd vcn ctp_L1_7 0 NSYN W=10u L=1u
MnTa_L1_7_3 dpre_L2_13 vcn ctn_L1_7 0 NSYN W=10u L=1u
MpTb_L1_7_3 vrefd gp_2_13_0 ctn_L1_7 0 NSYN W=10u L=1u
Msa_bk_L1_7 ctn_L1_7 ctn_L1_7 0 0 NMIR W=20u L=1u
Msb_bk_L1_7 dpre_L1_7 ctn_L1_7 0 0 NMIR W=20u L=1u
Msc_bk_L1_7 ctp_L1_7 ctp_L1_7 0 0 NMIR W=20u L=1u
Msd_bk_L1_7 dpf_bk_L1_7 ctp_L1_7 0 0 NMIR W=20u L=1u
Mse_bk_L1_7 dpf_bk_L1_7 dpf_bk_L1_7 vdd vdd PMIR W=60u L=1u
Msf_bk_L1_7 dpre_L1_7 dpf_bk_L1_7 vdd vdd PMIR W=60u L=1u
R_bk_L1_7 dpre_L1_7 vrefd 16000.0
MpTa_L1_8_0 dpre_L2_1 gp_2_1_3 ctp_L1_8 0 NSYN W=10u L=1u
MnTb_L1_8_0 vrefd vcn ctp_L1_8 0 NSYN W=10u L=1u
MnTa_L1_8_0 dpre_L2_1 vcn ctn_L1_8 0 NSYN W=10u L=1u
MpTb_L1_8_0 vrefd gp_2_1_3 ctn_L1_8 0 NSYN W=10u L=1u
MpTa_L1_8_1 dpre_L2_5 gp_2_5_3 ctp_L1_8 0 NSYN W=10u L=1u
MnTb_L1_8_1 vrefd vcn ctp_L1_8 0 NSYN W=10u L=1u
MnTa_L1_8_1 dpre_L2_5 vcn ctn_L1_8 0 NSYN W=10u L=1u
MpTb_L1_8_1 vrefd gp_2_5_3 ctn_L1_8 0 NSYN W=10u L=1u
MpTa_L1_8_2 dpre_L2_11 gp_2_11_0 ctp_L1_8 0 NSYN W=10u L=1u
MnTb_L1_8_2 vrefd vcn ctp_L1_8 0 NSYN W=10u L=1u
MnTa_L1_8_2 dpre_L2_11 vcn ctn_L1_8 0 NSYN W=10u L=1u
MpTb_L1_8_2 vrefd gp_2_11_0 ctn_L1_8 0 NSYN W=10u L=1u
MpTa_L1_8_3 dpre_L2_14 gp_2_14_1 ctp_L1_8 0 NSYN W=10u L=1u
MnTb_L1_8_3 vrefd vcn ctp_L1_8 0 NSYN W=10u L=1u
MnTa_L1_8_3 dpre_L2_14 vcn ctn_L1_8 0 NSYN W=10u L=1u
MpTb_L1_8_3 vrefd gp_2_14_1 ctn_L1_8 0 NSYN W=10u L=1u
Msa_bk_L1_8 ctn_L1_8 ctn_L1_8 0 0 NMIR W=20u L=1u
Msb_bk_L1_8 dpre_L1_8 ctn_L1_8 0 0 NMIR W=20u L=1u
Msc_bk_L1_8 ctp_L1_8 ctp_L1_8 0 0 NMIR W=20u L=1u
Msd_bk_L1_8 dpf_bk_L1_8 ctp_L1_8 0 0 NMIR W=20u L=1u
Mse_bk_L1_8 dpf_bk_L1_8 dpf_bk_L1_8 vdd vdd PMIR W=60u L=1u
Msf_bk_L1_8 dpre_L1_8 dpf_bk_L1_8 vdd vdd PMIR W=60u L=1u
R_bk_L1_8 dpre_L1_8 vrefd 16000.0
MpTa_L1_9_0 dpre_L2_2 gp_2_2_3 ctp_L1_9 0 NSYN W=10u L=1u
MnTb_L1_9_0 vrefd vcn ctp_L1_9 0 NSYN W=10u L=1u
MnTa_L1_9_0 dpre_L2_2 vcn ctn_L1_9 0 NSYN W=10u L=1u
MpTb_L1_9_0 vrefd gp_2_2_3 ctn_L1_9 0 NSYN W=10u L=1u
MpTa_L1_9_1 dpre_L2_5 gp_2_5_2 ctp_L1_9 0 NSYN W=10u L=1u
MnTb_L1_9_1 vrefd vcn ctp_L1_9 0 NSYN W=10u L=1u
MnTa_L1_9_1 dpre_L2_5 vcn ctn_L1_9 0 NSYN W=10u L=1u
MpTb_L1_9_1 vrefd gp_2_5_2 ctn_L1_9 0 NSYN W=10u L=1u
MpTa_L1_9_2 dpre_L2_8 gp_2_8_3 ctp_L1_9 0 NSYN W=10u L=1u
MnTb_L1_9_2 vrefd vcn ctp_L1_9 0 NSYN W=10u L=1u
MnTa_L1_9_2 dpre_L2_8 vcn ctn_L1_9 0 NSYN W=10u L=1u
MpTb_L1_9_2 vrefd gp_2_8_3 ctn_L1_9 0 NSYN W=10u L=1u
MpTa_L1_9_3 dpre_L2_14 gp_2_14_2 ctp_L1_9 0 NSYN W=10u L=1u
MnTb_L1_9_3 vrefd vcn ctp_L1_9 0 NSYN W=10u L=1u
MnTa_L1_9_3 dpre_L2_14 vcn ctn_L1_9 0 NSYN W=10u L=1u
MpTb_L1_9_3 vrefd gp_2_14_2 ctn_L1_9 0 NSYN W=10u L=1u
Msa_bk_L1_9 ctn_L1_9 ctn_L1_9 0 0 NMIR W=20u L=1u
Msb_bk_L1_9 dpre_L1_9 ctn_L1_9 0 0 NMIR W=20u L=1u
Msc_bk_L1_9 ctp_L1_9 ctp_L1_9 0 0 NMIR W=20u L=1u
Msd_bk_L1_9 dpf_bk_L1_9 ctp_L1_9 0 0 NMIR W=20u L=1u
Mse_bk_L1_9 dpf_bk_L1_9 dpf_bk_L1_9 vdd vdd PMIR W=60u L=1u
Msf_bk_L1_9 dpre_L1_9 dpf_bk_L1_9 vdd vdd PMIR W=60u L=1u
R_bk_L1_9 dpre_L1_9 vrefd 16000.0
MpTa_L1_10_0 dpre_L2_3 gp_2_3_2 ctp_L1_10 0 NSYN W=10u L=1u
MnTb_L1_10_0 vrefd vcn ctp_L1_10 0 NSYN W=10u L=1u
MnTa_L1_10_0 dpre_L2_3 vcn ctn_L1_10 0 NSYN W=10u L=1u
MpTb_L1_10_0 vrefd gp_2_3_2 ctn_L1_10 0 NSYN W=10u L=1u
MpTa_L1_10_1 dpre_L2_6 gp_2_6_1 ctp_L1_10 0 NSYN W=10u L=1u
MnTb_L1_10_1 vrefd vcn ctp_L1_10 0 NSYN W=10u L=1u
MnTa_L1_10_1 dpre_L2_6 vcn ctn_L1_10 0 NSYN W=10u L=1u
MpTb_L1_10_1 vrefd gp_2_6_1 ctn_L1_10 0 NSYN W=10u L=1u
MpTa_L1_10_2 dpre_L2_10 gp_2_10_3 ctp_L1_10 0 NSYN W=10u L=1u
MnTb_L1_10_2 vrefd vcn ctp_L1_10 0 NSYN W=10u L=1u
MnTa_L1_10_2 dpre_L2_10 vcn ctn_L1_10 0 NSYN W=10u L=1u
MpTb_L1_10_2 vrefd gp_2_10_3 ctn_L1_10 0 NSYN W=10u L=1u
MpTa_L1_10_3 dpre_L2_13 gp_2_13_2 ctp_L1_10 0 NSYN W=10u L=1u
MnTb_L1_10_3 vrefd vcn ctp_L1_10 0 NSYN W=10u L=1u
MnTa_L1_10_3 dpre_L2_13 vcn ctn_L1_10 0 NSYN W=10u L=1u
MpTb_L1_10_3 vrefd gp_2_13_2 ctn_L1_10 0 NSYN W=10u L=1u
Msa_bk_L1_10 ctn_L1_10 ctn_L1_10 0 0 NMIR W=20u L=1u
Msb_bk_L1_10 dpre_L1_10 ctn_L1_10 0 0 NMIR W=20u L=1u
Msc_bk_L1_10 ctp_L1_10 ctp_L1_10 0 0 NMIR W=20u L=1u
Msd_bk_L1_10 dpf_bk_L1_10 ctp_L1_10 0 0 NMIR W=20u L=1u
Mse_bk_L1_10 dpf_bk_L1_10 dpf_bk_L1_10 vdd vdd PMIR W=60u L=1u
Msf_bk_L1_10 dpre_L1_10 dpf_bk_L1_10 vdd vdd PMIR W=60u L=1u
R_bk_L1_10 dpre_L1_10 vrefd 16000.0
MpTa_L1_11_0 dpre_L2_0 gp_2_0_2 ctp_L1_11 0 NSYN W=10u L=1u
MnTb_L1_11_0 vrefd vcn ctp_L1_11 0 NSYN W=10u L=1u
MnTa_L1_11_0 dpre_L2_0 vcn ctn_L1_11 0 NSYN W=10u L=1u
MpTb_L1_11_0 vrefd gp_2_0_2 ctn_L1_11 0 NSYN W=10u L=1u
MpTa_L1_11_1 dpre_L2_7 gp_2_7_1 ctp_L1_11 0 NSYN W=10u L=1u
MnTb_L1_11_1 vrefd vcn ctp_L1_11 0 NSYN W=10u L=1u
MnTa_L1_11_1 dpre_L2_7 vcn ctn_L1_11 0 NSYN W=10u L=1u
MpTb_L1_11_1 vrefd gp_2_7_1 ctn_L1_11 0 NSYN W=10u L=1u
MpTa_L1_11_2 dpre_L2_9 gp_2_9_0 ctp_L1_11 0 NSYN W=10u L=1u
MnTb_L1_11_2 vrefd vcn ctp_L1_11 0 NSYN W=10u L=1u
MnTa_L1_11_2 dpre_L2_9 vcn ctn_L1_11 0 NSYN W=10u L=1u
MpTb_L1_11_2 vrefd gp_2_9_0 ctn_L1_11 0 NSYN W=10u L=1u
MpTa_L1_11_3 dpre_L2_13 gp_2_13_1 ctp_L1_11 0 NSYN W=10u L=1u
MnTb_L1_11_3 vrefd vcn ctp_L1_11 0 NSYN W=10u L=1u
MnTa_L1_11_3 dpre_L2_13 vcn ctn_L1_11 0 NSYN W=10u L=1u
MpTb_L1_11_3 vrefd gp_2_13_1 ctn_L1_11 0 NSYN W=10u L=1u
Msa_bk_L1_11 ctn_L1_11 ctn_L1_11 0 0 NMIR W=20u L=1u
Msb_bk_L1_11 dpre_L1_11 ctn_L1_11 0 0 NMIR W=20u L=1u
Msc_bk_L1_11 ctp_L1_11 ctp_L1_11 0 0 NMIR W=20u L=1u
Msd_bk_L1_11 dpf_bk_L1_11 ctp_L1_11 0 0 NMIR W=20u L=1u
Mse_bk_L1_11 dpf_bk_L1_11 dpf_bk_L1_11 vdd vdd PMIR W=60u L=1u
Msf_bk_L1_11 dpre_L1_11 dpf_bk_L1_11 vdd vdd PMIR W=60u L=1u
R_bk_L1_11 dpre_L1_11 vrefd 16000.0
MpTa_L1_12_0 dpre_L2_1 gp_2_1_1 ctp_L1_12 0 NSYN W=10u L=1u
MnTb_L1_12_0 vrefd vcn ctp_L1_12 0 NSYN W=10u L=1u
MnTa_L1_12_0 dpre_L2_1 vcn ctn_L1_12 0 NSYN W=10u L=1u
MpTb_L1_12_0 vrefd gp_2_1_1 ctn_L1_12 0 NSYN W=10u L=1u
MpTa_L1_12_1 dpre_L2_7 gp_2_7_2 ctp_L1_12 0 NSYN W=10u L=1u
MnTb_L1_12_1 vrefd vcn ctp_L1_12 0 NSYN W=10u L=1u
MnTa_L1_12_1 dpre_L2_7 vcn ctn_L1_12 0 NSYN W=10u L=1u
MpTb_L1_12_1 vrefd gp_2_7_2 ctn_L1_12 0 NSYN W=10u L=1u
MpTa_L1_12_2 dpre_L2_8 gp_2_8_2 ctp_L1_12 0 NSYN W=10u L=1u
MnTb_L1_12_2 vrefd vcn ctp_L1_12 0 NSYN W=10u L=1u
MnTa_L1_12_2 dpre_L2_8 vcn ctn_L1_12 0 NSYN W=10u L=1u
MpTb_L1_12_2 vrefd gp_2_8_2 ctn_L1_12 0 NSYN W=10u L=1u
MpTa_L1_12_3 dpre_L2_12 gp_2_12_3 ctp_L1_12 0 NSYN W=10u L=1u
MnTb_L1_12_3 vrefd vcn ctp_L1_12 0 NSYN W=10u L=1u
MnTa_L1_12_3 dpre_L2_12 vcn ctn_L1_12 0 NSYN W=10u L=1u
MpTb_L1_12_3 vrefd gp_2_12_3 ctn_L1_12 0 NSYN W=10u L=1u
Msa_bk_L1_12 ctn_L1_12 ctn_L1_12 0 0 NMIR W=20u L=1u
Msb_bk_L1_12 dpre_L1_12 ctn_L1_12 0 0 NMIR W=20u L=1u
Msc_bk_L1_12 ctp_L1_12 ctp_L1_12 0 0 NMIR W=20u L=1u
Msd_bk_L1_12 dpf_bk_L1_12 ctp_L1_12 0 0 NMIR W=20u L=1u
Mse_bk_L1_12 dpf_bk_L1_12 dpf_bk_L1_12 vdd vdd PMIR W=60u L=1u
Msf_bk_L1_12 dpre_L1_12 dpf_bk_L1_12 vdd vdd PMIR W=60u L=1u
R_bk_L1_12 dpre_L1_12 vrefd 16000.0
MpTa_L1_13_0 dpre_L2_1 gp_2_1_0 ctp_L1_13 0 NSYN W=10u L=1u
MnTb_L1_13_0 vrefd vcn ctp_L1_13 0 NSYN W=10u L=1u
MnTa_L1_13_0 dpre_L2_1 vcn ctn_L1_13 0 NSYN W=10u L=1u
MpTb_L1_13_0 vrefd gp_2_1_0 ctn_L1_13 0 NSYN W=10u L=1u
MpTa_L1_13_1 dpre_L2_4 gp_2_4_2 ctp_L1_13 0 NSYN W=10u L=1u
MnTb_L1_13_1 vrefd vcn ctp_L1_13 0 NSYN W=10u L=1u
MnTa_L1_13_1 dpre_L2_4 vcn ctn_L1_13 0 NSYN W=10u L=1u
MpTb_L1_13_1 vrefd gp_2_4_2 ctn_L1_13 0 NSYN W=10u L=1u
MpTa_L1_13_2 dpre_L2_8 gp_2_8_0 ctp_L1_13 0 NSYN W=10u L=1u
MnTb_L1_13_2 vrefd vcn ctp_L1_13 0 NSYN W=10u L=1u
MnTa_L1_13_2 dpre_L2_8 vcn ctn_L1_13 0 NSYN W=10u L=1u
MpTb_L1_13_2 vrefd gp_2_8_0 ctn_L1_13 0 NSYN W=10u L=1u
MpTa_L1_13_3 dpre_L2_14 gp_2_14_3 ctp_L1_13 0 NSYN W=10u L=1u
MnTb_L1_13_3 vrefd vcn ctp_L1_13 0 NSYN W=10u L=1u
MnTa_L1_13_3 dpre_L2_14 vcn ctn_L1_13 0 NSYN W=10u L=1u
MpTb_L1_13_3 vrefd gp_2_14_3 ctn_L1_13 0 NSYN W=10u L=1u
Msa_bk_L1_13 ctn_L1_13 ctn_L1_13 0 0 NMIR W=20u L=1u
Msb_bk_L1_13 dpre_L1_13 ctn_L1_13 0 0 NMIR W=20u L=1u
Msc_bk_L1_13 ctp_L1_13 ctp_L1_13 0 0 NMIR W=20u L=1u
Msd_bk_L1_13 dpf_bk_L1_13 ctp_L1_13 0 0 NMIR W=20u L=1u
Mse_bk_L1_13 dpf_bk_L1_13 dpf_bk_L1_13 vdd vdd PMIR W=60u L=1u
Msf_bk_L1_13 dpre_L1_13 dpf_bk_L1_13 vdd vdd PMIR W=60u L=1u
R_bk_L1_13 dpre_L1_13 vrefd 16000.0
MpTa_L1_14_0 dpre_L2_1 gp_2_1_2 ctp_L1_14 0 NSYN W=10u L=1u
MnTb_L1_14_0 vrefd vcn ctp_L1_14 0 NSYN W=10u L=1u
MnTa_L1_14_0 dpre_L2_1 vcn ctn_L1_14 0 NSYN W=10u L=1u
MpTb_L1_14_0 vrefd gp_2_1_2 ctn_L1_14 0 NSYN W=10u L=1u
MpTa_L1_14_1 dpre_L2_6 gp_2_6_2 ctp_L1_14 0 NSYN W=10u L=1u
MnTb_L1_14_1 vrefd vcn ctp_L1_14 0 NSYN W=10u L=1u
MnTa_L1_14_1 dpre_L2_6 vcn ctn_L1_14 0 NSYN W=10u L=1u
MpTb_L1_14_1 vrefd gp_2_6_2 ctn_L1_14 0 NSYN W=10u L=1u
MpTa_L1_14_2 dpre_L2_11 gp_2_11_2 ctp_L1_14 0 NSYN W=10u L=1u
MnTb_L1_14_2 vrefd vcn ctp_L1_14 0 NSYN W=10u L=1u
MnTa_L1_14_2 dpre_L2_11 vcn ctn_L1_14 0 NSYN W=10u L=1u
MpTb_L1_14_2 vrefd gp_2_11_2 ctn_L1_14 0 NSYN W=10u L=1u
MpTa_L1_14_3 dpre_L2_12 gp_2_12_2 ctp_L1_14 0 NSYN W=10u L=1u
MnTb_L1_14_3 vrefd vcn ctp_L1_14 0 NSYN W=10u L=1u
MnTa_L1_14_3 dpre_L2_12 vcn ctn_L1_14 0 NSYN W=10u L=1u
MpTb_L1_14_3 vrefd gp_2_12_2 ctn_L1_14 0 NSYN W=10u L=1u
Msa_bk_L1_14 ctn_L1_14 ctn_L1_14 0 0 NMIR W=20u L=1u
Msb_bk_L1_14 dpre_L1_14 ctn_L1_14 0 0 NMIR W=20u L=1u
Msc_bk_L1_14 ctp_L1_14 ctp_L1_14 0 0 NMIR W=20u L=1u
Msd_bk_L1_14 dpf_bk_L1_14 ctp_L1_14 0 0 NMIR W=20u L=1u
Mse_bk_L1_14 dpf_bk_L1_14 dpf_bk_L1_14 vdd vdd PMIR W=60u L=1u
Msf_bk_L1_14 dpre_L1_14 dpf_bk_L1_14 vdd vdd PMIR W=60u L=1u
R_bk_L1_14 dpre_L1_14 vrefd 16000.0
MpTa_L1_15_0 dpre_L2_2 gp_2_2_0 ctp_L1_15 0 NSYN W=10u L=1u
MnTb_L1_15_0 vrefd vcn ctp_L1_15 0 NSYN W=10u L=1u
MnTa_L1_15_0 dpre_L2_2 vcn ctn_L1_15 0 NSYN W=10u L=1u
MpTb_L1_15_0 vrefd gp_2_2_0 ctn_L1_15 0 NSYN W=10u L=1u
MpTa_L1_15_1 dpre_L2_6 gp_2_6_3 ctp_L1_15 0 NSYN W=10u L=1u
MnTb_L1_15_1 vrefd vcn ctp_L1_15 0 NSYN W=10u L=1u
MnTa_L1_15_1 dpre_L2_6 vcn ctn_L1_15 0 NSYN W=10u L=1u
MpTb_L1_15_1 vrefd gp_2_6_3 ctn_L1_15 0 NSYN W=10u L=1u
MpTa_L1_15_2 dpre_L2_10 gp_2_10_1 ctp_L1_15 0 NSYN W=10u L=1u
MnTb_L1_15_2 vrefd vcn ctp_L1_15 0 NSYN W=10u L=1u
MnTa_L1_15_2 dpre_L2_10 vcn ctn_L1_15 0 NSYN W=10u L=1u
MpTb_L1_15_2 vrefd gp_2_10_1 ctn_L1_15 0 NSYN W=10u L=1u
MpTa_L1_15_3 dpre_L2_15 gp_2_15_0 ctp_L1_15 0 NSYN W=10u L=1u
MnTb_L1_15_3 vrefd vcn ctp_L1_15 0 NSYN W=10u L=1u
MnTa_L1_15_3 dpre_L2_15 vcn ctn_L1_15 0 NSYN W=10u L=1u
MpTb_L1_15_3 vrefd gp_2_15_0 ctn_L1_15 0 NSYN W=10u L=1u
Msa_bk_L1_15 ctn_L1_15 ctn_L1_15 0 0 NMIR W=20u L=1u
Msb_bk_L1_15 dpre_L1_15 ctn_L1_15 0 0 NMIR W=20u L=1u
Msc_bk_L1_15 ctp_L1_15 ctp_L1_15 0 0 NMIR W=20u L=1u
Msd_bk_L1_15 dpf_bk_L1_15 ctp_L1_15 0 0 NMIR W=20u L=1u
Mse_bk_L1_15 dpf_bk_L1_15 dpf_bk_L1_15 vdd vdd PMIR W=60u L=1u
Msf_bk_L1_15 dpre_L1_15 dpf_bk_L1_15 vdd vdd PMIR W=60u L=1u
R_bk_L1_15 dpre_L1_15 vrefd 16000.0
Rcm_L1_0 dpre_L1_0 d1bar_L1 10000.0
Rcm_L1_1 dpre_L1_1 d1bar_L1 10000.0
Rcm_L1_2 dpre_L1_2 d1bar_L1 10000.0
Rcm_L1_3 dpre_L1_3 d1bar_L1 10000.0
Rcm_L1_4 dpre_L1_4 d1bar_L1 10000.0
Rcm_L1_5 dpre_L1_5 d1bar_L1 10000.0
Rcm_L1_6 dpre_L1_6 d1bar_L1 10000.0
Rcm_L1_7 dpre_L1_7 d1bar_L1 10000.0
Rcm_L1_8 dpre_L1_8 d1bar_L1 10000.0
Rcm_L1_9 dpre_L1_9 d1bar_L1 10000.0
Rcm_L1_10 dpre_L1_10 d1bar_L1 10000.0
Rcm_L1_11 dpre_L1_11 d1bar_L1 10000.0
Rcm_L1_12 dpre_L1_12 d1bar_L1 10000.0
Rcm_L1_13 dpre_L1_13 d1bar_L1 10000.0
Rcm_L1_14 dpre_L1_14 d1bar_L1 10000.0
Rcm_L1_15 dpre_L1_15 d1bar_L1 10000.0
Ccm_L1 d1bar_L1 0 50f
Mct_L1_0 ctail_L1_0 vcbias 0 0 NMIR W=10u L=1u
Mca_L1_0 cna_L1_0 z_L1_0 ctail_L1_0 0 NSYN W=20u L=1u
Mcb_L1_0 uon_L1_0 vthr ctail_L1_0 0 NSYN W=20u L=1u
Mcp1_L1_0 cna_L1_0 cna_L1_0 vdd vdd PMIR W=40u L=1u
Mcp2_L1_0 uon_L1_0 cna_L1_0 vdd vdd PMIR W=40u L=1u
Rulk_L1_0 uon_L1_0 vulk 60000.0
Mt_uU_L1_0_0 ts_uU_L1_0_0 a4 0 0 NMIR W=48.0u L=1u
Mo1_uU_L1_0_0 da_uU_L1_0_0 d1bar_L1 ts_uU_L1_0_0 0 NMIR W=20u L=1u
Mo2_uU_L1_0_0 gp_1_0_0 dpre_L1_0 ts_uU_L1_0_0 0 NMIR W=20u L=1u
Mo3_uU_L1_0_0 da_uU_L1_0_0 da_uU_L1_0_0 vdd vdd PMIR W=60u L=1u
Mo4_uU_L1_0_0 gp_1_0_0 da_uU_L1_0_0 vdd vdd PMIR W=60u L=1u
Mt_uU_L1_0_1 ts_uU_L1_0_1 a0 0 0 NMIR W=48.0u L=1u
Mo1_uU_L1_0_1 da_uU_L1_0_1 d1bar_L1 ts_uU_L1_0_1 0 NMIR W=20u L=1u
Mo2_uU_L1_0_1 gp_1_0_1 dpre_L1_0 ts_uU_L1_0_1 0 NMIR W=20u L=1u
Mo3_uU_L1_0_1 da_uU_L1_0_1 da_uU_L1_0_1 vdd vdd PMIR W=60u L=1u
Mo4_uU_L1_0_1 gp_1_0_1 da_uU_L1_0_1 vdd vdd PMIR W=60u L=1u
Mt_uU_L1_0_2 ts_uU_L1_0_2 a5 0 0 NMIR W=48.0u L=1u
Mo1_uU_L1_0_2 da_uU_L1_0_2 d1bar_L1 ts_uU_L1_0_2 0 NMIR W=20u L=1u
Mo2_uU_L1_0_2 gp_1_0_2 dpre_L1_0 ts_uU_L1_0_2 0 NMIR W=20u L=1u
Mo3_uU_L1_0_2 da_uU_L1_0_2 da_uU_L1_0_2 vdd vdd PMIR W=60u L=1u
Mo4_uU_L1_0_2 gp_1_0_2 da_uU_L1_0_2 vdd vdd PMIR W=60u L=1u
Mt_uU_L1_0_3 ts_uU_L1_0_3 a1 0 0 NMIR W=48.0u L=1u
Mo1_uU_L1_0_3 da_uU_L1_0_3 d1bar_L1 ts_uU_L1_0_3 0 NMIR W=20u L=1u
Mo2_uU_L1_0_3 gp_1_0_3 dpre_L1_0 ts_uU_L1_0_3 0 NMIR W=20u L=1u
Mo3_uU_L1_0_3 da_uU_L1_0_3 da_uU_L1_0_3 vdd vdd PMIR W=60u L=1u
Mo4_uU_L1_0_3 gp_1_0_3 da_uU_L1_0_3 vdd vdd PMIR W=60u L=1u
Mct_L1_1 ctail_L1_1 vcbias 0 0 NMIR W=10u L=1u
Mca_L1_1 cna_L1_1 z_L1_1 ctail_L1_1 0 NSYN W=20u L=1u
Mcb_L1_1 uon_L1_1 vthr ctail_L1_1 0 NSYN W=20u L=1u
Mcp1_L1_1 cna_L1_1 cna_L1_1 vdd vdd PMIR W=40u L=1u
Mcp2_L1_1 uon_L1_1 cna_L1_1 vdd vdd PMIR W=40u L=1u
Rulk_L1_1 uon_L1_1 vulk 60000.0
Mt_uU_L1_1_0 ts_uU_L1_1_0 a0 0 0 NMIR W=48.0u L=1u
Mo1_uU_L1_1_0 da_uU_L1_1_0 d1bar_L1 ts_uU_L1_1_0 0 NMIR W=20u L=1u
Mo2_uU_L1_1_0 gp_1_1_0 dpre_L1_1 ts_uU_L1_1_0 0 NMIR W=20u L=1u
Mo3_uU_L1_1_0 da_uU_L1_1_0 da_uU_L1_1_0 vdd vdd PMIR W=60u L=1u
Mo4_uU_L1_1_0 gp_1_1_0 da_uU_L1_1_0 vdd vdd PMIR W=60u L=1u
Mt_uU_L1_1_1 ts_uU_L1_1_1 a5 0 0 NMIR W=48.0u L=1u
Mo1_uU_L1_1_1 da_uU_L1_1_1 d1bar_L1 ts_uU_L1_1_1 0 NMIR W=20u L=1u
Mo2_uU_L1_1_1 gp_1_1_1 dpre_L1_1 ts_uU_L1_1_1 0 NMIR W=20u L=1u
Mo3_uU_L1_1_1 da_uU_L1_1_1 da_uU_L1_1_1 vdd vdd PMIR W=60u L=1u
Mo4_uU_L1_1_1 gp_1_1_1 da_uU_L1_1_1 vdd vdd PMIR W=60u L=1u
Mt_uU_L1_1_2 ts_uU_L1_1_2 a1 0 0 NMIR W=48.0u L=1u
Mo1_uU_L1_1_2 da_uU_L1_1_2 d1bar_L1 ts_uU_L1_1_2 0 NMIR W=20u L=1u
Mo2_uU_L1_1_2 gp_1_1_2 dpre_L1_1 ts_uU_L1_1_2 0 NMIR W=20u L=1u
Mo3_uU_L1_1_2 da_uU_L1_1_2 da_uU_L1_1_2 vdd vdd PMIR W=60u L=1u
Mo4_uU_L1_1_2 gp_1_1_2 da_uU_L1_1_2 vdd vdd PMIR W=60u L=1u
Mt_uU_L1_1_3 ts_uU_L1_1_3 a4 0 0 NMIR W=48.0u L=1u
Mo1_uU_L1_1_3 da_uU_L1_1_3 d1bar_L1 ts_uU_L1_1_3 0 NMIR W=20u L=1u
Mo2_uU_L1_1_3 gp_1_1_3 dpre_L1_1 ts_uU_L1_1_3 0 NMIR W=20u L=1u
Mo3_uU_L1_1_3 da_uU_L1_1_3 da_uU_L1_1_3 vdd vdd PMIR W=60u L=1u
Mo4_uU_L1_1_3 gp_1_1_3 da_uU_L1_1_3 vdd vdd PMIR W=60u L=1u
Mct_L1_2 ctail_L1_2 vcbias 0 0 NMIR W=10u L=1u
Mca_L1_2 cna_L1_2 z_L1_2 ctail_L1_2 0 NSYN W=20u L=1u
Mcb_L1_2 uon_L1_2 vthr ctail_L1_2 0 NSYN W=20u L=1u
Mcp1_L1_2 cna_L1_2 cna_L1_2 vdd vdd PMIR W=40u L=1u
Mcp2_L1_2 uon_L1_2 cna_L1_2 vdd vdd PMIR W=40u L=1u
Rulk_L1_2 uon_L1_2 vulk 60000.0
Mt_uU_L1_2_0 ts_uU_L1_2_0 a1 0 0 NMIR W=48.0u L=1u
Mo1_uU_L1_2_0 da_uU_L1_2_0 d1bar_L1 ts_uU_L1_2_0 0 NMIR W=20u L=1u
Mo2_uU_L1_2_0 gp_1_2_0 dpre_L1_2 ts_uU_L1_2_0 0 NMIR W=20u L=1u
Mo3_uU_L1_2_0 da_uU_L1_2_0 da_uU_L1_2_0 vdd vdd PMIR W=60u L=1u
Mo4_uU_L1_2_0 gp_1_2_0 da_uU_L1_2_0 vdd vdd PMIR W=60u L=1u
Mt_uU_L1_2_1 ts_uU_L1_2_1 a5 0 0 NMIR W=48.0u L=1u
Mo1_uU_L1_2_1 da_uU_L1_2_1 d1bar_L1 ts_uU_L1_2_1 0 NMIR W=20u L=1u
Mo2_uU_L1_2_1 gp_1_2_1 dpre_L1_2 ts_uU_L1_2_1 0 NMIR W=20u L=1u
Mo3_uU_L1_2_1 da_uU_L1_2_1 da_uU_L1_2_1 vdd vdd PMIR W=60u L=1u
Mo4_uU_L1_2_1 gp_1_2_1 da_uU_L1_2_1 vdd vdd PMIR W=60u L=1u
Mt_uU_L1_2_2 ts_uU_L1_2_2 a0 0 0 NMIR W=48.0u L=1u
Mo1_uU_L1_2_2 da_uU_L1_2_2 d1bar_L1 ts_uU_L1_2_2 0 NMIR W=20u L=1u
Mo2_uU_L1_2_2 gp_1_2_2 dpre_L1_2 ts_uU_L1_2_2 0 NMIR W=20u L=1u
Mo3_uU_L1_2_2 da_uU_L1_2_2 da_uU_L1_2_2 vdd vdd PMIR W=60u L=1u
Mo4_uU_L1_2_2 gp_1_2_2 da_uU_L1_2_2 vdd vdd PMIR W=60u L=1u
Mt_uU_L1_2_3 ts_uU_L1_2_3 a4 0 0 NMIR W=48.0u L=1u
Mo1_uU_L1_2_3 da_uU_L1_2_3 d1bar_L1 ts_uU_L1_2_3 0 NMIR W=20u L=1u
Mo2_uU_L1_2_3 gp_1_2_3 dpre_L1_2 ts_uU_L1_2_3 0 NMIR W=20u L=1u
Mo3_uU_L1_2_3 da_uU_L1_2_3 da_uU_L1_2_3 vdd vdd PMIR W=60u L=1u
Mo4_uU_L1_2_3 gp_1_2_3 da_uU_L1_2_3 vdd vdd PMIR W=60u L=1u
Mct_L1_3 ctail_L1_3 vcbias 0 0 NMIR W=10u L=1u
Mca_L1_3 cna_L1_3 z_L1_3 ctail_L1_3 0 NSYN W=20u L=1u
Mcb_L1_3 uon_L1_3 vthr ctail_L1_3 0 NSYN W=20u L=1u
Mcp1_L1_3 cna_L1_3 cna_L1_3 vdd vdd PMIR W=40u L=1u
Mcp2_L1_3 uon_L1_3 cna_L1_3 vdd vdd PMIR W=40u L=1u
Rulk_L1_3 uon_L1_3 vulk 60000.0
Mt_uU_L1_3_0 ts_uU_L1_3_0 a4 0 0 NMIR W=48.0u L=1u
Mo1_uU_L1_3_0 da_uU_L1_3_0 d1bar_L1 ts_uU_L1_3_0 0 NMIR W=20u L=1u
Mo2_uU_L1_3_0 gp_1_3_0 dpre_L1_3 ts_uU_L1_3_0 0 NMIR W=20u L=1u
Mo3_uU_L1_3_0 da_uU_L1_3_0 da_uU_L1_3_0 vdd vdd PMIR W=60u L=1u
Mo4_uU_L1_3_0 gp_1_3_0 da_uU_L1_3_0 vdd vdd PMIR W=60u L=1u
Mt_uU_L1_3_1 ts_uU_L1_3_1 a0 0 0 NMIR W=48.0u L=1u
Mo1_uU_L1_3_1 da_uU_L1_3_1 d1bar_L1 ts_uU_L1_3_1 0 NMIR W=20u L=1u
Mo2_uU_L1_3_1 gp_1_3_1 dpre_L1_3 ts_uU_L1_3_1 0 NMIR W=20u L=1u
Mo3_uU_L1_3_1 da_uU_L1_3_1 da_uU_L1_3_1 vdd vdd PMIR W=60u L=1u
Mo4_uU_L1_3_1 gp_1_3_1 da_uU_L1_3_1 vdd vdd PMIR W=60u L=1u
Mt_uU_L1_3_2 ts_uU_L1_3_2 a5 0 0 NMIR W=48.0u L=1u
Mo1_uU_L1_3_2 da_uU_L1_3_2 d1bar_L1 ts_uU_L1_3_2 0 NMIR W=20u L=1u
Mo2_uU_L1_3_2 gp_1_3_2 dpre_L1_3 ts_uU_L1_3_2 0 NMIR W=20u L=1u
Mo3_uU_L1_3_2 da_uU_L1_3_2 da_uU_L1_3_2 vdd vdd PMIR W=60u L=1u
Mo4_uU_L1_3_2 gp_1_3_2 da_uU_L1_3_2 vdd vdd PMIR W=60u L=1u
Mt_uU_L1_3_3 ts_uU_L1_3_3 a1 0 0 NMIR W=48.0u L=1u
Mo1_uU_L1_3_3 da_uU_L1_3_3 d1bar_L1 ts_uU_L1_3_3 0 NMIR W=20u L=1u
Mo2_uU_L1_3_3 gp_1_3_3 dpre_L1_3 ts_uU_L1_3_3 0 NMIR W=20u L=1u
Mo3_uU_L1_3_3 da_uU_L1_3_3 da_uU_L1_3_3 vdd vdd PMIR W=60u L=1u
Mo4_uU_L1_3_3 gp_1_3_3 da_uU_L1_3_3 vdd vdd PMIR W=60u L=1u
Mct_L1_4 ctail_L1_4 vcbias 0 0 NMIR W=10u L=1u
Mca_L1_4 cna_L1_4 z_L1_4 ctail_L1_4 0 NSYN W=20u L=1u
Mcb_L1_4 uon_L1_4 vthr ctail_L1_4 0 NSYN W=20u L=1u
Mcp1_L1_4 cna_L1_4 cna_L1_4 vdd vdd PMIR W=40u L=1u
Mcp2_L1_4 uon_L1_4 cna_L1_4 vdd vdd PMIR W=40u L=1u
Rulk_L1_4 uon_L1_4 vulk 60000.0
Mt_uU_L1_4_0 ts_uU_L1_4_0 a2 0 0 NMIR W=48.0u L=1u
Mo1_uU_L1_4_0 da_uU_L1_4_0 d1bar_L1 ts_uU_L1_4_0 0 NMIR W=20u L=1u
Mo2_uU_L1_4_0 gp_1_4_0 dpre_L1_4 ts_uU_L1_4_0 0 NMIR W=20u L=1u
Mo3_uU_L1_4_0 da_uU_L1_4_0 da_uU_L1_4_0 vdd vdd PMIR W=60u L=1u
Mo4_uU_L1_4_0 gp_1_4_0 da_uU_L1_4_0 vdd vdd PMIR W=60u L=1u
Mt_uU_L1_4_1 ts_uU_L1_4_1 a6 0 0 NMIR W=48.0u L=1u
Mo1_uU_L1_4_1 da_uU_L1_4_1 d1bar_L1 ts_uU_L1_4_1 0 NMIR W=20u L=1u
Mo2_uU_L1_4_1 gp_1_4_1 dpre_L1_4 ts_uU_L1_4_1 0 NMIR W=20u L=1u
Mo3_uU_L1_4_1 da_uU_L1_4_1 da_uU_L1_4_1 vdd vdd PMIR W=60u L=1u
Mo4_uU_L1_4_1 gp_1_4_1 da_uU_L1_4_1 vdd vdd PMIR W=60u L=1u
Mt_uU_L1_4_2 ts_uU_L1_4_2 a7 0 0 NMIR W=48.0u L=1u
Mo1_uU_L1_4_2 da_uU_L1_4_2 d1bar_L1 ts_uU_L1_4_2 0 NMIR W=20u L=1u
Mo2_uU_L1_4_2 gp_1_4_2 dpre_L1_4 ts_uU_L1_4_2 0 NMIR W=20u L=1u
Mo3_uU_L1_4_2 da_uU_L1_4_2 da_uU_L1_4_2 vdd vdd PMIR W=60u L=1u
Mo4_uU_L1_4_2 gp_1_4_2 da_uU_L1_4_2 vdd vdd PMIR W=60u L=1u
Mt_uU_L1_4_3 ts_uU_L1_4_3 a3 0 0 NMIR W=48.0u L=1u
Mo1_uU_L1_4_3 da_uU_L1_4_3 d1bar_L1 ts_uU_L1_4_3 0 NMIR W=20u L=1u
Mo2_uU_L1_4_3 gp_1_4_3 dpre_L1_4 ts_uU_L1_4_3 0 NMIR W=20u L=1u
Mo3_uU_L1_4_3 da_uU_L1_4_3 da_uU_L1_4_3 vdd vdd PMIR W=60u L=1u
Mo4_uU_L1_4_3 gp_1_4_3 da_uU_L1_4_3 vdd vdd PMIR W=60u L=1u
Mct_L1_5 ctail_L1_5 vcbias 0 0 NMIR W=10u L=1u
Mca_L1_5 cna_L1_5 z_L1_5 ctail_L1_5 0 NSYN W=20u L=1u
Mcb_L1_5 uon_L1_5 vthr ctail_L1_5 0 NSYN W=20u L=1u
Mcp1_L1_5 cna_L1_5 cna_L1_5 vdd vdd PMIR W=40u L=1u
Mcp2_L1_5 uon_L1_5 cna_L1_5 vdd vdd PMIR W=40u L=1u
Rulk_L1_5 uon_L1_5 vulk 60000.0
Mt_uU_L1_5_0 ts_uU_L1_5_0 a3 0 0 NMIR W=48.0u L=1u
Mo1_uU_L1_5_0 da_uU_L1_5_0 d1bar_L1 ts_uU_L1_5_0 0 NMIR W=20u L=1u
Mo2_uU_L1_5_0 gp_1_5_0 dpre_L1_5 ts_uU_L1_5_0 0 NMIR W=20u L=1u
Mo3_uU_L1_5_0 da_uU_L1_5_0 da_uU_L1_5_0 vdd vdd PMIR W=60u L=1u
Mo4_uU_L1_5_0 gp_1_5_0 da_uU_L1_5_0 vdd vdd PMIR W=60u L=1u
Mt_uU_L1_5_1 ts_uU_L1_5_1 a6 0 0 NMIR W=48.0u L=1u
Mo1_uU_L1_5_1 da_uU_L1_5_1 d1bar_L1 ts_uU_L1_5_1 0 NMIR W=20u L=1u
Mo2_uU_L1_5_1 gp_1_5_1 dpre_L1_5 ts_uU_L1_5_1 0 NMIR W=20u L=1u
Mo3_uU_L1_5_1 da_uU_L1_5_1 da_uU_L1_5_1 vdd vdd PMIR W=60u L=1u
Mo4_uU_L1_5_1 gp_1_5_1 da_uU_L1_5_1 vdd vdd PMIR W=60u L=1u
Mt_uU_L1_5_2 ts_uU_L1_5_2 a2 0 0 NMIR W=48.0u L=1u
Mo1_uU_L1_5_2 da_uU_L1_5_2 d1bar_L1 ts_uU_L1_5_2 0 NMIR W=20u L=1u
Mo2_uU_L1_5_2 gp_1_5_2 dpre_L1_5 ts_uU_L1_5_2 0 NMIR W=20u L=1u
Mo3_uU_L1_5_2 da_uU_L1_5_2 da_uU_L1_5_2 vdd vdd PMIR W=60u L=1u
Mo4_uU_L1_5_2 gp_1_5_2 da_uU_L1_5_2 vdd vdd PMIR W=60u L=1u
Mt_uU_L1_5_3 ts_uU_L1_5_3 a7 0 0 NMIR W=48.0u L=1u
Mo1_uU_L1_5_3 da_uU_L1_5_3 d1bar_L1 ts_uU_L1_5_3 0 NMIR W=20u L=1u
Mo2_uU_L1_5_3 gp_1_5_3 dpre_L1_5 ts_uU_L1_5_3 0 NMIR W=20u L=1u
Mo3_uU_L1_5_3 da_uU_L1_5_3 da_uU_L1_5_3 vdd vdd PMIR W=60u L=1u
Mo4_uU_L1_5_3 gp_1_5_3 da_uU_L1_5_3 vdd vdd PMIR W=60u L=1u
Mct_L1_6 ctail_L1_6 vcbias 0 0 NMIR W=10u L=1u
Mca_L1_6 cna_L1_6 z_L1_6 ctail_L1_6 0 NSYN W=20u L=1u
Mcb_L1_6 uon_L1_6 vthr ctail_L1_6 0 NSYN W=20u L=1u
Mcp1_L1_6 cna_L1_6 cna_L1_6 vdd vdd PMIR W=40u L=1u
Mcp2_L1_6 uon_L1_6 cna_L1_6 vdd vdd PMIR W=40u L=1u
Rulk_L1_6 uon_L1_6 vulk 60000.0
Mt_uU_L1_6_0 ts_uU_L1_6_0 a7 0 0 NMIR W=48.0u L=1u
Mo1_uU_L1_6_0 da_uU_L1_6_0 d1bar_L1 ts_uU_L1_6_0 0 NMIR W=20u L=1u
Mo2_uU_L1_6_0 gp_1_6_0 dpre_L1_6 ts_uU_L1_6_0 0 NMIR W=20u L=1u
Mo3_uU_L1_6_0 da_uU_L1_6_0 da_uU_L1_6_0 vdd vdd PMIR W=60u L=1u
Mo4_uU_L1_6_0 gp_1_6_0 da_uU_L1_6_0 vdd vdd PMIR W=60u L=1u
Mt_uU_L1_6_1 ts_uU_L1_6_1 a6 0 0 NMIR W=48.0u L=1u
Mo1_uU_L1_6_1 da_uU_L1_6_1 d1bar_L1 ts_uU_L1_6_1 0 NMIR W=20u L=1u
Mo2_uU_L1_6_1 gp_1_6_1 dpre_L1_6 ts_uU_L1_6_1 0 NMIR W=20u L=1u
Mo3_uU_L1_6_1 da_uU_L1_6_1 da_uU_L1_6_1 vdd vdd PMIR W=60u L=1u
Mo4_uU_L1_6_1 gp_1_6_1 da_uU_L1_6_1 vdd vdd PMIR W=60u L=1u
Mt_uU_L1_6_2 ts_uU_L1_6_2 a3 0 0 NMIR W=48.0u L=1u
Mo1_uU_L1_6_2 da_uU_L1_6_2 d1bar_L1 ts_uU_L1_6_2 0 NMIR W=20u L=1u
Mo2_uU_L1_6_2 gp_1_6_2 dpre_L1_6 ts_uU_L1_6_2 0 NMIR W=20u L=1u
Mo3_uU_L1_6_2 da_uU_L1_6_2 da_uU_L1_6_2 vdd vdd PMIR W=60u L=1u
Mo4_uU_L1_6_2 gp_1_6_2 da_uU_L1_6_2 vdd vdd PMIR W=60u L=1u
Mt_uU_L1_6_3 ts_uU_L1_6_3 a2 0 0 NMIR W=48.0u L=1u
Mo1_uU_L1_6_3 da_uU_L1_6_3 d1bar_L1 ts_uU_L1_6_3 0 NMIR W=20u L=1u
Mo2_uU_L1_6_3 gp_1_6_3 dpre_L1_6 ts_uU_L1_6_3 0 NMIR W=20u L=1u
Mo3_uU_L1_6_3 da_uU_L1_6_3 da_uU_L1_6_3 vdd vdd PMIR W=60u L=1u
Mo4_uU_L1_6_3 gp_1_6_3 da_uU_L1_6_3 vdd vdd PMIR W=60u L=1u
Mct_L1_7 ctail_L1_7 vcbias 0 0 NMIR W=10u L=1u
Mca_L1_7 cna_L1_7 z_L1_7 ctail_L1_7 0 NSYN W=20u L=1u
Mcb_L1_7 uon_L1_7 vthr ctail_L1_7 0 NSYN W=20u L=1u
Mcp1_L1_7 cna_L1_7 cna_L1_7 vdd vdd PMIR W=40u L=1u
Mcp2_L1_7 uon_L1_7 cna_L1_7 vdd vdd PMIR W=40u L=1u
Rulk_L1_7 uon_L1_7 vulk 60000.0
Mt_uU_L1_7_0 ts_uU_L1_7_0 a7 0 0 NMIR W=48.0u L=1u
Mo1_uU_L1_7_0 da_uU_L1_7_0 d1bar_L1 ts_uU_L1_7_0 0 NMIR W=20u L=1u
Mo2_uU_L1_7_0 gp_1_7_0 dpre_L1_7 ts_uU_L1_7_0 0 NMIR W=20u L=1u
Mo3_uU_L1_7_0 da_uU_L1_7_0 da_uU_L1_7_0 vdd vdd PMIR W=60u L=1u
Mo4_uU_L1_7_0 gp_1_7_0 da_uU_L1_7_0 vdd vdd PMIR W=60u L=1u
Mt_uU_L1_7_1 ts_uU_L1_7_1 a2 0 0 NMIR W=48.0u L=1u
Mo1_uU_L1_7_1 da_uU_L1_7_1 d1bar_L1 ts_uU_L1_7_1 0 NMIR W=20u L=1u
Mo2_uU_L1_7_1 gp_1_7_1 dpre_L1_7 ts_uU_L1_7_1 0 NMIR W=20u L=1u
Mo3_uU_L1_7_1 da_uU_L1_7_1 da_uU_L1_7_1 vdd vdd PMIR W=60u L=1u
Mo4_uU_L1_7_1 gp_1_7_1 da_uU_L1_7_1 vdd vdd PMIR W=60u L=1u
Mt_uU_L1_7_2 ts_uU_L1_7_2 a6 0 0 NMIR W=48.0u L=1u
Mo1_uU_L1_7_2 da_uU_L1_7_2 d1bar_L1 ts_uU_L1_7_2 0 NMIR W=20u L=1u
Mo2_uU_L1_7_2 gp_1_7_2 dpre_L1_7 ts_uU_L1_7_2 0 NMIR W=20u L=1u
Mo3_uU_L1_7_2 da_uU_L1_7_2 da_uU_L1_7_2 vdd vdd PMIR W=60u L=1u
Mo4_uU_L1_7_2 gp_1_7_2 da_uU_L1_7_2 vdd vdd PMIR W=60u L=1u
Mt_uU_L1_7_3 ts_uU_L1_7_3 a3 0 0 NMIR W=48.0u L=1u
Mo1_uU_L1_7_3 da_uU_L1_7_3 d1bar_L1 ts_uU_L1_7_3 0 NMIR W=20u L=1u
Mo2_uU_L1_7_3 gp_1_7_3 dpre_L1_7 ts_uU_L1_7_3 0 NMIR W=20u L=1u
Mo3_uU_L1_7_3 da_uU_L1_7_3 da_uU_L1_7_3 vdd vdd PMIR W=60u L=1u
Mo4_uU_L1_7_3 gp_1_7_3 da_uU_L1_7_3 vdd vdd PMIR W=60u L=1u
Mct_L1_8 ctail_L1_8 vcbias 0 0 NMIR W=10u L=1u
Mca_L1_8 cna_L1_8 z_L1_8 ctail_L1_8 0 NSYN W=20u L=1u
Mcb_L1_8 uon_L1_8 vthr ctail_L1_8 0 NSYN W=20u L=1u
Mcp1_L1_8 cna_L1_8 cna_L1_8 vdd vdd PMIR W=40u L=1u
Mcp2_L1_8 uon_L1_8 cna_L1_8 vdd vdd PMIR W=40u L=1u
Rulk_L1_8 uon_L1_8 vulk 60000.0
Mt_uU_L1_8_0 ts_uU_L1_8_0 a12 0 0 NMIR W=48.0u L=1u
Mo1_uU_L1_8_0 da_uU_L1_8_0 d1bar_L1 ts_uU_L1_8_0 0 NMIR W=20u L=1u
Mo2_uU_L1_8_0 gp_1_8_0 dpre_L1_8 ts_uU_L1_8_0 0 NMIR W=20u L=1u
Mo3_uU_L1_8_0 da_uU_L1_8_0 da_uU_L1_8_0 vdd vdd PMIR W=60u L=1u
Mo4_uU_L1_8_0 gp_1_8_0 da_uU_L1_8_0 vdd vdd PMIR W=60u L=1u
Mt_uU_L1_8_1 ts_uU_L1_8_1 a8 0 0 NMIR W=48.0u L=1u
Mo1_uU_L1_8_1 da_uU_L1_8_1 d1bar_L1 ts_uU_L1_8_1 0 NMIR W=20u L=1u
Mo2_uU_L1_8_1 gp_1_8_1 dpre_L1_8 ts_uU_L1_8_1 0 NMIR W=20u L=1u
Mo3_uU_L1_8_1 da_uU_L1_8_1 da_uU_L1_8_1 vdd vdd PMIR W=60u L=1u
Mo4_uU_L1_8_1 gp_1_8_1 da_uU_L1_8_1 vdd vdd PMIR W=60u L=1u
Mt_uU_L1_8_2 ts_uU_L1_8_2 a9 0 0 NMIR W=48.0u L=1u
Mo1_uU_L1_8_2 da_uU_L1_8_2 d1bar_L1 ts_uU_L1_8_2 0 NMIR W=20u L=1u
Mo2_uU_L1_8_2 gp_1_8_2 dpre_L1_8 ts_uU_L1_8_2 0 NMIR W=20u L=1u
Mo3_uU_L1_8_2 da_uU_L1_8_2 da_uU_L1_8_2 vdd vdd PMIR W=60u L=1u
Mo4_uU_L1_8_2 gp_1_8_2 da_uU_L1_8_2 vdd vdd PMIR W=60u L=1u
Mt_uU_L1_8_3 ts_uU_L1_8_3 a13 0 0 NMIR W=48.0u L=1u
Mo1_uU_L1_8_3 da_uU_L1_8_3 d1bar_L1 ts_uU_L1_8_3 0 NMIR W=20u L=1u
Mo2_uU_L1_8_3 gp_1_8_3 dpre_L1_8 ts_uU_L1_8_3 0 NMIR W=20u L=1u
Mo3_uU_L1_8_3 da_uU_L1_8_3 da_uU_L1_8_3 vdd vdd PMIR W=60u L=1u
Mo4_uU_L1_8_3 gp_1_8_3 da_uU_L1_8_3 vdd vdd PMIR W=60u L=1u
Mct_L1_9 ctail_L1_9 vcbias 0 0 NMIR W=10u L=1u
Mca_L1_9 cna_L1_9 z_L1_9 ctail_L1_9 0 NSYN W=20u L=1u
Mcb_L1_9 uon_L1_9 vthr ctail_L1_9 0 NSYN W=20u L=1u
Mcp1_L1_9 cna_L1_9 cna_L1_9 vdd vdd PMIR W=40u L=1u
Mcp2_L1_9 uon_L1_9 cna_L1_9 vdd vdd PMIR W=40u L=1u
Rulk_L1_9 uon_L1_9 vulk 60000.0
Mt_uU_L1_9_0 ts_uU_L1_9_0 a8 0 0 NMIR W=48.0u L=1u
Mo1_uU_L1_9_0 da_uU_L1_9_0 d1bar_L1 ts_uU_L1_9_0 0 NMIR W=20u L=1u
Mo2_uU_L1_9_0 gp_1_9_0 dpre_L1_9 ts_uU_L1_9_0 0 NMIR W=20u L=1u
Mo3_uU_L1_9_0 da_uU_L1_9_0 da_uU_L1_9_0 vdd vdd PMIR W=60u L=1u
Mo4_uU_L1_9_0 gp_1_9_0 da_uU_L1_9_0 vdd vdd PMIR W=60u L=1u
Mt_uU_L1_9_1 ts_uU_L1_9_1 a13 0 0 NMIR W=48.0u L=1u
Mo1_uU_L1_9_1 da_uU_L1_9_1 d1bar_L1 ts_uU_L1_9_1 0 NMIR W=20u L=1u
Mo2_uU_L1_9_1 gp_1_9_1 dpre_L1_9 ts_uU_L1_9_1 0 NMIR W=20u L=1u
Mo3_uU_L1_9_1 da_uU_L1_9_1 da_uU_L1_9_1 vdd vdd PMIR W=60u L=1u
Mo4_uU_L1_9_1 gp_1_9_1 da_uU_L1_9_1 vdd vdd PMIR W=60u L=1u
Mt_uU_L1_9_2 ts_uU_L1_9_2 a12 0 0 NMIR W=48.0u L=1u
Mo1_uU_L1_9_2 da_uU_L1_9_2 d1bar_L1 ts_uU_L1_9_2 0 NMIR W=20u L=1u
Mo2_uU_L1_9_2 gp_1_9_2 dpre_L1_9 ts_uU_L1_9_2 0 NMIR W=20u L=1u
Mo3_uU_L1_9_2 da_uU_L1_9_2 da_uU_L1_9_2 vdd vdd PMIR W=60u L=1u
Mo4_uU_L1_9_2 gp_1_9_2 da_uU_L1_9_2 vdd vdd PMIR W=60u L=1u
Mt_uU_L1_9_3 ts_uU_L1_9_3 a9 0 0 NMIR W=48.0u L=1u
Mo1_uU_L1_9_3 da_uU_L1_9_3 d1bar_L1 ts_uU_L1_9_3 0 NMIR W=20u L=1u
Mo2_uU_L1_9_3 gp_1_9_3 dpre_L1_9 ts_uU_L1_9_3 0 NMIR W=20u L=1u
Mo3_uU_L1_9_3 da_uU_L1_9_3 da_uU_L1_9_3 vdd vdd PMIR W=60u L=1u
Mo4_uU_L1_9_3 gp_1_9_3 da_uU_L1_9_3 vdd vdd PMIR W=60u L=1u
Mct_L1_10 ctail_L1_10 vcbias 0 0 NMIR W=10u L=1u
Mca_L1_10 cna_L1_10 z_L1_10 ctail_L1_10 0 NSYN W=20u L=1u
Mcb_L1_10 uon_L1_10 vthr ctail_L1_10 0 NSYN W=20u L=1u
Mcp1_L1_10 cna_L1_10 cna_L1_10 vdd vdd PMIR W=40u L=1u
Mcp2_L1_10 uon_L1_10 cna_L1_10 vdd vdd PMIR W=40u L=1u
Rulk_L1_10 uon_L1_10 vulk 60000.0
Mt_uU_L1_10_0 ts_uU_L1_10_0 a13 0 0 NMIR W=48.0u L=1u
Mo1_uU_L1_10_0 da_uU_L1_10_0 d1bar_L1 ts_uU_L1_10_0 0 NMIR W=20u L=1u
Mo2_uU_L1_10_0 gp_1_10_0 dpre_L1_10 ts_uU_L1_10_0 0 NMIR W=20u L=1u
Mo3_uU_L1_10_0 da_uU_L1_10_0 da_uU_L1_10_0 vdd vdd PMIR W=60u L=1u
Mo4_uU_L1_10_0 gp_1_10_0 da_uU_L1_10_0 vdd vdd PMIR W=60u L=1u
Mt_uU_L1_10_1 ts_uU_L1_10_1 a12 0 0 NMIR W=48.0u L=1u
Mo1_uU_L1_10_1 da_uU_L1_10_1 d1bar_L1 ts_uU_L1_10_1 0 NMIR W=20u L=1u
Mo2_uU_L1_10_1 gp_1_10_1 dpre_L1_10 ts_uU_L1_10_1 0 NMIR W=20u L=1u
Mo3_uU_L1_10_1 da_uU_L1_10_1 da_uU_L1_10_1 vdd vdd PMIR W=60u L=1u
Mo4_uU_L1_10_1 gp_1_10_1 da_uU_L1_10_1 vdd vdd PMIR W=60u L=1u
Mt_uU_L1_10_2 ts_uU_L1_10_2 a8 0 0 NMIR W=48.0u L=1u
Mo1_uU_L1_10_2 da_uU_L1_10_2 d1bar_L1 ts_uU_L1_10_2 0 NMIR W=20u L=1u
Mo2_uU_L1_10_2 gp_1_10_2 dpre_L1_10 ts_uU_L1_10_2 0 NMIR W=20u L=1u
Mo3_uU_L1_10_2 da_uU_L1_10_2 da_uU_L1_10_2 vdd vdd PMIR W=60u L=1u
Mo4_uU_L1_10_2 gp_1_10_2 da_uU_L1_10_2 vdd vdd PMIR W=60u L=1u
Mt_uU_L1_10_3 ts_uU_L1_10_3 a9 0 0 NMIR W=48.0u L=1u
Mo1_uU_L1_10_3 da_uU_L1_10_3 d1bar_L1 ts_uU_L1_10_3 0 NMIR W=20u L=1u
Mo2_uU_L1_10_3 gp_1_10_3 dpre_L1_10 ts_uU_L1_10_3 0 NMIR W=20u L=1u
Mo3_uU_L1_10_3 da_uU_L1_10_3 da_uU_L1_10_3 vdd vdd PMIR W=60u L=1u
Mo4_uU_L1_10_3 gp_1_10_3 da_uU_L1_10_3 vdd vdd PMIR W=60u L=1u
Mct_L1_11 ctail_L1_11 vcbias 0 0 NMIR W=10u L=1u
Mca_L1_11 cna_L1_11 z_L1_11 ctail_L1_11 0 NSYN W=20u L=1u
Mcb_L1_11 uon_L1_11 vthr ctail_L1_11 0 NSYN W=20u L=1u
Mcp1_L1_11 cna_L1_11 cna_L1_11 vdd vdd PMIR W=40u L=1u
Mcp2_L1_11 uon_L1_11 cna_L1_11 vdd vdd PMIR W=40u L=1u
Rulk_L1_11 uon_L1_11 vulk 60000.0
Mt_uU_L1_11_0 ts_uU_L1_11_0 a9 0 0 NMIR W=48.0u L=1u
Mo1_uU_L1_11_0 da_uU_L1_11_0 d1bar_L1 ts_uU_L1_11_0 0 NMIR W=20u L=1u
Mo2_uU_L1_11_0 gp_1_11_0 dpre_L1_11 ts_uU_L1_11_0 0 NMIR W=20u L=1u
Mo3_uU_L1_11_0 da_uU_L1_11_0 da_uU_L1_11_0 vdd vdd PMIR W=60u L=1u
Mo4_uU_L1_11_0 gp_1_11_0 da_uU_L1_11_0 vdd vdd PMIR W=60u L=1u
Mt_uU_L1_11_1 ts_uU_L1_11_1 a12 0 0 NMIR W=48.0u L=1u
Mo1_uU_L1_11_1 da_uU_L1_11_1 d1bar_L1 ts_uU_L1_11_1 0 NMIR W=20u L=1u
Mo2_uU_L1_11_1 gp_1_11_1 dpre_L1_11 ts_uU_L1_11_1 0 NMIR W=20u L=1u
Mo3_uU_L1_11_1 da_uU_L1_11_1 da_uU_L1_11_1 vdd vdd PMIR W=60u L=1u
Mo4_uU_L1_11_1 gp_1_11_1 da_uU_L1_11_1 vdd vdd PMIR W=60u L=1u
Mt_uU_L1_11_2 ts_uU_L1_11_2 a13 0 0 NMIR W=48.0u L=1u
Mo1_uU_L1_11_2 da_uU_L1_11_2 d1bar_L1 ts_uU_L1_11_2 0 NMIR W=20u L=1u
Mo2_uU_L1_11_2 gp_1_11_2 dpre_L1_11 ts_uU_L1_11_2 0 NMIR W=20u L=1u
Mo3_uU_L1_11_2 da_uU_L1_11_2 da_uU_L1_11_2 vdd vdd PMIR W=60u L=1u
Mo4_uU_L1_11_2 gp_1_11_2 da_uU_L1_11_2 vdd vdd PMIR W=60u L=1u
Mt_uU_L1_11_3 ts_uU_L1_11_3 a8 0 0 NMIR W=48.0u L=1u
Mo1_uU_L1_11_3 da_uU_L1_11_3 d1bar_L1 ts_uU_L1_11_3 0 NMIR W=20u L=1u
Mo2_uU_L1_11_3 gp_1_11_3 dpre_L1_11 ts_uU_L1_11_3 0 NMIR W=20u L=1u
Mo3_uU_L1_11_3 da_uU_L1_11_3 da_uU_L1_11_3 vdd vdd PMIR W=60u L=1u
Mo4_uU_L1_11_3 gp_1_11_3 da_uU_L1_11_3 vdd vdd PMIR W=60u L=1u
Mct_L1_12 ctail_L1_12 vcbias 0 0 NMIR W=10u L=1u
Mca_L1_12 cna_L1_12 z_L1_12 ctail_L1_12 0 NSYN W=20u L=1u
Mcb_L1_12 uon_L1_12 vthr ctail_L1_12 0 NSYN W=20u L=1u
Mcp1_L1_12 cna_L1_12 cna_L1_12 vdd vdd PMIR W=40u L=1u
Mcp2_L1_12 uon_L1_12 cna_L1_12 vdd vdd PMIR W=40u L=1u
Rulk_L1_12 uon_L1_12 vulk 60000.0
Mt_uU_L1_12_0 ts_uU_L1_12_0 a10 0 0 NMIR W=48.0u L=1u
Mo1_uU_L1_12_0 da_uU_L1_12_0 d1bar_L1 ts_uU_L1_12_0 0 NMIR W=20u L=1u
Mo2_uU_L1_12_0 gp_1_12_0 dpre_L1_12 ts_uU_L1_12_0 0 NMIR W=20u L=1u
Mo3_uU_L1_12_0 da_uU_L1_12_0 da_uU_L1_12_0 vdd vdd PMIR W=60u L=1u
Mo4_uU_L1_12_0 gp_1_12_0 da_uU_L1_12_0 vdd vdd PMIR W=60u L=1u
Mt_uU_L1_12_1 ts_uU_L1_12_1 a14 0 0 NMIR W=48.0u L=1u
Mo1_uU_L1_12_1 da_uU_L1_12_1 d1bar_L1 ts_uU_L1_12_1 0 NMIR W=20u L=1u
Mo2_uU_L1_12_1 gp_1_12_1 dpre_L1_12 ts_uU_L1_12_1 0 NMIR W=20u L=1u
Mo3_uU_L1_12_1 da_uU_L1_12_1 da_uU_L1_12_1 vdd vdd PMIR W=60u L=1u
Mo4_uU_L1_12_1 gp_1_12_1 da_uU_L1_12_1 vdd vdd PMIR W=60u L=1u
Mt_uU_L1_12_2 ts_uU_L1_12_2 a15 0 0 NMIR W=48.0u L=1u
Mo1_uU_L1_12_2 da_uU_L1_12_2 d1bar_L1 ts_uU_L1_12_2 0 NMIR W=20u L=1u
Mo2_uU_L1_12_2 gp_1_12_2 dpre_L1_12 ts_uU_L1_12_2 0 NMIR W=20u L=1u
Mo3_uU_L1_12_2 da_uU_L1_12_2 da_uU_L1_12_2 vdd vdd PMIR W=60u L=1u
Mo4_uU_L1_12_2 gp_1_12_2 da_uU_L1_12_2 vdd vdd PMIR W=60u L=1u
Mt_uU_L1_12_3 ts_uU_L1_12_3 a11 0 0 NMIR W=48.0u L=1u
Mo1_uU_L1_12_3 da_uU_L1_12_3 d1bar_L1 ts_uU_L1_12_3 0 NMIR W=20u L=1u
Mo2_uU_L1_12_3 gp_1_12_3 dpre_L1_12 ts_uU_L1_12_3 0 NMIR W=20u L=1u
Mo3_uU_L1_12_3 da_uU_L1_12_3 da_uU_L1_12_3 vdd vdd PMIR W=60u L=1u
Mo4_uU_L1_12_3 gp_1_12_3 da_uU_L1_12_3 vdd vdd PMIR W=60u L=1u
Mct_L1_13 ctail_L1_13 vcbias 0 0 NMIR W=10u L=1u
Mca_L1_13 cna_L1_13 z_L1_13 ctail_L1_13 0 NSYN W=20u L=1u
Mcb_L1_13 uon_L1_13 vthr ctail_L1_13 0 NSYN W=20u L=1u
Mcp1_L1_13 cna_L1_13 cna_L1_13 vdd vdd PMIR W=40u L=1u
Mcp2_L1_13 uon_L1_13 cna_L1_13 vdd vdd PMIR W=40u L=1u
Rulk_L1_13 uon_L1_13 vulk 60000.0
Mt_uU_L1_13_0 ts_uU_L1_13_0 a15 0 0 NMIR W=48.0u L=1u
Mo1_uU_L1_13_0 da_uU_L1_13_0 d1bar_L1 ts_uU_L1_13_0 0 NMIR W=20u L=1u
Mo2_uU_L1_13_0 gp_1_13_0 dpre_L1_13 ts_uU_L1_13_0 0 NMIR W=20u L=1u
Mo3_uU_L1_13_0 da_uU_L1_13_0 da_uU_L1_13_0 vdd vdd PMIR W=60u L=1u
Mo4_uU_L1_13_0 gp_1_13_0 da_uU_L1_13_0 vdd vdd PMIR W=60u L=1u
Mt_uU_L1_13_1 ts_uU_L1_13_1 a14 0 0 NMIR W=48.0u L=1u
Mo1_uU_L1_13_1 da_uU_L1_13_1 d1bar_L1 ts_uU_L1_13_1 0 NMIR W=20u L=1u
Mo2_uU_L1_13_1 gp_1_13_1 dpre_L1_13 ts_uU_L1_13_1 0 NMIR W=20u L=1u
Mo3_uU_L1_13_1 da_uU_L1_13_1 da_uU_L1_13_1 vdd vdd PMIR W=60u L=1u
Mo4_uU_L1_13_1 gp_1_13_1 da_uU_L1_13_1 vdd vdd PMIR W=60u L=1u
Mt_uU_L1_13_2 ts_uU_L1_13_2 a10 0 0 NMIR W=48.0u L=1u
Mo1_uU_L1_13_2 da_uU_L1_13_2 d1bar_L1 ts_uU_L1_13_2 0 NMIR W=20u L=1u
Mo2_uU_L1_13_2 gp_1_13_2 dpre_L1_13 ts_uU_L1_13_2 0 NMIR W=20u L=1u
Mo3_uU_L1_13_2 da_uU_L1_13_2 da_uU_L1_13_2 vdd vdd PMIR W=60u L=1u
Mo4_uU_L1_13_2 gp_1_13_2 da_uU_L1_13_2 vdd vdd PMIR W=60u L=1u
Mt_uU_L1_13_3 ts_uU_L1_13_3 a11 0 0 NMIR W=48.0u L=1u
Mo1_uU_L1_13_3 da_uU_L1_13_3 d1bar_L1 ts_uU_L1_13_3 0 NMIR W=20u L=1u
Mo2_uU_L1_13_3 gp_1_13_3 dpre_L1_13 ts_uU_L1_13_3 0 NMIR W=20u L=1u
Mo3_uU_L1_13_3 da_uU_L1_13_3 da_uU_L1_13_3 vdd vdd PMIR W=60u L=1u
Mo4_uU_L1_13_3 gp_1_13_3 da_uU_L1_13_3 vdd vdd PMIR W=60u L=1u
Mct_L1_14 ctail_L1_14 vcbias 0 0 NMIR W=10u L=1u
Mca_L1_14 cna_L1_14 z_L1_14 ctail_L1_14 0 NSYN W=20u L=1u
Mcb_L1_14 uon_L1_14 vthr ctail_L1_14 0 NSYN W=20u L=1u
Mcp1_L1_14 cna_L1_14 cna_L1_14 vdd vdd PMIR W=40u L=1u
Mcp2_L1_14 uon_L1_14 cna_L1_14 vdd vdd PMIR W=40u L=1u
Rulk_L1_14 uon_L1_14 vulk 60000.0
Mt_uU_L1_14_0 ts_uU_L1_14_0 a15 0 0 NMIR W=48.0u L=1u
Mo1_uU_L1_14_0 da_uU_L1_14_0 d1bar_L1 ts_uU_L1_14_0 0 NMIR W=20u L=1u
Mo2_uU_L1_14_0 gp_1_14_0 dpre_L1_14 ts_uU_L1_14_0 0 NMIR W=20u L=1u
Mo3_uU_L1_14_0 da_uU_L1_14_0 da_uU_L1_14_0 vdd vdd PMIR W=60u L=1u
Mo4_uU_L1_14_0 gp_1_14_0 da_uU_L1_14_0 vdd vdd PMIR W=60u L=1u
Mt_uU_L1_14_1 ts_uU_L1_14_1 a10 0 0 NMIR W=48.0u L=1u
Mo1_uU_L1_14_1 da_uU_L1_14_1 d1bar_L1 ts_uU_L1_14_1 0 NMIR W=20u L=1u
Mo2_uU_L1_14_1 gp_1_14_1 dpre_L1_14 ts_uU_L1_14_1 0 NMIR W=20u L=1u
Mo3_uU_L1_14_1 da_uU_L1_14_1 da_uU_L1_14_1 vdd vdd PMIR W=60u L=1u
Mo4_uU_L1_14_1 gp_1_14_1 da_uU_L1_14_1 vdd vdd PMIR W=60u L=1u
Mt_uU_L1_14_2 ts_uU_L1_14_2 a11 0 0 NMIR W=48.0u L=1u
Mo1_uU_L1_14_2 da_uU_L1_14_2 d1bar_L1 ts_uU_L1_14_2 0 NMIR W=20u L=1u
Mo2_uU_L1_14_2 gp_1_14_2 dpre_L1_14 ts_uU_L1_14_2 0 NMIR W=20u L=1u
Mo3_uU_L1_14_2 da_uU_L1_14_2 da_uU_L1_14_2 vdd vdd PMIR W=60u L=1u
Mo4_uU_L1_14_2 gp_1_14_2 da_uU_L1_14_2 vdd vdd PMIR W=60u L=1u
Mt_uU_L1_14_3 ts_uU_L1_14_3 a14 0 0 NMIR W=48.0u L=1u
Mo1_uU_L1_14_3 da_uU_L1_14_3 d1bar_L1 ts_uU_L1_14_3 0 NMIR W=20u L=1u
Mo2_uU_L1_14_3 gp_1_14_3 dpre_L1_14 ts_uU_L1_14_3 0 NMIR W=20u L=1u
Mo3_uU_L1_14_3 da_uU_L1_14_3 da_uU_L1_14_3 vdd vdd PMIR W=60u L=1u
Mo4_uU_L1_14_3 gp_1_14_3 da_uU_L1_14_3 vdd vdd PMIR W=60u L=1u
Mct_L1_15 ctail_L1_15 vcbias 0 0 NMIR W=10u L=1u
Mca_L1_15 cna_L1_15 z_L1_15 ctail_L1_15 0 NSYN W=20u L=1u
Mcb_L1_15 uon_L1_15 vthr ctail_L1_15 0 NSYN W=20u L=1u
Mcp1_L1_15 cna_L1_15 cna_L1_15 vdd vdd PMIR W=40u L=1u
Mcp2_L1_15 uon_L1_15 cna_L1_15 vdd vdd PMIR W=40u L=1u
Rulk_L1_15 uon_L1_15 vulk 60000.0
Mt_uU_L1_15_0 ts_uU_L1_15_0 a11 0 0 NMIR W=48.0u L=1u
Mo1_uU_L1_15_0 da_uU_L1_15_0 d1bar_L1 ts_uU_L1_15_0 0 NMIR W=20u L=1u
Mo2_uU_L1_15_0 gp_1_15_0 dpre_L1_15 ts_uU_L1_15_0 0 NMIR W=20u L=1u
Mo3_uU_L1_15_0 da_uU_L1_15_0 da_uU_L1_15_0 vdd vdd PMIR W=60u L=1u
Mo4_uU_L1_15_0 gp_1_15_0 da_uU_L1_15_0 vdd vdd PMIR W=60u L=1u
Mt_uU_L1_15_1 ts_uU_L1_15_1 a10 0 0 NMIR W=48.0u L=1u
Mo1_uU_L1_15_1 da_uU_L1_15_1 d1bar_L1 ts_uU_L1_15_1 0 NMIR W=20u L=1u
Mo2_uU_L1_15_1 gp_1_15_1 dpre_L1_15 ts_uU_L1_15_1 0 NMIR W=20u L=1u
Mo3_uU_L1_15_1 da_uU_L1_15_1 da_uU_L1_15_1 vdd vdd PMIR W=60u L=1u
Mo4_uU_L1_15_1 gp_1_15_1 da_uU_L1_15_1 vdd vdd PMIR W=60u L=1u
Mt_uU_L1_15_2 ts_uU_L1_15_2 a14 0 0 NMIR W=48.0u L=1u
Mo1_uU_L1_15_2 da_uU_L1_15_2 d1bar_L1 ts_uU_L1_15_2 0 NMIR W=20u L=1u
Mo2_uU_L1_15_2 gp_1_15_2 dpre_L1_15 ts_uU_L1_15_2 0 NMIR W=20u L=1u
Mo3_uU_L1_15_2 da_uU_L1_15_2 da_uU_L1_15_2 vdd vdd PMIR W=60u L=1u
Mo4_uU_L1_15_2 gp_1_15_2 da_uU_L1_15_2 vdd vdd PMIR W=60u L=1u
Mt_uU_L1_15_3 ts_uU_L1_15_3 a15 0 0 NMIR W=48.0u L=1u
Mo1_uU_L1_15_3 da_uU_L1_15_3 d1bar_L1 ts_uU_L1_15_3 0 NMIR W=20u L=1u
Mo2_uU_L1_15_3 gp_1_15_3 dpre_L1_15 ts_uU_L1_15_3 0 NMIR W=20u L=1u
Mo3_uU_L1_15_3 da_uU_L1_15_3 da_uU_L1_15_3 vdd vdd PMIR W=60u L=1u
Mo4_uU_L1_15_3 gp_1_15_3 da_uU_L1_15_3 vdd vdd PMIR W=60u L=1u
.IC v(a0)=0.3 v(a1)=0.6885 v(a10)=1.389 v(a11)=0.9315 v(a12)=0.4335 v(a13)=1.5497 v(a14)=0.6085 v(a15)=0.3 v(a2)=0.9401 v(a3)=0.3191 v(a4)=0.7074 v(a5)=1.6046
.IC v(a6)=0.7429 v(a7)=1.3786 v(a8)=0.997 v(a9)=0.8241 v(boff)=1.9 v(bx)=1.7 v(cna_L1_0)=2.2702495 v(cna_L1_1)=2.3702623 v(cna_L1_10)=2.3413742 v(cna_L1_11)=2.2881287 v(cna_L1_12)=2.4365501 v(cna_L1_13)=2.2575179
.IC v(cna_L1_14)=2.2795616 v(cna_L1_15)=2.1449193 v(cna_L1_2)=2.38154 v(cna_L1_3)=2.2527424 v(cna_L1_4)=2.2804609 v(cna_L1_5)=2.3097881 v(cna_L1_6)=2.3793716 v(cna_L1_7)=2.4878244 v(cna_L1_8)=2.3216971 v(cna_L1_9)=2.1081512 v(cna_L2_0)=2.2820225 v(cna_L2_1)=2.2731727
.IC v(cna_L2_10)=2.4125713 v(cna_L2_11)=2.2989683 v(cna_L2_12)=2.4254756 v(cna_L2_13)=2.1735025 v(cna_L2_14)=2.4196636 v(cna_L2_15)=2.1253742 v(cna_L2_2)=2.146825 v(cna_L2_3)=2.3145726 v(cna_L2_4)=2.2931432 v(cna_L2_5)=2.2419903 v(cna_L2_6)=2.4024667 v(cna_L2_7)=2.1850959
.IC v(cna_L2_8)=2.4353414 v(cna_L2_9)=2.2365357 v(coln_L1_0)=0.74912567 v(coln_L1_1)=0.74912567 v(coln_L1_10)=0.83953484 v(coln_L1_11)=0.83953484 v(coln_L1_12)=0.76311717 v(coln_L1_13)=0.76311717 v(coln_L1_14)=0.76311717 v(coln_L1_15)=0.76311717 v(coln_L1_2)=0.74912567 v(coln_L1_3)=0.74912567
.IC v(coln_L1_4)=0.79097208 v(coln_L1_5)=0.79097208 v(coln_L1_6)=0.79097208 v(coln_L1_7)=0.79097208 v(coln_L1_8)=0.83953484 v(coln_L1_9)=0.83953484 v(coln_L2_0)=0.84585312 v(coln_L2_1)=0.83710493 v(coln_L2_10)=0.84216604 v(coln_L2_11)=0.84121685 v(coln_L2_12)=0.83722809 v(coln_L2_13)=0.84299337
.IC v(coln_L2_14)=0.84849173 v(coln_L2_15)=0.84793407 v(coln_L2_2)=0.85634107 v(coln_L2_3)=0.83734892 v(coln_L2_4)=0.84032455 v(coln_L2_5)=0.850424 v(coln_L2_6)=0.84265059 v(coln_L2_7)=0.84324798 v(coln_L2_8)=0.84773881 v(coln_L2_9)=0.84552528 v(colno0)=0.84256829 v(colno1)=0.84884069
.IC v(colno2)=0.86196785 v(colp_L1_0)=0.76168998 v(colp_L1_1)=0.72528291 v(colp_L1_10)=0.8260019 v(colp_L1_11)=0.83987046 v(colp_L1_12)=0.71358471 v(colp_L1_13)=0.77862199 v(colp_L1_14)=0.77118687 v(colp_L1_15)=0.82046216 v(colp_L1_2)=0.72037146 v(colp_L1_3)=0.76789015 v(colp_L1_4)=0.79656457
.IC v(colp_L1_5)=0.78766691 v(colp_L1_6)=0.76480032 v(colp_L1_7)=0.72181157 v(colp_L1_8)=0.83104054 v(colp_L1_9)=0.89837825 v(colp_L2_0)=0.84746615 v(colp_L2_1)=0.84163848 v(colp_L2_10)=0.80710093 v(colp_L2_11)=0.83858773 v(colp_L2_12)=0.79800335 v(colp_L2_13)=0.8763714 v(colp_L2_14)=0.81144115
.IC v(colp_L2_15)=0.89778356 v(colp_L2_2)=0.8969273 v(colp_L2_3)=0.83078306 v(colp_L2_4)=0.83928067 v(colp_L2_5)=0.86257874 v(colp_L2_6)=0.81055047 v(colp_L2_7)=0.87288148 v(colp_L2_8)=0.80434979 v(colp_L2_9)=0.85961678 v(colpo0)=0.83144953 v(colpo1)=0.83079643 v(colpo2)=0.84926191
.IC v(ctail_L1_0)=0.11308345 v(ctail_L1_1)=0.061839047 v(ctail_L1_10)=0.080502263 v(ctail_L1_11)=0.10341263 v(ctail_L1_12)=0.026371371 v(ctail_L1_13)=0.1206657 v(ctail_L1_14)=0.10790995 v(ctail_L1_15)=0.22575418 v(ctail_L1_2)=0.054019969 v(ctail_L1_3)=0.12366979 v(ctail_L1_4)=0.10742628 v(ctail_L1_5)=0.093091475
.IC v(ctail_L1_6)=0.055469196 v(ctail_L1_7)=0.015915256 v(ctail_L1_8)=0.088017257 v(ctail_L1_9)=0.29312718 v(ctail_L2_0)=0.10659293 v(ctail_L2_1)=0.11142656 v(ctail_L2_10)=0.03626994 v(ctail_L2_11)=0.098065206 v(ctail_L2_12)=0.030535949 v(ctail_L2_13)=0.19010154 v(ctail_L2_14)=0.033000133 v(ctail_L2_15)=0.25701351
.IC v(ctail_L2_2)=0.22306542 v(ctail_L2_3)=0.091003576 v(ctail_L2_4)=0.10089232 v(ctail_L2_5)=0.13077333 v(ctail_L2_6)=0.041432098 v(ctail_L2_7)=0.17793062 v(ctail_L2_8)=0.026792296 v(ctail_L2_9)=0.134566 v(ctn_L1_0)=0.96548239 v(ctn_L1_1)=0.9738928 v(ctn_L1_10)=0.97322642 v(ctn_L1_11)=0.97374788
.IC v(ctn_L1_12)=0.97971316 v(ctn_L1_13)=0.99504256 v(ctn_L1_14)=0.95829361 v(ctn_L1_15)=0.97885733 v(ctn_L1_2)=0.98295152 v(ctn_L1_3)=0.96768775 v(ctn_L1_4)=0.94564963 v(ctn_L1_5)=0.98497119 v(ctn_L1_6)=0.96842513 v(ctn_L1_7)=0.98068989 v(ctn_L1_8)=0.95160339 v(ctn_L1_9)=0.96512851
.IC v(ctn_L2_11)=0.80293983 v(ctn_L2_12)=0.82762536 v(ctn_L2_13)=0.75071508 v(ctn_L2_15)=0.75254131 v(ctn_L2_5)=0.7825156 v(ctn_L2_7)=0.80110033 v(ctn_L2_9)=0.83432442 v(ctp_L1_0)=0.97223397 v(ctp_L1_1)=0.97948191 v(ctp_L1_10)=0.97964385 v(ctp_L1_11)=0.97124882 v(ctp_L1_12)=0.97645629
.IC v(ctp_L1_13)=0.98760597 v(ctp_L1_14)=0.96952121 v(ctp_L1_15)=0.97754572 v(ctp_L1_2)=0.98112695 v(ctp_L1_3)=0.97187121 v(ctp_L1_4)=0.96274502 v(ctp_L1_5)=0.98055173 v(ctp_L1_6)=0.96614569 v(ctp_L1_7)=0.97092823 v(ctp_L1_8)=0.96789269 v(ctp_L1_9)=0.9754598 v(ctp_L2_11)=0.80154927
.IC v(ctp_L2_12)=0.82423603 v(ctp_L2_13)=0.75491782 v(ctp_L2_15)=0.76343354 v(ctp_L2_5)=0.79264311 v(ctp_L2_7)=0.81336667 v(ctp_L2_9)=0.80826838 v(d1bar_L1)=1.2729493 v(d1bar_L2)=0.98362833 v(d2e_0)=0.80558203 v(d2e_1)=1.3920926 v(d2e_2)=1.4094215 v(d2e_n_0)=1.7891227
.IC v(d2e_n_1)=0.79088566 v(d2e_n_2)=0.76489721 v(d2e_nb_0)=1.1592672 v(d2e_nb_1)=0.78032376 v(d2e_nb_2)=0.78238791 v(d2e_pb_0)=0.80166794 v(d2e_pb_1)=0.91438667 v(d2e_pb_2)=0.91205928 v(d2ebar)=1.0334938 v(d2en_ns_0)=0.92031242 v(d2en_ns_1)=0.91977993 v(d2en_ns_2)=0.93496094
.IC v(d2en_ps_0)=2.0028756 v(d2en_ps_1)=2.1467506 v(d2en_ps_2)=2.1335515 v(da_oU_0_0)=2.1903208 v(da_oU_0_1)=2.2001689 v(da_oU_0_2)=2.1776709 v(da_oU_0_3)=2.19199 v(da_oU_1_0)=2.4999594 v(da_oU_1_1)=2.4999594 v(da_oU_1_2)=2.4718911 v(da_oU_1_3)=2.4999594 v(da_oU_2_0)=2.499959
.IC v(da_oU_2_1)=2.4233569 v(da_oU_2_2)=2.4999594 v(da_oU_2_3)=2.4999594 v(da_uU_L1_0_0)=2.3074499 v(da_uU_L1_0_1)=2.4999594 v(da_uU_L1_0_2)=1.8940293 v(da_uU_L1_0_3)=2.3284631 v(da_uU_L1_10_0)=1.9000482 v(da_uU_L1_10_1)=2.4999594 v(da_uU_L1_10_2)=2.0329637 v(da_uU_L1_10_3)=2.1801908 v(da_uU_L1_11_0)=2.147788
.IC v(da_uU_L1_11_1)=2.4999531 v(da_uU_L1_11_2)=1.8882194 v(da_uU_L1_11_3)=2.0113665 v(da_uU_L1_12_0)=1.9087085 v(da_uU_L1_12_1)=2.3802615 v(da_uU_L1_12_2)=2.4999401 v(da_uU_L1_12_3)=2.0450297 v(da_uU_L1_13_0)=2.4999401 v(da_uU_L1_13_1)=2.3670571 v(da_uU_L1_13_2)=1.9034737 v(da_uU_L1_13_3)=2.0342562 v(da_uU_L1_14_0)=2.4999594
.IC v(da_uU_L1_14_1)=1.9294946 v(da_uU_L1_14_2)=2.0845455 v(da_uU_L1_14_3)=2.4380839 v(da_uU_L1_15_0)=2.0501549 v(da_uU_L1_15_1)=1.9116822 v(da_uU_L1_15_2)=2.3869289 v(da_uU_L1_15_3)=2.4997512 v(da_uU_L1_1_0)=2.4999594 v(da_uU_L1_1_1)=1.8927213 v(da_uU_L1_1_2)=2.3253469 v(da_uU_L1_1_3)=2.3038416 v(da_uU_L1_2_0)=2.298186
.IC v(da_uU_L1_2_1)=1.8832269 v(da_uU_L1_2_2)=2.4999531 v(da_uU_L1_2_3)=2.2769063 v(da_uU_L1_3_0)=2.2983893 v(da_uU_L1_3_1)=2.4999594 v(da_uU_L1_3_2)=1.890906 v(da_uU_L1_3_3)=2.3192895 v(da_uU_L1_4_0)=2.0946422 v(da_uU_L1_4_1)=2.3072061 v(da_uU_L1_4_2)=1.9408986 v(da_uU_L1_4_3)=2.4999594 v(da_uU_L1_5_0)=2.4999401
.IC v(da_uU_L1_5_1)=2.2293177 v(da_uU_L1_5_2)=2.0362308 v(da_uU_L1_5_3)=1.9089585 v(da_uU_L1_6_0)=1.9115402 v(da_uU_L1_6_1)=2.2360589 v(da_uU_L1_6_2)=2.4999594 v(da_uU_L1_6_3)=2.0414812 v(da_uU_L1_7_0)=1.9011853 v(da_uU_L1_7_1)=2.0236515 v(da_uU_L1_7_2)=2.2122973 v(da_uU_L1_7_3)=2.4999401 v(da_uU_L1_8_0)=2.4999594
.IC v(da_uU_L1_8_1)=2.0568891 v(da_uU_L1_8_2)=2.214103 v(da_uU_L1_8_3)=1.9128568 v(da_uU_L1_9_0)=2.0421737 v(da_uU_L1_9_1)=1.9057543 v(da_uU_L1_9_2)=2.4990037 v(da_uU_L1_9_3)=2.194113 v(da_uU_L2_0_0)=2.1933969 v(da_uU_L2_0_1)=2.1931263 v(da_uU_L2_0_2)=2.19342 v(da_uU_L2_0_3)=2.1948905 v(da_uU_L2_10_0)=2.2090366
.IC v(da_uU_L2_10_1)=2.185675 v(da_uU_L2_10_2)=2.2055064 v(da_uU_L2_10_3)=2.2072862 v(da_uU_L2_11_0)=2.1780755 v(da_uU_L2_11_1)=2.17557 v(da_uU_L2_11_2)=2.181524 v(da_uU_L2_11_3)=2.1735531 v(da_uU_L2_12_0)=2.1760421 v(da_uU_L2_12_1)=2.1843444 v(da_uU_L2_12_2)=2.1829736 v(da_uU_L2_12_3)=2.1815378 v(da_uU_L2_13_0)=2.1762267
.IC v(da_uU_L2_13_1)=2.1759247 v(da_uU_L2_13_2)=2.1834834 v(da_uU_L2_13_3)=2.1777604 v(da_uU_L2_14_0)=2.2003898 v(da_uU_L2_14_1)=2.2033278 v(da_uU_L2_14_2)=2.1796643 v(da_uU_L2_14_3)=2.2058478 v(da_uU_L2_15_0)=2.1662381 v(da_uU_L2_15_1)=2.1767335 v(da_uU_L2_15_2)=2.1780001 v(da_uU_L2_15_3)=2.1830152 v(da_uU_L2_1_0)=2.2015904
.IC v(da_uU_L2_1_1)=2.2018297 v(da_uU_L2_1_2)=2.2031956 v(da_uU_L2_1_3)=2.1991733 v(da_uU_L2_2_0)=2.1816971 v(da_uU_L2_2_1)=2.1941012 v(da_uU_L2_2_2)=2.1956704 v(da_uU_L2_2_3)=2.175514 v(da_uU_L2_3_0)=2.2014069 v(da_uU_L2_3_1)=2.1955495 v(da_uU_L2_3_2)=2.2026139 v(da_uU_L2_3_3)=2.2045105 v(da_uU_L2_4_0)=2.1978183
.IC v(da_uU_L2_4_1)=2.2079015 v(da_uU_L2_4_2)=2.2039227 v(da_uU_L2_4_3)=2.1963907 v(da_uU_L2_5_0)=2.1756872 v(da_uU_L2_5_1)=2.175116 v(da_uU_L2_5_2)=2.1581412 v(da_uU_L2_5_3)=2.1785134 v(da_uU_L2_6_0)=2.2040804 v(da_uU_L2_6_1)=2.2053687 v(da_uU_L2_6_2)=2.205244 v(da_uU_L2_6_3)=2.1842059 v(da_uU_L2_7_0)=2.1799091
.IC v(da_uU_L2_7_1)=2.17798 v(da_uU_L2_7_2)=2.1847308 v(da_uU_L2_7_3)=2.1779828 v(da_uU_L2_8_0)=2.2036693 v(da_uU_L2_8_1)=2.1994196 v(da_uU_L2_8_2)=2.204619 v(da_uU_L2_8_3)=2.1781387 v(da_uU_L2_9_0)=2.171814 v(da_uU_L2_9_1)=2.173515 v(da_uU_L2_9_2)=2.173248 v(da_uU_L2_9_3)=2.1719176 v(dmp_L1_0)=2.4997501
.IC v(dmp_L1_1)=2.4999502 v(dmp_L1_10)=2.4999502 v(dmp_L1_11)=2.4999502 v(dmp_L1_12)=2.4999502 v(dmp_L1_13)=2.4999502 v(dmp_L1_14)=2.4999502 v(dmp_L1_15)=2.4999502 v(dmp_L1_2)=2.4999502 v(dmp_L1_3)=2.4999502 v(dmp_L1_4)=2.4999502 v(dmp_L1_5)=2.4999502 v(dmp_L1_6)=2.4999502
.IC v(dmp_L1_7)=2.4999502 v(dmp_L1_8)=2.4999502 v(dmp_L1_9)=2.4999502 v(dmp_L2_0)=2.4999502 v(dmp_L2_1)=2.4999502 v(dmp_L2_10)=2.4999502 v(dmp_L2_11)=2.4999502 v(dmp_L2_12)=2.4999502 v(dmp_L2_13)=2.4999502 v(dmp_L2_14)=2.4980273 v(dmp_L2_15)=2.4999502 v(dmp_L2_2)=2.4999502
.IC v(dmp_L2_3)=2.4997514 v(dmp_L2_4)=2.499013 v(dmp_L2_5)=2.4999502 v(dmp_L2_6)=2.4999502 v(dmp_L2_7)=2.4999502 v(dmp_L2_8)=2.4960553 v(dmp_L2_9)=2.4998701 v(dpf_bk_L1_0)=2.0229462 v(dpf_bk_L1_1)=2.0156925 v(dpf_bk_L1_10)=2.0155305 v(dpf_bk_L1_11)=2.0239323 v(dpf_bk_L1_12)=2.0187203
.IC v(dpf_bk_L1_13)=2.0075644 v(dpf_bk_L1_14)=2.0256617 v(dpf_bk_L1_15)=2.0176301 v(dpf_bk_L1_2)=2.0140465 v(dpf_bk_L1_3)=2.0233093 v(dpf_bk_L1_4)=2.0324458 v(dpf_bk_L1_5)=2.014622 v(dpf_bk_L1_6)=2.0290409 v(dpf_bk_L1_7)=2.0242532 v(dpf_bk_L1_8)=2.0272919 v(dpf_bk_L1_9)=2.0197176 v(dpf_bk_L2_11)=2.1943573
.IC v(dpf_bk_L2_12)=2.1715083 v(dpf_bk_L2_13)=2.2413856 v(dpf_bk_L2_15)=2.232791 v(dpf_bk_L2_5)=2.2033326 v(dpf_bk_L2_7)=2.1824529 v(dpf_bk_L2_9)=2.187588 v(dpf_h_L1_0)=2.2345505 v(dpf_h_L1_1)=2.2713174 v(dpf_h_L1_10)=2.1697307 v(dpf_h_L1_11)=2.1557739 v(dpf_h_L1_12)=2.2831423 v(dpf_h_L1_13)=2.217469
.IC v(dpf_h_L1_14)=2.2249684 v(dpf_h_L1_15)=2.1753078 v(dpf_h_L1_2)=2.2762814 v(dpf_h_L1_3)=2.2282943 v(dpf_h_L1_4)=2.1993803 v(dpf_h_L1_5)=2.2083488 v(dpf_h_L1_6)=2.2314119 v(dpf_h_L1_7)=2.2748258 v(dpf_h_L1_8)=2.1646591 v(dpf_h_L1_9)=2.0969768 v(dpf_h_L2_0)=2.1481331 v(dpf_h_L2_1)=2.1539952
.IC v(dpf_h_L2_10)=2.1887641 v(dpf_h_L2_11)=2.1570645 v(dpf_h_L2_12)=2.1979304 v(dpf_h_L2_13)=2.1190768 v(dpf_h_L2_14)=2.1843922 v(dpf_h_L2_15)=2.0975737 v(dpf_h_L2_2)=2.0984333 v(dpf_h_L2_3)=2.1649183 v(dpf_h_L2_4)=2.1563673 v(dpf_h_L2_5)=2.1329374 v(dpf_h_L2_6)=2.1852893 v(dpf_h_L2_7)=2.1225832
.IC v(dpf_h_L2_8)=2.1915356 v(dpf_h_L2_9)=2.135915 v(dpf_o0)=2.1642475 v(dpf_o1)=2.1649048 v(dpf_o2)=2.146327 v(dpre_L1_0)=1.3384479 v(dpre_L1_1)=1.3321763 v(dpre_L1_10)=1.3377796 v(dpre_L1_11)=1.2765383 v(dpre_L1_12)=1.2718984 v(dpre_L1_13)=1.2437623 v(dpre_L1_14)=1.367239
.IC v(dpre_L1_15)=1.2852277 v(dpre_L1_2)=1.2821202 v(dpre_L1_3)=1.321329 v(dpre_L1_4)=1.4030165 v(dpre_L1_5)=1.2642838 v(dpre_L1_6)=1.2774968 v(dpre_L1_7)=1.2273503 v(dpre_L1_8)=1.3996047 v(dpre_L1_9)=1.3629132 v(dpre_L2_0)=1.0347462 v(dpre_L2_1)=1.0377663 v(dpre_L2_10)=1.0494754
.IC v(dpre_L2_11)=0.972936 v(dpre_L2_12)=0.9776913 v(dpre_L2_13)=0.98051208 v(dpre_L2_14)=1.0500556 v(dpre_L2_15)=0.98293285 v(dpre_L2_2)=1.034628 v(dpre_L2_3)=1.0367274 v(dpre_L2_4)=1.0451604 v(dpre_L2_5)=0.97382254 v(dpre_L2_6)=1.0444504 v(dpre_L2_7)=0.98658807 v(dpre_L2_8)=1.0452415
.IC v(dpre_L2_9)=0.96748998 v(gp_1_0_0)=1.5372 v(gp_1_0_1)=2.0496 v(gp_1_0_2)=1.9896 v(gp_1_0_3)=1.6236 v(gp_1_0_b)=1.7964 v(gp_1_10_0)=1.6584 v(gp_1_10_1)=1.8636 v(gp_1_10_2)=2.0748 v(gp_1_10_3)=2.0496 v(gp_1_10_b)=1.8036 v(gp_1_11_0)=1.8636
.IC v(gp_1_11_1)=1.4652 v(gp_1_11_2)=1.6152 v(gp_1_11_3)=2.0136 v(gp_1_11_b)=1.7388 v(gp_1_12_0)=1.5648 v(gp_1_12_1)=1.8348 v(gp_1_12_2)=1.9464 v(gp_1_12_3)=1.926 v(gp_1_12_b)=1.71 v(gp_1_13_0)=1.7556 v(gp_1_13_1)=1.806 v(gp_1_13_2)=2.0004
.IC v(gp_1_13_3)=1.8156 v(gp_1_13_b)=1.7232 v(gp_1_14_0)=1.7928 v(gp_1_14_1)=1.4616 v(gp_1_14_2)=1.4712 v(gp_1_14_3)=1.9464 v(gp_1_14_b)=2.148 v(gp_1_15_0)=1.8672 v(gp_1_15_1)=1.7232 v(gp_1_15_2)=1.5624 v(gp_1_15_3)=1.8012 v(gp_1_15_b)=2.1468
.IC v(gp_1_1_0)=1.764 v(gp_1_1_1)=1.9092 v(gp_1_1_2)=2.0076 v(gp_1_1_3)=1.5072 v(gp_1_1_b)=1.4604 v(gp_1_2_0)=2.0412 v(gp_1_2_1)=1.752 v(gp_1_2_2)=1.9884 v(gp_1_2_3)=1.4412 v(gp_1_2_b)=1.7604 v(gp_1_3_0)=1.9596 v(gp_1_3_1)=1.6044
.IC v(gp_1_3_2)=2.1204 v(gp_1_3_3)=2.0892 v(gp_1_3_b)=1.4616 v(gp_1_4_0)=1.458 v(gp_1_4_1)=1.83 v(gp_1_4_2)=2.1156 v(gp_1_4_3)=1.7148 v(gp_1_4_b)=1.596 v(gp_1_5_0)=1.7436 v(gp_1_5_1)=1.4604 v(gp_1_5_2)=1.5996 v(gp_1_5_3)=1.7556
.IC v(gp_1_5_b)=1.7964 v(gp_1_6_0)=1.608 v(gp_1_6_1)=1.6068 v(gp_1_6_2)=1.5972 v(gp_1_6_3)=1.7712 v(gp_1_6_b)=1.6488 v(gp_1_7_0)=1.4556 v(gp_1_7_1)=2.0436 v(gp_1_7_2)=1.8408 v(gp_1_7_3)=1.902 v(gp_1_7_b)=1.5744 v(gp_1_8_0)=2.1552
.IC v(gp_1_8_1)=2.0592 v(gp_1_8_2)=1.5276 v(gp_1_8_3)=1.68 v(gp_1_8_b)=1.9596 v(gp_1_9_0)=1.9524 v(gp_1_9_1)=2.1144 v(gp_1_9_2)=1.7436 v(gp_1_9_3)=2.0376 v(gp_1_9_b)=1.9224 v(gp_2_0_0)=1.9944 v(gp_2_0_1)=1.8288 v(gp_2_0_2)=2.0592
.IC v(gp_2_0_3)=1.6068 v(gp_2_0_b)=1.8096 v(gp_2_10_0)=1.6884 v(gp_2_10_1)=1.4904 v(gp_2_10_2)=1.5552 v(gp_2_10_3)=1.8192 v(gp_2_10_b)=1.5612 v(gp_2_11_0)=1.6368 v(gp_2_11_1)=1.9524 v(gp_2_11_2)=1.7676 v(gp_2_11_3)=1.6716 v(gp_2_11_b)=1.7808
.IC v(gp_2_12_0)=1.4568 v(gp_2_12_1)=1.7184 v(gp_2_12_2)=1.7436 v(gp_2_12_3)=1.5756 v(gp_2_12_b)=1.518 v(gp_2_13_0)=2.088 v(gp_2_13_1)=1.8072 v(gp_2_13_2)=1.59 v(gp_2_13_3)=1.8756 v(gp_2_13_b)=2.028 v(gp_2_14_0)=1.4544 v(gp_2_14_1)=1.4532
.IC v(gp_2_14_2)=1.5456 v(gp_2_14_3)=1.9572 v(gp_2_14_b)=1.5552 v(gp_2_15_0)=1.9476 v(gp_2_15_1)=1.9284 v(gp_2_15_2)=1.8324 v(gp_2_15_3)=1.5984 v(gp_2_15_b)=2.142 v(gp_2_1_0)=2.1252 v(gp_2_1_1)=1.8564 v(gp_2_1_2)=1.77 v(gp_2_1_3)=1.6344
.IC v(gp_2_1_b)=1.8348 v(gp_2_2_0)=2.1288 v(gp_2_2_1)=1.4436 v(gp_2_2_2)=2.004 v(gp_2_2_3)=2.0304 v(gp_2_2_b)=2.0784 v(gp_2_3_0)=1.9728 v(gp_2_3_1)=2.022 v(gp_2_3_2)=1.8132 v(gp_2_3_3)=1.8444 v(gp_2_3_b)=1.7472 v(gp_2_4_0)=1.4808
.IC v(gp_2_4_1)=2.0664 v(gp_2_4_2)=1.8504 v(gp_2_4_3)=1.584 v(gp_2_4_b)=1.8036 v(gp_2_5_0)=1.7892 v(gp_2_5_1)=1.6968 v(gp_2_5_2)=1.6896 v(gp_2_5_3)=1.8276 v(gp_2_5_b)=1.8888 v(gp_2_6_0)=1.8804 v(gp_2_6_1)=1.77 v(gp_2_6_2)=1.4604
.IC v(gp_2_6_3)=1.6056 v(gp_2_6_b)=1.5672 v(gp_2_7_0)=1.8612 v(gp_2_7_1)=2.0604 v(gp_2_7_2)=2.0148 v(gp_2_7_3)=2.0136 v(gp_2_7_b)=2.028 v(gp_2_8_0)=1.6236 v(gp_2_8_1)=2.046 v(gp_2_8_2)=1.9248 v(gp_2_8_3)=1.5 v(gp_2_8_b)=1.452
.IC v(gp_2_9_0)=1.4508 v(gp_2_9_1)=1.9836 v(gp_2_9_2)=1.62 v(gp_2_9_3)=1.5192 v(gp_2_9_b)=1.89 v(gp_o_0_0)=2.0148 v(gp_o_0_1)=1.812 v(gp_o_0_2)=1.6008 v(gp_o_0_3)=1.9068 v(gp_o_0_b)=1.7244 v(gp_o_1_0)=1.8552 v(gp_o_1_1)=1.6716
.IC v(gp_o_1_2)=1.8948 v(gp_o_1_3)=1.482 v(gp_o_1_b)=1.6548 v(gp_o_2_0)=2.1372 v(gp_o_2_1)=2.07 v(gp_o_2_2)=1.6608 v(gp_o_2_3)=2.058 v(gp_o_2_b)=1.6632 v(hdd_L1_0)=2.4001109 v(hdd_L1_1)=2.4999502 v(hdd_L1_10)=2.4999502 v(hdd_L1_11)=2.4302829
.IC v(hdd_L1_12)=2.4999502 v(hdd_L1_13)=2.3782475 v(hdd_L1_14)=2.4158991 v(hdd_L1_15)=2.1623201 v(hdd_L1_2)=2.4999502 v(hdd_L1_3)=2.3699583 v(hdd_L1_4)=2.4174151 v(hdd_L1_5)=2.4660914 v(hdd_L1_6)=2.4999502 v(hdd_L1_7)=2.4999502 v(hdd_L1_8)=2.4854659 v(hdd_L1_9)=2.0699585
.IC v(hdd_L2_0)=2.4200442 v(hdd_L2_1)=2.4050849 v(hdd_L2_10)=2.4999502 v(hdd_L2_11)=2.4482994 v(hdd_L2_12)=2.4999502 v(hdd_L2_13)=2.2227346 v(hdd_L2_14)=2.4999502 v(hdd_L2_15)=2.1163994 v(hdd_L2_2)=2.1665536 v(hdd_L2_3)=2.4739007 v(hdd_L2_4)=2.4386421 v(hdd_L2_5)=2.351105
.IC v(hdd_L2_6)=2.4999502 v(hdd_L2_7)=2.2457624 v(hdd_L2_8)=2.4999502 v(hdd_L2_9)=2.3414337 v(hv_L1_0)=0.84593183 v(hv_L1_1)=0.83220456 v(hv_L1_10)=0.82912934 v(hv_L1_11)=0.84960901 v(hv_L1_12)=0.83178118 v(hv_L1_13)=0.83303094 v(hv_L1_14)=0.8285674 v(hv_L1_15)=0.88169094
.IC v(hv_L1_2)=0.8251424 v(hv_L1_3)=0.84967606 v(hv_L1_4)=0.84606199 v(hv_L1_5)=0.84384465 v(hv_L1_6)=0.84470384 v(hv_L1_7)=0.84947973 v(hv_L1_8)=0.8371557 v(hv_L1_9)=0.90068327 v(hv_L2_0)=0.74276182 v(hv_L2_1)=0.76023961 v(hv_L2_10)=0.70000003 v(hv_L2_11)=0.82044701
.IC v(hv_L2_12)=0.8372629 v(hv_L2_13)=0.89069217 v(hv_L2_14)=0.70000003 v(hv_L2_15)=0.96310618 v(hv_L2_2)=1.4338824 v(hv_L2_3)=0.70455966 v(hv_L2_4)=0.72519089 v(hv_L2_5)=0.84755513 v(hv_L2_6)=0.70000003 v(hv_L2_7)=0.87189215 v(hv_L2_8)=0.70000003 v(hv_L2_9)=0.84097742
.IC v(tail_L1_0)=0.002340326 v(tail_L1_1)=0 v(tail_L1_10)=0 v(tail_L1_11)=0.0011386246 v(tail_L1_12)=0 v(tail_L1_13)=0.0034805622 v(tail_L1_14)=0.0016578583 v(tail_L1_15)=0.027234987 v(tail_L1_2)=0 v(tail_L1_3)=0.0039723246 v(tail_L1_4)=0.0015985268 v(tail_L1_5)=0.00026903657
.IC v(tail_L1_6)=0 v(tail_L1_7)=0 v(tail_L1_8)=4.9402336e-05 v(tail_L1_9)=0.044675366 v(tail_L2_0)=0.0014982101 v(tail_L2_1)=0.0021125916 v(tail_L2_10)=0 v(tail_L2_11)=0.00062577587 v(tail_L2_12)=0 v(tail_L2_13)=0.018250486 v(tail_L2_14)=-1.3784454e-172 v(tail_L2_15)=0.035333416
.IC v(tail_L2_2)=0.02654419 v(tail_L2_3)=0.00015935077 v(tail_L2_4)=0.00088167921 v(tail_L2_5)=0.0052130381 v(tail_L2_6)=0 v(tail_L2_7)=0.015313541 v(tail_L2_8)=-1.3856117e-170 v(tail_L2_9)=0.0059156055 v(tg0)=1 v(tg1)=0 v(tg2)=0 v(ts_oU_0_0)=0.22727073
.IC v(ts_oU_0_1)=0.23703791 v(ts_oU_0_2)=0.21472202 v(ts_oU_0_3)=0.22892639 v(ts_oU_1_0)=0.54712434 v(ts_oU_1_1)=0.5566764 v(ts_oU_1_2)=0.50577662 v(ts_oU_1_3)=0.5523803 v(ts_oU_2_0)=0.56527511 v(ts_oU_2_1)=0.45788185 v(ts_oU_2_2)=0.53965053 v(ts_oU_2_3)=0.57514502 v(ts_uU_L1_0_0)=0.5823308
.IC v(ts_uU_L1_0_1)=0.83840241 v(ts_uU_L1_0_2)=0.17060635 v(ts_uU_L1_0_3)=0.60316873 v(ts_uU_L1_10_0)=0.17662442 v(ts_uU_L1_10_1)=0.83773399 v(ts_uU_L1_10_2)=0.30934134 v(ts_uU_L1_10_3)=0.45594847 v(ts_uU_L1_11_0)=0.4237184 v(ts_uU_L1_11_1)=0.77649425 v(ts_uU_L1_11_2)=0.16479674 v(ts_uU_L1_11_3)=0.28779967 v(ts_uU_L1_12_0)=0.1852821
.IC v(ts_uU_L1_12_1)=0.65449791 v(ts_uU_L1_12_2)=0.77290582 v(ts_uU_L1_12_3)=0.32137242 v(ts_uU_L1_13_0)=0.77290582 v(ts_uU_L1_13_1)=0.64141808 v(ts_uU_L1_13_2)=0.18004901 v(ts_uU_L1_13_3)=0.31063032 v(ts_uU_L1_14_0)=0.86719261 v(ts_uU_L1_14_1)=0.20605629 v(ts_uU_L1_14_2)=0.36075399 v(ts_uU_L1_14_3)=0.71173413 v(ts_uU_L1_15_0)=0.32648193
.IC v(ts_uU_L1_15_1)=0.1882546 v(ts_uU_L1_15_2)=0.6611011 v(ts_uU_L1_15_3)=0.78518353 v(ts_uU_L1_1_0)=0.8321308 v(ts_uU_L1_1_1)=0.16929849 v(ts_uU_L1_1_2)=0.60007903 v(ts_uU_L1_1_3)=0.57875178 v(ts_uU_L1_2_0)=0.57314149 v(ts_uU_L1_2_1)=0.15980389 v(ts_uU_L1_2_2)=0.78207624 v(ts_uU_L1_2_3)=0.55202654 v(ts_uU_L1_3_0)=0.57334314
.IC v(ts_uU_L1_3_1)=0.82128373 v(ts_uU_L1_3_2)=0.16748326 v(ts_uU_L1_3_3)=0.59407269 v(ts_uU_L1_4_0)=0.37081151 v(ts_uU_L1_4_1)=0.58208902 v(ts_uU_L1_4_2)=0.21745009 v(ts_uU_L1_4_3)=0.90296908 v(ts_uU_L1_5_0)=0.77290582 v(ts_uU_L1_5_1)=0.50477447 v(ts_uU_L1_5_2)=0.31259927 v(ts_uU_L1_5_3)=0.18553207 v(ts_uU_L1_6_0)=0.18811266
.IC v(ts_uU_L1_6_1)=0.51147074 v(ts_uU_L1_6_2)=0.7774528 v(ts_uU_L1_6_3)=0.31783453 v(ts_uU_L1_7_0)=0.17776125 v(ts_uU_L1_7_1)=0.30005419 v(ts_uU_L1_7_2)=0.48786369 v(ts_uU_L1_7_3)=0.77290582 v(ts_uU_L1_8_0)=0.8995576 v(ts_uU_L1_8_1)=0.33319474 v(ts_uU_L1_8_2)=0.48965801 v(ts_uU_L1_8_3)=0.18942873 v(ts_uU_L1_9_0)=0.31852493
.IC v(ts_uU_L1_9_1)=0.18232901 v(ts_uU_L1_9_2)=0.86286691 v(ts_uU_L1_9_3)=0.46979021 v(ts_uU_L2_0_0)=0.18060124 v(ts_uU_L2_0_1)=0.18033293 v(ts_uU_L2_0_2)=0.18062415 v(ts_uU_L2_0_3)=0.18208181 v(ts_uU_L2_10_0)=0.19610311 v(ts_uU_L2_10_1)=0.17294554 v(ts_uU_L2_10_2)=0.19260444 v(ts_uU_L2_10_3)=0.19436835 v(ts_uU_L2_11_0)=0.16541015
.IC v(ts_uU_L2_11_1)=0.16292547 v(ts_uU_L2_11_2)=0.16882968 v(ts_uU_L2_11_3)=0.16092536 v(ts_uU_L2_12_0)=0.16339372 v(ts_uU_L2_12_1)=0.17162622 v(ts_uU_L2_12_2)=0.17026707 v(ts_uU_L2_12_3)=0.1688434 v(ts_uU_L2_13_0)=0.16357672 v(ts_uU_L2_13_1)=0.16327728 v(ts_uU_L2_13_2)=0.17077251 v(ts_uU_L2_13_3)=0.16509767 v(ts_uU_L2_14_0)=0.18753309
.IC v(ts_uU_L2_14_1)=0.19044521 v(ts_uU_L2_14_2)=0.16698567 v(ts_uU_L2_14_3)=0.19294283 v(ts_uU_L2_15_0)=0.15367033 v(ts_uU_L2_15_1)=0.1640793 v(ts_uU_L2_15_2)=0.1653353 v(ts_uU_L2_15_3)=0.17030835 v(ts_uU_L2_1_0)=0.18872316 v(ts_uU_L2_1_1)=0.18896034 v(ts_uU_L2_1_2)=0.19031414 v(ts_uU_L2_1_3)=0.18632723 v(ts_uU_L2_2_0)=0.16900137
.IC v(ts_uU_L2_2_1)=0.18129938 v(ts_uU_L2_2_2)=0.182855 v(ts_uU_L2_2_3)=0.16286991 v(ts_uU_L2_3_0)=0.18854124 v(ts_uU_L2_3_1)=0.18273507 v(ts_uU_L2_3_2)=0.1897376 v(ts_uU_L2_3_3)=0.19161737 v(ts_uU_L2_4_0)=0.18498414 v(ts_uU_L2_4_1)=0.19497821 v(ts_uU_L2_4_2)=0.19103484 v(ts_uU_L2_4_3)=0.18356898 v(ts_uU_L2_5_0)=0.16304175
.IC v(ts_uU_L2_5_1)=0.16247529 v(ts_uU_L2_5_2)=0.14563849 v(ts_uU_L2_5_3)=0.16584437 v(ts_uU_L2_6_0)=0.19119111 v(ts_uU_L2_6_1)=0.19246796 v(ts_uU_L2_6_2)=0.19234439 v(ts_uU_L2_6_3)=0.17148896 v(ts_uU_L2_7_0)=0.16722839 v(ts_uU_L2_7_1)=0.16531538 v(ts_uU_L2_7_2)=0.17200942 v(ts_uU_L2_7_3)=0.16531822 v(ts_uU_L2_8_0)=0.19078368
.IC v(ts_uU_L2_8_1)=0.18657141 v(ts_uU_L2_8_2)=0.19172489 v(ts_uU_L2_8_3)=0.16547278 v(ts_uU_L2_9_0)=0.15920056 v(ts_uU_L2_9_1)=0.1608875 v(ts_uU_L2_9_2)=0.1606227 v(ts_uU_L2_9_3)=0.1593033 v(uon_L1_0)=2.1296634 v(uon_L1_1)=0.18047283 v(uon_L1_10)=0.42461516 v(uon_L1_11)=1.6533285 v(uon_L1_12)=0.075146113
.IC v(uon_L1_13)=2.4864466 v(uon_L1_14)=1.8778576 v(uon_L1_15)=2.9177481 v(uon_L1_2)=0.15218962 v(uon_L1_3)=2.6238495 v(uon_L1_4)=1.8539637 v(uon_L1_5)=1.1177117 v(uon_L1_6)=0.15708166 v(uon_L1_7)=0.050714171 v(uon_L1_8)=0.84372217 v(uon_L1_9)=2.9321801 v(uon_L2_0)=1.8126524
.IC v(uon_L2_1)=2.0497659 v(uon_L2_10)=0.10012119 v(uon_L2_11)=1.3794052 v(uon_L2_12)=0.085399668 v(uon_L2_13)=2.8998841 v(uon_L2_14)=0.091633867 v(uon_L2_15)=2.9266873 v(uon_L2_2)=2.9167402 v(uon_L2_3)=1.005838 v(uon_L2_4)=1.5251747 v(uon_L2_5)=2.7979849 v(uon_L2_6)=0.11409259
.IC v(uon_L2_7)=2.8906537 v(uon_L2_8)=0.07616741 v(uon_L2_9)=2.816325 v(vcbias)=1 v(vcn)=1.8 v(vdd)=3 v(vg0)=0.7 v(vmid)=0.5 v(vrefd)=1.2 v(vrefh)=0.5 v(vrefo)=0.5 v(vtb)=1.4
.IC v(vthr)=0.5 v(vulk)=0.6 v(y_0)=0.49870332 v(y_1)=0.45956032 v(y_2)=0.49201013 v(z_L1_0)=0.60581047 v(z_L1_1)=0.42697591 v(z_L1_10)=0.48246695 v(z_L1_11)=0.57331201 v(z_L1_12)=0.30708073 v(z_L1_13)=0.62965288 v(z_L1_14)=0.58874655
.IC v(z_L1_15)=0.878724 v(z_L1_2)=0.40478521 v(z_L1_3)=0.63875711 v(z_L1_4)=0.58711473 v(z_L1_5)=0.53534759 v(z_L1_6)=0.40899745 v(z_L1_7)=0.23139487 v(z_L1_8)=0.51507924 v(z_L1_9)=0.99318199 v(z_L2_0)=0.5842877 v(z_L2_1)=0.60042076 v(z_L2_10)=0.34750726
.IC v(z_L2_11)=0.5541289 v(z_L2_12)=0.32534275 v(z_L2_13)=0.80649115 v(z_L2_14)=0.33520649 v(z_L2_15)=0.93500841 v(z_L2_2)=0.87359574 v(z_L2_3)=0.52715496 v(z_L2_4)=0.56439083 v(z_L2_5)=0.65959715 v(z_L2_6)=0.36553799 v(z_L2_7)=0.77948918 v(z_L2_8)=0.30904014
.IC v(z_L2_9)=0.67035953
.options TIMEINT method=gear reltol=1e-2 abstol=1e-5 maxord=2
.options NONLIN abstol=1e-5 reltol=1e-2
.TRAN 0.10200000000000001 600.0 0 0.10200000000000001 UIC
.PRINT TRAN FORMAT=NOINDEX FILE=xyce_out.prn V(y_0) V(y_1) V(y_2) V(gp_1_0_0) V(gp_1_0_1) V(gp_1_0_2) V(gp_1_0_3) V(gp_1_1_0) V(gp_1_1_1) V(gp_1_1_2) V(gp_1_1_3) V(gp_1_2_0) V(gp_1_2_1) V(gp_1_2_2) V(gp_1_2_3) V(gp_1_3_0) V(gp_1_3_1) V(gp_1_3_2) V(gp_1_3_3) V(gp_1_4_0) V(gp_1_4_1) V(gp_1_4_2) V(gp_1_4_3) V(gp_1_5_0) V(gp_1_5_1) V(gp_1_5_2) V(gp_1_5_3) V(gp_1_6_0) V(gp_1_6_1) V(gp_1_6_2) V(gp_1_6_3) V(gp_1_7_0) V(gp_1_7_1) V(gp_1_7_2) V(gp_1_7_3) V(gp_1_8_0) V(gp_1_8_1) V(gp_1_8_2) V(gp_1_8_3) V(gp_1_9_0) V(gp_1_9_1) V(gp_1_9_2) V(gp_1_9_3) V(gp_1_10_0) V(gp_1_10_1) V(gp_1_10_2) V(gp_1_10_3) V(gp_1_11_0) V(gp_1_11_1) V(gp_1_11_2) V(gp_1_11_3) V(gp_1_12_0) V(gp_1_12_1) V(gp_1_12_2) V(gp_1_12_3) V(gp_1_13_0) V(gp_1_13_1) V(gp_1_13_2) V(gp_1_13_3) V(gp_1_14_0) V(gp_1_14_1) V(gp_1_14_2) V(gp_1_14_3) V(gp_1_15_0) V(gp_1_15_1) V(gp_1_15_2) V(gp_1_15_3) V(gp_2_0_0) V(gp_2_0_1) V(gp_2_0_2) V(gp_2_0_3) V(gp_2_1_0) V(gp_2_1_1) V(gp_2_1_2) V(gp_2_1_3) V(gp_2_2_0) V(gp_2_2_1) V(gp_2_2_2) V(gp_2_2_3) V(gp_2_3_0) V(gp_2_3_1) V(gp_2_3_2) V(gp_2_3_3) V(gp_2_4_0) V(gp_2_4_1) V(gp_2_4_2) V(gp_2_4_3) V(gp_2_5_0) V(gp_2_5_1) V(gp_2_5_2) V(gp_2_5_3) V(gp_2_6_0) V(gp_2_6_1) V(gp_2_6_2) V(gp_2_6_3) V(gp_2_7_0) V(gp_2_7_1) V(gp_2_7_2) V(gp_2_7_3) V(gp_2_8_0) V(gp_2_8_1) V(gp_2_8_2) V(gp_2_8_3) V(gp_2_9_0) V(gp_2_9_1) V(gp_2_9_2) V(gp_2_9_3) V(gp_2_10_0) V(gp_2_10_1) V(gp_2_10_2) V(gp_2_10_3) V(gp_2_11_0) V(gp_2_11_1) V(gp_2_11_2) V(gp_2_11_3) V(gp_2_12_0) V(gp_2_12_1) V(gp_2_12_2) V(gp_2_12_3) V(gp_2_13_0) V(gp_2_13_1) V(gp_2_13_2) V(gp_2_13_3) V(gp_2_14_0) V(gp_2_14_1) V(gp_2_14_2) V(gp_2_14_3) V(gp_2_15_0) V(gp_2_15_1) V(gp_2_15_2) V(gp_2_15_3) V(gp_o_0_0) V(gp_o_0_1) V(gp_o_0_2) V(gp_o_0_3) V(gp_o_1_0) V(gp_o_1_1) V(gp_o_1_2) V(gp_o_1_3) V(gp_o_2_0) V(gp_o_2_1) V(gp_o_2_2) V(gp_o_2_3)
.END
