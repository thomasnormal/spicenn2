fully-transistor current-mode EP
.model NNR NMOS (LEVEL=1 VTO=0.2  KP=120u LAMBDA=0.02 GAMMA=0 PHI=0.7)
.model PNR PMOS (LEVEL=1 VTO=-0.2 KP=40u  LAMBDA=0.02 GAMMA=0 PHI=0.7)
.subckt ota inp outp wg vdd vref
M1 d1 inp tl 0 NNR W=200u L=100u
M2 outp vref tl 0 NNR W=200u L=100u
Mt tl wg 0 0 NNR W=200u L=100u
M3 d1 d1 vdd vdd PNR W=500u L=100u
M4 outp d1 vdd vdd PNR W=500u L=100u
.ends
.subckt neuron u a ac vdd vref vbn
M1 ac u  tn 0 NNR W=200u L=100u
M2 a  vref tn 0 NNR W=200u L=100u
Mt tn vbn 0 0 NNR W=200u L=100u
RL1 vdd ac 800k
RL2 vdd a  800k
.ends

Vdd vdd 0 1.0
Vref vref 0 0.5
Vbn vbn 0 0.30
Vmid nmid 0 0.5
Vt vt 0 0.5
Vhi vhi 0 0.8
Vlo vlo 0 0.2
Va_x1 a_x1 0 0.5
Vac_x1 ac_x1 0 0.5
Va_x2 a_x2 0 0.5
Vac_x2 ac_x2 0 0.5
Rlk_h1 u_h1 nmid 3k
Xn_h1 u_h1 a_h1 ac_h1 vdd vref vbn neuron
Vgp_i11 gp_i11 0 0.6386
Vgn_i11 gn_i11 0 0.2500
Xp_i11 a_x1 u_h1 gp_i11 vdd vref ota
Xn_i11 ac_x1 u_h1 gn_i11 vdd vref ota
Vgp_i21 gp_i21 0 0.2500
Vgn_i21 gn_i21 0 0.6386
Xp_i21 a_x2 u_h1 gp_i21 vdd vref ota
Xn_i21 ac_x2 u_h1 gn_i21 vdd vref ota
Vgp_bo1 gp_bo1 0 0.2696
Vgn_bo1 gn_bo1 0 0.5304
Xp_bo1 a_o u_h1 gp_bo1 vdd vref ota
Xn_bo1 ac_o u_h1 gn_bo1 vdd vref ota
Vgp_bh1 gp_bh1 0 0.2500
Vgn_bh1 gn_bh1 0 0.6368
Xp_bh1 vhi u_h1 gp_bh1 vdd vref ota
Xn_bh1 vlo u_h1 gn_bh1 vdd vref ota
Rlk_h2 u_h2 nmid 3k
Xn_h2 u_h2 a_h2 ac_h2 vdd vref vbn neuron
Vgp_i12 gp_i12 0 0.6400
Vgn_i12 gn_i12 0 0.2500
Xp_i12 a_x1 u_h2 gp_i12 vdd vref ota
Xn_i12 ac_x1 u_h2 gn_i12 vdd vref ota
Vgp_i22 gp_i22 0 0.2500
Vgn_i22 gn_i22 0 0.6400
Xp_i22 a_x2 u_h2 gp_i22 vdd vref ota
Xn_i22 ac_x2 u_h2 gn_i22 vdd vref ota
Vgp_bo2 gp_bo2 0 0.4199
Vgn_bo2 gn_bo2 0 0.3801
Xp_bo2 a_o u_h2 gp_bo2 vdd vref ota
Xn_bo2 ac_o u_h2 gn_bo2 vdd vref ota
Vgp_bh2 gp_bh2 0 0.4054
Vgn_bh2 gn_bh2 0 0.3946
Xp_bh2 vhi u_h2 gp_bh2 vdd vref ota
Xn_bh2 vlo u_h2 gn_bh2 vdd vref ota
Rlk_h3 u_h3 nmid 3k
Xn_h3 u_h3 a_h3 ac_h3 vdd vref vbn neuron
Vgp_i13 gp_i13 0 0.6386
Vgn_i13 gn_i13 0 0.2500
Xp_i13 a_x1 u_h3 gp_i13 vdd vref ota
Xn_i13 ac_x1 u_h3 gn_i13 vdd vref ota
Vgp_i23 gp_i23 0 0.2500
Vgn_i23 gn_i23 0 0.6386
Xp_i23 a_x2 u_h3 gp_i23 vdd vref ota
Xn_i23 ac_x2 u_h3 gn_i23 vdd vref ota
Vgp_bo3 gp_bo3 0 0.2709
Vgn_bo3 gn_bo3 0 0.5291
Xp_bo3 a_o u_h3 gp_bo3 vdd vref ota
Xn_bo3 ac_o u_h3 gn_bo3 vdd vref ota
Vgp_bh3 gp_bh3 0 0.2500
Vgn_bh3 gn_bh3 0 0.6370
Xp_bh3 vhi u_h3 gp_bh3 vdd vref ota
Xn_bh3 vlo u_h3 gn_bh3 vdd vref ota
Rlk_h4 u_h4 nmid 3k
Xn_h4 u_h4 a_h4 ac_h4 vdd vref vbn neuron
Vgp_i14 gp_i14 0 0.6400
Vgn_i14 gn_i14 0 0.2500
Xp_i14 a_x1 u_h4 gp_i14 vdd vref ota
Xn_i14 ac_x1 u_h4 gn_i14 vdd vref ota
Vgp_i24 gp_i24 0 0.2500
Vgn_i24 gn_i24 0 0.6400
Xp_i24 a_x2 u_h4 gp_i24 vdd vref ota
Xn_i24 ac_x2 u_h4 gn_i24 vdd vref ota
Vgp_bo4 gp_bo4 0 0.4470
Vgn_bo4 gn_bo4 0 0.3530
Xp_bo4 a_o u_h4 gp_bo4 vdd vref ota
Xn_bo4 ac_o u_h4 gn_bo4 vdd vref ota
Vgp_bh4 gp_bh4 0 0.2500
Vgn_bh4 gn_bh4 0 0.5949
Xp_bh4 vhi u_h4 gp_bh4 vdd vref ota
Xn_bh4 vlo u_h4 gn_bh4 vdd vref ota
Rlk_h5 u_h5 nmid 3k
Xn_h5 u_h5 a_h5 ac_h5 vdd vref vbn neuron
Vgp_i15 gp_i15 0 0.6400
Vgn_i15 gn_i15 0 0.2500
Xp_i15 a_x1 u_h5 gp_i15 vdd vref ota
Xn_i15 ac_x1 u_h5 gn_i15 vdd vref ota
Vgp_i25 gp_i25 0 0.2500
Vgn_i25 gn_i25 0 0.6400
Xp_i25 a_x2 u_h5 gp_i25 vdd vref ota
Xn_i25 ac_x2 u_h5 gn_i25 vdd vref ota
Vgp_bo5 gp_bo5 0 0.4161
Vgn_bo5 gn_bo5 0 0.3839
Xp_bo5 a_o u_h5 gp_bo5 vdd vref ota
Xn_bo5 ac_o u_h5 gn_bo5 vdd vref ota
Vgp_bh5 gp_bh5 0 0.3993
Vgn_bh5 gn_bh5 0 0.4007
Xp_bh5 vhi u_h5 gp_bh5 vdd vref ota
Xn_bh5 vlo u_h5 gn_bh5 vdd vref ota
Rlk_h6 u_h6 nmid 3k
Xn_h6 u_h6 a_h6 ac_h6 vdd vref vbn neuron
Vgp_i16 gp_i16 0 0.6400
Vgn_i16 gn_i16 0 0.2500
Xp_i16 a_x1 u_h6 gp_i16 vdd vref ota
Xn_i16 ac_x1 u_h6 gn_i16 vdd vref ota
Vgp_i26 gp_i26 0 0.2500
Vgn_i26 gn_i26 0 0.6400
Xp_i26 a_x2 u_h6 gp_i26 vdd vref ota
Xn_i26 ac_x2 u_h6 gn_i26 vdd vref ota
Vgp_bo6 gp_bo6 0 0.4161
Vgn_bo6 gn_bo6 0 0.3839
Xp_bo6 a_o u_h6 gp_bo6 vdd vref ota
Xn_bo6 ac_o u_h6 gn_bo6 vdd vref ota
Vgp_bh6 gp_bh6 0 0.3993
Vgn_bh6 gn_bh6 0 0.4007
Xp_bh6 vhi u_h6 gp_bh6 vdd vref ota
Xn_bh6 vlo u_h6 gn_bh6 vdd vref ota
Rlk_o u_o nmid 3k
Xn_o u_o a_o ac_o vdd vref vbn neuron
Vgp_fo1 gp_fo1 0 0.2696
Vgn_fo1 gn_fo1 0 0.5304
Xp_fo1 a_h1 u_o gp_fo1 vdd vref ota
Xn_fo1 ac_h1 u_o gn_fo1 vdd vref ota
Vgp_fo2 gp_fo2 0 0.4199
Vgn_fo2 gn_fo2 0 0.3801
Xp_fo2 a_h2 u_o gp_fo2 vdd vref ota
Xn_fo2 ac_h2 u_o gn_fo2 vdd vref ota
Vgp_fo3 gp_fo3 0 0.2709
Vgn_fo3 gn_fo3 0 0.5291
Xp_fo3 a_h3 u_o gp_fo3 vdd vref ota
Xn_fo3 ac_h3 u_o gn_fo3 vdd vref ota
Vgp_fo4 gp_fo4 0 0.4470
Vgn_fo4 gn_fo4 0 0.3530
Xp_fo4 a_h4 u_o gp_fo4 vdd vref ota
Xn_fo4 ac_h4 u_o gn_fo4 vdd vref ota
Vgp_fo5 gp_fo5 0 0.4161
Vgn_fo5 gn_fo5 0 0.3839
Xp_fo5 a_h5 u_o gp_fo5 vdd vref ota
Xn_fo5 ac_h5 u_o gn_fo5 vdd vref ota
Vgp_fo6 gp_fo6 0 0.4161
Vgn_fo6 gn_fo6 0 0.3839
Xp_fo6 a_h6 u_o gp_fo6 vdd vref ota
Xn_fo6 ac_h6 u_o gn_fo6 vdd vref ota
Vgp_bo_ gp_bo_ 0 0.5237
Vgn_bo_ gn_bo_ 0 0.2763
Xp_bo_ vhi u_o gp_bo_ vdd vref ota
Xn_bo_ vlo u_o gn_bo_ vdd vref ota
Rb u_o vt 1e10
.control
alter Va_x1 0.2
alter Vac_x1 0.8
alter Va_x2 0.2
alter Vac_x2 0.8
alter Rb 1e10
op
wrdata tf0.dat v(a_h1) v(a_h2) v(a_h3) v(a_h4) v(a_h5) v(a_h6) v(u_o) v(a_o)
alter Vt 0.43
alter Rb 30000.0
op
wrdata tn0.dat v(a_h1) v(a_h2) v(a_h3) v(a_h4) v(a_h5) v(a_h6) v(u_o) v(a_o)
alter Va_x1 0.2
alter Vac_x1 0.8
alter Va_x2 0.8
alter Vac_x2 0.2
alter Rb 1e10
op
wrdata tf1.dat v(a_h1) v(a_h2) v(a_h3) v(a_h4) v(a_h5) v(a_h6) v(u_o) v(a_o)
alter Vt 0.57
alter Rb 30000.0
op
wrdata tn1.dat v(a_h1) v(a_h2) v(a_h3) v(a_h4) v(a_h5) v(a_h6) v(u_o) v(a_o)
alter Va_x1 0.8
alter Vac_x1 0.2
alter Va_x2 0.2
alter Vac_x2 0.8
alter Rb 1e10
op
wrdata tf2.dat v(a_h1) v(a_h2) v(a_h3) v(a_h4) v(a_h5) v(a_h6) v(u_o) v(a_o)
alter Vt 0.57
alter Rb 30000.0
op
wrdata tn2.dat v(a_h1) v(a_h2) v(a_h3) v(a_h4) v(a_h5) v(a_h6) v(u_o) v(a_o)
alter Va_x1 0.8
alter Vac_x1 0.2
alter Va_x2 0.8
alter Vac_x2 0.2
alter Rb 1e10
op
wrdata tf3.dat v(a_h1) v(a_h2) v(a_h3) v(a_h4) v(a_h5) v(a_h6) v(u_o) v(a_o)
alter Vt 0.43
alter Rb 30000.0
op
wrdata tn3.dat v(a_h1) v(a_h2) v(a_h3) v(a_h4) v(a_h5) v(a_h6) v(u_o) v(a_o)
.endc
.end
