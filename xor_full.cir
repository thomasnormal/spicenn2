* XOR fully-transistor trainer (parameterized)
.model NSYN NMOS (LEVEL=1 VTO=0.2 KP=50u  LAMBDA=0    GAMMA=0 PHI=0.7)
.model NMIR NMOS (LEVEL=1 VTO=0.5 KP=120u LAMBDA=0.02 GAMMA=0 PHI=0.7)
.model PMIR PMOS (LEVEL=1 VTO=-0.5 KP=40u LAMBDA=0.02 GAMMA=0 PHI=0.7)
.model NREL NMOS (LEVEL=1 VTO=0.5 KP=120u LAMBDA=0.02 GAMMA=0 PHI=0.7)
.param Cg=0.0005 Ke=0.3 Vd0=1.2 VG0=0.7 VC=1.8 bb=0.05
Vvdd vdd 0 3
Vrefh vrefh 0 0.5
Vrefo vrefo 0 0.5
Vg0 vg0 0 0.7
Vvc vcn 0 1.8
Vvmid vmid 0 0.5
Vvtb vtb 0 1.4
Va1 a1 0 PWL(0.0000 0.7000 0.1980 0.7000 0.3000 0.7000 0.4980 0.7000 0.6000 1.3000 0.7980 1.3000 0.9000 1.3000 1.0980 1.3000 1.2000 0.7000 1.3980 0.7000 1.5000 0.7000 1.6980 0.7000 1.8000 1.3000 1.9980 1.3000 2.1000 1.3000 2.2980 1.3000 2.4000 0.7000 2.5980 0.7000 2.7000 0.7000 2.8980 0.7000 3.0000 1.3000 3.1980 1.3000 3.3000 1.3000 3.4980 1.3000 3.6000 0.7000 3.7980 0.7000 3.9000 0.7000 4.0980 0.7000 4.2000 1.3000 4.3980 1.3000 4.5000 1.3000 4.6980 1.3000 4.8000 0.7000 4.9980 0.7000 5.1000 0.7000 5.2980 0.7000 5.4000 1.3000 5.5980 1.3000 5.7000 1.3000 5.8980 1.3000 6.0000 0.7000 6.1980 0.7000 6.3000 0.7000 6.4980 0.7000 6.6000 1.3000 6.7980 1.3000 6.9000 1.3000 7.0980 1.3000 7.2000 0.7000 7.3980 0.7000 7.5000 0.7000 7.6980 0.7000 7.8000 1.3000 7.9980 1.3000 8.1000 1.3000 8.2980 1.3000 8.4000 0.7000 8.5980 0.7000 8.7000 0.7000 8.8980 0.7000 9.0000 1.3000 9.1980 1.3000 9.3000 1.3000 9.4980 1.3000 9.6000 0.7000 9.7980 0.7000 9.9000 0.7000 10.0980 0.7000 10.2000 1.3000 10.3980 1.3000 10.5000 1.3000 10.6980 1.3000 10.8000 0.7000 10.9980 0.7000 11.1000 0.7000 11.2980 0.7000 11.4000 1.3000 11.5980 1.3000 11.7000 1.3000 11.8980 1.3000 12.0000 0.7000 12.1980 0.7000 12.3000 0.7000 12.4980 0.7000 12.6000 1.3000 12.7980 1.3000 12.9000 1.3000 13.0980 1.3000 13.2000 0.7000 13.3980 0.7000 13.5000 0.7000 13.6980 0.7000 13.8000 1.3000 13.9980 1.3000 14.1000 1.3000 14.2980 1.3000 14.4000 0.7000 14.5980 0.7000 14.7000 0.7000 14.8980 0.7000 15.0000 1.3000 15.1980 1.3000 15.3000 1.3000 15.4980 1.3000 15.6000 0.7000 15.7980 0.7000 15.9000 0.7000 16.0980 0.7000 16.2000 1.3000 16.3980 1.3000 16.5000 1.3000 16.6980 1.3000 16.8000 0.7000 16.9980 0.7000 17.1000 0.7000 17.2980 0.7000 17.4000 1.3000 17.5980 1.3000 17.7000 1.3000 17.8980 1.3000 18.0000 0.7000 18.1980 0.7000 18.3000 0.7000 18.4980 0.7000 18.6000 1.3000 18.7980 1.3000 18.9000 1.3000 19.0980 1.3000 19.2000 0.7000 19.3980 0.7000 19.5000 0.7000 19.6980 0.7000 19.8000 1.3000 19.9980 1.3000 20.1000 1.3000 20.2980 1.3000 20.4000 0.7000 20.5980 0.7000 20.7000 0.7000 20.8980 0.7000 21.0000 1.3000 21.1980 1.3000 21.3000 1.3000 21.4980 1.3000 21.6000 0.7000 21.7980 0.7000 21.9000 0.7000 22.0980 0.7000 22.2000 1.3000 22.3980 1.3000 22.5000 1.3000 22.6980 1.3000 22.8000 0.7000 22.9980 0.7000 23.1000 0.7000 23.2980 0.7000 23.4000 1.3000 23.5980 1.3000 23.7000 1.3000 23.8980 1.3000 24.0000 0.7000 24.1980 0.7000 24.3000 0.7000 24.4980 0.7000 24.6000 1.3000 24.7980 1.3000 24.9000 1.3000 25.0980 1.3000 25.2000 0.7000 25.3980 0.7000 25.5000 0.7000 25.6980 0.7000 25.8000 1.3000 25.9980 1.3000 26.1000 1.3000 26.2980 1.3000 26.4000 0.7000 26.5980 0.7000 26.7000 0.7000 26.8980 0.7000 27.0000 1.3000 27.1980 1.3000 27.3000 1.3000 27.4980 1.3000 27.6000 0.7000 27.7980 0.7000 27.9000 0.7000 28.0980 0.7000 28.2000 1.3000 28.3980 1.3000 28.5000 1.3000 28.6980 1.3000 28.8000 0.7000 28.9980 0.7000 29.1000 0.7000 29.2980 0.7000 29.4000 1.3000 29.5980 1.3000 29.7000 1.3000 29.8980 1.3000 30.0000 0.7000 30.1980 0.7000 30.3000 0.7000 30.4980 0.7000 30.6000 1.3000 30.7980 1.3000 30.9000 1.3000 31.0980 1.3000 31.2000 0.7000 31.3980 0.7000 31.5000 0.7000 31.6980 0.7000 31.8000 1.3000 31.9980 1.3000 32.1000 1.3000 32.2980 1.3000 32.4000 0.7000 32.5980 0.7000 32.7000 0.7000 32.8980 0.7000 33.0000 1.3000 33.1980 1.3000 33.3000 1.3000 33.4980 1.3000 33.6000 0.7000 33.7980 0.7000 33.9000 0.7000 34.0980 0.7000 34.2000 1.3000 34.3980 1.3000 34.5000 1.3000 34.6980 1.3000 34.8000 0.7000 34.9980 0.7000 35.1000 0.7000 35.2980 0.7000 35.4000 1.3000 35.5980 1.3000 35.7000 1.3000 35.8980 1.3000 36.0000 0.7000 36.1980 0.7000 36.3000 0.7000 36.4980 0.7000 36.6000 1.3000 36.7980 1.3000 36.9000 1.3000 37.0980 1.3000 37.2000 0.7000 37.3980 0.7000 37.5000 0.7000 37.6980 0.7000 37.8000 1.3000 37.9980 1.3000 38.1000 1.3000 38.2980 1.3000 38.4000 0.7000 38.5980 0.7000 38.7000 0.7000 38.8980 0.7000 39.0000 1.3000 39.1980 1.3000 39.3000 1.3000 39.4980 1.3000 39.6000 0.7000 39.7980 0.7000 39.9000 0.7000 40.0980 0.7000 40.2000 1.3000 40.3980 1.3000 40.5000 1.3000 40.6980 1.3000 40.8000 0.7000 40.9980 0.7000 41.1000 0.7000 41.2980 0.7000 41.4000 1.3000 41.5980 1.3000 41.7000 1.3000 41.8980 1.3000 42.0000 0.7000 42.1980 0.7000 42.3000 0.7000 42.4980 0.7000 42.6000 1.3000 42.7980 1.3000 42.9000 1.3000 43.0980 1.3000 43.2000 0.7000 43.3980 0.7000 43.5000 0.7000 43.6980 0.7000 43.8000 1.3000 43.9980 1.3000 44.1000 1.3000 44.2980 1.3000 44.4000 0.7000 44.5980 0.7000 44.7000 0.7000 44.8980 0.7000 45.0000 1.3000 45.1980 1.3000 45.3000 1.3000 45.4980 1.3000 45.6000 0.7000 45.7980 0.7000 45.9000 0.7000 46.0980 0.7000 46.2000 1.3000 46.3980 1.3000 46.5000 1.3000 46.6980 1.3000 46.8000 0.7000 46.9980 0.7000 47.1000 0.7000 47.2980 0.7000 47.4000 1.3000 47.5980 1.3000 47.7000 1.3000 47.8980 1.3000 48.0000 0.7000 48.1980 0.7000 48.3000 0.7000 48.4980 0.7000 48.6000 1.3000 48.7980 1.3000 48.9000 1.3000 49.0980 1.3000 49.2000 0.7000 49.3980 0.7000 49.5000 0.7000 49.6980 0.7000 49.8000 1.3000 49.9980 1.3000 50.1000 1.3000 50.2980 1.3000 50.4000 0.7000 50.5980 0.7000 50.7000 0.7000 50.8980 0.7000 51.0000 1.3000 51.1980 1.3000 51.3000 1.3000 51.4980 1.3000 51.6000 0.7000 51.7980 0.7000 51.9000 0.7000 52.0980 0.7000 52.2000 1.3000 52.3980 1.3000 52.5000 1.3000 52.6980 1.3000 52.8000 0.7000 52.9980 0.7000 53.1000 0.7000 53.2980 0.7000 53.4000 1.3000 53.5980 1.3000 53.7000 1.3000 53.8980 1.3000 54.0000 0.7000 54.1980 0.7000 54.3000 0.7000 54.4980 0.7000 54.6000 1.3000 54.7980 1.3000 54.9000 1.3000 55.0980 1.3000 55.2000 0.7000 55.3980 0.7000 55.5000 0.7000 55.6980 0.7000 55.8000 1.3000 55.9980 1.3000 56.1000 1.3000 56.2980 1.3000 56.4000 0.7000 56.5980 0.7000 56.7000 0.7000 56.8980 0.7000 57.0000 1.3000 57.1980 1.3000 57.3000 1.3000 57.4980 1.3000 57.6000 0.7000 57.7980 0.7000 57.9000 0.7000 58.0980 0.7000 58.2000 1.3000 58.3980 1.3000 58.5000 1.3000 58.6980 1.3000 58.8000 0.7000 58.9980 0.7000 59.1000 0.7000 59.2980 0.7000 59.4000 1.3000 59.5980 1.3000 59.7000 1.3000 59.8980 1.3000 60.0000 0.7000 60.1980 0.7000 60.3000 0.7000 60.4980 0.7000 60.6000 1.3000 60.7980 1.3000 60.9000 1.3000 61.0980 1.3000 61.2000 0.7000 61.3980 0.7000 61.5000 0.7000 61.6980 0.7000 61.8000 1.3000 61.9980 1.3000 62.1000 1.3000 62.2980 1.3000 62.4000 0.7000 62.5980 0.7000 62.7000 0.7000 62.8980 0.7000 63.0000 1.3000 63.1980 1.3000 63.3000 1.3000 63.4980 1.3000 63.6000 0.7000 63.7980 0.7000 63.9000 0.7000 64.0980 0.7000 64.2000 1.3000 64.3980 1.3000 64.5000 1.3000 64.6980 1.3000 64.8000 0.7000 64.9980 0.7000 65.1000 0.7000 65.2980 0.7000 65.4000 1.3000 65.5980 1.3000 65.7000 1.3000 65.8980 1.3000 66.0000 0.7000 66.1980 0.7000 66.3000 0.7000 66.4980 0.7000 66.6000 1.3000 66.7980 1.3000 66.9000 1.3000 67.0980 1.3000 67.2000 0.7000 67.3980 0.7000 67.5000 0.7000 67.6980 0.7000 67.8000 1.3000 67.9980 1.3000 68.1000 1.3000 68.2980 1.3000 68.4000 0.7000 68.5980 0.7000 68.7000 0.7000 68.8980 0.7000 69.0000 1.3000 69.1980 1.3000 69.3000 1.3000 69.4980 1.3000 69.6000 0.7000 69.7980 0.7000 69.9000 0.7000 70.0980 0.7000 70.2000 1.3000 70.3980 1.3000 70.5000 1.3000 70.6980 1.3000 70.8000 0.7000 70.9980 0.7000 71.1000 0.7000 71.2980 0.7000 71.4000 1.3000 71.5980 1.3000 71.7000 1.3000 71.8980 1.3000 72.0000 0.7000 72.1980 0.7000 72.3000 0.7000 72.4980 0.7000 72.6000 1.3000 72.7980 1.3000 72.9000 1.3000 73.0980 1.3000 73.2000 0.7000 73.3980 0.7000 73.5000 0.7000 73.6980 0.7000 73.8000 1.3000 73.9980 1.3000 74.1000 1.3000 74.2980 1.3000 74.4000 0.7000 74.5980 0.7000 74.7000 0.7000 74.8980 0.7000 75.0000 1.3000 75.1980 1.3000 75.3000 1.3000 75.4980 1.3000 75.6000 0.7000 75.7980 0.7000 75.9000 0.7000 76.0980 0.7000 76.2000 1.3000 76.3980 1.3000 76.5000 1.3000 76.6980 1.3000 76.8000 0.7000 76.9980 0.7000 77.1000 0.7000 77.2980 0.7000 77.4000 1.3000 77.5980 1.3000 77.7000 1.3000 77.8980 1.3000 78.0000 0.7000 78.1980 0.7000 78.3000 0.7000 78.4980 0.7000 78.6000 1.3000 78.7980 1.3000 78.9000 1.3000 79.0980 1.3000 79.2000 0.7000 79.3980 0.7000 79.5000 0.7000 79.6980 0.7000 79.8000 1.3000 79.9980 1.3000 80.1000 1.3000 80.2980 1.3000 80.4000 0.7000 80.5980 0.7000 80.7000 0.7000 80.8980 0.7000 81.0000 1.3000 81.1980 1.3000 81.3000 1.3000 81.4980 1.3000 81.6000 0.7000 81.7980 0.7000 81.9000 0.7000 82.0980 0.7000 82.2000 1.3000 82.3980 1.3000 82.5000 1.3000 82.6980 1.3000 82.8000 0.7000 82.9980 0.7000 83.1000 0.7000 83.2980 0.7000 83.4000 1.3000 83.5980 1.3000 83.7000 1.3000 83.8980 1.3000 84.0000 0.7000 84.1980 0.7000 84.3000 0.7000 84.4980 0.7000 84.6000 1.3000 84.7980 1.3000 84.9000 1.3000 85.0980 1.3000 85.2000 0.7000 85.3980 0.7000 85.5000 0.7000 85.6980 0.7000 85.8000 1.3000 85.9980 1.3000 86.1000 1.3000 86.2980 1.3000 86.4000 0.7000 86.5980 0.7000 86.7000 0.7000 86.8980 0.7000 87.0000 1.3000 87.1980 1.3000 87.3000 1.3000 87.4980 1.3000 87.6000 0.7000 87.7980 0.7000 87.9000 0.7000 88.0980 0.7000 88.2000 1.3000 88.3980 1.3000 88.5000 1.3000 88.6980 1.3000 88.8000 0.7000 88.9980 0.7000 89.1000 0.7000 89.2980 0.7000 89.4000 1.3000 89.5980 1.3000 89.7000 1.3000 89.8980 1.3000 90.0000 0.7000 90.1980 0.7000 90.3000 0.7000 90.4980 0.7000 90.6000 1.3000 90.7980 1.3000 90.9000 1.3000 91.0980 1.3000 91.2000 0.7000 91.3980 0.7000 91.5000 0.7000 91.6980 0.7000 91.8000 1.3000 91.9980 1.3000 92.1000 1.3000 92.2980 1.3000 92.4000 0.7000 92.5980 0.7000 92.7000 0.7000 92.8980 0.7000 93.0000 1.3000 93.1980 1.3000 93.3000 1.3000 93.4980 1.3000 93.6000 0.7000 93.7980 0.7000 93.9000 0.7000 94.0980 0.7000 94.2000 1.3000 94.3980 1.3000 94.5000 1.3000 94.6980 1.3000 94.8000 0.7000 94.9980 0.7000 95.1000 0.7000 95.2980 0.7000 95.4000 1.3000 95.5980 1.3000 95.7000 1.3000 95.8980 1.3000 96.0000 0.7000 96.1980 0.7000 96.3000 0.7000 96.4980 0.7000 96.6000 1.3000 96.7980 1.3000 96.9000 1.3000 97.0980 1.3000 97.2000 0.7000 97.3980 0.7000 97.5000 0.7000 97.6980 0.7000 97.8000 1.3000 97.9980 1.3000 98.1000 1.3000 98.2980 1.3000 98.4000 0.7000 98.5980 0.7000 98.7000 0.7000 98.8980 0.7000 99.0000 1.3000 99.1980 1.3000 99.3000 1.3000 99.4980 1.3000 99.6000 0.7000 99.7980 0.7000 99.9000 0.7000 100.0980 0.7000 100.2000 1.3000 100.3980 1.3000 100.5000 1.3000 100.6980 1.3000 100.8000 0.7000 100.9980 0.7000 101.1000 0.7000 101.2980 0.7000 101.4000 1.3000 101.5980 1.3000 101.7000 1.3000 101.8980 1.3000 102.0000 0.7000 102.1980 0.7000 102.3000 0.7000 102.4980 0.7000 102.6000 1.3000 102.7980 1.3000 102.9000 1.3000 103.0980 1.3000 103.2000 0.7000 103.3980 0.7000 103.5000 0.7000 103.6980 0.7000 103.8000 1.3000 103.9980 1.3000 104.1000 1.3000 104.2980 1.3000 104.4000 0.7000 104.5980 0.7000 104.7000 0.7000 104.8980 0.7000 105.0000 1.3000 105.1980 1.3000 105.3000 1.3000 105.4980 1.3000 105.6000 0.7000 105.7980 0.7000 105.9000 0.7000 106.0980 0.7000 106.2000 1.3000 106.3980 1.3000 106.5000 1.3000 106.6980 1.3000 106.8000 0.7000 106.9980 0.7000 107.1000 0.7000 107.2980 0.7000 107.4000 1.3000 107.5980 1.3000 107.7000 1.3000 107.8980 1.3000 108.0000 0.7000 108.1980 0.7000 108.3000 0.7000 108.4980 0.7000 108.6000 1.3000 108.7980 1.3000 108.9000 1.3000 109.0980 1.3000 109.2000 0.7000 109.3980 0.7000 109.5000 0.7000 109.6980 0.7000 109.8000 1.3000 109.9980 1.3000 110.1000 1.3000 110.2980 1.3000 110.4000 0.7000 110.5980 0.7000 110.7000 0.7000 110.8980 0.7000 111.0000 1.3000 111.1980 1.3000 111.3000 1.3000 111.4980 1.3000 111.6000 0.7000 111.7980 0.7000 111.9000 0.7000 112.0980 0.7000 112.2000 1.3000 112.3980 1.3000 112.5000 1.3000 112.6980 1.3000 112.8000 0.7000 112.9980 0.7000 113.1000 0.7000 113.2980 0.7000 113.4000 1.3000 113.5980 1.3000 113.7000 1.3000 113.8980 1.3000 114.0000 0.7000 114.1980 0.7000 114.3000 0.7000 114.4980 0.7000 114.6000 1.3000 114.7980 1.3000 114.9000 1.3000 115.0980 1.3000 115.2000 0.7000 115.3980 0.7000 115.5000 0.7000 115.6980 0.7000 115.8000 1.3000 115.9980 1.3000 116.1000 1.3000 116.2980 1.3000 116.4000 0.7000 116.5980 0.7000 116.7000 0.7000 116.8980 0.7000 117.0000 1.3000 117.1980 1.3000 117.3000 1.3000 117.4980 1.3000 117.6000 0.7000 117.7980 0.7000 117.9000 0.7000 118.0980 0.7000 118.2000 1.3000 118.3980 1.3000 118.5000 1.3000 118.6980 1.3000 118.8000 0.7000 118.9980 0.7000 119.1000 0.7000 119.2980 0.7000 119.4000 1.3000 119.5980 1.3000 119.7000 1.3000 119.8980 1.3000 120.0000 0.7000 120.1980 0.7000 120.3000 0.7000 120.4980 0.7000 120.6000 1.3000 120.7980 1.3000 120.9000 1.3000 121.0980 1.3000 121.2000 0.7000 121.3980 0.7000 121.5000 0.7000 121.6980 0.7000 121.8000 1.3000 121.9980 1.3000 122.1000 1.3000 122.2980 1.3000 122.4000 0.7000 122.5980 0.7000 122.7000 0.7000 122.8980 0.7000 123.0000 1.3000 123.1980 1.3000 123.3000 1.3000 123.4980 1.3000 123.6000 0.7000 123.7980 0.7000 123.9000 0.7000 124.0980 0.7000 124.2000 1.3000 124.3980 1.3000 124.5000 1.3000 124.6980 1.3000 124.8000 0.7000 124.9980 0.7000 125.1000 0.7000 125.2980 0.7000 125.4000 1.3000 125.5980 1.3000 125.7000 1.3000 125.8980 1.3000 126.0000 0.7000 126.1980 0.7000 126.3000 0.7000 126.4980 0.7000 126.6000 1.3000 126.7980 1.3000 126.9000 1.3000 127.0980 1.3000 127.2000 0.7000 127.3980 0.7000 127.5000 0.7000 127.6980 0.7000 127.8000 1.3000 127.9980 1.3000 128.1000 1.3000 128.2980 1.3000 128.4000 0.7000 128.5980 0.7000 128.7000 0.7000 128.8980 0.7000 129.0000 1.3000 129.1980 1.3000 129.3000 1.3000 129.4980 1.3000 129.6000 0.7000 129.7980 0.7000 129.9000 0.7000 130.0980 0.7000 130.2000 1.3000 130.3980 1.3000 130.5000 1.3000 130.6980 1.3000 130.8000 0.7000 130.9980 0.7000 131.1000 0.7000 131.2980 0.7000 131.4000 1.3000 131.5980 1.3000 131.7000 1.3000 131.8980 1.3000 132.0000 0.7000 132.1980 0.7000 132.3000 0.7000 132.4980 0.7000 132.6000 1.3000 132.7980 1.3000 132.9000 1.3000 133.0980 1.3000 133.2000 0.7000 133.3980 0.7000 133.5000 0.7000 133.6980 0.7000 133.8000 1.3000 133.9980 1.3000 134.1000 1.3000 134.2980 1.3000 134.4000 0.7000 134.5980 0.7000 134.7000 0.7000 134.8980 0.7000 135.0000 1.3000 135.1980 1.3000 135.3000 1.3000 135.4980 1.3000 135.6000 0.7000 135.7980 0.7000 135.9000 0.7000 136.0980 0.7000 136.2000 1.3000 136.3980 1.3000 136.5000 1.3000 136.6980 1.3000 136.8000 0.7000 136.9980 0.7000 137.1000 0.7000 137.2980 0.7000 137.4000 1.3000 137.5980 1.3000 137.7000 1.3000 137.8980 1.3000 138.0000 0.7000 138.1980 0.7000 138.3000 0.7000 138.4980 0.7000 138.6000 1.3000 138.7980 1.3000 138.9000 1.3000 139.0980 1.3000 139.2000 0.7000 139.3980 0.7000 139.5000 0.7000 139.6980 0.7000 139.8000 1.3000 139.9980 1.3000 140.1000 1.3000 140.2980 1.3000 140.4000 0.7000 140.5980 0.7000 140.7000 0.7000 140.8980 0.7000 141.0000 1.3000 141.1980 1.3000 141.3000 1.3000 141.4980 1.3000 141.6000 0.7000 141.7980 0.7000 141.9000 0.7000 142.0980 0.7000 142.2000 1.3000 142.3980 1.3000 142.5000 1.3000 142.6980 1.3000 142.8000 0.7000 142.9980 0.7000 143.1000 0.7000 143.2980 0.7000 143.4000 1.3000 143.5980 1.3000 143.7000 1.3000 143.8980 1.3000 144.0000 0.7000 144.1980 0.7000 144.3000 0.7000 144.4980 0.7000 144.6000 1.3000 144.7980 1.3000 144.9000 1.3000 145.0980 1.3000 145.2000 0.7000 145.3980 0.7000 145.5000 0.7000 145.6980 0.7000 145.8000 1.3000 145.9980 1.3000 146.1000 1.3000 146.2980 1.3000 146.4000 0.7000 146.5980 0.7000 146.7000 0.7000 146.8980 0.7000 147.0000 1.3000 147.1980 1.3000 147.3000 1.3000 147.4980 1.3000 147.6000 0.7000 147.7980 0.7000 147.9000 0.7000 148.0980 0.7000 148.2000 1.3000 148.3980 1.3000 148.5000 1.3000 148.6980 1.3000 148.8000 0.7000 148.9980 0.7000 149.1000 0.7000 149.2980 0.7000 149.4000 1.3000 149.5980 1.3000 149.7000 1.3000 149.8980 1.3000 150.0000 0.7000 150.1980 0.7000 150.3000 0.7000 150.4980 0.7000 150.6000 1.3000 150.7980 1.3000 150.9000 1.3000 151.0980 1.3000 151.2000 0.7000 151.3980 0.7000 151.5000 0.7000 151.6980 0.7000 151.8000 1.3000 151.9980 1.3000 152.1000 1.3000 152.2980 1.3000 152.4000 0.7000 152.5980 0.7000 152.7000 0.7000 152.8980 0.7000 153.0000 1.3000 153.1980 1.3000 153.3000 1.3000 153.4980 1.3000 153.6000 0.7000 153.7980 0.7000 153.9000 0.7000 154.0980 0.7000 154.2000 1.3000 154.3980 1.3000 154.5000 1.3000 154.6980 1.3000 154.8000 0.7000 154.9980 0.7000 155.1000 0.7000 155.2980 0.7000 155.4000 1.3000 155.5980 1.3000 155.7000 1.3000 155.8980 1.3000 156.0000 0.7000 156.1980 0.7000 156.3000 0.7000 156.4980 0.7000 156.6000 1.3000 156.7980 1.3000 156.9000 1.3000 157.0980 1.3000 157.2000 0.7000 157.3980 0.7000 157.5000 0.7000 157.6980 0.7000 157.8000 1.3000 157.9980 1.3000 158.1000 1.3000 158.2980 1.3000 158.4000 0.7000 158.5980 0.7000 158.7000 0.7000 158.8980 0.7000 159.0000 1.3000 159.1980 1.3000 159.3000 1.3000 159.4980 1.3000 159.6000 0.7000 159.7980 0.7000 159.9000 0.7000 160.0980 0.7000 160.2000 1.3000 160.3980 1.3000 160.5000 1.3000 160.6980 1.3000 160.8000 0.7000 160.9980 0.7000 161.1000 0.7000 161.2980 0.7000 161.4000 1.3000 161.5980 1.3000 161.7000 1.3000 161.8980 1.3000 162.0000 0.7000 162.1980 0.7000 162.3000 0.7000 162.4980 0.7000 162.6000 1.3000 162.7980 1.3000 162.9000 1.3000 163.0980 1.3000 163.2000 0.7000 163.3980 0.7000 163.5000 0.7000 163.6980 0.7000 163.8000 1.3000 163.9980 1.3000 164.1000 1.3000 164.2980 1.3000 164.4000 0.7000 164.5980 0.7000 164.7000 0.7000 164.8980 0.7000 165.0000 1.3000 165.1980 1.3000 165.3000 1.3000 165.4980 1.3000 165.6000 0.7000 165.7980 0.7000 165.9000 0.7000 166.0980 0.7000 166.2000 1.3000 166.3980 1.3000 166.5000 1.3000 166.6980 1.3000 166.8000 0.7000 166.9980 0.7000 167.1000 0.7000 167.2980 0.7000 167.4000 1.3000 167.5980 1.3000 167.7000 1.3000 167.8980 1.3000 168.0000 0.7000 168.1980 0.7000 168.3000 0.7000 168.4980 0.7000 168.6000 1.3000 168.7980 1.3000 168.9000 1.3000 169.0980 1.3000 169.2000 0.7000 169.3980 0.7000 169.5000 0.7000 169.6980 0.7000 169.8000 1.3000 169.9980 1.3000 170.1000 1.3000 170.2980 1.3000 170.4000 0.7000 170.5980 0.7000 170.7000 0.7000 170.8980 0.7000 171.0000 1.3000 171.1980 1.3000 171.3000 1.3000 171.4980 1.3000 171.6000 0.7000 171.7980 0.7000 171.9000 0.7000 172.0980 0.7000 172.2000 1.3000 172.3980 1.3000 172.5000 1.3000 172.6980 1.3000 172.8000 0.7000 172.9980 0.7000 173.1000 0.7000 173.2980 0.7000 173.4000 1.3000 173.5980 1.3000 173.7000 1.3000 173.8980 1.3000 174.0000 0.7000 174.1980 0.7000 174.3000 0.7000 174.4980 0.7000 174.6000 1.3000 174.7980 1.3000 174.9000 1.3000 175.0980 1.3000 175.2000 0.7000 175.3980 0.7000 175.5000 0.7000 175.6980 0.7000 175.8000 1.3000 175.9980 1.3000 176.1000 1.3000 176.2980 1.3000 176.4000 0.7000 176.5980 0.7000 176.7000 0.7000 176.8980 0.7000 177.0000 1.3000 177.1980 1.3000 177.3000 1.3000 177.4980 1.3000 177.6000 0.7000 177.7980 0.7000 177.9000 0.7000 178.0980 0.7000 178.2000 1.3000 178.3980 1.3000 178.5000 1.3000 178.6980 1.3000 178.8000 0.7000 178.9980 0.7000 179.1000 0.7000 179.2980 0.7000 179.4000 1.3000 179.5980 1.3000 179.7000 1.3000 179.8980 1.3000 180.0000 0.7000 180.1980 0.7000 180.3000 0.7000 180.4980 0.7000 180.6000 1.3000 180.7980 1.3000 180.9000 1.3000 181.0980 1.3000 181.2000 0.7000 181.3980 0.7000 181.5000 0.7000 181.6980 0.7000 181.8000 1.3000 181.9980 1.3000 182.1000 1.3000 182.2980 1.3000 182.4000 0.7000 182.5980 0.7000 182.7000 0.7000 182.8980 0.7000 183.0000 1.3000 183.1980 1.3000 183.3000 1.3000 183.4980 1.3000 183.6000 0.7000 183.7980 0.7000 183.9000 0.7000 184.0980 0.7000 184.2000 1.3000 184.3980 1.3000 184.5000 1.3000 184.6980 1.3000 184.8000 0.7000 184.9980 0.7000 185.1000 0.7000 185.2980 0.7000 185.4000 1.3000 185.5980 1.3000 185.7000 1.3000 185.8980 1.3000 186.0000 0.7000 186.1980 0.7000 186.3000 0.7000 186.4980 0.7000 186.6000 1.3000 186.7980 1.3000 186.9000 1.3000 187.0980 1.3000 187.2000 0.7000 187.3980 0.7000 187.5000 0.7000 187.6980 0.7000 187.8000 1.3000 187.9980 1.3000 188.1000 1.3000 188.2980 1.3000 188.4000 0.7000 188.5980 0.7000 188.7000 0.7000 188.8980 0.7000 189.0000 1.3000 189.1980 1.3000 189.3000 1.3000 189.4980 1.3000 189.6000 0.7000 189.7980 0.7000 189.9000 0.7000 190.0980 0.7000 190.2000 1.3000 190.3980 1.3000 190.5000 1.3000 190.6980 1.3000 190.8000 0.7000 190.9980 0.7000 191.1000 0.7000 191.2980 0.7000 191.4000 1.3000 191.5980 1.3000 191.7000 1.3000 191.8980 1.3000 192.0000 0.7000 192.1980 0.7000 192.3000 0.7000 192.4980 0.7000 192.6000 1.3000 192.7980 1.3000 192.9000 1.3000 193.0980 1.3000 193.2000 0.7000 193.3980 0.7000 193.5000 0.7000 193.6980 0.7000 193.8000 1.3000 193.9980 1.3000 194.1000 1.3000 194.2980 1.3000 194.4000 0.7000 194.5980 0.7000 194.7000 0.7000 194.8980 0.7000 195.0000 1.3000 195.1980 1.3000 195.3000 1.3000 195.4980 1.3000 195.6000 0.7000 195.7980 0.7000 195.9000 0.7000 196.0980 0.7000 196.2000 1.3000 196.3980 1.3000 196.5000 1.3000 196.6980 1.3000 196.8000 0.7000 196.9980 0.7000 197.1000 0.7000 197.2980 0.7000 197.4000 1.3000 197.5980 1.3000 197.7000 1.3000 197.8980 1.3000 198.0000 0.7000 198.1980 0.7000 198.3000 0.7000 198.4980 0.7000 198.6000 1.3000 198.7980 1.3000 198.9000 1.3000 199.0980 1.3000 199.2000 0.7000 199.3980 0.7000 199.5000 0.7000 199.6980 0.7000 199.8000 1.3000 199.9980 1.3000 200.1000 1.3000 200.2980 1.3000 200.4000 0.7000 200.5980 0.7000 200.7000 0.7000 200.8980 0.7000 201.0000 1.3000 201.1980 1.3000 201.3000 1.3000 201.4980 1.3000 201.6000 0.7000 201.7980 0.7000 201.9000 0.7000 202.0980 0.7000 202.2000 1.3000 202.3980 1.3000 202.5000 1.3000 202.6980 1.3000 202.8000 0.7000 202.9980 0.7000 203.1000 0.7000 203.2980 0.7000 203.4000 1.3000 203.5980 1.3000 203.7000 1.3000 203.8980 1.3000 204.0000 0.7000 204.1980 0.7000 204.3000 0.7000 204.4980 0.7000 204.6000 1.3000 204.7980 1.3000 204.9000 1.3000 205.0980 1.3000 205.2000 0.7000 205.3980 0.7000 205.5000 0.7000 205.6980 0.7000 205.8000 1.3000 205.9980 1.3000 206.1000 1.3000 206.2980 1.3000 206.4000 0.7000 206.5980 0.7000 206.7000 0.7000 206.8980 0.7000 207.0000 1.3000 207.1980 1.3000 207.3000 1.3000 207.4980 1.3000 207.6000 0.7000 207.7980 0.7000 207.9000 0.7000 208.0980 0.7000 208.2000 1.3000 208.3980 1.3000 208.5000 1.3000 208.6980 1.3000 208.8000 0.7000 208.9980 0.7000 209.1000 0.7000 209.2980 0.7000 209.4000 1.3000 209.5980 1.3000 209.7000 1.3000 209.8980 1.3000 210.0000 0.7000 210.1980 0.7000 210.3000 0.7000 210.4980 0.7000 210.6000 1.3000 210.7980 1.3000 210.9000 1.3000 211.0980 1.3000 211.2000 0.7000 211.3980 0.7000 211.5000 0.7000 211.6980 0.7000 211.8000 1.3000 211.9980 1.3000 212.1000 1.3000 212.2980 1.3000 212.4000 0.7000 212.5980 0.7000 212.7000 0.7000 212.8980 0.7000 213.0000 1.3000 213.1980 1.3000 213.3000 1.3000 213.4980 1.3000 213.6000 0.7000 213.7980 0.7000 213.9000 0.7000 214.0980 0.7000 214.2000 1.3000 214.3980 1.3000 214.5000 1.3000 214.6980 1.3000 214.8000 0.7000 214.9980 0.7000 215.1000 0.7000 215.2980 0.7000 215.4000 1.3000 215.5980 1.3000 215.7000 1.3000 215.8980 1.3000 216.0000 0.7000 216.1980 0.7000 216.3000 0.7000 216.4980 0.7000 216.6000 1.3000 216.7980 1.3000 216.9000 1.3000 217.0980 1.3000 217.2000 0.7000 217.3980 0.7000 217.5000 0.7000 217.6980 0.7000 217.8000 1.3000 217.9980 1.3000 218.1000 1.3000 218.2980 1.3000 218.4000 0.7000 218.5980 0.7000 218.7000 0.7000 218.8980 0.7000 219.0000 1.3000 219.1980 1.3000 219.3000 1.3000 219.4980 1.3000 219.6000 0.7000 219.7980 0.7000 219.9000 0.7000 220.0980 0.7000 220.2000 1.3000 220.3980 1.3000 220.5000 1.3000 220.6980 1.3000 220.8000 0.7000 220.9980 0.7000 221.1000 0.7000 221.2980 0.7000 221.4000 1.3000 221.5980 1.3000 221.7000 1.3000 221.8980 1.3000 222.0000 0.7000 222.1980 0.7000 222.3000 0.7000 222.4980 0.7000 222.6000 1.3000 222.7980 1.3000 222.9000 1.3000 223.0980 1.3000 223.2000 0.7000 223.3980 0.7000 223.5000 0.7000 223.6980 0.7000 223.8000 1.3000 223.9980 1.3000 224.1000 1.3000 224.2980 1.3000 224.4000 0.7000 224.5980 0.7000 224.7000 0.7000 224.8980 0.7000 225.0000 1.3000 225.1980 1.3000 225.3000 1.3000 225.4980 1.3000 225.6000 0.7000 225.7980 0.7000 225.9000 0.7000 226.0980 0.7000 226.2000 1.3000 226.3980 1.3000 226.5000 1.3000 226.6980 1.3000 226.8000 0.7000 226.9980 0.7000 227.1000 0.7000 227.2980 0.7000 227.4000 1.3000 227.5980 1.3000 227.7000 1.3000 227.8980 1.3000 228.0000 0.7000 228.1980 0.7000 228.3000 0.7000 228.4980 0.7000 228.6000 1.3000 228.7980 1.3000 228.9000 1.3000 229.0980 1.3000 229.2000 0.7000 229.3980 0.7000 229.5000 0.7000 229.6980 0.7000 229.8000 1.3000 229.9980 1.3000 230.1000 1.3000 230.2980 1.3000 230.4000 0.7000 230.5980 0.7000 230.7000 0.7000 230.8980 0.7000 231.0000 1.3000 231.1980 1.3000 231.3000 1.3000 231.4980 1.3000 231.6000 0.7000 231.7980 0.7000 231.9000 0.7000 232.0980 0.7000 232.2000 1.3000 232.3980 1.3000 232.5000 1.3000 232.6980 1.3000 232.8000 0.7000 232.9980 0.7000 233.1000 0.7000 233.2980 0.7000 233.4000 1.3000 233.5980 1.3000 233.7000 1.3000 233.8980 1.3000 234.0000 0.7000 234.1980 0.7000 234.3000 0.7000 234.4980 0.7000 234.6000 1.3000 234.7980 1.3000 234.9000 1.3000 235.0980 1.3000 235.2000 0.7000 235.3980 0.7000 235.5000 0.7000 235.6980 0.7000 235.8000 1.3000 235.9980 1.3000 236.1000 1.3000 236.2980 1.3000 236.4000 0.7000 236.5980 0.7000 236.7000 0.7000 236.8980 0.7000 237.0000 1.3000 237.1980 1.3000 237.3000 1.3000 237.4980 1.3000 237.6000 0.7000 237.7980 0.7000 237.9000 0.7000 238.0980 0.7000 238.2000 1.3000 238.3980 1.3000 238.5000 1.3000 238.6980 1.3000 238.8000 0.7000 238.9980 0.7000 239.1000 0.7000 239.2980 0.7000 239.4000 1.3000 239.5980 1.3000 239.7000 1.3000 239.8980 1.3000 240.0000 0.7000 240.1980 0.7000 240.3000 0.7000 240.4980 0.7000 240.6000 1.3000 240.7980 1.3000 240.9000 1.3000 241.0980 1.3000 241.2000 0.7000 241.3980 0.7000 241.5000 0.7000 241.6980 0.7000 241.8000 1.3000 241.9980 1.3000 242.1000 1.3000 242.2980 1.3000 242.4000 0.7000 242.5980 0.7000 242.7000 0.7000 242.8980 0.7000 243.0000 1.3000 243.1980 1.3000 243.3000 1.3000 243.4980 1.3000 243.6000 0.7000 243.7980 0.7000 243.9000 0.7000 244.0980 0.7000 244.2000 1.3000 244.3980 1.3000 244.5000 1.3000 244.6980 1.3000 244.8000 0.7000 244.9980 0.7000 245.1000 0.7000 245.2980 0.7000 245.4000 1.3000 245.5980 1.3000 245.7000 1.3000 245.8980 1.3000 246.0000 0.7000 246.1980 0.7000 246.3000 0.7000 246.4980 0.7000 246.6000 1.3000 246.7980 1.3000 246.9000 1.3000 247.0980 1.3000 247.2000 0.7000 247.3980 0.7000 247.5000 0.7000 247.6980 0.7000 247.8000 1.3000 247.9980 1.3000 248.1000 1.3000 248.2980 1.3000 248.4000 0.7000 248.5980 0.7000 248.7000 0.7000 248.8980 0.7000 249.0000 1.3000 249.1980 1.3000 249.3000 1.3000 249.4980 1.3000 249.6000 0.7000 249.7980 0.7000 249.9000 0.7000 250.0980 0.7000 250.2000 1.3000 250.3980 1.3000 250.5000 1.3000 250.6980 1.3000 250.8000 0.7000 250.9980 0.7000 251.1000 0.7000 251.2980 0.7000 251.4000 1.3000 251.5980 1.3000 251.7000 1.3000 251.8980 1.3000 252.0000 0.7000 252.1980 0.7000 252.3000 0.7000 252.4980 0.7000 252.6000 1.3000 252.7980 1.3000 252.9000 1.3000 253.0980 1.3000 253.2000 0.7000 253.3980 0.7000 253.5000 0.7000 253.6980 0.7000 253.8000 1.3000 253.9980 1.3000 254.1000 1.3000 254.2980 1.3000 254.4000 0.7000 254.5980 0.7000 254.7000 0.7000 254.8980 0.7000 255.0000 1.3000 255.1980 1.3000 255.3000 1.3000 255.4980 1.3000 255.6000 0.7000 255.7980 0.7000 255.9000 0.7000 256.0980 0.7000 256.2000 1.3000 256.3980 1.3000 256.5000 1.3000 256.6980 1.3000 256.8000 0.7000 256.9980 0.7000 257.1000 0.7000 257.2980 0.7000 257.4000 1.3000 257.5980 1.3000 257.7000 1.3000 257.8980 1.3000 258.0000 0.7000 258.1980 0.7000 258.3000 0.7000 258.4980 0.7000 258.6000 1.3000 258.7980 1.3000 258.9000 1.3000 259.0980 1.3000 259.2000 0.7000 259.3980 0.7000 259.5000 0.7000 259.6980 0.7000 259.8000 1.3000 259.9980 1.3000 260.1000 1.3000 260.2980 1.3000 260.4000 0.7000 260.5980 0.7000 260.7000 0.7000 260.8980 0.7000 261.0000 1.3000 261.1980 1.3000 261.3000 1.3000 261.4980 1.3000 261.6000 0.7000 261.7980 0.7000 261.9000 0.7000 262.0980 0.7000 262.2000 1.3000 262.3980 1.3000 262.5000 1.3000 262.6980 1.3000 262.8000 0.7000 262.9980 0.7000 263.1000 0.7000 263.2980 0.7000 263.4000 1.3000 263.5980 1.3000 263.7000 1.3000 263.8980 1.3000 264.0000 0.7000 264.1980 0.7000 264.3000 0.7000 264.4980 0.7000 264.6000 1.3000 264.7980 1.3000 264.9000 1.3000 265.0980 1.3000 265.2000 0.7000 265.3980 0.7000 265.5000 0.7000 265.6980 0.7000 265.8000 1.3000 265.9980 1.3000 266.1000 1.3000 266.2980 1.3000 266.4000 0.7000 266.5980 0.7000 266.7000 0.7000 266.8980 0.7000 267.0000 1.3000 267.1980 1.3000 267.3000 1.3000 267.4980 1.3000 267.6000 0.7000 267.7980 0.7000 267.9000 0.7000 268.0980 0.7000 268.2000 1.3000 268.3980 1.3000 268.5000 1.3000 268.6980 1.3000 268.8000 0.7000 268.9980 0.7000 269.1000 0.7000 269.2980 0.7000 269.4000 1.3000 269.5980 1.3000 269.7000 1.3000 269.8980 1.3000 270.0000 0.7000 270.1980 0.7000 270.3000 0.7000 270.4980 0.7000 270.6000 1.3000 270.7980 1.3000 270.9000 1.3000 271.0980 1.3000 271.2000 0.7000 271.3980 0.7000 271.5000 0.7000 271.6980 0.7000 271.8000 1.3000 271.9980 1.3000 272.1000 1.3000 272.2980 1.3000 272.4000 0.7000 272.5980 0.7000 272.7000 0.7000 272.8980 0.7000 273.0000 1.3000 273.1980 1.3000 273.3000 1.3000 273.4980 1.3000 273.6000 0.7000 273.7980 0.7000 273.9000 0.7000 274.0980 0.7000 274.2000 1.3000 274.3980 1.3000 274.5000 1.3000 274.6980 1.3000 274.8000 0.7000 274.9980 0.7000 275.1000 0.7000 275.2980 0.7000 275.4000 1.3000 275.5980 1.3000 275.7000 1.3000 275.8980 1.3000 276.0000 0.7000 276.1980 0.7000 276.3000 0.7000 276.4980 0.7000 276.6000 1.3000 276.7980 1.3000 276.9000 1.3000 277.0980 1.3000 277.2000 0.7000 277.3980 0.7000 277.5000 0.7000 277.6980 0.7000 277.8000 1.3000 277.9980 1.3000 278.1000 1.3000 278.2980 1.3000 278.4000 0.7000 278.5980 0.7000 278.7000 0.7000 278.8980 0.7000 279.0000 1.3000 279.1980 1.3000 279.3000 1.3000 279.4980 1.3000 279.6000 0.7000 279.7980 0.7000 279.9000 0.7000 280.0980 0.7000 280.2000 1.3000 280.3980 1.3000 280.5000 1.3000 280.6980 1.3000 280.8000 0.7000 280.9980 0.7000 281.1000 0.7000 281.2980 0.7000 281.4000 1.3000 281.5980 1.3000 281.7000 1.3000 281.8980 1.3000 282.0000 0.7000 282.1980 0.7000 282.3000 0.7000 282.4980 0.7000 282.6000 1.3000 282.7980 1.3000 282.9000 1.3000 283.0980 1.3000 283.2000 0.7000 283.3980 0.7000 283.5000 0.7000 283.6980 0.7000 283.8000 1.3000 283.9980 1.3000 284.1000 1.3000 284.2980 1.3000 284.4000 0.7000 284.5980 0.7000 284.7000 0.7000 284.8980 0.7000 285.0000 1.3000 285.1980 1.3000 285.3000 1.3000 285.4980 1.3000 285.6000 0.7000 285.7980 0.7000 285.9000 0.7000 286.0980 0.7000 286.2000 1.3000 286.3980 1.3000 286.5000 1.3000 286.6980 1.3000 286.8000 0.7000 286.9980 0.7000 287.1000 0.7000 287.2980 0.7000 287.4000 1.3000 287.5980 1.3000 287.7000 1.3000 287.8980 1.3000 288.0000 0.7000 288.1980 0.7000 288.3000 0.7000 288.4980 0.7000 288.6000 1.3000 288.7980 1.3000 288.9000 1.3000 289.0980 1.3000 289.2000 0.7000 289.3980 0.7000 289.5000 0.7000 289.6980 0.7000 289.8000 1.3000 289.9980 1.3000 290.1000 1.3000 290.2980 1.3000 290.4000 0.7000 290.5980 0.7000 290.7000 0.7000 290.8980 0.7000 291.0000 1.3000 291.1980 1.3000 291.3000 1.3000 291.4980 1.3000 291.6000 0.7000 291.7980 0.7000 291.9000 0.7000 292.0980 0.7000 292.2000 1.3000 292.3980 1.3000 292.5000 1.3000 292.6980 1.3000 292.8000 0.7000 292.9980 0.7000 293.1000 0.7000 293.2980 0.7000 293.4000 1.3000 293.5980 1.3000 293.7000 1.3000 293.8980 1.3000 294.0000 0.7000 294.1980 0.7000 294.3000 0.7000 294.4980 0.7000 294.6000 1.3000 294.7980 1.3000 294.9000 1.3000 295.0980 1.3000 295.2000 0.7000 295.3980 0.7000 295.5000 0.7000 295.6980 0.7000 295.8000 1.3000 295.9980 1.3000 296.1000 1.3000 296.2980 1.3000 296.4000 0.7000 296.5980 0.7000 296.7000 0.7000 296.8980 0.7000 297.0000 1.3000 297.1980 1.3000 297.3000 1.3000 297.4980 1.3000 297.6000 0.7000 297.7980 0.7000 297.9000 0.7000 298.0980 0.7000 298.2000 1.3000 298.3980 1.3000 298.5000 1.3000 298.6980 1.3000 298.8000 0.7000 298.9980 0.7000 299.1000 0.7000 299.2980 0.7000 299.4000 1.3000 299.5980 1.3000 299.7000 1.3000 299.8980 1.3000 300.0000 0.7000 300.1980 0.7000 300.3000 0.7000 300.4980 0.7000 300.6000 1.3000 300.7980 1.3000 300.9000 1.3000 301.0980 1.3000 301.2000 0.7000 301.3980 0.7000 301.5000 0.7000 301.6980 0.7000 301.8000 1.3000 301.9980 1.3000 302.1000 1.3000 302.2980 1.3000 302.4000 0.7000 302.5980 0.7000 302.7000 0.7000 302.8980 0.7000 303.0000 1.3000 303.1980 1.3000 303.3000 1.3000 303.4980 1.3000 303.6000 0.7000 303.7980 0.7000 303.9000 0.7000 304.0980 0.7000 304.2000 1.3000 304.3980 1.3000 304.5000 1.3000 304.6980 1.3000 304.8000 0.7000 304.9980 0.7000 305.1000 0.7000 305.2980 0.7000 305.4000 1.3000 305.5980 1.3000 305.7000 1.3000 305.8980 1.3000 306.0000 0.7000 306.1980 0.7000 306.3000 0.7000 306.4980 0.7000 306.6000 1.3000 306.7980 1.3000 306.9000 1.3000 307.0980 1.3000 307.2000 0.7000 307.3980 0.7000 307.5000 0.7000 307.6980 0.7000 307.8000 1.3000 307.9980 1.3000 308.1000 1.3000 308.2980 1.3000 308.4000 0.7000 308.5980 0.7000 308.7000 0.7000 308.8980 0.7000 309.0000 1.3000 309.1980 1.3000 309.3000 1.3000 309.4980 1.3000 309.6000 0.7000 309.7980 0.7000 309.9000 0.7000 310.0980 0.7000 310.2000 1.3000 310.3980 1.3000 310.5000 1.3000 310.6980 1.3000 310.8000 0.7000 310.9980 0.7000 311.1000 0.7000 311.2980 0.7000 311.4000 1.3000 311.5980 1.3000 311.7000 1.3000 311.8980 1.3000 312.0000 0.7000 312.1980 0.7000 312.3000 0.7000 312.4980 0.7000 312.6000 1.3000 312.7980 1.3000 312.9000 1.3000 313.0980 1.3000 313.2000 0.7000 313.3980 0.7000 313.5000 0.7000 313.6980 0.7000 313.8000 1.3000 313.9980 1.3000 314.1000 1.3000 314.2980 1.3000 314.4000 0.7000 314.5980 0.7000 314.7000 0.7000 314.8980 0.7000 315.0000 1.3000 315.1980 1.3000 315.3000 1.3000 315.4980 1.3000 315.6000 0.7000 315.7980 0.7000 315.9000 0.7000 316.0980 0.7000 316.2000 1.3000 316.3980 1.3000 316.5000 1.3000 316.6980 1.3000 316.8000 0.7000 316.9980 0.7000 317.1000 0.7000 317.2980 0.7000 317.4000 1.3000 317.5980 1.3000 317.7000 1.3000 317.8980 1.3000 318.0000 0.7000 318.1980 0.7000 318.3000 0.7000 318.4980 0.7000 318.6000 1.3000 318.7980 1.3000 318.9000 1.3000 319.0980 1.3000 319.2000 0.7000 319.3980 0.7000 319.5000 0.7000 319.6980 0.7000 319.8000 1.3000 319.9980 1.3000 320.1000 1.3000 320.2980 1.3000 320.4000 0.7000 320.5980 0.7000 320.7000 0.7000 320.8980 0.7000 321.0000 1.3000 321.1980 1.3000 321.3000 1.3000 321.4980 1.3000 321.6000 0.7000 321.7980 0.7000 321.9000 0.7000 322.0980 0.7000 322.2000 1.3000 322.3980 1.3000 322.5000 1.3000 322.6980 1.3000 322.8000 0.7000 322.9980 0.7000 323.1000 0.7000 323.2980 0.7000 323.4000 1.3000 323.5980 1.3000 323.7000 1.3000 323.8980 1.3000 324.0000 0.7000 324.1980 0.7000 324.3000 0.7000 324.4980 0.7000 324.6000 1.3000 324.7980 1.3000 324.9000 1.3000 325.0980 1.3000 325.2000 0.7000 325.3980 0.7000 325.5000 0.7000 325.6980 0.7000 325.8000 1.3000 325.9980 1.3000 326.1000 1.3000 326.2980 1.3000 326.4000 0.7000 326.5980 0.7000 326.7000 0.7000 326.8980 0.7000 327.0000 1.3000 327.1980 1.3000 327.3000 1.3000 327.4980 1.3000 327.6000 0.7000 327.7980 0.7000 327.9000 0.7000 328.0980 0.7000 328.2000 1.3000 328.3980 1.3000 328.5000 1.3000 328.6980 1.3000 328.8000 0.7000 328.9980 0.7000 329.1000 0.7000 329.2980 0.7000 329.4000 1.3000 329.5980 1.3000 329.7000 1.3000 329.8980 1.3000 330.0000 0.7000 330.1980 0.7000 330.3000 0.7000 330.4980 0.7000 330.6000 1.3000 330.7980 1.3000 330.9000 1.3000 331.0980 1.3000 331.2000 0.7000 331.3980 0.7000 331.5000 0.7000 331.6980 0.7000 331.8000 1.3000 331.9980 1.3000 332.1000 1.3000 332.2980 1.3000 332.4000 0.7000 332.5980 0.7000 332.7000 0.7000 332.8980 0.7000 333.0000 1.3000 333.1980 1.3000 333.3000 1.3000 333.4980 1.3000 333.6000 0.7000 333.7980 0.7000 333.9000 0.7000 334.0980 0.7000 334.2000 1.3000 334.3980 1.3000 334.5000 1.3000 334.6980 1.3000 334.8000 0.7000 334.9980 0.7000 335.1000 0.7000 335.2980 0.7000 335.4000 1.3000 335.5980 1.3000 335.7000 1.3000 335.8980 1.3000 336.0000 0.7000 336.1980 0.7000 336.3000 0.7000 336.4980 0.7000 336.6000 1.3000 336.7980 1.3000 336.9000 1.3000 337.0980 1.3000 337.2000 0.7000 337.3980 0.7000 337.5000 0.7000 337.6980 0.7000 337.8000 1.3000 337.9980 1.3000 338.1000 1.3000 338.2980 1.3000 338.4000 0.7000 338.5980 0.7000 338.7000 0.7000 338.8980 0.7000 339.0000 1.3000 339.1980 1.3000 339.3000 1.3000 339.4980 1.3000 339.6000 0.7000 339.7980 0.7000 339.9000 0.7000 340.0980 0.7000 340.2000 1.3000 340.3980 1.3000 340.5000 1.3000 340.6980 1.3000 340.8000 0.7000 340.9980 0.7000 341.1000 0.7000 341.2980 0.7000 341.4000 1.3000 341.5980 1.3000 341.7000 1.3000 341.8980 1.3000 342.0000 0.7000 342.1980 0.7000 342.3000 0.7000 342.4980 0.7000 342.6000 1.3000 342.7980 1.3000 342.9000 1.3000 343.0980 1.3000 343.2000 0.7000 343.3980 0.7000 343.5000 0.7000 343.6980 0.7000 343.8000 1.3000 343.9980 1.3000 344.1000 1.3000 344.2980 1.3000 344.4000 0.7000 344.5980 0.7000 344.7000 0.7000 344.8980 0.7000 345.0000 1.3000 345.1980 1.3000 345.3000 1.3000 345.4980 1.3000 345.6000 0.7000 345.7980 0.7000 345.9000 0.7000 346.0980 0.7000 346.2000 1.3000 346.3980 1.3000 346.5000 1.3000 346.6980 1.3000 346.8000 0.7000 346.9980 0.7000 347.1000 0.7000 347.2980 0.7000 347.4000 1.3000 347.5980 1.3000 347.7000 1.3000 347.8980 1.3000 348.0000 0.7000 348.1980 0.7000 348.3000 0.7000 348.4980 0.7000 348.6000 1.3000 348.7980 1.3000 348.9000 1.3000 349.0980 1.3000 349.2000 0.7000 349.3980 0.7000 349.5000 0.7000 349.6980 0.7000 349.8000 1.3000 349.9980 1.3000 350.1000 1.3000 350.2980 1.3000 350.4000 0.7000 350.5980 0.7000 350.7000 0.7000 350.8980 0.7000 351.0000 1.3000 351.1980 1.3000 351.3000 1.3000 351.4980 1.3000 351.6000 0.7000 351.7980 0.7000 351.9000 0.7000 352.0980 0.7000 352.2000 1.3000 352.3980 1.3000 352.5000 1.3000 352.6980 1.3000 352.8000 0.7000 352.9980 0.7000 353.1000 0.7000 353.2980 0.7000 353.4000 1.3000 353.5980 1.3000 353.7000 1.3000 353.8980 1.3000 354.0000 0.7000 354.1980 0.7000 354.3000 0.7000 354.4980 0.7000 354.6000 1.3000 354.7980 1.3000 354.9000 1.3000 355.0980 1.3000 355.2000 0.7000 355.3980 0.7000 355.5000 0.7000 355.6980 0.7000 355.8000 1.3000 355.9980 1.3000 356.1000 1.3000 356.2980 1.3000 356.4000 0.7000 356.5980 0.7000 356.7000 0.7000 356.8980 0.7000 357.0000 1.3000 357.1980 1.3000 357.3000 1.3000 357.4980 1.3000 357.6000 0.7000 357.7980 0.7000 357.9000 0.7000 358.0980 0.7000 358.2000 1.3000 358.3980 1.3000 358.5000 1.3000 358.6980 1.3000 358.8000 0.7000 358.9980 0.7000 359.1000 0.7000 359.2980 0.7000 359.4000 1.3000 359.5980 1.3000 359.7000 1.3000 359.8980 1.3000 360.0000 1.3000)
Va2 a2 0 PWL(0.0000 0.7000 0.1980 0.7000 0.3000 1.3000 0.4980 1.3000 0.6000 0.7000 0.7980 0.7000 0.9000 1.3000 1.0980 1.3000 1.2000 0.7000 1.3980 0.7000 1.5000 1.3000 1.6980 1.3000 1.8000 0.7000 1.9980 0.7000 2.1000 1.3000 2.2980 1.3000 2.4000 0.7000 2.5980 0.7000 2.7000 1.3000 2.8980 1.3000 3.0000 0.7000 3.1980 0.7000 3.3000 1.3000 3.4980 1.3000 3.6000 0.7000 3.7980 0.7000 3.9000 1.3000 4.0980 1.3000 4.2000 0.7000 4.3980 0.7000 4.5000 1.3000 4.6980 1.3000 4.8000 0.7000 4.9980 0.7000 5.1000 1.3000 5.2980 1.3000 5.4000 0.7000 5.5980 0.7000 5.7000 1.3000 5.8980 1.3000 6.0000 0.7000 6.1980 0.7000 6.3000 1.3000 6.4980 1.3000 6.6000 0.7000 6.7980 0.7000 6.9000 1.3000 7.0980 1.3000 7.2000 0.7000 7.3980 0.7000 7.5000 1.3000 7.6980 1.3000 7.8000 0.7000 7.9980 0.7000 8.1000 1.3000 8.2980 1.3000 8.4000 0.7000 8.5980 0.7000 8.7000 1.3000 8.8980 1.3000 9.0000 0.7000 9.1980 0.7000 9.3000 1.3000 9.4980 1.3000 9.6000 0.7000 9.7980 0.7000 9.9000 1.3000 10.0980 1.3000 10.2000 0.7000 10.3980 0.7000 10.5000 1.3000 10.6980 1.3000 10.8000 0.7000 10.9980 0.7000 11.1000 1.3000 11.2980 1.3000 11.4000 0.7000 11.5980 0.7000 11.7000 1.3000 11.8980 1.3000 12.0000 0.7000 12.1980 0.7000 12.3000 1.3000 12.4980 1.3000 12.6000 0.7000 12.7980 0.7000 12.9000 1.3000 13.0980 1.3000 13.2000 0.7000 13.3980 0.7000 13.5000 1.3000 13.6980 1.3000 13.8000 0.7000 13.9980 0.7000 14.1000 1.3000 14.2980 1.3000 14.4000 0.7000 14.5980 0.7000 14.7000 1.3000 14.8980 1.3000 15.0000 0.7000 15.1980 0.7000 15.3000 1.3000 15.4980 1.3000 15.6000 0.7000 15.7980 0.7000 15.9000 1.3000 16.0980 1.3000 16.2000 0.7000 16.3980 0.7000 16.5000 1.3000 16.6980 1.3000 16.8000 0.7000 16.9980 0.7000 17.1000 1.3000 17.2980 1.3000 17.4000 0.7000 17.5980 0.7000 17.7000 1.3000 17.8980 1.3000 18.0000 0.7000 18.1980 0.7000 18.3000 1.3000 18.4980 1.3000 18.6000 0.7000 18.7980 0.7000 18.9000 1.3000 19.0980 1.3000 19.2000 0.7000 19.3980 0.7000 19.5000 1.3000 19.6980 1.3000 19.8000 0.7000 19.9980 0.7000 20.1000 1.3000 20.2980 1.3000 20.4000 0.7000 20.5980 0.7000 20.7000 1.3000 20.8980 1.3000 21.0000 0.7000 21.1980 0.7000 21.3000 1.3000 21.4980 1.3000 21.6000 0.7000 21.7980 0.7000 21.9000 1.3000 22.0980 1.3000 22.2000 0.7000 22.3980 0.7000 22.5000 1.3000 22.6980 1.3000 22.8000 0.7000 22.9980 0.7000 23.1000 1.3000 23.2980 1.3000 23.4000 0.7000 23.5980 0.7000 23.7000 1.3000 23.8980 1.3000 24.0000 0.7000 24.1980 0.7000 24.3000 1.3000 24.4980 1.3000 24.6000 0.7000 24.7980 0.7000 24.9000 1.3000 25.0980 1.3000 25.2000 0.7000 25.3980 0.7000 25.5000 1.3000 25.6980 1.3000 25.8000 0.7000 25.9980 0.7000 26.1000 1.3000 26.2980 1.3000 26.4000 0.7000 26.5980 0.7000 26.7000 1.3000 26.8980 1.3000 27.0000 0.7000 27.1980 0.7000 27.3000 1.3000 27.4980 1.3000 27.6000 0.7000 27.7980 0.7000 27.9000 1.3000 28.0980 1.3000 28.2000 0.7000 28.3980 0.7000 28.5000 1.3000 28.6980 1.3000 28.8000 0.7000 28.9980 0.7000 29.1000 1.3000 29.2980 1.3000 29.4000 0.7000 29.5980 0.7000 29.7000 1.3000 29.8980 1.3000 30.0000 0.7000 30.1980 0.7000 30.3000 1.3000 30.4980 1.3000 30.6000 0.7000 30.7980 0.7000 30.9000 1.3000 31.0980 1.3000 31.2000 0.7000 31.3980 0.7000 31.5000 1.3000 31.6980 1.3000 31.8000 0.7000 31.9980 0.7000 32.1000 1.3000 32.2980 1.3000 32.4000 0.7000 32.5980 0.7000 32.7000 1.3000 32.8980 1.3000 33.0000 0.7000 33.1980 0.7000 33.3000 1.3000 33.4980 1.3000 33.6000 0.7000 33.7980 0.7000 33.9000 1.3000 34.0980 1.3000 34.2000 0.7000 34.3980 0.7000 34.5000 1.3000 34.6980 1.3000 34.8000 0.7000 34.9980 0.7000 35.1000 1.3000 35.2980 1.3000 35.4000 0.7000 35.5980 0.7000 35.7000 1.3000 35.8980 1.3000 36.0000 0.7000 36.1980 0.7000 36.3000 1.3000 36.4980 1.3000 36.6000 0.7000 36.7980 0.7000 36.9000 1.3000 37.0980 1.3000 37.2000 0.7000 37.3980 0.7000 37.5000 1.3000 37.6980 1.3000 37.8000 0.7000 37.9980 0.7000 38.1000 1.3000 38.2980 1.3000 38.4000 0.7000 38.5980 0.7000 38.7000 1.3000 38.8980 1.3000 39.0000 0.7000 39.1980 0.7000 39.3000 1.3000 39.4980 1.3000 39.6000 0.7000 39.7980 0.7000 39.9000 1.3000 40.0980 1.3000 40.2000 0.7000 40.3980 0.7000 40.5000 1.3000 40.6980 1.3000 40.8000 0.7000 40.9980 0.7000 41.1000 1.3000 41.2980 1.3000 41.4000 0.7000 41.5980 0.7000 41.7000 1.3000 41.8980 1.3000 42.0000 0.7000 42.1980 0.7000 42.3000 1.3000 42.4980 1.3000 42.6000 0.7000 42.7980 0.7000 42.9000 1.3000 43.0980 1.3000 43.2000 0.7000 43.3980 0.7000 43.5000 1.3000 43.6980 1.3000 43.8000 0.7000 43.9980 0.7000 44.1000 1.3000 44.2980 1.3000 44.4000 0.7000 44.5980 0.7000 44.7000 1.3000 44.8980 1.3000 45.0000 0.7000 45.1980 0.7000 45.3000 1.3000 45.4980 1.3000 45.6000 0.7000 45.7980 0.7000 45.9000 1.3000 46.0980 1.3000 46.2000 0.7000 46.3980 0.7000 46.5000 1.3000 46.6980 1.3000 46.8000 0.7000 46.9980 0.7000 47.1000 1.3000 47.2980 1.3000 47.4000 0.7000 47.5980 0.7000 47.7000 1.3000 47.8980 1.3000 48.0000 0.7000 48.1980 0.7000 48.3000 1.3000 48.4980 1.3000 48.6000 0.7000 48.7980 0.7000 48.9000 1.3000 49.0980 1.3000 49.2000 0.7000 49.3980 0.7000 49.5000 1.3000 49.6980 1.3000 49.8000 0.7000 49.9980 0.7000 50.1000 1.3000 50.2980 1.3000 50.4000 0.7000 50.5980 0.7000 50.7000 1.3000 50.8980 1.3000 51.0000 0.7000 51.1980 0.7000 51.3000 1.3000 51.4980 1.3000 51.6000 0.7000 51.7980 0.7000 51.9000 1.3000 52.0980 1.3000 52.2000 0.7000 52.3980 0.7000 52.5000 1.3000 52.6980 1.3000 52.8000 0.7000 52.9980 0.7000 53.1000 1.3000 53.2980 1.3000 53.4000 0.7000 53.5980 0.7000 53.7000 1.3000 53.8980 1.3000 54.0000 0.7000 54.1980 0.7000 54.3000 1.3000 54.4980 1.3000 54.6000 0.7000 54.7980 0.7000 54.9000 1.3000 55.0980 1.3000 55.2000 0.7000 55.3980 0.7000 55.5000 1.3000 55.6980 1.3000 55.8000 0.7000 55.9980 0.7000 56.1000 1.3000 56.2980 1.3000 56.4000 0.7000 56.5980 0.7000 56.7000 1.3000 56.8980 1.3000 57.0000 0.7000 57.1980 0.7000 57.3000 1.3000 57.4980 1.3000 57.6000 0.7000 57.7980 0.7000 57.9000 1.3000 58.0980 1.3000 58.2000 0.7000 58.3980 0.7000 58.5000 1.3000 58.6980 1.3000 58.8000 0.7000 58.9980 0.7000 59.1000 1.3000 59.2980 1.3000 59.4000 0.7000 59.5980 0.7000 59.7000 1.3000 59.8980 1.3000 60.0000 0.7000 60.1980 0.7000 60.3000 1.3000 60.4980 1.3000 60.6000 0.7000 60.7980 0.7000 60.9000 1.3000 61.0980 1.3000 61.2000 0.7000 61.3980 0.7000 61.5000 1.3000 61.6980 1.3000 61.8000 0.7000 61.9980 0.7000 62.1000 1.3000 62.2980 1.3000 62.4000 0.7000 62.5980 0.7000 62.7000 1.3000 62.8980 1.3000 63.0000 0.7000 63.1980 0.7000 63.3000 1.3000 63.4980 1.3000 63.6000 0.7000 63.7980 0.7000 63.9000 1.3000 64.0980 1.3000 64.2000 0.7000 64.3980 0.7000 64.5000 1.3000 64.6980 1.3000 64.8000 0.7000 64.9980 0.7000 65.1000 1.3000 65.2980 1.3000 65.4000 0.7000 65.5980 0.7000 65.7000 1.3000 65.8980 1.3000 66.0000 0.7000 66.1980 0.7000 66.3000 1.3000 66.4980 1.3000 66.6000 0.7000 66.7980 0.7000 66.9000 1.3000 67.0980 1.3000 67.2000 0.7000 67.3980 0.7000 67.5000 1.3000 67.6980 1.3000 67.8000 0.7000 67.9980 0.7000 68.1000 1.3000 68.2980 1.3000 68.4000 0.7000 68.5980 0.7000 68.7000 1.3000 68.8980 1.3000 69.0000 0.7000 69.1980 0.7000 69.3000 1.3000 69.4980 1.3000 69.6000 0.7000 69.7980 0.7000 69.9000 1.3000 70.0980 1.3000 70.2000 0.7000 70.3980 0.7000 70.5000 1.3000 70.6980 1.3000 70.8000 0.7000 70.9980 0.7000 71.1000 1.3000 71.2980 1.3000 71.4000 0.7000 71.5980 0.7000 71.7000 1.3000 71.8980 1.3000 72.0000 0.7000 72.1980 0.7000 72.3000 1.3000 72.4980 1.3000 72.6000 0.7000 72.7980 0.7000 72.9000 1.3000 73.0980 1.3000 73.2000 0.7000 73.3980 0.7000 73.5000 1.3000 73.6980 1.3000 73.8000 0.7000 73.9980 0.7000 74.1000 1.3000 74.2980 1.3000 74.4000 0.7000 74.5980 0.7000 74.7000 1.3000 74.8980 1.3000 75.0000 0.7000 75.1980 0.7000 75.3000 1.3000 75.4980 1.3000 75.6000 0.7000 75.7980 0.7000 75.9000 1.3000 76.0980 1.3000 76.2000 0.7000 76.3980 0.7000 76.5000 1.3000 76.6980 1.3000 76.8000 0.7000 76.9980 0.7000 77.1000 1.3000 77.2980 1.3000 77.4000 0.7000 77.5980 0.7000 77.7000 1.3000 77.8980 1.3000 78.0000 0.7000 78.1980 0.7000 78.3000 1.3000 78.4980 1.3000 78.6000 0.7000 78.7980 0.7000 78.9000 1.3000 79.0980 1.3000 79.2000 0.7000 79.3980 0.7000 79.5000 1.3000 79.6980 1.3000 79.8000 0.7000 79.9980 0.7000 80.1000 1.3000 80.2980 1.3000 80.4000 0.7000 80.5980 0.7000 80.7000 1.3000 80.8980 1.3000 81.0000 0.7000 81.1980 0.7000 81.3000 1.3000 81.4980 1.3000 81.6000 0.7000 81.7980 0.7000 81.9000 1.3000 82.0980 1.3000 82.2000 0.7000 82.3980 0.7000 82.5000 1.3000 82.6980 1.3000 82.8000 0.7000 82.9980 0.7000 83.1000 1.3000 83.2980 1.3000 83.4000 0.7000 83.5980 0.7000 83.7000 1.3000 83.8980 1.3000 84.0000 0.7000 84.1980 0.7000 84.3000 1.3000 84.4980 1.3000 84.6000 0.7000 84.7980 0.7000 84.9000 1.3000 85.0980 1.3000 85.2000 0.7000 85.3980 0.7000 85.5000 1.3000 85.6980 1.3000 85.8000 0.7000 85.9980 0.7000 86.1000 1.3000 86.2980 1.3000 86.4000 0.7000 86.5980 0.7000 86.7000 1.3000 86.8980 1.3000 87.0000 0.7000 87.1980 0.7000 87.3000 1.3000 87.4980 1.3000 87.6000 0.7000 87.7980 0.7000 87.9000 1.3000 88.0980 1.3000 88.2000 0.7000 88.3980 0.7000 88.5000 1.3000 88.6980 1.3000 88.8000 0.7000 88.9980 0.7000 89.1000 1.3000 89.2980 1.3000 89.4000 0.7000 89.5980 0.7000 89.7000 1.3000 89.8980 1.3000 90.0000 0.7000 90.1980 0.7000 90.3000 1.3000 90.4980 1.3000 90.6000 0.7000 90.7980 0.7000 90.9000 1.3000 91.0980 1.3000 91.2000 0.7000 91.3980 0.7000 91.5000 1.3000 91.6980 1.3000 91.8000 0.7000 91.9980 0.7000 92.1000 1.3000 92.2980 1.3000 92.4000 0.7000 92.5980 0.7000 92.7000 1.3000 92.8980 1.3000 93.0000 0.7000 93.1980 0.7000 93.3000 1.3000 93.4980 1.3000 93.6000 0.7000 93.7980 0.7000 93.9000 1.3000 94.0980 1.3000 94.2000 0.7000 94.3980 0.7000 94.5000 1.3000 94.6980 1.3000 94.8000 0.7000 94.9980 0.7000 95.1000 1.3000 95.2980 1.3000 95.4000 0.7000 95.5980 0.7000 95.7000 1.3000 95.8980 1.3000 96.0000 0.7000 96.1980 0.7000 96.3000 1.3000 96.4980 1.3000 96.6000 0.7000 96.7980 0.7000 96.9000 1.3000 97.0980 1.3000 97.2000 0.7000 97.3980 0.7000 97.5000 1.3000 97.6980 1.3000 97.8000 0.7000 97.9980 0.7000 98.1000 1.3000 98.2980 1.3000 98.4000 0.7000 98.5980 0.7000 98.7000 1.3000 98.8980 1.3000 99.0000 0.7000 99.1980 0.7000 99.3000 1.3000 99.4980 1.3000 99.6000 0.7000 99.7980 0.7000 99.9000 1.3000 100.0980 1.3000 100.2000 0.7000 100.3980 0.7000 100.5000 1.3000 100.6980 1.3000 100.8000 0.7000 100.9980 0.7000 101.1000 1.3000 101.2980 1.3000 101.4000 0.7000 101.5980 0.7000 101.7000 1.3000 101.8980 1.3000 102.0000 0.7000 102.1980 0.7000 102.3000 1.3000 102.4980 1.3000 102.6000 0.7000 102.7980 0.7000 102.9000 1.3000 103.0980 1.3000 103.2000 0.7000 103.3980 0.7000 103.5000 1.3000 103.6980 1.3000 103.8000 0.7000 103.9980 0.7000 104.1000 1.3000 104.2980 1.3000 104.4000 0.7000 104.5980 0.7000 104.7000 1.3000 104.8980 1.3000 105.0000 0.7000 105.1980 0.7000 105.3000 1.3000 105.4980 1.3000 105.6000 0.7000 105.7980 0.7000 105.9000 1.3000 106.0980 1.3000 106.2000 0.7000 106.3980 0.7000 106.5000 1.3000 106.6980 1.3000 106.8000 0.7000 106.9980 0.7000 107.1000 1.3000 107.2980 1.3000 107.4000 0.7000 107.5980 0.7000 107.7000 1.3000 107.8980 1.3000 108.0000 0.7000 108.1980 0.7000 108.3000 1.3000 108.4980 1.3000 108.6000 0.7000 108.7980 0.7000 108.9000 1.3000 109.0980 1.3000 109.2000 0.7000 109.3980 0.7000 109.5000 1.3000 109.6980 1.3000 109.8000 0.7000 109.9980 0.7000 110.1000 1.3000 110.2980 1.3000 110.4000 0.7000 110.5980 0.7000 110.7000 1.3000 110.8980 1.3000 111.0000 0.7000 111.1980 0.7000 111.3000 1.3000 111.4980 1.3000 111.6000 0.7000 111.7980 0.7000 111.9000 1.3000 112.0980 1.3000 112.2000 0.7000 112.3980 0.7000 112.5000 1.3000 112.6980 1.3000 112.8000 0.7000 112.9980 0.7000 113.1000 1.3000 113.2980 1.3000 113.4000 0.7000 113.5980 0.7000 113.7000 1.3000 113.8980 1.3000 114.0000 0.7000 114.1980 0.7000 114.3000 1.3000 114.4980 1.3000 114.6000 0.7000 114.7980 0.7000 114.9000 1.3000 115.0980 1.3000 115.2000 0.7000 115.3980 0.7000 115.5000 1.3000 115.6980 1.3000 115.8000 0.7000 115.9980 0.7000 116.1000 1.3000 116.2980 1.3000 116.4000 0.7000 116.5980 0.7000 116.7000 1.3000 116.8980 1.3000 117.0000 0.7000 117.1980 0.7000 117.3000 1.3000 117.4980 1.3000 117.6000 0.7000 117.7980 0.7000 117.9000 1.3000 118.0980 1.3000 118.2000 0.7000 118.3980 0.7000 118.5000 1.3000 118.6980 1.3000 118.8000 0.7000 118.9980 0.7000 119.1000 1.3000 119.2980 1.3000 119.4000 0.7000 119.5980 0.7000 119.7000 1.3000 119.8980 1.3000 120.0000 0.7000 120.1980 0.7000 120.3000 1.3000 120.4980 1.3000 120.6000 0.7000 120.7980 0.7000 120.9000 1.3000 121.0980 1.3000 121.2000 0.7000 121.3980 0.7000 121.5000 1.3000 121.6980 1.3000 121.8000 0.7000 121.9980 0.7000 122.1000 1.3000 122.2980 1.3000 122.4000 0.7000 122.5980 0.7000 122.7000 1.3000 122.8980 1.3000 123.0000 0.7000 123.1980 0.7000 123.3000 1.3000 123.4980 1.3000 123.6000 0.7000 123.7980 0.7000 123.9000 1.3000 124.0980 1.3000 124.2000 0.7000 124.3980 0.7000 124.5000 1.3000 124.6980 1.3000 124.8000 0.7000 124.9980 0.7000 125.1000 1.3000 125.2980 1.3000 125.4000 0.7000 125.5980 0.7000 125.7000 1.3000 125.8980 1.3000 126.0000 0.7000 126.1980 0.7000 126.3000 1.3000 126.4980 1.3000 126.6000 0.7000 126.7980 0.7000 126.9000 1.3000 127.0980 1.3000 127.2000 0.7000 127.3980 0.7000 127.5000 1.3000 127.6980 1.3000 127.8000 0.7000 127.9980 0.7000 128.1000 1.3000 128.2980 1.3000 128.4000 0.7000 128.5980 0.7000 128.7000 1.3000 128.8980 1.3000 129.0000 0.7000 129.1980 0.7000 129.3000 1.3000 129.4980 1.3000 129.6000 0.7000 129.7980 0.7000 129.9000 1.3000 130.0980 1.3000 130.2000 0.7000 130.3980 0.7000 130.5000 1.3000 130.6980 1.3000 130.8000 0.7000 130.9980 0.7000 131.1000 1.3000 131.2980 1.3000 131.4000 0.7000 131.5980 0.7000 131.7000 1.3000 131.8980 1.3000 132.0000 0.7000 132.1980 0.7000 132.3000 1.3000 132.4980 1.3000 132.6000 0.7000 132.7980 0.7000 132.9000 1.3000 133.0980 1.3000 133.2000 0.7000 133.3980 0.7000 133.5000 1.3000 133.6980 1.3000 133.8000 0.7000 133.9980 0.7000 134.1000 1.3000 134.2980 1.3000 134.4000 0.7000 134.5980 0.7000 134.7000 1.3000 134.8980 1.3000 135.0000 0.7000 135.1980 0.7000 135.3000 1.3000 135.4980 1.3000 135.6000 0.7000 135.7980 0.7000 135.9000 1.3000 136.0980 1.3000 136.2000 0.7000 136.3980 0.7000 136.5000 1.3000 136.6980 1.3000 136.8000 0.7000 136.9980 0.7000 137.1000 1.3000 137.2980 1.3000 137.4000 0.7000 137.5980 0.7000 137.7000 1.3000 137.8980 1.3000 138.0000 0.7000 138.1980 0.7000 138.3000 1.3000 138.4980 1.3000 138.6000 0.7000 138.7980 0.7000 138.9000 1.3000 139.0980 1.3000 139.2000 0.7000 139.3980 0.7000 139.5000 1.3000 139.6980 1.3000 139.8000 0.7000 139.9980 0.7000 140.1000 1.3000 140.2980 1.3000 140.4000 0.7000 140.5980 0.7000 140.7000 1.3000 140.8980 1.3000 141.0000 0.7000 141.1980 0.7000 141.3000 1.3000 141.4980 1.3000 141.6000 0.7000 141.7980 0.7000 141.9000 1.3000 142.0980 1.3000 142.2000 0.7000 142.3980 0.7000 142.5000 1.3000 142.6980 1.3000 142.8000 0.7000 142.9980 0.7000 143.1000 1.3000 143.2980 1.3000 143.4000 0.7000 143.5980 0.7000 143.7000 1.3000 143.8980 1.3000 144.0000 0.7000 144.1980 0.7000 144.3000 1.3000 144.4980 1.3000 144.6000 0.7000 144.7980 0.7000 144.9000 1.3000 145.0980 1.3000 145.2000 0.7000 145.3980 0.7000 145.5000 1.3000 145.6980 1.3000 145.8000 0.7000 145.9980 0.7000 146.1000 1.3000 146.2980 1.3000 146.4000 0.7000 146.5980 0.7000 146.7000 1.3000 146.8980 1.3000 147.0000 0.7000 147.1980 0.7000 147.3000 1.3000 147.4980 1.3000 147.6000 0.7000 147.7980 0.7000 147.9000 1.3000 148.0980 1.3000 148.2000 0.7000 148.3980 0.7000 148.5000 1.3000 148.6980 1.3000 148.8000 0.7000 148.9980 0.7000 149.1000 1.3000 149.2980 1.3000 149.4000 0.7000 149.5980 0.7000 149.7000 1.3000 149.8980 1.3000 150.0000 0.7000 150.1980 0.7000 150.3000 1.3000 150.4980 1.3000 150.6000 0.7000 150.7980 0.7000 150.9000 1.3000 151.0980 1.3000 151.2000 0.7000 151.3980 0.7000 151.5000 1.3000 151.6980 1.3000 151.8000 0.7000 151.9980 0.7000 152.1000 1.3000 152.2980 1.3000 152.4000 0.7000 152.5980 0.7000 152.7000 1.3000 152.8980 1.3000 153.0000 0.7000 153.1980 0.7000 153.3000 1.3000 153.4980 1.3000 153.6000 0.7000 153.7980 0.7000 153.9000 1.3000 154.0980 1.3000 154.2000 0.7000 154.3980 0.7000 154.5000 1.3000 154.6980 1.3000 154.8000 0.7000 154.9980 0.7000 155.1000 1.3000 155.2980 1.3000 155.4000 0.7000 155.5980 0.7000 155.7000 1.3000 155.8980 1.3000 156.0000 0.7000 156.1980 0.7000 156.3000 1.3000 156.4980 1.3000 156.6000 0.7000 156.7980 0.7000 156.9000 1.3000 157.0980 1.3000 157.2000 0.7000 157.3980 0.7000 157.5000 1.3000 157.6980 1.3000 157.8000 0.7000 157.9980 0.7000 158.1000 1.3000 158.2980 1.3000 158.4000 0.7000 158.5980 0.7000 158.7000 1.3000 158.8980 1.3000 159.0000 0.7000 159.1980 0.7000 159.3000 1.3000 159.4980 1.3000 159.6000 0.7000 159.7980 0.7000 159.9000 1.3000 160.0980 1.3000 160.2000 0.7000 160.3980 0.7000 160.5000 1.3000 160.6980 1.3000 160.8000 0.7000 160.9980 0.7000 161.1000 1.3000 161.2980 1.3000 161.4000 0.7000 161.5980 0.7000 161.7000 1.3000 161.8980 1.3000 162.0000 0.7000 162.1980 0.7000 162.3000 1.3000 162.4980 1.3000 162.6000 0.7000 162.7980 0.7000 162.9000 1.3000 163.0980 1.3000 163.2000 0.7000 163.3980 0.7000 163.5000 1.3000 163.6980 1.3000 163.8000 0.7000 163.9980 0.7000 164.1000 1.3000 164.2980 1.3000 164.4000 0.7000 164.5980 0.7000 164.7000 1.3000 164.8980 1.3000 165.0000 0.7000 165.1980 0.7000 165.3000 1.3000 165.4980 1.3000 165.6000 0.7000 165.7980 0.7000 165.9000 1.3000 166.0980 1.3000 166.2000 0.7000 166.3980 0.7000 166.5000 1.3000 166.6980 1.3000 166.8000 0.7000 166.9980 0.7000 167.1000 1.3000 167.2980 1.3000 167.4000 0.7000 167.5980 0.7000 167.7000 1.3000 167.8980 1.3000 168.0000 0.7000 168.1980 0.7000 168.3000 1.3000 168.4980 1.3000 168.6000 0.7000 168.7980 0.7000 168.9000 1.3000 169.0980 1.3000 169.2000 0.7000 169.3980 0.7000 169.5000 1.3000 169.6980 1.3000 169.8000 0.7000 169.9980 0.7000 170.1000 1.3000 170.2980 1.3000 170.4000 0.7000 170.5980 0.7000 170.7000 1.3000 170.8980 1.3000 171.0000 0.7000 171.1980 0.7000 171.3000 1.3000 171.4980 1.3000 171.6000 0.7000 171.7980 0.7000 171.9000 1.3000 172.0980 1.3000 172.2000 0.7000 172.3980 0.7000 172.5000 1.3000 172.6980 1.3000 172.8000 0.7000 172.9980 0.7000 173.1000 1.3000 173.2980 1.3000 173.4000 0.7000 173.5980 0.7000 173.7000 1.3000 173.8980 1.3000 174.0000 0.7000 174.1980 0.7000 174.3000 1.3000 174.4980 1.3000 174.6000 0.7000 174.7980 0.7000 174.9000 1.3000 175.0980 1.3000 175.2000 0.7000 175.3980 0.7000 175.5000 1.3000 175.6980 1.3000 175.8000 0.7000 175.9980 0.7000 176.1000 1.3000 176.2980 1.3000 176.4000 0.7000 176.5980 0.7000 176.7000 1.3000 176.8980 1.3000 177.0000 0.7000 177.1980 0.7000 177.3000 1.3000 177.4980 1.3000 177.6000 0.7000 177.7980 0.7000 177.9000 1.3000 178.0980 1.3000 178.2000 0.7000 178.3980 0.7000 178.5000 1.3000 178.6980 1.3000 178.8000 0.7000 178.9980 0.7000 179.1000 1.3000 179.2980 1.3000 179.4000 0.7000 179.5980 0.7000 179.7000 1.3000 179.8980 1.3000 180.0000 0.7000 180.1980 0.7000 180.3000 1.3000 180.4980 1.3000 180.6000 0.7000 180.7980 0.7000 180.9000 1.3000 181.0980 1.3000 181.2000 0.7000 181.3980 0.7000 181.5000 1.3000 181.6980 1.3000 181.8000 0.7000 181.9980 0.7000 182.1000 1.3000 182.2980 1.3000 182.4000 0.7000 182.5980 0.7000 182.7000 1.3000 182.8980 1.3000 183.0000 0.7000 183.1980 0.7000 183.3000 1.3000 183.4980 1.3000 183.6000 0.7000 183.7980 0.7000 183.9000 1.3000 184.0980 1.3000 184.2000 0.7000 184.3980 0.7000 184.5000 1.3000 184.6980 1.3000 184.8000 0.7000 184.9980 0.7000 185.1000 1.3000 185.2980 1.3000 185.4000 0.7000 185.5980 0.7000 185.7000 1.3000 185.8980 1.3000 186.0000 0.7000 186.1980 0.7000 186.3000 1.3000 186.4980 1.3000 186.6000 0.7000 186.7980 0.7000 186.9000 1.3000 187.0980 1.3000 187.2000 0.7000 187.3980 0.7000 187.5000 1.3000 187.6980 1.3000 187.8000 0.7000 187.9980 0.7000 188.1000 1.3000 188.2980 1.3000 188.4000 0.7000 188.5980 0.7000 188.7000 1.3000 188.8980 1.3000 189.0000 0.7000 189.1980 0.7000 189.3000 1.3000 189.4980 1.3000 189.6000 0.7000 189.7980 0.7000 189.9000 1.3000 190.0980 1.3000 190.2000 0.7000 190.3980 0.7000 190.5000 1.3000 190.6980 1.3000 190.8000 0.7000 190.9980 0.7000 191.1000 1.3000 191.2980 1.3000 191.4000 0.7000 191.5980 0.7000 191.7000 1.3000 191.8980 1.3000 192.0000 0.7000 192.1980 0.7000 192.3000 1.3000 192.4980 1.3000 192.6000 0.7000 192.7980 0.7000 192.9000 1.3000 193.0980 1.3000 193.2000 0.7000 193.3980 0.7000 193.5000 1.3000 193.6980 1.3000 193.8000 0.7000 193.9980 0.7000 194.1000 1.3000 194.2980 1.3000 194.4000 0.7000 194.5980 0.7000 194.7000 1.3000 194.8980 1.3000 195.0000 0.7000 195.1980 0.7000 195.3000 1.3000 195.4980 1.3000 195.6000 0.7000 195.7980 0.7000 195.9000 1.3000 196.0980 1.3000 196.2000 0.7000 196.3980 0.7000 196.5000 1.3000 196.6980 1.3000 196.8000 0.7000 196.9980 0.7000 197.1000 1.3000 197.2980 1.3000 197.4000 0.7000 197.5980 0.7000 197.7000 1.3000 197.8980 1.3000 198.0000 0.7000 198.1980 0.7000 198.3000 1.3000 198.4980 1.3000 198.6000 0.7000 198.7980 0.7000 198.9000 1.3000 199.0980 1.3000 199.2000 0.7000 199.3980 0.7000 199.5000 1.3000 199.6980 1.3000 199.8000 0.7000 199.9980 0.7000 200.1000 1.3000 200.2980 1.3000 200.4000 0.7000 200.5980 0.7000 200.7000 1.3000 200.8980 1.3000 201.0000 0.7000 201.1980 0.7000 201.3000 1.3000 201.4980 1.3000 201.6000 0.7000 201.7980 0.7000 201.9000 1.3000 202.0980 1.3000 202.2000 0.7000 202.3980 0.7000 202.5000 1.3000 202.6980 1.3000 202.8000 0.7000 202.9980 0.7000 203.1000 1.3000 203.2980 1.3000 203.4000 0.7000 203.5980 0.7000 203.7000 1.3000 203.8980 1.3000 204.0000 0.7000 204.1980 0.7000 204.3000 1.3000 204.4980 1.3000 204.6000 0.7000 204.7980 0.7000 204.9000 1.3000 205.0980 1.3000 205.2000 0.7000 205.3980 0.7000 205.5000 1.3000 205.6980 1.3000 205.8000 0.7000 205.9980 0.7000 206.1000 1.3000 206.2980 1.3000 206.4000 0.7000 206.5980 0.7000 206.7000 1.3000 206.8980 1.3000 207.0000 0.7000 207.1980 0.7000 207.3000 1.3000 207.4980 1.3000 207.6000 0.7000 207.7980 0.7000 207.9000 1.3000 208.0980 1.3000 208.2000 0.7000 208.3980 0.7000 208.5000 1.3000 208.6980 1.3000 208.8000 0.7000 208.9980 0.7000 209.1000 1.3000 209.2980 1.3000 209.4000 0.7000 209.5980 0.7000 209.7000 1.3000 209.8980 1.3000 210.0000 0.7000 210.1980 0.7000 210.3000 1.3000 210.4980 1.3000 210.6000 0.7000 210.7980 0.7000 210.9000 1.3000 211.0980 1.3000 211.2000 0.7000 211.3980 0.7000 211.5000 1.3000 211.6980 1.3000 211.8000 0.7000 211.9980 0.7000 212.1000 1.3000 212.2980 1.3000 212.4000 0.7000 212.5980 0.7000 212.7000 1.3000 212.8980 1.3000 213.0000 0.7000 213.1980 0.7000 213.3000 1.3000 213.4980 1.3000 213.6000 0.7000 213.7980 0.7000 213.9000 1.3000 214.0980 1.3000 214.2000 0.7000 214.3980 0.7000 214.5000 1.3000 214.6980 1.3000 214.8000 0.7000 214.9980 0.7000 215.1000 1.3000 215.2980 1.3000 215.4000 0.7000 215.5980 0.7000 215.7000 1.3000 215.8980 1.3000 216.0000 0.7000 216.1980 0.7000 216.3000 1.3000 216.4980 1.3000 216.6000 0.7000 216.7980 0.7000 216.9000 1.3000 217.0980 1.3000 217.2000 0.7000 217.3980 0.7000 217.5000 1.3000 217.6980 1.3000 217.8000 0.7000 217.9980 0.7000 218.1000 1.3000 218.2980 1.3000 218.4000 0.7000 218.5980 0.7000 218.7000 1.3000 218.8980 1.3000 219.0000 0.7000 219.1980 0.7000 219.3000 1.3000 219.4980 1.3000 219.6000 0.7000 219.7980 0.7000 219.9000 1.3000 220.0980 1.3000 220.2000 0.7000 220.3980 0.7000 220.5000 1.3000 220.6980 1.3000 220.8000 0.7000 220.9980 0.7000 221.1000 1.3000 221.2980 1.3000 221.4000 0.7000 221.5980 0.7000 221.7000 1.3000 221.8980 1.3000 222.0000 0.7000 222.1980 0.7000 222.3000 1.3000 222.4980 1.3000 222.6000 0.7000 222.7980 0.7000 222.9000 1.3000 223.0980 1.3000 223.2000 0.7000 223.3980 0.7000 223.5000 1.3000 223.6980 1.3000 223.8000 0.7000 223.9980 0.7000 224.1000 1.3000 224.2980 1.3000 224.4000 0.7000 224.5980 0.7000 224.7000 1.3000 224.8980 1.3000 225.0000 0.7000 225.1980 0.7000 225.3000 1.3000 225.4980 1.3000 225.6000 0.7000 225.7980 0.7000 225.9000 1.3000 226.0980 1.3000 226.2000 0.7000 226.3980 0.7000 226.5000 1.3000 226.6980 1.3000 226.8000 0.7000 226.9980 0.7000 227.1000 1.3000 227.2980 1.3000 227.4000 0.7000 227.5980 0.7000 227.7000 1.3000 227.8980 1.3000 228.0000 0.7000 228.1980 0.7000 228.3000 1.3000 228.4980 1.3000 228.6000 0.7000 228.7980 0.7000 228.9000 1.3000 229.0980 1.3000 229.2000 0.7000 229.3980 0.7000 229.5000 1.3000 229.6980 1.3000 229.8000 0.7000 229.9980 0.7000 230.1000 1.3000 230.2980 1.3000 230.4000 0.7000 230.5980 0.7000 230.7000 1.3000 230.8980 1.3000 231.0000 0.7000 231.1980 0.7000 231.3000 1.3000 231.4980 1.3000 231.6000 0.7000 231.7980 0.7000 231.9000 1.3000 232.0980 1.3000 232.2000 0.7000 232.3980 0.7000 232.5000 1.3000 232.6980 1.3000 232.8000 0.7000 232.9980 0.7000 233.1000 1.3000 233.2980 1.3000 233.4000 0.7000 233.5980 0.7000 233.7000 1.3000 233.8980 1.3000 234.0000 0.7000 234.1980 0.7000 234.3000 1.3000 234.4980 1.3000 234.6000 0.7000 234.7980 0.7000 234.9000 1.3000 235.0980 1.3000 235.2000 0.7000 235.3980 0.7000 235.5000 1.3000 235.6980 1.3000 235.8000 0.7000 235.9980 0.7000 236.1000 1.3000 236.2980 1.3000 236.4000 0.7000 236.5980 0.7000 236.7000 1.3000 236.8980 1.3000 237.0000 0.7000 237.1980 0.7000 237.3000 1.3000 237.4980 1.3000 237.6000 0.7000 237.7980 0.7000 237.9000 1.3000 238.0980 1.3000 238.2000 0.7000 238.3980 0.7000 238.5000 1.3000 238.6980 1.3000 238.8000 0.7000 238.9980 0.7000 239.1000 1.3000 239.2980 1.3000 239.4000 0.7000 239.5980 0.7000 239.7000 1.3000 239.8980 1.3000 240.0000 0.7000 240.1980 0.7000 240.3000 1.3000 240.4980 1.3000 240.6000 0.7000 240.7980 0.7000 240.9000 1.3000 241.0980 1.3000 241.2000 0.7000 241.3980 0.7000 241.5000 1.3000 241.6980 1.3000 241.8000 0.7000 241.9980 0.7000 242.1000 1.3000 242.2980 1.3000 242.4000 0.7000 242.5980 0.7000 242.7000 1.3000 242.8980 1.3000 243.0000 0.7000 243.1980 0.7000 243.3000 1.3000 243.4980 1.3000 243.6000 0.7000 243.7980 0.7000 243.9000 1.3000 244.0980 1.3000 244.2000 0.7000 244.3980 0.7000 244.5000 1.3000 244.6980 1.3000 244.8000 0.7000 244.9980 0.7000 245.1000 1.3000 245.2980 1.3000 245.4000 0.7000 245.5980 0.7000 245.7000 1.3000 245.8980 1.3000 246.0000 0.7000 246.1980 0.7000 246.3000 1.3000 246.4980 1.3000 246.6000 0.7000 246.7980 0.7000 246.9000 1.3000 247.0980 1.3000 247.2000 0.7000 247.3980 0.7000 247.5000 1.3000 247.6980 1.3000 247.8000 0.7000 247.9980 0.7000 248.1000 1.3000 248.2980 1.3000 248.4000 0.7000 248.5980 0.7000 248.7000 1.3000 248.8980 1.3000 249.0000 0.7000 249.1980 0.7000 249.3000 1.3000 249.4980 1.3000 249.6000 0.7000 249.7980 0.7000 249.9000 1.3000 250.0980 1.3000 250.2000 0.7000 250.3980 0.7000 250.5000 1.3000 250.6980 1.3000 250.8000 0.7000 250.9980 0.7000 251.1000 1.3000 251.2980 1.3000 251.4000 0.7000 251.5980 0.7000 251.7000 1.3000 251.8980 1.3000 252.0000 0.7000 252.1980 0.7000 252.3000 1.3000 252.4980 1.3000 252.6000 0.7000 252.7980 0.7000 252.9000 1.3000 253.0980 1.3000 253.2000 0.7000 253.3980 0.7000 253.5000 1.3000 253.6980 1.3000 253.8000 0.7000 253.9980 0.7000 254.1000 1.3000 254.2980 1.3000 254.4000 0.7000 254.5980 0.7000 254.7000 1.3000 254.8980 1.3000 255.0000 0.7000 255.1980 0.7000 255.3000 1.3000 255.4980 1.3000 255.6000 0.7000 255.7980 0.7000 255.9000 1.3000 256.0980 1.3000 256.2000 0.7000 256.3980 0.7000 256.5000 1.3000 256.6980 1.3000 256.8000 0.7000 256.9980 0.7000 257.1000 1.3000 257.2980 1.3000 257.4000 0.7000 257.5980 0.7000 257.7000 1.3000 257.8980 1.3000 258.0000 0.7000 258.1980 0.7000 258.3000 1.3000 258.4980 1.3000 258.6000 0.7000 258.7980 0.7000 258.9000 1.3000 259.0980 1.3000 259.2000 0.7000 259.3980 0.7000 259.5000 1.3000 259.6980 1.3000 259.8000 0.7000 259.9980 0.7000 260.1000 1.3000 260.2980 1.3000 260.4000 0.7000 260.5980 0.7000 260.7000 1.3000 260.8980 1.3000 261.0000 0.7000 261.1980 0.7000 261.3000 1.3000 261.4980 1.3000 261.6000 0.7000 261.7980 0.7000 261.9000 1.3000 262.0980 1.3000 262.2000 0.7000 262.3980 0.7000 262.5000 1.3000 262.6980 1.3000 262.8000 0.7000 262.9980 0.7000 263.1000 1.3000 263.2980 1.3000 263.4000 0.7000 263.5980 0.7000 263.7000 1.3000 263.8980 1.3000 264.0000 0.7000 264.1980 0.7000 264.3000 1.3000 264.4980 1.3000 264.6000 0.7000 264.7980 0.7000 264.9000 1.3000 265.0980 1.3000 265.2000 0.7000 265.3980 0.7000 265.5000 1.3000 265.6980 1.3000 265.8000 0.7000 265.9980 0.7000 266.1000 1.3000 266.2980 1.3000 266.4000 0.7000 266.5980 0.7000 266.7000 1.3000 266.8980 1.3000 267.0000 0.7000 267.1980 0.7000 267.3000 1.3000 267.4980 1.3000 267.6000 0.7000 267.7980 0.7000 267.9000 1.3000 268.0980 1.3000 268.2000 0.7000 268.3980 0.7000 268.5000 1.3000 268.6980 1.3000 268.8000 0.7000 268.9980 0.7000 269.1000 1.3000 269.2980 1.3000 269.4000 0.7000 269.5980 0.7000 269.7000 1.3000 269.8980 1.3000 270.0000 0.7000 270.1980 0.7000 270.3000 1.3000 270.4980 1.3000 270.6000 0.7000 270.7980 0.7000 270.9000 1.3000 271.0980 1.3000 271.2000 0.7000 271.3980 0.7000 271.5000 1.3000 271.6980 1.3000 271.8000 0.7000 271.9980 0.7000 272.1000 1.3000 272.2980 1.3000 272.4000 0.7000 272.5980 0.7000 272.7000 1.3000 272.8980 1.3000 273.0000 0.7000 273.1980 0.7000 273.3000 1.3000 273.4980 1.3000 273.6000 0.7000 273.7980 0.7000 273.9000 1.3000 274.0980 1.3000 274.2000 0.7000 274.3980 0.7000 274.5000 1.3000 274.6980 1.3000 274.8000 0.7000 274.9980 0.7000 275.1000 1.3000 275.2980 1.3000 275.4000 0.7000 275.5980 0.7000 275.7000 1.3000 275.8980 1.3000 276.0000 0.7000 276.1980 0.7000 276.3000 1.3000 276.4980 1.3000 276.6000 0.7000 276.7980 0.7000 276.9000 1.3000 277.0980 1.3000 277.2000 0.7000 277.3980 0.7000 277.5000 1.3000 277.6980 1.3000 277.8000 0.7000 277.9980 0.7000 278.1000 1.3000 278.2980 1.3000 278.4000 0.7000 278.5980 0.7000 278.7000 1.3000 278.8980 1.3000 279.0000 0.7000 279.1980 0.7000 279.3000 1.3000 279.4980 1.3000 279.6000 0.7000 279.7980 0.7000 279.9000 1.3000 280.0980 1.3000 280.2000 0.7000 280.3980 0.7000 280.5000 1.3000 280.6980 1.3000 280.8000 0.7000 280.9980 0.7000 281.1000 1.3000 281.2980 1.3000 281.4000 0.7000 281.5980 0.7000 281.7000 1.3000 281.8980 1.3000 282.0000 0.7000 282.1980 0.7000 282.3000 1.3000 282.4980 1.3000 282.6000 0.7000 282.7980 0.7000 282.9000 1.3000 283.0980 1.3000 283.2000 0.7000 283.3980 0.7000 283.5000 1.3000 283.6980 1.3000 283.8000 0.7000 283.9980 0.7000 284.1000 1.3000 284.2980 1.3000 284.4000 0.7000 284.5980 0.7000 284.7000 1.3000 284.8980 1.3000 285.0000 0.7000 285.1980 0.7000 285.3000 1.3000 285.4980 1.3000 285.6000 0.7000 285.7980 0.7000 285.9000 1.3000 286.0980 1.3000 286.2000 0.7000 286.3980 0.7000 286.5000 1.3000 286.6980 1.3000 286.8000 0.7000 286.9980 0.7000 287.1000 1.3000 287.2980 1.3000 287.4000 0.7000 287.5980 0.7000 287.7000 1.3000 287.8980 1.3000 288.0000 0.7000 288.1980 0.7000 288.3000 1.3000 288.4980 1.3000 288.6000 0.7000 288.7980 0.7000 288.9000 1.3000 289.0980 1.3000 289.2000 0.7000 289.3980 0.7000 289.5000 1.3000 289.6980 1.3000 289.8000 0.7000 289.9980 0.7000 290.1000 1.3000 290.2980 1.3000 290.4000 0.7000 290.5980 0.7000 290.7000 1.3000 290.8980 1.3000 291.0000 0.7000 291.1980 0.7000 291.3000 1.3000 291.4980 1.3000 291.6000 0.7000 291.7980 0.7000 291.9000 1.3000 292.0980 1.3000 292.2000 0.7000 292.3980 0.7000 292.5000 1.3000 292.6980 1.3000 292.8000 0.7000 292.9980 0.7000 293.1000 1.3000 293.2980 1.3000 293.4000 0.7000 293.5980 0.7000 293.7000 1.3000 293.8980 1.3000 294.0000 0.7000 294.1980 0.7000 294.3000 1.3000 294.4980 1.3000 294.6000 0.7000 294.7980 0.7000 294.9000 1.3000 295.0980 1.3000 295.2000 0.7000 295.3980 0.7000 295.5000 1.3000 295.6980 1.3000 295.8000 0.7000 295.9980 0.7000 296.1000 1.3000 296.2980 1.3000 296.4000 0.7000 296.5980 0.7000 296.7000 1.3000 296.8980 1.3000 297.0000 0.7000 297.1980 0.7000 297.3000 1.3000 297.4980 1.3000 297.6000 0.7000 297.7980 0.7000 297.9000 1.3000 298.0980 1.3000 298.2000 0.7000 298.3980 0.7000 298.5000 1.3000 298.6980 1.3000 298.8000 0.7000 298.9980 0.7000 299.1000 1.3000 299.2980 1.3000 299.4000 0.7000 299.5980 0.7000 299.7000 1.3000 299.8980 1.3000 300.0000 0.7000 300.1980 0.7000 300.3000 1.3000 300.4980 1.3000 300.6000 0.7000 300.7980 0.7000 300.9000 1.3000 301.0980 1.3000 301.2000 0.7000 301.3980 0.7000 301.5000 1.3000 301.6980 1.3000 301.8000 0.7000 301.9980 0.7000 302.1000 1.3000 302.2980 1.3000 302.4000 0.7000 302.5980 0.7000 302.7000 1.3000 302.8980 1.3000 303.0000 0.7000 303.1980 0.7000 303.3000 1.3000 303.4980 1.3000 303.6000 0.7000 303.7980 0.7000 303.9000 1.3000 304.0980 1.3000 304.2000 0.7000 304.3980 0.7000 304.5000 1.3000 304.6980 1.3000 304.8000 0.7000 304.9980 0.7000 305.1000 1.3000 305.2980 1.3000 305.4000 0.7000 305.5980 0.7000 305.7000 1.3000 305.8980 1.3000 306.0000 0.7000 306.1980 0.7000 306.3000 1.3000 306.4980 1.3000 306.6000 0.7000 306.7980 0.7000 306.9000 1.3000 307.0980 1.3000 307.2000 0.7000 307.3980 0.7000 307.5000 1.3000 307.6980 1.3000 307.8000 0.7000 307.9980 0.7000 308.1000 1.3000 308.2980 1.3000 308.4000 0.7000 308.5980 0.7000 308.7000 1.3000 308.8980 1.3000 309.0000 0.7000 309.1980 0.7000 309.3000 1.3000 309.4980 1.3000 309.6000 0.7000 309.7980 0.7000 309.9000 1.3000 310.0980 1.3000 310.2000 0.7000 310.3980 0.7000 310.5000 1.3000 310.6980 1.3000 310.8000 0.7000 310.9980 0.7000 311.1000 1.3000 311.2980 1.3000 311.4000 0.7000 311.5980 0.7000 311.7000 1.3000 311.8980 1.3000 312.0000 0.7000 312.1980 0.7000 312.3000 1.3000 312.4980 1.3000 312.6000 0.7000 312.7980 0.7000 312.9000 1.3000 313.0980 1.3000 313.2000 0.7000 313.3980 0.7000 313.5000 1.3000 313.6980 1.3000 313.8000 0.7000 313.9980 0.7000 314.1000 1.3000 314.2980 1.3000 314.4000 0.7000 314.5980 0.7000 314.7000 1.3000 314.8980 1.3000 315.0000 0.7000 315.1980 0.7000 315.3000 1.3000 315.4980 1.3000 315.6000 0.7000 315.7980 0.7000 315.9000 1.3000 316.0980 1.3000 316.2000 0.7000 316.3980 0.7000 316.5000 1.3000 316.6980 1.3000 316.8000 0.7000 316.9980 0.7000 317.1000 1.3000 317.2980 1.3000 317.4000 0.7000 317.5980 0.7000 317.7000 1.3000 317.8980 1.3000 318.0000 0.7000 318.1980 0.7000 318.3000 1.3000 318.4980 1.3000 318.6000 0.7000 318.7980 0.7000 318.9000 1.3000 319.0980 1.3000 319.2000 0.7000 319.3980 0.7000 319.5000 1.3000 319.6980 1.3000 319.8000 0.7000 319.9980 0.7000 320.1000 1.3000 320.2980 1.3000 320.4000 0.7000 320.5980 0.7000 320.7000 1.3000 320.8980 1.3000 321.0000 0.7000 321.1980 0.7000 321.3000 1.3000 321.4980 1.3000 321.6000 0.7000 321.7980 0.7000 321.9000 1.3000 322.0980 1.3000 322.2000 0.7000 322.3980 0.7000 322.5000 1.3000 322.6980 1.3000 322.8000 0.7000 322.9980 0.7000 323.1000 1.3000 323.2980 1.3000 323.4000 0.7000 323.5980 0.7000 323.7000 1.3000 323.8980 1.3000 324.0000 0.7000 324.1980 0.7000 324.3000 1.3000 324.4980 1.3000 324.6000 0.7000 324.7980 0.7000 324.9000 1.3000 325.0980 1.3000 325.2000 0.7000 325.3980 0.7000 325.5000 1.3000 325.6980 1.3000 325.8000 0.7000 325.9980 0.7000 326.1000 1.3000 326.2980 1.3000 326.4000 0.7000 326.5980 0.7000 326.7000 1.3000 326.8980 1.3000 327.0000 0.7000 327.1980 0.7000 327.3000 1.3000 327.4980 1.3000 327.6000 0.7000 327.7980 0.7000 327.9000 1.3000 328.0980 1.3000 328.2000 0.7000 328.3980 0.7000 328.5000 1.3000 328.6980 1.3000 328.8000 0.7000 328.9980 0.7000 329.1000 1.3000 329.2980 1.3000 329.4000 0.7000 329.5980 0.7000 329.7000 1.3000 329.8980 1.3000 330.0000 0.7000 330.1980 0.7000 330.3000 1.3000 330.4980 1.3000 330.6000 0.7000 330.7980 0.7000 330.9000 1.3000 331.0980 1.3000 331.2000 0.7000 331.3980 0.7000 331.5000 1.3000 331.6980 1.3000 331.8000 0.7000 331.9980 0.7000 332.1000 1.3000 332.2980 1.3000 332.4000 0.7000 332.5980 0.7000 332.7000 1.3000 332.8980 1.3000 333.0000 0.7000 333.1980 0.7000 333.3000 1.3000 333.4980 1.3000 333.6000 0.7000 333.7980 0.7000 333.9000 1.3000 334.0980 1.3000 334.2000 0.7000 334.3980 0.7000 334.5000 1.3000 334.6980 1.3000 334.8000 0.7000 334.9980 0.7000 335.1000 1.3000 335.2980 1.3000 335.4000 0.7000 335.5980 0.7000 335.7000 1.3000 335.8980 1.3000 336.0000 0.7000 336.1980 0.7000 336.3000 1.3000 336.4980 1.3000 336.6000 0.7000 336.7980 0.7000 336.9000 1.3000 337.0980 1.3000 337.2000 0.7000 337.3980 0.7000 337.5000 1.3000 337.6980 1.3000 337.8000 0.7000 337.9980 0.7000 338.1000 1.3000 338.2980 1.3000 338.4000 0.7000 338.5980 0.7000 338.7000 1.3000 338.8980 1.3000 339.0000 0.7000 339.1980 0.7000 339.3000 1.3000 339.4980 1.3000 339.6000 0.7000 339.7980 0.7000 339.9000 1.3000 340.0980 1.3000 340.2000 0.7000 340.3980 0.7000 340.5000 1.3000 340.6980 1.3000 340.8000 0.7000 340.9980 0.7000 341.1000 1.3000 341.2980 1.3000 341.4000 0.7000 341.5980 0.7000 341.7000 1.3000 341.8980 1.3000 342.0000 0.7000 342.1980 0.7000 342.3000 1.3000 342.4980 1.3000 342.6000 0.7000 342.7980 0.7000 342.9000 1.3000 343.0980 1.3000 343.2000 0.7000 343.3980 0.7000 343.5000 1.3000 343.6980 1.3000 343.8000 0.7000 343.9980 0.7000 344.1000 1.3000 344.2980 1.3000 344.4000 0.7000 344.5980 0.7000 344.7000 1.3000 344.8980 1.3000 345.0000 0.7000 345.1980 0.7000 345.3000 1.3000 345.4980 1.3000 345.6000 0.7000 345.7980 0.7000 345.9000 1.3000 346.0980 1.3000 346.2000 0.7000 346.3980 0.7000 346.5000 1.3000 346.6980 1.3000 346.8000 0.7000 346.9980 0.7000 347.1000 1.3000 347.2980 1.3000 347.4000 0.7000 347.5980 0.7000 347.7000 1.3000 347.8980 1.3000 348.0000 0.7000 348.1980 0.7000 348.3000 1.3000 348.4980 1.3000 348.6000 0.7000 348.7980 0.7000 348.9000 1.3000 349.0980 1.3000 349.2000 0.7000 349.3980 0.7000 349.5000 1.3000 349.6980 1.3000 349.8000 0.7000 349.9980 0.7000 350.1000 1.3000 350.2980 1.3000 350.4000 0.7000 350.5980 0.7000 350.7000 1.3000 350.8980 1.3000 351.0000 0.7000 351.1980 0.7000 351.3000 1.3000 351.4980 1.3000 351.6000 0.7000 351.7980 0.7000 351.9000 1.3000 352.0980 1.3000 352.2000 0.7000 352.3980 0.7000 352.5000 1.3000 352.6980 1.3000 352.8000 0.7000 352.9980 0.7000 353.1000 1.3000 353.2980 1.3000 353.4000 0.7000 353.5980 0.7000 353.7000 1.3000 353.8980 1.3000 354.0000 0.7000 354.1980 0.7000 354.3000 1.3000 354.4980 1.3000 354.6000 0.7000 354.7980 0.7000 354.9000 1.3000 355.0980 1.3000 355.2000 0.7000 355.3980 0.7000 355.5000 1.3000 355.6980 1.3000 355.8000 0.7000 355.9980 0.7000 356.1000 1.3000 356.2980 1.3000 356.4000 0.7000 356.5980 0.7000 356.7000 1.3000 356.8980 1.3000 357.0000 0.7000 357.1980 0.7000 357.3000 1.3000 357.4980 1.3000 357.6000 0.7000 357.7980 0.7000 357.9000 1.3000 358.0980 1.3000 358.2000 0.7000 358.3980 0.7000 358.5000 1.3000 358.6980 1.3000 358.8000 0.7000 358.9980 0.7000 359.1000 1.3000 359.2980 1.3000 359.4000 0.7000 359.5980 0.7000 359.7000 1.3000 359.8980 1.3000 360.0000 1.3000)
Vtg tg 0 PWL(0.0000 0.0000 0.1980 0.0000 0.3000 1.0000 0.4980 1.0000 0.6000 1.0000 0.7980 1.0000 0.9000 0.0000 1.0980 0.0000 1.2000 0.0000 1.3980 0.0000 1.5000 1.0000 1.6980 1.0000 1.8000 1.0000 1.9980 1.0000 2.1000 0.0000 2.2980 0.0000 2.4000 0.0000 2.5980 0.0000 2.7000 1.0000 2.8980 1.0000 3.0000 1.0000 3.1980 1.0000 3.3000 0.0000 3.4980 0.0000 3.6000 0.0000 3.7980 0.0000 3.9000 1.0000 4.0980 1.0000 4.2000 1.0000 4.3980 1.0000 4.5000 0.0000 4.6980 0.0000 4.8000 0.0000 4.9980 0.0000 5.1000 1.0000 5.2980 1.0000 5.4000 1.0000 5.5980 1.0000 5.7000 0.0000 5.8980 0.0000 6.0000 0.0000 6.1980 0.0000 6.3000 1.0000 6.4980 1.0000 6.6000 1.0000 6.7980 1.0000 6.9000 0.0000 7.0980 0.0000 7.2000 0.0000 7.3980 0.0000 7.5000 1.0000 7.6980 1.0000 7.8000 1.0000 7.9980 1.0000 8.1000 0.0000 8.2980 0.0000 8.4000 0.0000 8.5980 0.0000 8.7000 1.0000 8.8980 1.0000 9.0000 1.0000 9.1980 1.0000 9.3000 0.0000 9.4980 0.0000 9.6000 0.0000 9.7980 0.0000 9.9000 1.0000 10.0980 1.0000 10.2000 1.0000 10.3980 1.0000 10.5000 0.0000 10.6980 0.0000 10.8000 0.0000 10.9980 0.0000 11.1000 1.0000 11.2980 1.0000 11.4000 1.0000 11.5980 1.0000 11.7000 0.0000 11.8980 0.0000 12.0000 0.0000 12.1980 0.0000 12.3000 1.0000 12.4980 1.0000 12.6000 1.0000 12.7980 1.0000 12.9000 0.0000 13.0980 0.0000 13.2000 0.0000 13.3980 0.0000 13.5000 1.0000 13.6980 1.0000 13.8000 1.0000 13.9980 1.0000 14.1000 0.0000 14.2980 0.0000 14.4000 0.0000 14.5980 0.0000 14.7000 1.0000 14.8980 1.0000 15.0000 1.0000 15.1980 1.0000 15.3000 0.0000 15.4980 0.0000 15.6000 0.0000 15.7980 0.0000 15.9000 1.0000 16.0980 1.0000 16.2000 1.0000 16.3980 1.0000 16.5000 0.0000 16.6980 0.0000 16.8000 0.0000 16.9980 0.0000 17.1000 1.0000 17.2980 1.0000 17.4000 1.0000 17.5980 1.0000 17.7000 0.0000 17.8980 0.0000 18.0000 0.0000 18.1980 0.0000 18.3000 1.0000 18.4980 1.0000 18.6000 1.0000 18.7980 1.0000 18.9000 0.0000 19.0980 0.0000 19.2000 0.0000 19.3980 0.0000 19.5000 1.0000 19.6980 1.0000 19.8000 1.0000 19.9980 1.0000 20.1000 0.0000 20.2980 0.0000 20.4000 0.0000 20.5980 0.0000 20.7000 1.0000 20.8980 1.0000 21.0000 1.0000 21.1980 1.0000 21.3000 0.0000 21.4980 0.0000 21.6000 0.0000 21.7980 0.0000 21.9000 1.0000 22.0980 1.0000 22.2000 1.0000 22.3980 1.0000 22.5000 0.0000 22.6980 0.0000 22.8000 0.0000 22.9980 0.0000 23.1000 1.0000 23.2980 1.0000 23.4000 1.0000 23.5980 1.0000 23.7000 0.0000 23.8980 0.0000 24.0000 0.0000 24.1980 0.0000 24.3000 1.0000 24.4980 1.0000 24.6000 1.0000 24.7980 1.0000 24.9000 0.0000 25.0980 0.0000 25.2000 0.0000 25.3980 0.0000 25.5000 1.0000 25.6980 1.0000 25.8000 1.0000 25.9980 1.0000 26.1000 0.0000 26.2980 0.0000 26.4000 0.0000 26.5980 0.0000 26.7000 1.0000 26.8980 1.0000 27.0000 1.0000 27.1980 1.0000 27.3000 0.0000 27.4980 0.0000 27.6000 0.0000 27.7980 0.0000 27.9000 1.0000 28.0980 1.0000 28.2000 1.0000 28.3980 1.0000 28.5000 0.0000 28.6980 0.0000 28.8000 0.0000 28.9980 0.0000 29.1000 1.0000 29.2980 1.0000 29.4000 1.0000 29.5980 1.0000 29.7000 0.0000 29.8980 0.0000 30.0000 0.0000 30.1980 0.0000 30.3000 1.0000 30.4980 1.0000 30.6000 1.0000 30.7980 1.0000 30.9000 0.0000 31.0980 0.0000 31.2000 0.0000 31.3980 0.0000 31.5000 1.0000 31.6980 1.0000 31.8000 1.0000 31.9980 1.0000 32.1000 0.0000 32.2980 0.0000 32.4000 0.0000 32.5980 0.0000 32.7000 1.0000 32.8980 1.0000 33.0000 1.0000 33.1980 1.0000 33.3000 0.0000 33.4980 0.0000 33.6000 0.0000 33.7980 0.0000 33.9000 1.0000 34.0980 1.0000 34.2000 1.0000 34.3980 1.0000 34.5000 0.0000 34.6980 0.0000 34.8000 0.0000 34.9980 0.0000 35.1000 1.0000 35.2980 1.0000 35.4000 1.0000 35.5980 1.0000 35.7000 0.0000 35.8980 0.0000 36.0000 0.0000 36.1980 0.0000 36.3000 1.0000 36.4980 1.0000 36.6000 1.0000 36.7980 1.0000 36.9000 0.0000 37.0980 0.0000 37.2000 0.0000 37.3980 0.0000 37.5000 1.0000 37.6980 1.0000 37.8000 1.0000 37.9980 1.0000 38.1000 0.0000 38.2980 0.0000 38.4000 0.0000 38.5980 0.0000 38.7000 1.0000 38.8980 1.0000 39.0000 1.0000 39.1980 1.0000 39.3000 0.0000 39.4980 0.0000 39.6000 0.0000 39.7980 0.0000 39.9000 1.0000 40.0980 1.0000 40.2000 1.0000 40.3980 1.0000 40.5000 0.0000 40.6980 0.0000 40.8000 0.0000 40.9980 0.0000 41.1000 1.0000 41.2980 1.0000 41.4000 1.0000 41.5980 1.0000 41.7000 0.0000 41.8980 0.0000 42.0000 0.0000 42.1980 0.0000 42.3000 1.0000 42.4980 1.0000 42.6000 1.0000 42.7980 1.0000 42.9000 0.0000 43.0980 0.0000 43.2000 0.0000 43.3980 0.0000 43.5000 1.0000 43.6980 1.0000 43.8000 1.0000 43.9980 1.0000 44.1000 0.0000 44.2980 0.0000 44.4000 0.0000 44.5980 0.0000 44.7000 1.0000 44.8980 1.0000 45.0000 1.0000 45.1980 1.0000 45.3000 0.0000 45.4980 0.0000 45.6000 0.0000 45.7980 0.0000 45.9000 1.0000 46.0980 1.0000 46.2000 1.0000 46.3980 1.0000 46.5000 0.0000 46.6980 0.0000 46.8000 0.0000 46.9980 0.0000 47.1000 1.0000 47.2980 1.0000 47.4000 1.0000 47.5980 1.0000 47.7000 0.0000 47.8980 0.0000 48.0000 0.0000 48.1980 0.0000 48.3000 1.0000 48.4980 1.0000 48.6000 1.0000 48.7980 1.0000 48.9000 0.0000 49.0980 0.0000 49.2000 0.0000 49.3980 0.0000 49.5000 1.0000 49.6980 1.0000 49.8000 1.0000 49.9980 1.0000 50.1000 0.0000 50.2980 0.0000 50.4000 0.0000 50.5980 0.0000 50.7000 1.0000 50.8980 1.0000 51.0000 1.0000 51.1980 1.0000 51.3000 0.0000 51.4980 0.0000 51.6000 0.0000 51.7980 0.0000 51.9000 1.0000 52.0980 1.0000 52.2000 1.0000 52.3980 1.0000 52.5000 0.0000 52.6980 0.0000 52.8000 0.0000 52.9980 0.0000 53.1000 1.0000 53.2980 1.0000 53.4000 1.0000 53.5980 1.0000 53.7000 0.0000 53.8980 0.0000 54.0000 0.0000 54.1980 0.0000 54.3000 1.0000 54.4980 1.0000 54.6000 1.0000 54.7980 1.0000 54.9000 0.0000 55.0980 0.0000 55.2000 0.0000 55.3980 0.0000 55.5000 1.0000 55.6980 1.0000 55.8000 1.0000 55.9980 1.0000 56.1000 0.0000 56.2980 0.0000 56.4000 0.0000 56.5980 0.0000 56.7000 1.0000 56.8980 1.0000 57.0000 1.0000 57.1980 1.0000 57.3000 0.0000 57.4980 0.0000 57.6000 0.0000 57.7980 0.0000 57.9000 1.0000 58.0980 1.0000 58.2000 1.0000 58.3980 1.0000 58.5000 0.0000 58.6980 0.0000 58.8000 0.0000 58.9980 0.0000 59.1000 1.0000 59.2980 1.0000 59.4000 1.0000 59.5980 1.0000 59.7000 0.0000 59.8980 0.0000 60.0000 0.0000 60.1980 0.0000 60.3000 1.0000 60.4980 1.0000 60.6000 1.0000 60.7980 1.0000 60.9000 0.0000 61.0980 0.0000 61.2000 0.0000 61.3980 0.0000 61.5000 1.0000 61.6980 1.0000 61.8000 1.0000 61.9980 1.0000 62.1000 0.0000 62.2980 0.0000 62.4000 0.0000 62.5980 0.0000 62.7000 1.0000 62.8980 1.0000 63.0000 1.0000 63.1980 1.0000 63.3000 0.0000 63.4980 0.0000 63.6000 0.0000 63.7980 0.0000 63.9000 1.0000 64.0980 1.0000 64.2000 1.0000 64.3980 1.0000 64.5000 0.0000 64.6980 0.0000 64.8000 0.0000 64.9980 0.0000 65.1000 1.0000 65.2980 1.0000 65.4000 1.0000 65.5980 1.0000 65.7000 0.0000 65.8980 0.0000 66.0000 0.0000 66.1980 0.0000 66.3000 1.0000 66.4980 1.0000 66.6000 1.0000 66.7980 1.0000 66.9000 0.0000 67.0980 0.0000 67.2000 0.0000 67.3980 0.0000 67.5000 1.0000 67.6980 1.0000 67.8000 1.0000 67.9980 1.0000 68.1000 0.0000 68.2980 0.0000 68.4000 0.0000 68.5980 0.0000 68.7000 1.0000 68.8980 1.0000 69.0000 1.0000 69.1980 1.0000 69.3000 0.0000 69.4980 0.0000 69.6000 0.0000 69.7980 0.0000 69.9000 1.0000 70.0980 1.0000 70.2000 1.0000 70.3980 1.0000 70.5000 0.0000 70.6980 0.0000 70.8000 0.0000 70.9980 0.0000 71.1000 1.0000 71.2980 1.0000 71.4000 1.0000 71.5980 1.0000 71.7000 0.0000 71.8980 0.0000 72.0000 0.0000 72.1980 0.0000 72.3000 1.0000 72.4980 1.0000 72.6000 1.0000 72.7980 1.0000 72.9000 0.0000 73.0980 0.0000 73.2000 0.0000 73.3980 0.0000 73.5000 1.0000 73.6980 1.0000 73.8000 1.0000 73.9980 1.0000 74.1000 0.0000 74.2980 0.0000 74.4000 0.0000 74.5980 0.0000 74.7000 1.0000 74.8980 1.0000 75.0000 1.0000 75.1980 1.0000 75.3000 0.0000 75.4980 0.0000 75.6000 0.0000 75.7980 0.0000 75.9000 1.0000 76.0980 1.0000 76.2000 1.0000 76.3980 1.0000 76.5000 0.0000 76.6980 0.0000 76.8000 0.0000 76.9980 0.0000 77.1000 1.0000 77.2980 1.0000 77.4000 1.0000 77.5980 1.0000 77.7000 0.0000 77.8980 0.0000 78.0000 0.0000 78.1980 0.0000 78.3000 1.0000 78.4980 1.0000 78.6000 1.0000 78.7980 1.0000 78.9000 0.0000 79.0980 0.0000 79.2000 0.0000 79.3980 0.0000 79.5000 1.0000 79.6980 1.0000 79.8000 1.0000 79.9980 1.0000 80.1000 0.0000 80.2980 0.0000 80.4000 0.0000 80.5980 0.0000 80.7000 1.0000 80.8980 1.0000 81.0000 1.0000 81.1980 1.0000 81.3000 0.0000 81.4980 0.0000 81.6000 0.0000 81.7980 0.0000 81.9000 1.0000 82.0980 1.0000 82.2000 1.0000 82.3980 1.0000 82.5000 0.0000 82.6980 0.0000 82.8000 0.0000 82.9980 0.0000 83.1000 1.0000 83.2980 1.0000 83.4000 1.0000 83.5980 1.0000 83.7000 0.0000 83.8980 0.0000 84.0000 0.0000 84.1980 0.0000 84.3000 1.0000 84.4980 1.0000 84.6000 1.0000 84.7980 1.0000 84.9000 0.0000 85.0980 0.0000 85.2000 0.0000 85.3980 0.0000 85.5000 1.0000 85.6980 1.0000 85.8000 1.0000 85.9980 1.0000 86.1000 0.0000 86.2980 0.0000 86.4000 0.0000 86.5980 0.0000 86.7000 1.0000 86.8980 1.0000 87.0000 1.0000 87.1980 1.0000 87.3000 0.0000 87.4980 0.0000 87.6000 0.0000 87.7980 0.0000 87.9000 1.0000 88.0980 1.0000 88.2000 1.0000 88.3980 1.0000 88.5000 0.0000 88.6980 0.0000 88.8000 0.0000 88.9980 0.0000 89.1000 1.0000 89.2980 1.0000 89.4000 1.0000 89.5980 1.0000 89.7000 0.0000 89.8980 0.0000 90.0000 0.0000 90.1980 0.0000 90.3000 1.0000 90.4980 1.0000 90.6000 1.0000 90.7980 1.0000 90.9000 0.0000 91.0980 0.0000 91.2000 0.0000 91.3980 0.0000 91.5000 1.0000 91.6980 1.0000 91.8000 1.0000 91.9980 1.0000 92.1000 0.0000 92.2980 0.0000 92.4000 0.0000 92.5980 0.0000 92.7000 1.0000 92.8980 1.0000 93.0000 1.0000 93.1980 1.0000 93.3000 0.0000 93.4980 0.0000 93.6000 0.0000 93.7980 0.0000 93.9000 1.0000 94.0980 1.0000 94.2000 1.0000 94.3980 1.0000 94.5000 0.0000 94.6980 0.0000 94.8000 0.0000 94.9980 0.0000 95.1000 1.0000 95.2980 1.0000 95.4000 1.0000 95.5980 1.0000 95.7000 0.0000 95.8980 0.0000 96.0000 0.0000 96.1980 0.0000 96.3000 1.0000 96.4980 1.0000 96.6000 1.0000 96.7980 1.0000 96.9000 0.0000 97.0980 0.0000 97.2000 0.0000 97.3980 0.0000 97.5000 1.0000 97.6980 1.0000 97.8000 1.0000 97.9980 1.0000 98.1000 0.0000 98.2980 0.0000 98.4000 0.0000 98.5980 0.0000 98.7000 1.0000 98.8980 1.0000 99.0000 1.0000 99.1980 1.0000 99.3000 0.0000 99.4980 0.0000 99.6000 0.0000 99.7980 0.0000 99.9000 1.0000 100.0980 1.0000 100.2000 1.0000 100.3980 1.0000 100.5000 0.0000 100.6980 0.0000 100.8000 0.0000 100.9980 0.0000 101.1000 1.0000 101.2980 1.0000 101.4000 1.0000 101.5980 1.0000 101.7000 0.0000 101.8980 0.0000 102.0000 0.0000 102.1980 0.0000 102.3000 1.0000 102.4980 1.0000 102.6000 1.0000 102.7980 1.0000 102.9000 0.0000 103.0980 0.0000 103.2000 0.0000 103.3980 0.0000 103.5000 1.0000 103.6980 1.0000 103.8000 1.0000 103.9980 1.0000 104.1000 0.0000 104.2980 0.0000 104.4000 0.0000 104.5980 0.0000 104.7000 1.0000 104.8980 1.0000 105.0000 1.0000 105.1980 1.0000 105.3000 0.0000 105.4980 0.0000 105.6000 0.0000 105.7980 0.0000 105.9000 1.0000 106.0980 1.0000 106.2000 1.0000 106.3980 1.0000 106.5000 0.0000 106.6980 0.0000 106.8000 0.0000 106.9980 0.0000 107.1000 1.0000 107.2980 1.0000 107.4000 1.0000 107.5980 1.0000 107.7000 0.0000 107.8980 0.0000 108.0000 0.0000 108.1980 0.0000 108.3000 1.0000 108.4980 1.0000 108.6000 1.0000 108.7980 1.0000 108.9000 0.0000 109.0980 0.0000 109.2000 0.0000 109.3980 0.0000 109.5000 1.0000 109.6980 1.0000 109.8000 1.0000 109.9980 1.0000 110.1000 0.0000 110.2980 0.0000 110.4000 0.0000 110.5980 0.0000 110.7000 1.0000 110.8980 1.0000 111.0000 1.0000 111.1980 1.0000 111.3000 0.0000 111.4980 0.0000 111.6000 0.0000 111.7980 0.0000 111.9000 1.0000 112.0980 1.0000 112.2000 1.0000 112.3980 1.0000 112.5000 0.0000 112.6980 0.0000 112.8000 0.0000 112.9980 0.0000 113.1000 1.0000 113.2980 1.0000 113.4000 1.0000 113.5980 1.0000 113.7000 0.0000 113.8980 0.0000 114.0000 0.0000 114.1980 0.0000 114.3000 1.0000 114.4980 1.0000 114.6000 1.0000 114.7980 1.0000 114.9000 0.0000 115.0980 0.0000 115.2000 0.0000 115.3980 0.0000 115.5000 1.0000 115.6980 1.0000 115.8000 1.0000 115.9980 1.0000 116.1000 0.0000 116.2980 0.0000 116.4000 0.0000 116.5980 0.0000 116.7000 1.0000 116.8980 1.0000 117.0000 1.0000 117.1980 1.0000 117.3000 0.0000 117.4980 0.0000 117.6000 0.0000 117.7980 0.0000 117.9000 1.0000 118.0980 1.0000 118.2000 1.0000 118.3980 1.0000 118.5000 0.0000 118.6980 0.0000 118.8000 0.0000 118.9980 0.0000 119.1000 1.0000 119.2980 1.0000 119.4000 1.0000 119.5980 1.0000 119.7000 0.0000 119.8980 0.0000 120.0000 0.0000 120.1980 0.0000 120.3000 1.0000 120.4980 1.0000 120.6000 1.0000 120.7980 1.0000 120.9000 0.0000 121.0980 0.0000 121.2000 0.0000 121.3980 0.0000 121.5000 1.0000 121.6980 1.0000 121.8000 1.0000 121.9980 1.0000 122.1000 0.0000 122.2980 0.0000 122.4000 0.0000 122.5980 0.0000 122.7000 1.0000 122.8980 1.0000 123.0000 1.0000 123.1980 1.0000 123.3000 0.0000 123.4980 0.0000 123.6000 0.0000 123.7980 0.0000 123.9000 1.0000 124.0980 1.0000 124.2000 1.0000 124.3980 1.0000 124.5000 0.0000 124.6980 0.0000 124.8000 0.0000 124.9980 0.0000 125.1000 1.0000 125.2980 1.0000 125.4000 1.0000 125.5980 1.0000 125.7000 0.0000 125.8980 0.0000 126.0000 0.0000 126.1980 0.0000 126.3000 1.0000 126.4980 1.0000 126.6000 1.0000 126.7980 1.0000 126.9000 0.0000 127.0980 0.0000 127.2000 0.0000 127.3980 0.0000 127.5000 1.0000 127.6980 1.0000 127.8000 1.0000 127.9980 1.0000 128.1000 0.0000 128.2980 0.0000 128.4000 0.0000 128.5980 0.0000 128.7000 1.0000 128.8980 1.0000 129.0000 1.0000 129.1980 1.0000 129.3000 0.0000 129.4980 0.0000 129.6000 0.0000 129.7980 0.0000 129.9000 1.0000 130.0980 1.0000 130.2000 1.0000 130.3980 1.0000 130.5000 0.0000 130.6980 0.0000 130.8000 0.0000 130.9980 0.0000 131.1000 1.0000 131.2980 1.0000 131.4000 1.0000 131.5980 1.0000 131.7000 0.0000 131.8980 0.0000 132.0000 0.0000 132.1980 0.0000 132.3000 1.0000 132.4980 1.0000 132.6000 1.0000 132.7980 1.0000 132.9000 0.0000 133.0980 0.0000 133.2000 0.0000 133.3980 0.0000 133.5000 1.0000 133.6980 1.0000 133.8000 1.0000 133.9980 1.0000 134.1000 0.0000 134.2980 0.0000 134.4000 0.0000 134.5980 0.0000 134.7000 1.0000 134.8980 1.0000 135.0000 1.0000 135.1980 1.0000 135.3000 0.0000 135.4980 0.0000 135.6000 0.0000 135.7980 0.0000 135.9000 1.0000 136.0980 1.0000 136.2000 1.0000 136.3980 1.0000 136.5000 0.0000 136.6980 0.0000 136.8000 0.0000 136.9980 0.0000 137.1000 1.0000 137.2980 1.0000 137.4000 1.0000 137.5980 1.0000 137.7000 0.0000 137.8980 0.0000 138.0000 0.0000 138.1980 0.0000 138.3000 1.0000 138.4980 1.0000 138.6000 1.0000 138.7980 1.0000 138.9000 0.0000 139.0980 0.0000 139.2000 0.0000 139.3980 0.0000 139.5000 1.0000 139.6980 1.0000 139.8000 1.0000 139.9980 1.0000 140.1000 0.0000 140.2980 0.0000 140.4000 0.0000 140.5980 0.0000 140.7000 1.0000 140.8980 1.0000 141.0000 1.0000 141.1980 1.0000 141.3000 0.0000 141.4980 0.0000 141.6000 0.0000 141.7980 0.0000 141.9000 1.0000 142.0980 1.0000 142.2000 1.0000 142.3980 1.0000 142.5000 0.0000 142.6980 0.0000 142.8000 0.0000 142.9980 0.0000 143.1000 1.0000 143.2980 1.0000 143.4000 1.0000 143.5980 1.0000 143.7000 0.0000 143.8980 0.0000 144.0000 0.0000 144.1980 0.0000 144.3000 1.0000 144.4980 1.0000 144.6000 1.0000 144.7980 1.0000 144.9000 0.0000 145.0980 0.0000 145.2000 0.0000 145.3980 0.0000 145.5000 1.0000 145.6980 1.0000 145.8000 1.0000 145.9980 1.0000 146.1000 0.0000 146.2980 0.0000 146.4000 0.0000 146.5980 0.0000 146.7000 1.0000 146.8980 1.0000 147.0000 1.0000 147.1980 1.0000 147.3000 0.0000 147.4980 0.0000 147.6000 0.0000 147.7980 0.0000 147.9000 1.0000 148.0980 1.0000 148.2000 1.0000 148.3980 1.0000 148.5000 0.0000 148.6980 0.0000 148.8000 0.0000 148.9980 0.0000 149.1000 1.0000 149.2980 1.0000 149.4000 1.0000 149.5980 1.0000 149.7000 0.0000 149.8980 0.0000 150.0000 0.0000 150.1980 0.0000 150.3000 1.0000 150.4980 1.0000 150.6000 1.0000 150.7980 1.0000 150.9000 0.0000 151.0980 0.0000 151.2000 0.0000 151.3980 0.0000 151.5000 1.0000 151.6980 1.0000 151.8000 1.0000 151.9980 1.0000 152.1000 0.0000 152.2980 0.0000 152.4000 0.0000 152.5980 0.0000 152.7000 1.0000 152.8980 1.0000 153.0000 1.0000 153.1980 1.0000 153.3000 0.0000 153.4980 0.0000 153.6000 0.0000 153.7980 0.0000 153.9000 1.0000 154.0980 1.0000 154.2000 1.0000 154.3980 1.0000 154.5000 0.0000 154.6980 0.0000 154.8000 0.0000 154.9980 0.0000 155.1000 1.0000 155.2980 1.0000 155.4000 1.0000 155.5980 1.0000 155.7000 0.0000 155.8980 0.0000 156.0000 0.0000 156.1980 0.0000 156.3000 1.0000 156.4980 1.0000 156.6000 1.0000 156.7980 1.0000 156.9000 0.0000 157.0980 0.0000 157.2000 0.0000 157.3980 0.0000 157.5000 1.0000 157.6980 1.0000 157.8000 1.0000 157.9980 1.0000 158.1000 0.0000 158.2980 0.0000 158.4000 0.0000 158.5980 0.0000 158.7000 1.0000 158.8980 1.0000 159.0000 1.0000 159.1980 1.0000 159.3000 0.0000 159.4980 0.0000 159.6000 0.0000 159.7980 0.0000 159.9000 1.0000 160.0980 1.0000 160.2000 1.0000 160.3980 1.0000 160.5000 0.0000 160.6980 0.0000 160.8000 0.0000 160.9980 0.0000 161.1000 1.0000 161.2980 1.0000 161.4000 1.0000 161.5980 1.0000 161.7000 0.0000 161.8980 0.0000 162.0000 0.0000 162.1980 0.0000 162.3000 1.0000 162.4980 1.0000 162.6000 1.0000 162.7980 1.0000 162.9000 0.0000 163.0980 0.0000 163.2000 0.0000 163.3980 0.0000 163.5000 1.0000 163.6980 1.0000 163.8000 1.0000 163.9980 1.0000 164.1000 0.0000 164.2980 0.0000 164.4000 0.0000 164.5980 0.0000 164.7000 1.0000 164.8980 1.0000 165.0000 1.0000 165.1980 1.0000 165.3000 0.0000 165.4980 0.0000 165.6000 0.0000 165.7980 0.0000 165.9000 1.0000 166.0980 1.0000 166.2000 1.0000 166.3980 1.0000 166.5000 0.0000 166.6980 0.0000 166.8000 0.0000 166.9980 0.0000 167.1000 1.0000 167.2980 1.0000 167.4000 1.0000 167.5980 1.0000 167.7000 0.0000 167.8980 0.0000 168.0000 0.0000 168.1980 0.0000 168.3000 1.0000 168.4980 1.0000 168.6000 1.0000 168.7980 1.0000 168.9000 0.0000 169.0980 0.0000 169.2000 0.0000 169.3980 0.0000 169.5000 1.0000 169.6980 1.0000 169.8000 1.0000 169.9980 1.0000 170.1000 0.0000 170.2980 0.0000 170.4000 0.0000 170.5980 0.0000 170.7000 1.0000 170.8980 1.0000 171.0000 1.0000 171.1980 1.0000 171.3000 0.0000 171.4980 0.0000 171.6000 0.0000 171.7980 0.0000 171.9000 1.0000 172.0980 1.0000 172.2000 1.0000 172.3980 1.0000 172.5000 0.0000 172.6980 0.0000 172.8000 0.0000 172.9980 0.0000 173.1000 1.0000 173.2980 1.0000 173.4000 1.0000 173.5980 1.0000 173.7000 0.0000 173.8980 0.0000 174.0000 0.0000 174.1980 0.0000 174.3000 1.0000 174.4980 1.0000 174.6000 1.0000 174.7980 1.0000 174.9000 0.0000 175.0980 0.0000 175.2000 0.0000 175.3980 0.0000 175.5000 1.0000 175.6980 1.0000 175.8000 1.0000 175.9980 1.0000 176.1000 0.0000 176.2980 0.0000 176.4000 0.0000 176.5980 0.0000 176.7000 1.0000 176.8980 1.0000 177.0000 1.0000 177.1980 1.0000 177.3000 0.0000 177.4980 0.0000 177.6000 0.0000 177.7980 0.0000 177.9000 1.0000 178.0980 1.0000 178.2000 1.0000 178.3980 1.0000 178.5000 0.0000 178.6980 0.0000 178.8000 0.0000 178.9980 0.0000 179.1000 1.0000 179.2980 1.0000 179.4000 1.0000 179.5980 1.0000 179.7000 0.0000 179.8980 0.0000 180.0000 0.0000 180.1980 0.0000 180.3000 1.0000 180.4980 1.0000 180.6000 1.0000 180.7980 1.0000 180.9000 0.0000 181.0980 0.0000 181.2000 0.0000 181.3980 0.0000 181.5000 1.0000 181.6980 1.0000 181.8000 1.0000 181.9980 1.0000 182.1000 0.0000 182.2980 0.0000 182.4000 0.0000 182.5980 0.0000 182.7000 1.0000 182.8980 1.0000 183.0000 1.0000 183.1980 1.0000 183.3000 0.0000 183.4980 0.0000 183.6000 0.0000 183.7980 0.0000 183.9000 1.0000 184.0980 1.0000 184.2000 1.0000 184.3980 1.0000 184.5000 0.0000 184.6980 0.0000 184.8000 0.0000 184.9980 0.0000 185.1000 1.0000 185.2980 1.0000 185.4000 1.0000 185.5980 1.0000 185.7000 0.0000 185.8980 0.0000 186.0000 0.0000 186.1980 0.0000 186.3000 1.0000 186.4980 1.0000 186.6000 1.0000 186.7980 1.0000 186.9000 0.0000 187.0980 0.0000 187.2000 0.0000 187.3980 0.0000 187.5000 1.0000 187.6980 1.0000 187.8000 1.0000 187.9980 1.0000 188.1000 0.0000 188.2980 0.0000 188.4000 0.0000 188.5980 0.0000 188.7000 1.0000 188.8980 1.0000 189.0000 1.0000 189.1980 1.0000 189.3000 0.0000 189.4980 0.0000 189.6000 0.0000 189.7980 0.0000 189.9000 1.0000 190.0980 1.0000 190.2000 1.0000 190.3980 1.0000 190.5000 0.0000 190.6980 0.0000 190.8000 0.0000 190.9980 0.0000 191.1000 1.0000 191.2980 1.0000 191.4000 1.0000 191.5980 1.0000 191.7000 0.0000 191.8980 0.0000 192.0000 0.0000 192.1980 0.0000 192.3000 1.0000 192.4980 1.0000 192.6000 1.0000 192.7980 1.0000 192.9000 0.0000 193.0980 0.0000 193.2000 0.0000 193.3980 0.0000 193.5000 1.0000 193.6980 1.0000 193.8000 1.0000 193.9980 1.0000 194.1000 0.0000 194.2980 0.0000 194.4000 0.0000 194.5980 0.0000 194.7000 1.0000 194.8980 1.0000 195.0000 1.0000 195.1980 1.0000 195.3000 0.0000 195.4980 0.0000 195.6000 0.0000 195.7980 0.0000 195.9000 1.0000 196.0980 1.0000 196.2000 1.0000 196.3980 1.0000 196.5000 0.0000 196.6980 0.0000 196.8000 0.0000 196.9980 0.0000 197.1000 1.0000 197.2980 1.0000 197.4000 1.0000 197.5980 1.0000 197.7000 0.0000 197.8980 0.0000 198.0000 0.0000 198.1980 0.0000 198.3000 1.0000 198.4980 1.0000 198.6000 1.0000 198.7980 1.0000 198.9000 0.0000 199.0980 0.0000 199.2000 0.0000 199.3980 0.0000 199.5000 1.0000 199.6980 1.0000 199.8000 1.0000 199.9980 1.0000 200.1000 0.0000 200.2980 0.0000 200.4000 0.0000 200.5980 0.0000 200.7000 1.0000 200.8980 1.0000 201.0000 1.0000 201.1980 1.0000 201.3000 0.0000 201.4980 0.0000 201.6000 0.0000 201.7980 0.0000 201.9000 1.0000 202.0980 1.0000 202.2000 1.0000 202.3980 1.0000 202.5000 0.0000 202.6980 0.0000 202.8000 0.0000 202.9980 0.0000 203.1000 1.0000 203.2980 1.0000 203.4000 1.0000 203.5980 1.0000 203.7000 0.0000 203.8980 0.0000 204.0000 0.0000 204.1980 0.0000 204.3000 1.0000 204.4980 1.0000 204.6000 1.0000 204.7980 1.0000 204.9000 0.0000 205.0980 0.0000 205.2000 0.0000 205.3980 0.0000 205.5000 1.0000 205.6980 1.0000 205.8000 1.0000 205.9980 1.0000 206.1000 0.0000 206.2980 0.0000 206.4000 0.0000 206.5980 0.0000 206.7000 1.0000 206.8980 1.0000 207.0000 1.0000 207.1980 1.0000 207.3000 0.0000 207.4980 0.0000 207.6000 0.0000 207.7980 0.0000 207.9000 1.0000 208.0980 1.0000 208.2000 1.0000 208.3980 1.0000 208.5000 0.0000 208.6980 0.0000 208.8000 0.0000 208.9980 0.0000 209.1000 1.0000 209.2980 1.0000 209.4000 1.0000 209.5980 1.0000 209.7000 0.0000 209.8980 0.0000 210.0000 0.0000 210.1980 0.0000 210.3000 1.0000 210.4980 1.0000 210.6000 1.0000 210.7980 1.0000 210.9000 0.0000 211.0980 0.0000 211.2000 0.0000 211.3980 0.0000 211.5000 1.0000 211.6980 1.0000 211.8000 1.0000 211.9980 1.0000 212.1000 0.0000 212.2980 0.0000 212.4000 0.0000 212.5980 0.0000 212.7000 1.0000 212.8980 1.0000 213.0000 1.0000 213.1980 1.0000 213.3000 0.0000 213.4980 0.0000 213.6000 0.0000 213.7980 0.0000 213.9000 1.0000 214.0980 1.0000 214.2000 1.0000 214.3980 1.0000 214.5000 0.0000 214.6980 0.0000 214.8000 0.0000 214.9980 0.0000 215.1000 1.0000 215.2980 1.0000 215.4000 1.0000 215.5980 1.0000 215.7000 0.0000 215.8980 0.0000 216.0000 0.0000 216.1980 0.0000 216.3000 1.0000 216.4980 1.0000 216.6000 1.0000 216.7980 1.0000 216.9000 0.0000 217.0980 0.0000 217.2000 0.0000 217.3980 0.0000 217.5000 1.0000 217.6980 1.0000 217.8000 1.0000 217.9980 1.0000 218.1000 0.0000 218.2980 0.0000 218.4000 0.0000 218.5980 0.0000 218.7000 1.0000 218.8980 1.0000 219.0000 1.0000 219.1980 1.0000 219.3000 0.0000 219.4980 0.0000 219.6000 0.0000 219.7980 0.0000 219.9000 1.0000 220.0980 1.0000 220.2000 1.0000 220.3980 1.0000 220.5000 0.0000 220.6980 0.0000 220.8000 0.0000 220.9980 0.0000 221.1000 1.0000 221.2980 1.0000 221.4000 1.0000 221.5980 1.0000 221.7000 0.0000 221.8980 0.0000 222.0000 0.0000 222.1980 0.0000 222.3000 1.0000 222.4980 1.0000 222.6000 1.0000 222.7980 1.0000 222.9000 0.0000 223.0980 0.0000 223.2000 0.0000 223.3980 0.0000 223.5000 1.0000 223.6980 1.0000 223.8000 1.0000 223.9980 1.0000 224.1000 0.0000 224.2980 0.0000 224.4000 0.0000 224.5980 0.0000 224.7000 1.0000 224.8980 1.0000 225.0000 1.0000 225.1980 1.0000 225.3000 0.0000 225.4980 0.0000 225.6000 0.0000 225.7980 0.0000 225.9000 1.0000 226.0980 1.0000 226.2000 1.0000 226.3980 1.0000 226.5000 0.0000 226.6980 0.0000 226.8000 0.0000 226.9980 0.0000 227.1000 1.0000 227.2980 1.0000 227.4000 1.0000 227.5980 1.0000 227.7000 0.0000 227.8980 0.0000 228.0000 0.0000 228.1980 0.0000 228.3000 1.0000 228.4980 1.0000 228.6000 1.0000 228.7980 1.0000 228.9000 0.0000 229.0980 0.0000 229.2000 0.0000 229.3980 0.0000 229.5000 1.0000 229.6980 1.0000 229.8000 1.0000 229.9980 1.0000 230.1000 0.0000 230.2980 0.0000 230.4000 0.0000 230.5980 0.0000 230.7000 1.0000 230.8980 1.0000 231.0000 1.0000 231.1980 1.0000 231.3000 0.0000 231.4980 0.0000 231.6000 0.0000 231.7980 0.0000 231.9000 1.0000 232.0980 1.0000 232.2000 1.0000 232.3980 1.0000 232.5000 0.0000 232.6980 0.0000 232.8000 0.0000 232.9980 0.0000 233.1000 1.0000 233.2980 1.0000 233.4000 1.0000 233.5980 1.0000 233.7000 0.0000 233.8980 0.0000 234.0000 0.0000 234.1980 0.0000 234.3000 1.0000 234.4980 1.0000 234.6000 1.0000 234.7980 1.0000 234.9000 0.0000 235.0980 0.0000 235.2000 0.0000 235.3980 0.0000 235.5000 1.0000 235.6980 1.0000 235.8000 1.0000 235.9980 1.0000 236.1000 0.0000 236.2980 0.0000 236.4000 0.0000 236.5980 0.0000 236.7000 1.0000 236.8980 1.0000 237.0000 1.0000 237.1980 1.0000 237.3000 0.0000 237.4980 0.0000 237.6000 0.0000 237.7980 0.0000 237.9000 1.0000 238.0980 1.0000 238.2000 1.0000 238.3980 1.0000 238.5000 0.0000 238.6980 0.0000 238.8000 0.0000 238.9980 0.0000 239.1000 1.0000 239.2980 1.0000 239.4000 1.0000 239.5980 1.0000 239.7000 0.0000 239.8980 0.0000 240.0000 0.0000 240.1980 0.0000 240.3000 1.0000 240.4980 1.0000 240.6000 1.0000 240.7980 1.0000 240.9000 0.0000 241.0980 0.0000 241.2000 0.0000 241.3980 0.0000 241.5000 1.0000 241.6980 1.0000 241.8000 1.0000 241.9980 1.0000 242.1000 0.0000 242.2980 0.0000 242.4000 0.0000 242.5980 0.0000 242.7000 1.0000 242.8980 1.0000 243.0000 1.0000 243.1980 1.0000 243.3000 0.0000 243.4980 0.0000 243.6000 0.0000 243.7980 0.0000 243.9000 1.0000 244.0980 1.0000 244.2000 1.0000 244.3980 1.0000 244.5000 0.0000 244.6980 0.0000 244.8000 0.0000 244.9980 0.0000 245.1000 1.0000 245.2980 1.0000 245.4000 1.0000 245.5980 1.0000 245.7000 0.0000 245.8980 0.0000 246.0000 0.0000 246.1980 0.0000 246.3000 1.0000 246.4980 1.0000 246.6000 1.0000 246.7980 1.0000 246.9000 0.0000 247.0980 0.0000 247.2000 0.0000 247.3980 0.0000 247.5000 1.0000 247.6980 1.0000 247.8000 1.0000 247.9980 1.0000 248.1000 0.0000 248.2980 0.0000 248.4000 0.0000 248.5980 0.0000 248.7000 1.0000 248.8980 1.0000 249.0000 1.0000 249.1980 1.0000 249.3000 0.0000 249.4980 0.0000 249.6000 0.0000 249.7980 0.0000 249.9000 1.0000 250.0980 1.0000 250.2000 1.0000 250.3980 1.0000 250.5000 0.0000 250.6980 0.0000 250.8000 0.0000 250.9980 0.0000 251.1000 1.0000 251.2980 1.0000 251.4000 1.0000 251.5980 1.0000 251.7000 0.0000 251.8980 0.0000 252.0000 0.0000 252.1980 0.0000 252.3000 1.0000 252.4980 1.0000 252.6000 1.0000 252.7980 1.0000 252.9000 0.0000 253.0980 0.0000 253.2000 0.0000 253.3980 0.0000 253.5000 1.0000 253.6980 1.0000 253.8000 1.0000 253.9980 1.0000 254.1000 0.0000 254.2980 0.0000 254.4000 0.0000 254.5980 0.0000 254.7000 1.0000 254.8980 1.0000 255.0000 1.0000 255.1980 1.0000 255.3000 0.0000 255.4980 0.0000 255.6000 0.0000 255.7980 0.0000 255.9000 1.0000 256.0980 1.0000 256.2000 1.0000 256.3980 1.0000 256.5000 0.0000 256.6980 0.0000 256.8000 0.0000 256.9980 0.0000 257.1000 1.0000 257.2980 1.0000 257.4000 1.0000 257.5980 1.0000 257.7000 0.0000 257.8980 0.0000 258.0000 0.0000 258.1980 0.0000 258.3000 1.0000 258.4980 1.0000 258.6000 1.0000 258.7980 1.0000 258.9000 0.0000 259.0980 0.0000 259.2000 0.0000 259.3980 0.0000 259.5000 1.0000 259.6980 1.0000 259.8000 1.0000 259.9980 1.0000 260.1000 0.0000 260.2980 0.0000 260.4000 0.0000 260.5980 0.0000 260.7000 1.0000 260.8980 1.0000 261.0000 1.0000 261.1980 1.0000 261.3000 0.0000 261.4980 0.0000 261.6000 0.0000 261.7980 0.0000 261.9000 1.0000 262.0980 1.0000 262.2000 1.0000 262.3980 1.0000 262.5000 0.0000 262.6980 0.0000 262.8000 0.0000 262.9980 0.0000 263.1000 1.0000 263.2980 1.0000 263.4000 1.0000 263.5980 1.0000 263.7000 0.0000 263.8980 0.0000 264.0000 0.0000 264.1980 0.0000 264.3000 1.0000 264.4980 1.0000 264.6000 1.0000 264.7980 1.0000 264.9000 0.0000 265.0980 0.0000 265.2000 0.0000 265.3980 0.0000 265.5000 1.0000 265.6980 1.0000 265.8000 1.0000 265.9980 1.0000 266.1000 0.0000 266.2980 0.0000 266.4000 0.0000 266.5980 0.0000 266.7000 1.0000 266.8980 1.0000 267.0000 1.0000 267.1980 1.0000 267.3000 0.0000 267.4980 0.0000 267.6000 0.0000 267.7980 0.0000 267.9000 1.0000 268.0980 1.0000 268.2000 1.0000 268.3980 1.0000 268.5000 0.0000 268.6980 0.0000 268.8000 0.0000 268.9980 0.0000 269.1000 1.0000 269.2980 1.0000 269.4000 1.0000 269.5980 1.0000 269.7000 0.0000 269.8980 0.0000 270.0000 0.0000 270.1980 0.0000 270.3000 1.0000 270.4980 1.0000 270.6000 1.0000 270.7980 1.0000 270.9000 0.0000 271.0980 0.0000 271.2000 0.0000 271.3980 0.0000 271.5000 1.0000 271.6980 1.0000 271.8000 1.0000 271.9980 1.0000 272.1000 0.0000 272.2980 0.0000 272.4000 0.0000 272.5980 0.0000 272.7000 1.0000 272.8980 1.0000 273.0000 1.0000 273.1980 1.0000 273.3000 0.0000 273.4980 0.0000 273.6000 0.0000 273.7980 0.0000 273.9000 1.0000 274.0980 1.0000 274.2000 1.0000 274.3980 1.0000 274.5000 0.0000 274.6980 0.0000 274.8000 0.0000 274.9980 0.0000 275.1000 1.0000 275.2980 1.0000 275.4000 1.0000 275.5980 1.0000 275.7000 0.0000 275.8980 0.0000 276.0000 0.0000 276.1980 0.0000 276.3000 1.0000 276.4980 1.0000 276.6000 1.0000 276.7980 1.0000 276.9000 0.0000 277.0980 0.0000 277.2000 0.0000 277.3980 0.0000 277.5000 1.0000 277.6980 1.0000 277.8000 1.0000 277.9980 1.0000 278.1000 0.0000 278.2980 0.0000 278.4000 0.0000 278.5980 0.0000 278.7000 1.0000 278.8980 1.0000 279.0000 1.0000 279.1980 1.0000 279.3000 0.0000 279.4980 0.0000 279.6000 0.0000 279.7980 0.0000 279.9000 1.0000 280.0980 1.0000 280.2000 1.0000 280.3980 1.0000 280.5000 0.0000 280.6980 0.0000 280.8000 0.0000 280.9980 0.0000 281.1000 1.0000 281.2980 1.0000 281.4000 1.0000 281.5980 1.0000 281.7000 0.0000 281.8980 0.0000 282.0000 0.0000 282.1980 0.0000 282.3000 1.0000 282.4980 1.0000 282.6000 1.0000 282.7980 1.0000 282.9000 0.0000 283.0980 0.0000 283.2000 0.0000 283.3980 0.0000 283.5000 1.0000 283.6980 1.0000 283.8000 1.0000 283.9980 1.0000 284.1000 0.0000 284.2980 0.0000 284.4000 0.0000 284.5980 0.0000 284.7000 1.0000 284.8980 1.0000 285.0000 1.0000 285.1980 1.0000 285.3000 0.0000 285.4980 0.0000 285.6000 0.0000 285.7980 0.0000 285.9000 1.0000 286.0980 1.0000 286.2000 1.0000 286.3980 1.0000 286.5000 0.0000 286.6980 0.0000 286.8000 0.0000 286.9980 0.0000 287.1000 1.0000 287.2980 1.0000 287.4000 1.0000 287.5980 1.0000 287.7000 0.0000 287.8980 0.0000 288.0000 0.0000 288.1980 0.0000 288.3000 1.0000 288.4980 1.0000 288.6000 1.0000 288.7980 1.0000 288.9000 0.0000 289.0980 0.0000 289.2000 0.0000 289.3980 0.0000 289.5000 1.0000 289.6980 1.0000 289.8000 1.0000 289.9980 1.0000 290.1000 0.0000 290.2980 0.0000 290.4000 0.0000 290.5980 0.0000 290.7000 1.0000 290.8980 1.0000 291.0000 1.0000 291.1980 1.0000 291.3000 0.0000 291.4980 0.0000 291.6000 0.0000 291.7980 0.0000 291.9000 1.0000 292.0980 1.0000 292.2000 1.0000 292.3980 1.0000 292.5000 0.0000 292.6980 0.0000 292.8000 0.0000 292.9980 0.0000 293.1000 1.0000 293.2980 1.0000 293.4000 1.0000 293.5980 1.0000 293.7000 0.0000 293.8980 0.0000 294.0000 0.0000 294.1980 0.0000 294.3000 1.0000 294.4980 1.0000 294.6000 1.0000 294.7980 1.0000 294.9000 0.0000 295.0980 0.0000 295.2000 0.0000 295.3980 0.0000 295.5000 1.0000 295.6980 1.0000 295.8000 1.0000 295.9980 1.0000 296.1000 0.0000 296.2980 0.0000 296.4000 0.0000 296.5980 0.0000 296.7000 1.0000 296.8980 1.0000 297.0000 1.0000 297.1980 1.0000 297.3000 0.0000 297.4980 0.0000 297.6000 0.0000 297.7980 0.0000 297.9000 1.0000 298.0980 1.0000 298.2000 1.0000 298.3980 1.0000 298.5000 0.0000 298.6980 0.0000 298.8000 0.0000 298.9980 0.0000 299.1000 1.0000 299.2980 1.0000 299.4000 1.0000 299.5980 1.0000 299.7000 0.0000 299.8980 0.0000 300.0000 0.0000 300.1980 0.0000 300.3000 1.0000 300.4980 1.0000 300.6000 1.0000 300.7980 1.0000 300.9000 0.0000 301.0980 0.0000 301.2000 0.0000 301.3980 0.0000 301.5000 1.0000 301.6980 1.0000 301.8000 1.0000 301.9980 1.0000 302.1000 0.0000 302.2980 0.0000 302.4000 0.0000 302.5980 0.0000 302.7000 1.0000 302.8980 1.0000 303.0000 1.0000 303.1980 1.0000 303.3000 0.0000 303.4980 0.0000 303.6000 0.0000 303.7980 0.0000 303.9000 1.0000 304.0980 1.0000 304.2000 1.0000 304.3980 1.0000 304.5000 0.0000 304.6980 0.0000 304.8000 0.0000 304.9980 0.0000 305.1000 1.0000 305.2980 1.0000 305.4000 1.0000 305.5980 1.0000 305.7000 0.0000 305.8980 0.0000 306.0000 0.0000 306.1980 0.0000 306.3000 1.0000 306.4980 1.0000 306.6000 1.0000 306.7980 1.0000 306.9000 0.0000 307.0980 0.0000 307.2000 0.0000 307.3980 0.0000 307.5000 1.0000 307.6980 1.0000 307.8000 1.0000 307.9980 1.0000 308.1000 0.0000 308.2980 0.0000 308.4000 0.0000 308.5980 0.0000 308.7000 1.0000 308.8980 1.0000 309.0000 1.0000 309.1980 1.0000 309.3000 0.0000 309.4980 0.0000 309.6000 0.0000 309.7980 0.0000 309.9000 1.0000 310.0980 1.0000 310.2000 1.0000 310.3980 1.0000 310.5000 0.0000 310.6980 0.0000 310.8000 0.0000 310.9980 0.0000 311.1000 1.0000 311.2980 1.0000 311.4000 1.0000 311.5980 1.0000 311.7000 0.0000 311.8980 0.0000 312.0000 0.0000 312.1980 0.0000 312.3000 1.0000 312.4980 1.0000 312.6000 1.0000 312.7980 1.0000 312.9000 0.0000 313.0980 0.0000 313.2000 0.0000 313.3980 0.0000 313.5000 1.0000 313.6980 1.0000 313.8000 1.0000 313.9980 1.0000 314.1000 0.0000 314.2980 0.0000 314.4000 0.0000 314.5980 0.0000 314.7000 1.0000 314.8980 1.0000 315.0000 1.0000 315.1980 1.0000 315.3000 0.0000 315.4980 0.0000 315.6000 0.0000 315.7980 0.0000 315.9000 1.0000 316.0980 1.0000 316.2000 1.0000 316.3980 1.0000 316.5000 0.0000 316.6980 0.0000 316.8000 0.0000 316.9980 0.0000 317.1000 1.0000 317.2980 1.0000 317.4000 1.0000 317.5980 1.0000 317.7000 0.0000 317.8980 0.0000 318.0000 0.0000 318.1980 0.0000 318.3000 1.0000 318.4980 1.0000 318.6000 1.0000 318.7980 1.0000 318.9000 0.0000 319.0980 0.0000 319.2000 0.0000 319.3980 0.0000 319.5000 1.0000 319.6980 1.0000 319.8000 1.0000 319.9980 1.0000 320.1000 0.0000 320.2980 0.0000 320.4000 0.0000 320.5980 0.0000 320.7000 1.0000 320.8980 1.0000 321.0000 1.0000 321.1980 1.0000 321.3000 0.0000 321.4980 0.0000 321.6000 0.0000 321.7980 0.0000 321.9000 1.0000 322.0980 1.0000 322.2000 1.0000 322.3980 1.0000 322.5000 0.0000 322.6980 0.0000 322.8000 0.0000 322.9980 0.0000 323.1000 1.0000 323.2980 1.0000 323.4000 1.0000 323.5980 1.0000 323.7000 0.0000 323.8980 0.0000 324.0000 0.0000 324.1980 0.0000 324.3000 1.0000 324.4980 1.0000 324.6000 1.0000 324.7980 1.0000 324.9000 0.0000 325.0980 0.0000 325.2000 0.0000 325.3980 0.0000 325.5000 1.0000 325.6980 1.0000 325.8000 1.0000 325.9980 1.0000 326.1000 0.0000 326.2980 0.0000 326.4000 0.0000 326.5980 0.0000 326.7000 1.0000 326.8980 1.0000 327.0000 1.0000 327.1980 1.0000 327.3000 0.0000 327.4980 0.0000 327.6000 0.0000 327.7980 0.0000 327.9000 1.0000 328.0980 1.0000 328.2000 1.0000 328.3980 1.0000 328.5000 0.0000 328.6980 0.0000 328.8000 0.0000 328.9980 0.0000 329.1000 1.0000 329.2980 1.0000 329.4000 1.0000 329.5980 1.0000 329.7000 0.0000 329.8980 0.0000 330.0000 0.0000 330.1980 0.0000 330.3000 1.0000 330.4980 1.0000 330.6000 1.0000 330.7980 1.0000 330.9000 0.0000 331.0980 0.0000 331.2000 0.0000 331.3980 0.0000 331.5000 1.0000 331.6980 1.0000 331.8000 1.0000 331.9980 1.0000 332.1000 0.0000 332.2980 0.0000 332.4000 0.0000 332.5980 0.0000 332.7000 1.0000 332.8980 1.0000 333.0000 1.0000 333.1980 1.0000 333.3000 0.0000 333.4980 0.0000 333.6000 0.0000 333.7980 0.0000 333.9000 1.0000 334.0980 1.0000 334.2000 1.0000 334.3980 1.0000 334.5000 0.0000 334.6980 0.0000 334.8000 0.0000 334.9980 0.0000 335.1000 1.0000 335.2980 1.0000 335.4000 1.0000 335.5980 1.0000 335.7000 0.0000 335.8980 0.0000 336.0000 0.0000 336.1980 0.0000 336.3000 1.0000 336.4980 1.0000 336.6000 1.0000 336.7980 1.0000 336.9000 0.0000 337.0980 0.0000 337.2000 0.0000 337.3980 0.0000 337.5000 1.0000 337.6980 1.0000 337.8000 1.0000 337.9980 1.0000 338.1000 0.0000 338.2980 0.0000 338.4000 0.0000 338.5980 0.0000 338.7000 1.0000 338.8980 1.0000 339.0000 1.0000 339.1980 1.0000 339.3000 0.0000 339.4980 0.0000 339.6000 0.0000 339.7980 0.0000 339.9000 1.0000 340.0980 1.0000 340.2000 1.0000 340.3980 1.0000 340.5000 0.0000 340.6980 0.0000 340.8000 0.0000 340.9980 0.0000 341.1000 1.0000 341.2980 1.0000 341.4000 1.0000 341.5980 1.0000 341.7000 0.0000 341.8980 0.0000 342.0000 0.0000 342.1980 0.0000 342.3000 1.0000 342.4980 1.0000 342.6000 1.0000 342.7980 1.0000 342.9000 0.0000 343.0980 0.0000 343.2000 0.0000 343.3980 0.0000 343.5000 1.0000 343.6980 1.0000 343.8000 1.0000 343.9980 1.0000 344.1000 0.0000 344.2980 0.0000 344.4000 0.0000 344.5980 0.0000 344.7000 1.0000 344.8980 1.0000 345.0000 1.0000 345.1980 1.0000 345.3000 0.0000 345.4980 0.0000 345.6000 0.0000 345.7980 0.0000 345.9000 1.0000 346.0980 1.0000 346.2000 1.0000 346.3980 1.0000 346.5000 0.0000 346.6980 0.0000 346.8000 0.0000 346.9980 0.0000 347.1000 1.0000 347.2980 1.0000 347.4000 1.0000 347.5980 1.0000 347.7000 0.0000 347.8980 0.0000 348.0000 0.0000 348.1980 0.0000 348.3000 1.0000 348.4980 1.0000 348.6000 1.0000 348.7980 1.0000 348.9000 0.0000 349.0980 0.0000 349.2000 0.0000 349.3980 0.0000 349.5000 1.0000 349.6980 1.0000 349.8000 1.0000 349.9980 1.0000 350.1000 0.0000 350.2980 0.0000 350.4000 0.0000 350.5980 0.0000 350.7000 1.0000 350.8980 1.0000 351.0000 1.0000 351.1980 1.0000 351.3000 0.0000 351.4980 0.0000 351.6000 0.0000 351.7980 0.0000 351.9000 1.0000 352.0980 1.0000 352.2000 1.0000 352.3980 1.0000 352.5000 0.0000 352.6980 0.0000 352.8000 0.0000 352.9980 0.0000 353.1000 1.0000 353.2980 1.0000 353.4000 1.0000 353.5980 1.0000 353.7000 0.0000 353.8980 0.0000 354.0000 0.0000 354.1980 0.0000 354.3000 1.0000 354.4980 1.0000 354.6000 1.0000 354.7980 1.0000 354.9000 0.0000 355.0980 0.0000 355.2000 0.0000 355.3980 0.0000 355.5000 1.0000 355.6980 1.0000 355.8000 1.0000 355.9980 1.0000 356.1000 0.0000 356.2980 0.0000 356.4000 0.0000 356.5980 0.0000 356.7000 1.0000 356.8980 1.0000 357.0000 1.0000 357.1980 1.0000 357.3000 0.0000 357.4980 0.0000 357.6000 0.0000 357.7980 0.0000 357.9000 1.0000 358.0980 1.0000 358.2000 1.0000 358.3980 1.0000 358.5000 0.0000 358.6980 0.0000 358.8000 0.0000 358.9980 0.0000 359.1000 1.0000 359.2980 1.0000 359.4000 1.0000 359.5980 1.0000 359.7000 0.0000 359.8980 0.0000 360.0000 0.0000)
Vau1 au1 0 PWL(0.0000 0.3000 0.1980 0.3000 0.3000 0.3000 0.4980 0.3000 0.6000 1.0000 0.7980 1.0000 0.9000 1.0000 1.0980 1.0000 1.2000 0.3000 1.3980 0.3000 1.5000 0.3000 1.6980 0.3000 1.8000 1.0000 1.9980 1.0000 2.1000 1.0000 2.2980 1.0000 2.4000 0.3000 2.5980 0.3000 2.7000 0.3000 2.8980 0.3000 3.0000 1.0000 3.1980 1.0000 3.3000 1.0000 3.4980 1.0000 3.6000 0.3000 3.7980 0.3000 3.9000 0.3000 4.0980 0.3000 4.2000 1.0000 4.3980 1.0000 4.5000 1.0000 4.6980 1.0000 4.8000 0.3000 4.9980 0.3000 5.1000 0.3000 5.2980 0.3000 5.4000 1.0000 5.5980 1.0000 5.7000 1.0000 5.8980 1.0000 6.0000 0.3000 6.1980 0.3000 6.3000 0.3000 6.4980 0.3000 6.6000 1.0000 6.7980 1.0000 6.9000 1.0000 7.0980 1.0000 7.2000 0.3000 7.3980 0.3000 7.5000 0.3000 7.6980 0.3000 7.8000 1.0000 7.9980 1.0000 8.1000 1.0000 8.2980 1.0000 8.4000 0.3000 8.5980 0.3000 8.7000 0.3000 8.8980 0.3000 9.0000 1.0000 9.1980 1.0000 9.3000 1.0000 9.4980 1.0000 9.6000 0.3000 9.7980 0.3000 9.9000 0.3000 10.0980 0.3000 10.2000 1.0000 10.3980 1.0000 10.5000 1.0000 10.6980 1.0000 10.8000 0.3000 10.9980 0.3000 11.1000 0.3000 11.2980 0.3000 11.4000 1.0000 11.5980 1.0000 11.7000 1.0000 11.8980 1.0000 12.0000 0.3000 12.1980 0.3000 12.3000 0.3000 12.4980 0.3000 12.6000 1.0000 12.7980 1.0000 12.9000 1.0000 13.0980 1.0000 13.2000 0.3000 13.3980 0.3000 13.5000 0.3000 13.6980 0.3000 13.8000 1.0000 13.9980 1.0000 14.1000 1.0000 14.2980 1.0000 14.4000 0.3000 14.5980 0.3000 14.7000 0.3000 14.8980 0.3000 15.0000 1.0000 15.1980 1.0000 15.3000 1.0000 15.4980 1.0000 15.6000 0.3000 15.7980 0.3000 15.9000 0.3000 16.0980 0.3000 16.2000 1.0000 16.3980 1.0000 16.5000 1.0000 16.6980 1.0000 16.8000 0.3000 16.9980 0.3000 17.1000 0.3000 17.2980 0.3000 17.4000 1.0000 17.5980 1.0000 17.7000 1.0000 17.8980 1.0000 18.0000 0.3000 18.1980 0.3000 18.3000 0.3000 18.4980 0.3000 18.6000 1.0000 18.7980 1.0000 18.9000 1.0000 19.0980 1.0000 19.2000 0.3000 19.3980 0.3000 19.5000 0.3000 19.6980 0.3000 19.8000 1.0000 19.9980 1.0000 20.1000 1.0000 20.2980 1.0000 20.4000 0.3000 20.5980 0.3000 20.7000 0.3000 20.8980 0.3000 21.0000 1.0000 21.1980 1.0000 21.3000 1.0000 21.4980 1.0000 21.6000 0.3000 21.7980 0.3000 21.9000 0.3000 22.0980 0.3000 22.2000 1.0000 22.3980 1.0000 22.5000 1.0000 22.6980 1.0000 22.8000 0.3000 22.9980 0.3000 23.1000 0.3000 23.2980 0.3000 23.4000 1.0000 23.5980 1.0000 23.7000 1.0000 23.8980 1.0000 24.0000 0.3000 24.1980 0.3000 24.3000 0.3000 24.4980 0.3000 24.6000 1.0000 24.7980 1.0000 24.9000 1.0000 25.0980 1.0000 25.2000 0.3000 25.3980 0.3000 25.5000 0.3000 25.6980 0.3000 25.8000 1.0000 25.9980 1.0000 26.1000 1.0000 26.2980 1.0000 26.4000 0.3000 26.5980 0.3000 26.7000 0.3000 26.8980 0.3000 27.0000 1.0000 27.1980 1.0000 27.3000 1.0000 27.4980 1.0000 27.6000 0.3000 27.7980 0.3000 27.9000 0.3000 28.0980 0.3000 28.2000 1.0000 28.3980 1.0000 28.5000 1.0000 28.6980 1.0000 28.8000 0.3000 28.9980 0.3000 29.1000 0.3000 29.2980 0.3000 29.4000 1.0000 29.5980 1.0000 29.7000 1.0000 29.8980 1.0000 30.0000 0.3000 30.1980 0.3000 30.3000 0.3000 30.4980 0.3000 30.6000 1.0000 30.7980 1.0000 30.9000 1.0000 31.0980 1.0000 31.2000 0.3000 31.3980 0.3000 31.5000 0.3000 31.6980 0.3000 31.8000 1.0000 31.9980 1.0000 32.1000 1.0000 32.2980 1.0000 32.4000 0.3000 32.5980 0.3000 32.7000 0.3000 32.8980 0.3000 33.0000 1.0000 33.1980 1.0000 33.3000 1.0000 33.4980 1.0000 33.6000 0.3000 33.7980 0.3000 33.9000 0.3000 34.0980 0.3000 34.2000 1.0000 34.3980 1.0000 34.5000 1.0000 34.6980 1.0000 34.8000 0.3000 34.9980 0.3000 35.1000 0.3000 35.2980 0.3000 35.4000 1.0000 35.5980 1.0000 35.7000 1.0000 35.8980 1.0000 36.0000 0.3000 36.1980 0.3000 36.3000 0.3000 36.4980 0.3000 36.6000 1.0000 36.7980 1.0000 36.9000 1.0000 37.0980 1.0000 37.2000 0.3000 37.3980 0.3000 37.5000 0.3000 37.6980 0.3000 37.8000 1.0000 37.9980 1.0000 38.1000 1.0000 38.2980 1.0000 38.4000 0.3000 38.5980 0.3000 38.7000 0.3000 38.8980 0.3000 39.0000 1.0000 39.1980 1.0000 39.3000 1.0000 39.4980 1.0000 39.6000 0.3000 39.7980 0.3000 39.9000 0.3000 40.0980 0.3000 40.2000 1.0000 40.3980 1.0000 40.5000 1.0000 40.6980 1.0000 40.8000 0.3000 40.9980 0.3000 41.1000 0.3000 41.2980 0.3000 41.4000 1.0000 41.5980 1.0000 41.7000 1.0000 41.8980 1.0000 42.0000 0.3000 42.1980 0.3000 42.3000 0.3000 42.4980 0.3000 42.6000 1.0000 42.7980 1.0000 42.9000 1.0000 43.0980 1.0000 43.2000 0.3000 43.3980 0.3000 43.5000 0.3000 43.6980 0.3000 43.8000 1.0000 43.9980 1.0000 44.1000 1.0000 44.2980 1.0000 44.4000 0.3000 44.5980 0.3000 44.7000 0.3000 44.8980 0.3000 45.0000 1.0000 45.1980 1.0000 45.3000 1.0000 45.4980 1.0000 45.6000 0.3000 45.7980 0.3000 45.9000 0.3000 46.0980 0.3000 46.2000 1.0000 46.3980 1.0000 46.5000 1.0000 46.6980 1.0000 46.8000 0.3000 46.9980 0.3000 47.1000 0.3000 47.2980 0.3000 47.4000 1.0000 47.5980 1.0000 47.7000 1.0000 47.8980 1.0000 48.0000 0.3000 48.1980 0.3000 48.3000 0.3000 48.4980 0.3000 48.6000 1.0000 48.7980 1.0000 48.9000 1.0000 49.0980 1.0000 49.2000 0.3000 49.3980 0.3000 49.5000 0.3000 49.6980 0.3000 49.8000 1.0000 49.9980 1.0000 50.1000 1.0000 50.2980 1.0000 50.4000 0.3000 50.5980 0.3000 50.7000 0.3000 50.8980 0.3000 51.0000 1.0000 51.1980 1.0000 51.3000 1.0000 51.4980 1.0000 51.6000 0.3000 51.7980 0.3000 51.9000 0.3000 52.0980 0.3000 52.2000 1.0000 52.3980 1.0000 52.5000 1.0000 52.6980 1.0000 52.8000 0.3000 52.9980 0.3000 53.1000 0.3000 53.2980 0.3000 53.4000 1.0000 53.5980 1.0000 53.7000 1.0000 53.8980 1.0000 54.0000 0.3000 54.1980 0.3000 54.3000 0.3000 54.4980 0.3000 54.6000 1.0000 54.7980 1.0000 54.9000 1.0000 55.0980 1.0000 55.2000 0.3000 55.3980 0.3000 55.5000 0.3000 55.6980 0.3000 55.8000 1.0000 55.9980 1.0000 56.1000 1.0000 56.2980 1.0000 56.4000 0.3000 56.5980 0.3000 56.7000 0.3000 56.8980 0.3000 57.0000 1.0000 57.1980 1.0000 57.3000 1.0000 57.4980 1.0000 57.6000 0.3000 57.7980 0.3000 57.9000 0.3000 58.0980 0.3000 58.2000 1.0000 58.3980 1.0000 58.5000 1.0000 58.6980 1.0000 58.8000 0.3000 58.9980 0.3000 59.1000 0.3000 59.2980 0.3000 59.4000 1.0000 59.5980 1.0000 59.7000 1.0000 59.8980 1.0000 60.0000 0.3000 60.1980 0.3000 60.3000 0.3000 60.4980 0.3000 60.6000 1.0000 60.7980 1.0000 60.9000 1.0000 61.0980 1.0000 61.2000 0.3000 61.3980 0.3000 61.5000 0.3000 61.6980 0.3000 61.8000 1.0000 61.9980 1.0000 62.1000 1.0000 62.2980 1.0000 62.4000 0.3000 62.5980 0.3000 62.7000 0.3000 62.8980 0.3000 63.0000 1.0000 63.1980 1.0000 63.3000 1.0000 63.4980 1.0000 63.6000 0.3000 63.7980 0.3000 63.9000 0.3000 64.0980 0.3000 64.2000 1.0000 64.3980 1.0000 64.5000 1.0000 64.6980 1.0000 64.8000 0.3000 64.9980 0.3000 65.1000 0.3000 65.2980 0.3000 65.4000 1.0000 65.5980 1.0000 65.7000 1.0000 65.8980 1.0000 66.0000 0.3000 66.1980 0.3000 66.3000 0.3000 66.4980 0.3000 66.6000 1.0000 66.7980 1.0000 66.9000 1.0000 67.0980 1.0000 67.2000 0.3000 67.3980 0.3000 67.5000 0.3000 67.6980 0.3000 67.8000 1.0000 67.9980 1.0000 68.1000 1.0000 68.2980 1.0000 68.4000 0.3000 68.5980 0.3000 68.7000 0.3000 68.8980 0.3000 69.0000 1.0000 69.1980 1.0000 69.3000 1.0000 69.4980 1.0000 69.6000 0.3000 69.7980 0.3000 69.9000 0.3000 70.0980 0.3000 70.2000 1.0000 70.3980 1.0000 70.5000 1.0000 70.6980 1.0000 70.8000 0.3000 70.9980 0.3000 71.1000 0.3000 71.2980 0.3000 71.4000 1.0000 71.5980 1.0000 71.7000 1.0000 71.8980 1.0000 72.0000 0.3000 72.1980 0.3000 72.3000 0.3000 72.4980 0.3000 72.6000 1.0000 72.7980 1.0000 72.9000 1.0000 73.0980 1.0000 73.2000 0.3000 73.3980 0.3000 73.5000 0.3000 73.6980 0.3000 73.8000 1.0000 73.9980 1.0000 74.1000 1.0000 74.2980 1.0000 74.4000 0.3000 74.5980 0.3000 74.7000 0.3000 74.8980 0.3000 75.0000 1.0000 75.1980 1.0000 75.3000 1.0000 75.4980 1.0000 75.6000 0.3000 75.7980 0.3000 75.9000 0.3000 76.0980 0.3000 76.2000 1.0000 76.3980 1.0000 76.5000 1.0000 76.6980 1.0000 76.8000 0.3000 76.9980 0.3000 77.1000 0.3000 77.2980 0.3000 77.4000 1.0000 77.5980 1.0000 77.7000 1.0000 77.8980 1.0000 78.0000 0.3000 78.1980 0.3000 78.3000 0.3000 78.4980 0.3000 78.6000 1.0000 78.7980 1.0000 78.9000 1.0000 79.0980 1.0000 79.2000 0.3000 79.3980 0.3000 79.5000 0.3000 79.6980 0.3000 79.8000 1.0000 79.9980 1.0000 80.1000 1.0000 80.2980 1.0000 80.4000 0.3000 80.5980 0.3000 80.7000 0.3000 80.8980 0.3000 81.0000 1.0000 81.1980 1.0000 81.3000 1.0000 81.4980 1.0000 81.6000 0.3000 81.7980 0.3000 81.9000 0.3000 82.0980 0.3000 82.2000 1.0000 82.3980 1.0000 82.5000 1.0000 82.6980 1.0000 82.8000 0.3000 82.9980 0.3000 83.1000 0.3000 83.2980 0.3000 83.4000 1.0000 83.5980 1.0000 83.7000 1.0000 83.8980 1.0000 84.0000 0.3000 84.1980 0.3000 84.3000 0.3000 84.4980 0.3000 84.6000 1.0000 84.7980 1.0000 84.9000 1.0000 85.0980 1.0000 85.2000 0.3000 85.3980 0.3000 85.5000 0.3000 85.6980 0.3000 85.8000 1.0000 85.9980 1.0000 86.1000 1.0000 86.2980 1.0000 86.4000 0.3000 86.5980 0.3000 86.7000 0.3000 86.8980 0.3000 87.0000 1.0000 87.1980 1.0000 87.3000 1.0000 87.4980 1.0000 87.6000 0.3000 87.7980 0.3000 87.9000 0.3000 88.0980 0.3000 88.2000 1.0000 88.3980 1.0000 88.5000 1.0000 88.6980 1.0000 88.8000 0.3000 88.9980 0.3000 89.1000 0.3000 89.2980 0.3000 89.4000 1.0000 89.5980 1.0000 89.7000 1.0000 89.8980 1.0000 90.0000 0.3000 90.1980 0.3000 90.3000 0.3000 90.4980 0.3000 90.6000 1.0000 90.7980 1.0000 90.9000 1.0000 91.0980 1.0000 91.2000 0.3000 91.3980 0.3000 91.5000 0.3000 91.6980 0.3000 91.8000 1.0000 91.9980 1.0000 92.1000 1.0000 92.2980 1.0000 92.4000 0.3000 92.5980 0.3000 92.7000 0.3000 92.8980 0.3000 93.0000 1.0000 93.1980 1.0000 93.3000 1.0000 93.4980 1.0000 93.6000 0.3000 93.7980 0.3000 93.9000 0.3000 94.0980 0.3000 94.2000 1.0000 94.3980 1.0000 94.5000 1.0000 94.6980 1.0000 94.8000 0.3000 94.9980 0.3000 95.1000 0.3000 95.2980 0.3000 95.4000 1.0000 95.5980 1.0000 95.7000 1.0000 95.8980 1.0000 96.0000 0.3000 96.1980 0.3000 96.3000 0.3000 96.4980 0.3000 96.6000 1.0000 96.7980 1.0000 96.9000 1.0000 97.0980 1.0000 97.2000 0.3000 97.3980 0.3000 97.5000 0.3000 97.6980 0.3000 97.8000 1.0000 97.9980 1.0000 98.1000 1.0000 98.2980 1.0000 98.4000 0.3000 98.5980 0.3000 98.7000 0.3000 98.8980 0.3000 99.0000 1.0000 99.1980 1.0000 99.3000 1.0000 99.4980 1.0000 99.6000 0.3000 99.7980 0.3000 99.9000 0.3000 100.0980 0.3000 100.2000 1.0000 100.3980 1.0000 100.5000 1.0000 100.6980 1.0000 100.8000 0.3000 100.9980 0.3000 101.1000 0.3000 101.2980 0.3000 101.4000 1.0000 101.5980 1.0000 101.7000 1.0000 101.8980 1.0000 102.0000 0.3000 102.1980 0.3000 102.3000 0.3000 102.4980 0.3000 102.6000 1.0000 102.7980 1.0000 102.9000 1.0000 103.0980 1.0000 103.2000 0.3000 103.3980 0.3000 103.5000 0.3000 103.6980 0.3000 103.8000 1.0000 103.9980 1.0000 104.1000 1.0000 104.2980 1.0000 104.4000 0.3000 104.5980 0.3000 104.7000 0.3000 104.8980 0.3000 105.0000 1.0000 105.1980 1.0000 105.3000 1.0000 105.4980 1.0000 105.6000 0.3000 105.7980 0.3000 105.9000 0.3000 106.0980 0.3000 106.2000 1.0000 106.3980 1.0000 106.5000 1.0000 106.6980 1.0000 106.8000 0.3000 106.9980 0.3000 107.1000 0.3000 107.2980 0.3000 107.4000 1.0000 107.5980 1.0000 107.7000 1.0000 107.8980 1.0000 108.0000 0.3000 108.1980 0.3000 108.3000 0.3000 108.4980 0.3000 108.6000 1.0000 108.7980 1.0000 108.9000 1.0000 109.0980 1.0000 109.2000 0.3000 109.3980 0.3000 109.5000 0.3000 109.6980 0.3000 109.8000 1.0000 109.9980 1.0000 110.1000 1.0000 110.2980 1.0000 110.4000 0.3000 110.5980 0.3000 110.7000 0.3000 110.8980 0.3000 111.0000 1.0000 111.1980 1.0000 111.3000 1.0000 111.4980 1.0000 111.6000 0.3000 111.7980 0.3000 111.9000 0.3000 112.0980 0.3000 112.2000 1.0000 112.3980 1.0000 112.5000 1.0000 112.6980 1.0000 112.8000 0.3000 112.9980 0.3000 113.1000 0.3000 113.2980 0.3000 113.4000 1.0000 113.5980 1.0000 113.7000 1.0000 113.8980 1.0000 114.0000 0.3000 114.1980 0.3000 114.3000 0.3000 114.4980 0.3000 114.6000 1.0000 114.7980 1.0000 114.9000 1.0000 115.0980 1.0000 115.2000 0.3000 115.3980 0.3000 115.5000 0.3000 115.6980 0.3000 115.8000 1.0000 115.9980 1.0000 116.1000 1.0000 116.2980 1.0000 116.4000 0.3000 116.5980 0.3000 116.7000 0.3000 116.8980 0.3000 117.0000 1.0000 117.1980 1.0000 117.3000 1.0000 117.4980 1.0000 117.6000 0.3000 117.7980 0.3000 117.9000 0.3000 118.0980 0.3000 118.2000 1.0000 118.3980 1.0000 118.5000 1.0000 118.6980 1.0000 118.8000 0.3000 118.9980 0.3000 119.1000 0.3000 119.2980 0.3000 119.4000 1.0000 119.5980 1.0000 119.7000 1.0000 119.8980 1.0000 120.0000 0.3000 120.1980 0.3000 120.3000 0.3000 120.4980 0.3000 120.6000 1.0000 120.7980 1.0000 120.9000 1.0000 121.0980 1.0000 121.2000 0.3000 121.3980 0.3000 121.5000 0.3000 121.6980 0.3000 121.8000 1.0000 121.9980 1.0000 122.1000 1.0000 122.2980 1.0000 122.4000 0.3000 122.5980 0.3000 122.7000 0.3000 122.8980 0.3000 123.0000 1.0000 123.1980 1.0000 123.3000 1.0000 123.4980 1.0000 123.6000 0.3000 123.7980 0.3000 123.9000 0.3000 124.0980 0.3000 124.2000 1.0000 124.3980 1.0000 124.5000 1.0000 124.6980 1.0000 124.8000 0.3000 124.9980 0.3000 125.1000 0.3000 125.2980 0.3000 125.4000 1.0000 125.5980 1.0000 125.7000 1.0000 125.8980 1.0000 126.0000 0.3000 126.1980 0.3000 126.3000 0.3000 126.4980 0.3000 126.6000 1.0000 126.7980 1.0000 126.9000 1.0000 127.0980 1.0000 127.2000 0.3000 127.3980 0.3000 127.5000 0.3000 127.6980 0.3000 127.8000 1.0000 127.9980 1.0000 128.1000 1.0000 128.2980 1.0000 128.4000 0.3000 128.5980 0.3000 128.7000 0.3000 128.8980 0.3000 129.0000 1.0000 129.1980 1.0000 129.3000 1.0000 129.4980 1.0000 129.6000 0.3000 129.7980 0.3000 129.9000 0.3000 130.0980 0.3000 130.2000 1.0000 130.3980 1.0000 130.5000 1.0000 130.6980 1.0000 130.8000 0.3000 130.9980 0.3000 131.1000 0.3000 131.2980 0.3000 131.4000 1.0000 131.5980 1.0000 131.7000 1.0000 131.8980 1.0000 132.0000 0.3000 132.1980 0.3000 132.3000 0.3000 132.4980 0.3000 132.6000 1.0000 132.7980 1.0000 132.9000 1.0000 133.0980 1.0000 133.2000 0.3000 133.3980 0.3000 133.5000 0.3000 133.6980 0.3000 133.8000 1.0000 133.9980 1.0000 134.1000 1.0000 134.2980 1.0000 134.4000 0.3000 134.5980 0.3000 134.7000 0.3000 134.8980 0.3000 135.0000 1.0000 135.1980 1.0000 135.3000 1.0000 135.4980 1.0000 135.6000 0.3000 135.7980 0.3000 135.9000 0.3000 136.0980 0.3000 136.2000 1.0000 136.3980 1.0000 136.5000 1.0000 136.6980 1.0000 136.8000 0.3000 136.9980 0.3000 137.1000 0.3000 137.2980 0.3000 137.4000 1.0000 137.5980 1.0000 137.7000 1.0000 137.8980 1.0000 138.0000 0.3000 138.1980 0.3000 138.3000 0.3000 138.4980 0.3000 138.6000 1.0000 138.7980 1.0000 138.9000 1.0000 139.0980 1.0000 139.2000 0.3000 139.3980 0.3000 139.5000 0.3000 139.6980 0.3000 139.8000 1.0000 139.9980 1.0000 140.1000 1.0000 140.2980 1.0000 140.4000 0.3000 140.5980 0.3000 140.7000 0.3000 140.8980 0.3000 141.0000 1.0000 141.1980 1.0000 141.3000 1.0000 141.4980 1.0000 141.6000 0.3000 141.7980 0.3000 141.9000 0.3000 142.0980 0.3000 142.2000 1.0000 142.3980 1.0000 142.5000 1.0000 142.6980 1.0000 142.8000 0.3000 142.9980 0.3000 143.1000 0.3000 143.2980 0.3000 143.4000 1.0000 143.5980 1.0000 143.7000 1.0000 143.8980 1.0000 144.0000 0.3000 144.1980 0.3000 144.3000 0.3000 144.4980 0.3000 144.6000 1.0000 144.7980 1.0000 144.9000 1.0000 145.0980 1.0000 145.2000 0.3000 145.3980 0.3000 145.5000 0.3000 145.6980 0.3000 145.8000 1.0000 145.9980 1.0000 146.1000 1.0000 146.2980 1.0000 146.4000 0.3000 146.5980 0.3000 146.7000 0.3000 146.8980 0.3000 147.0000 1.0000 147.1980 1.0000 147.3000 1.0000 147.4980 1.0000 147.6000 0.3000 147.7980 0.3000 147.9000 0.3000 148.0980 0.3000 148.2000 1.0000 148.3980 1.0000 148.5000 1.0000 148.6980 1.0000 148.8000 0.3000 148.9980 0.3000 149.1000 0.3000 149.2980 0.3000 149.4000 1.0000 149.5980 1.0000 149.7000 1.0000 149.8980 1.0000 150.0000 0.3000 150.1980 0.3000 150.3000 0.3000 150.4980 0.3000 150.6000 1.0000 150.7980 1.0000 150.9000 1.0000 151.0980 1.0000 151.2000 0.3000 151.3980 0.3000 151.5000 0.3000 151.6980 0.3000 151.8000 1.0000 151.9980 1.0000 152.1000 1.0000 152.2980 1.0000 152.4000 0.3000 152.5980 0.3000 152.7000 0.3000 152.8980 0.3000 153.0000 1.0000 153.1980 1.0000 153.3000 1.0000 153.4980 1.0000 153.6000 0.3000 153.7980 0.3000 153.9000 0.3000 154.0980 0.3000 154.2000 1.0000 154.3980 1.0000 154.5000 1.0000 154.6980 1.0000 154.8000 0.3000 154.9980 0.3000 155.1000 0.3000 155.2980 0.3000 155.4000 1.0000 155.5980 1.0000 155.7000 1.0000 155.8980 1.0000 156.0000 0.3000 156.1980 0.3000 156.3000 0.3000 156.4980 0.3000 156.6000 1.0000 156.7980 1.0000 156.9000 1.0000 157.0980 1.0000 157.2000 0.3000 157.3980 0.3000 157.5000 0.3000 157.6980 0.3000 157.8000 1.0000 157.9980 1.0000 158.1000 1.0000 158.2980 1.0000 158.4000 0.3000 158.5980 0.3000 158.7000 0.3000 158.8980 0.3000 159.0000 1.0000 159.1980 1.0000 159.3000 1.0000 159.4980 1.0000 159.6000 0.3000 159.7980 0.3000 159.9000 0.3000 160.0980 0.3000 160.2000 1.0000 160.3980 1.0000 160.5000 1.0000 160.6980 1.0000 160.8000 0.3000 160.9980 0.3000 161.1000 0.3000 161.2980 0.3000 161.4000 1.0000 161.5980 1.0000 161.7000 1.0000 161.8980 1.0000 162.0000 0.3000 162.1980 0.3000 162.3000 0.3000 162.4980 0.3000 162.6000 1.0000 162.7980 1.0000 162.9000 1.0000 163.0980 1.0000 163.2000 0.3000 163.3980 0.3000 163.5000 0.3000 163.6980 0.3000 163.8000 1.0000 163.9980 1.0000 164.1000 1.0000 164.2980 1.0000 164.4000 0.3000 164.5980 0.3000 164.7000 0.3000 164.8980 0.3000 165.0000 1.0000 165.1980 1.0000 165.3000 1.0000 165.4980 1.0000 165.6000 0.3000 165.7980 0.3000 165.9000 0.3000 166.0980 0.3000 166.2000 1.0000 166.3980 1.0000 166.5000 1.0000 166.6980 1.0000 166.8000 0.3000 166.9980 0.3000 167.1000 0.3000 167.2980 0.3000 167.4000 1.0000 167.5980 1.0000 167.7000 1.0000 167.8980 1.0000 168.0000 0.3000 168.1980 0.3000 168.3000 0.3000 168.4980 0.3000 168.6000 1.0000 168.7980 1.0000 168.9000 1.0000 169.0980 1.0000 169.2000 0.3000 169.3980 0.3000 169.5000 0.3000 169.6980 0.3000 169.8000 1.0000 169.9980 1.0000 170.1000 1.0000 170.2980 1.0000 170.4000 0.3000 170.5980 0.3000 170.7000 0.3000 170.8980 0.3000 171.0000 1.0000 171.1980 1.0000 171.3000 1.0000 171.4980 1.0000 171.6000 0.3000 171.7980 0.3000 171.9000 0.3000 172.0980 0.3000 172.2000 1.0000 172.3980 1.0000 172.5000 1.0000 172.6980 1.0000 172.8000 0.3000 172.9980 0.3000 173.1000 0.3000 173.2980 0.3000 173.4000 1.0000 173.5980 1.0000 173.7000 1.0000 173.8980 1.0000 174.0000 0.3000 174.1980 0.3000 174.3000 0.3000 174.4980 0.3000 174.6000 1.0000 174.7980 1.0000 174.9000 1.0000 175.0980 1.0000 175.2000 0.3000 175.3980 0.3000 175.5000 0.3000 175.6980 0.3000 175.8000 1.0000 175.9980 1.0000 176.1000 1.0000 176.2980 1.0000 176.4000 0.3000 176.5980 0.3000 176.7000 0.3000 176.8980 0.3000 177.0000 1.0000 177.1980 1.0000 177.3000 1.0000 177.4980 1.0000 177.6000 0.3000 177.7980 0.3000 177.9000 0.3000 178.0980 0.3000 178.2000 1.0000 178.3980 1.0000 178.5000 1.0000 178.6980 1.0000 178.8000 0.3000 178.9980 0.3000 179.1000 0.3000 179.2980 0.3000 179.4000 1.0000 179.5980 1.0000 179.7000 1.0000 179.8980 1.0000 180.0000 0.3000 180.1980 0.3000 180.3000 0.3000 180.4980 0.3000 180.6000 1.0000 180.7980 1.0000 180.9000 1.0000 181.0980 1.0000 181.2000 0.3000 181.3980 0.3000 181.5000 0.3000 181.6980 0.3000 181.8000 1.0000 181.9980 1.0000 182.1000 1.0000 182.2980 1.0000 182.4000 0.3000 182.5980 0.3000 182.7000 0.3000 182.8980 0.3000 183.0000 1.0000 183.1980 1.0000 183.3000 1.0000 183.4980 1.0000 183.6000 0.3000 183.7980 0.3000 183.9000 0.3000 184.0980 0.3000 184.2000 1.0000 184.3980 1.0000 184.5000 1.0000 184.6980 1.0000 184.8000 0.3000 184.9980 0.3000 185.1000 0.3000 185.2980 0.3000 185.4000 1.0000 185.5980 1.0000 185.7000 1.0000 185.8980 1.0000 186.0000 0.3000 186.1980 0.3000 186.3000 0.3000 186.4980 0.3000 186.6000 1.0000 186.7980 1.0000 186.9000 1.0000 187.0980 1.0000 187.2000 0.3000 187.3980 0.3000 187.5000 0.3000 187.6980 0.3000 187.8000 1.0000 187.9980 1.0000 188.1000 1.0000 188.2980 1.0000 188.4000 0.3000 188.5980 0.3000 188.7000 0.3000 188.8980 0.3000 189.0000 1.0000 189.1980 1.0000 189.3000 1.0000 189.4980 1.0000 189.6000 0.3000 189.7980 0.3000 189.9000 0.3000 190.0980 0.3000 190.2000 1.0000 190.3980 1.0000 190.5000 1.0000 190.6980 1.0000 190.8000 0.3000 190.9980 0.3000 191.1000 0.3000 191.2980 0.3000 191.4000 1.0000 191.5980 1.0000 191.7000 1.0000 191.8980 1.0000 192.0000 0.3000 192.1980 0.3000 192.3000 0.3000 192.4980 0.3000 192.6000 1.0000 192.7980 1.0000 192.9000 1.0000 193.0980 1.0000 193.2000 0.3000 193.3980 0.3000 193.5000 0.3000 193.6980 0.3000 193.8000 1.0000 193.9980 1.0000 194.1000 1.0000 194.2980 1.0000 194.4000 0.3000 194.5980 0.3000 194.7000 0.3000 194.8980 0.3000 195.0000 1.0000 195.1980 1.0000 195.3000 1.0000 195.4980 1.0000 195.6000 0.3000 195.7980 0.3000 195.9000 0.3000 196.0980 0.3000 196.2000 1.0000 196.3980 1.0000 196.5000 1.0000 196.6980 1.0000 196.8000 0.3000 196.9980 0.3000 197.1000 0.3000 197.2980 0.3000 197.4000 1.0000 197.5980 1.0000 197.7000 1.0000 197.8980 1.0000 198.0000 0.3000 198.1980 0.3000 198.3000 0.3000 198.4980 0.3000 198.6000 1.0000 198.7980 1.0000 198.9000 1.0000 199.0980 1.0000 199.2000 0.3000 199.3980 0.3000 199.5000 0.3000 199.6980 0.3000 199.8000 1.0000 199.9980 1.0000 200.1000 1.0000 200.2980 1.0000 200.4000 0.3000 200.5980 0.3000 200.7000 0.3000 200.8980 0.3000 201.0000 1.0000 201.1980 1.0000 201.3000 1.0000 201.4980 1.0000 201.6000 0.3000 201.7980 0.3000 201.9000 0.3000 202.0980 0.3000 202.2000 1.0000 202.3980 1.0000 202.5000 1.0000 202.6980 1.0000 202.8000 0.3000 202.9980 0.3000 203.1000 0.3000 203.2980 0.3000 203.4000 1.0000 203.5980 1.0000 203.7000 1.0000 203.8980 1.0000 204.0000 0.3000 204.1980 0.3000 204.3000 0.3000 204.4980 0.3000 204.6000 1.0000 204.7980 1.0000 204.9000 1.0000 205.0980 1.0000 205.2000 0.3000 205.3980 0.3000 205.5000 0.3000 205.6980 0.3000 205.8000 1.0000 205.9980 1.0000 206.1000 1.0000 206.2980 1.0000 206.4000 0.3000 206.5980 0.3000 206.7000 0.3000 206.8980 0.3000 207.0000 1.0000 207.1980 1.0000 207.3000 1.0000 207.4980 1.0000 207.6000 0.3000 207.7980 0.3000 207.9000 0.3000 208.0980 0.3000 208.2000 1.0000 208.3980 1.0000 208.5000 1.0000 208.6980 1.0000 208.8000 0.3000 208.9980 0.3000 209.1000 0.3000 209.2980 0.3000 209.4000 1.0000 209.5980 1.0000 209.7000 1.0000 209.8980 1.0000 210.0000 0.3000 210.1980 0.3000 210.3000 0.3000 210.4980 0.3000 210.6000 1.0000 210.7980 1.0000 210.9000 1.0000 211.0980 1.0000 211.2000 0.3000 211.3980 0.3000 211.5000 0.3000 211.6980 0.3000 211.8000 1.0000 211.9980 1.0000 212.1000 1.0000 212.2980 1.0000 212.4000 0.3000 212.5980 0.3000 212.7000 0.3000 212.8980 0.3000 213.0000 1.0000 213.1980 1.0000 213.3000 1.0000 213.4980 1.0000 213.6000 0.3000 213.7980 0.3000 213.9000 0.3000 214.0980 0.3000 214.2000 1.0000 214.3980 1.0000 214.5000 1.0000 214.6980 1.0000 214.8000 0.3000 214.9980 0.3000 215.1000 0.3000 215.2980 0.3000 215.4000 1.0000 215.5980 1.0000 215.7000 1.0000 215.8980 1.0000 216.0000 0.3000 216.1980 0.3000 216.3000 0.3000 216.4980 0.3000 216.6000 1.0000 216.7980 1.0000 216.9000 1.0000 217.0980 1.0000 217.2000 0.3000 217.3980 0.3000 217.5000 0.3000 217.6980 0.3000 217.8000 1.0000 217.9980 1.0000 218.1000 1.0000 218.2980 1.0000 218.4000 0.3000 218.5980 0.3000 218.7000 0.3000 218.8980 0.3000 219.0000 1.0000 219.1980 1.0000 219.3000 1.0000 219.4980 1.0000 219.6000 0.3000 219.7980 0.3000 219.9000 0.3000 220.0980 0.3000 220.2000 1.0000 220.3980 1.0000 220.5000 1.0000 220.6980 1.0000 220.8000 0.3000 220.9980 0.3000 221.1000 0.3000 221.2980 0.3000 221.4000 1.0000 221.5980 1.0000 221.7000 1.0000 221.8980 1.0000 222.0000 0.3000 222.1980 0.3000 222.3000 0.3000 222.4980 0.3000 222.6000 1.0000 222.7980 1.0000 222.9000 1.0000 223.0980 1.0000 223.2000 0.3000 223.3980 0.3000 223.5000 0.3000 223.6980 0.3000 223.8000 1.0000 223.9980 1.0000 224.1000 1.0000 224.2980 1.0000 224.4000 0.3000 224.5980 0.3000 224.7000 0.3000 224.8980 0.3000 225.0000 1.0000 225.1980 1.0000 225.3000 1.0000 225.4980 1.0000 225.6000 0.3000 225.7980 0.3000 225.9000 0.3000 226.0980 0.3000 226.2000 1.0000 226.3980 1.0000 226.5000 1.0000 226.6980 1.0000 226.8000 0.3000 226.9980 0.3000 227.1000 0.3000 227.2980 0.3000 227.4000 1.0000 227.5980 1.0000 227.7000 1.0000 227.8980 1.0000 228.0000 0.3000 228.1980 0.3000 228.3000 0.3000 228.4980 0.3000 228.6000 1.0000 228.7980 1.0000 228.9000 1.0000 229.0980 1.0000 229.2000 0.3000 229.3980 0.3000 229.5000 0.3000 229.6980 0.3000 229.8000 1.0000 229.9980 1.0000 230.1000 1.0000 230.2980 1.0000 230.4000 0.3000 230.5980 0.3000 230.7000 0.3000 230.8980 0.3000 231.0000 1.0000 231.1980 1.0000 231.3000 1.0000 231.4980 1.0000 231.6000 0.3000 231.7980 0.3000 231.9000 0.3000 232.0980 0.3000 232.2000 1.0000 232.3980 1.0000 232.5000 1.0000 232.6980 1.0000 232.8000 0.3000 232.9980 0.3000 233.1000 0.3000 233.2980 0.3000 233.4000 1.0000 233.5980 1.0000 233.7000 1.0000 233.8980 1.0000 234.0000 0.3000 234.1980 0.3000 234.3000 0.3000 234.4980 0.3000 234.6000 1.0000 234.7980 1.0000 234.9000 1.0000 235.0980 1.0000 235.2000 0.3000 235.3980 0.3000 235.5000 0.3000 235.6980 0.3000 235.8000 1.0000 235.9980 1.0000 236.1000 1.0000 236.2980 1.0000 236.4000 0.3000 236.5980 0.3000 236.7000 0.3000 236.8980 0.3000 237.0000 1.0000 237.1980 1.0000 237.3000 1.0000 237.4980 1.0000 237.6000 0.3000 237.7980 0.3000 237.9000 0.3000 238.0980 0.3000 238.2000 1.0000 238.3980 1.0000 238.5000 1.0000 238.6980 1.0000 238.8000 0.3000 238.9980 0.3000 239.1000 0.3000 239.2980 0.3000 239.4000 1.0000 239.5980 1.0000 239.7000 1.0000 239.8980 1.0000 240.0000 0.3000 240.1980 0.3000 240.3000 0.3000 240.4980 0.3000 240.6000 1.0000 240.7980 1.0000 240.9000 1.0000 241.0980 1.0000 241.2000 0.3000 241.3980 0.3000 241.5000 0.3000 241.6980 0.3000 241.8000 1.0000 241.9980 1.0000 242.1000 1.0000 242.2980 1.0000 242.4000 0.3000 242.5980 0.3000 242.7000 0.3000 242.8980 0.3000 243.0000 1.0000 243.1980 1.0000 243.3000 1.0000 243.4980 1.0000 243.6000 0.3000 243.7980 0.3000 243.9000 0.3000 244.0980 0.3000 244.2000 1.0000 244.3980 1.0000 244.5000 1.0000 244.6980 1.0000 244.8000 0.3000 244.9980 0.3000 245.1000 0.3000 245.2980 0.3000 245.4000 1.0000 245.5980 1.0000 245.7000 1.0000 245.8980 1.0000 246.0000 0.3000 246.1980 0.3000 246.3000 0.3000 246.4980 0.3000 246.6000 1.0000 246.7980 1.0000 246.9000 1.0000 247.0980 1.0000 247.2000 0.3000 247.3980 0.3000 247.5000 0.3000 247.6980 0.3000 247.8000 1.0000 247.9980 1.0000 248.1000 1.0000 248.2980 1.0000 248.4000 0.3000 248.5980 0.3000 248.7000 0.3000 248.8980 0.3000 249.0000 1.0000 249.1980 1.0000 249.3000 1.0000 249.4980 1.0000 249.6000 0.3000 249.7980 0.3000 249.9000 0.3000 250.0980 0.3000 250.2000 1.0000 250.3980 1.0000 250.5000 1.0000 250.6980 1.0000 250.8000 0.3000 250.9980 0.3000 251.1000 0.3000 251.2980 0.3000 251.4000 1.0000 251.5980 1.0000 251.7000 1.0000 251.8980 1.0000 252.0000 0.3000 252.1980 0.3000 252.3000 0.3000 252.4980 0.3000 252.6000 1.0000 252.7980 1.0000 252.9000 1.0000 253.0980 1.0000 253.2000 0.3000 253.3980 0.3000 253.5000 0.3000 253.6980 0.3000 253.8000 1.0000 253.9980 1.0000 254.1000 1.0000 254.2980 1.0000 254.4000 0.3000 254.5980 0.3000 254.7000 0.3000 254.8980 0.3000 255.0000 1.0000 255.1980 1.0000 255.3000 1.0000 255.4980 1.0000 255.6000 0.3000 255.7980 0.3000 255.9000 0.3000 256.0980 0.3000 256.2000 1.0000 256.3980 1.0000 256.5000 1.0000 256.6980 1.0000 256.8000 0.3000 256.9980 0.3000 257.1000 0.3000 257.2980 0.3000 257.4000 1.0000 257.5980 1.0000 257.7000 1.0000 257.8980 1.0000 258.0000 0.3000 258.1980 0.3000 258.3000 0.3000 258.4980 0.3000 258.6000 1.0000 258.7980 1.0000 258.9000 1.0000 259.0980 1.0000 259.2000 0.3000 259.3980 0.3000 259.5000 0.3000 259.6980 0.3000 259.8000 1.0000 259.9980 1.0000 260.1000 1.0000 260.2980 1.0000 260.4000 0.3000 260.5980 0.3000 260.7000 0.3000 260.8980 0.3000 261.0000 1.0000 261.1980 1.0000 261.3000 1.0000 261.4980 1.0000 261.6000 0.3000 261.7980 0.3000 261.9000 0.3000 262.0980 0.3000 262.2000 1.0000 262.3980 1.0000 262.5000 1.0000 262.6980 1.0000 262.8000 0.3000 262.9980 0.3000 263.1000 0.3000 263.2980 0.3000 263.4000 1.0000 263.5980 1.0000 263.7000 1.0000 263.8980 1.0000 264.0000 0.3000 264.1980 0.3000 264.3000 0.3000 264.4980 0.3000 264.6000 1.0000 264.7980 1.0000 264.9000 1.0000 265.0980 1.0000 265.2000 0.3000 265.3980 0.3000 265.5000 0.3000 265.6980 0.3000 265.8000 1.0000 265.9980 1.0000 266.1000 1.0000 266.2980 1.0000 266.4000 0.3000 266.5980 0.3000 266.7000 0.3000 266.8980 0.3000 267.0000 1.0000 267.1980 1.0000 267.3000 1.0000 267.4980 1.0000 267.6000 0.3000 267.7980 0.3000 267.9000 0.3000 268.0980 0.3000 268.2000 1.0000 268.3980 1.0000 268.5000 1.0000 268.6980 1.0000 268.8000 0.3000 268.9980 0.3000 269.1000 0.3000 269.2980 0.3000 269.4000 1.0000 269.5980 1.0000 269.7000 1.0000 269.8980 1.0000 270.0000 0.3000 270.1980 0.3000 270.3000 0.3000 270.4980 0.3000 270.6000 1.0000 270.7980 1.0000 270.9000 1.0000 271.0980 1.0000 271.2000 0.3000 271.3980 0.3000 271.5000 0.3000 271.6980 0.3000 271.8000 1.0000 271.9980 1.0000 272.1000 1.0000 272.2980 1.0000 272.4000 0.3000 272.5980 0.3000 272.7000 0.3000 272.8980 0.3000 273.0000 1.0000 273.1980 1.0000 273.3000 1.0000 273.4980 1.0000 273.6000 0.3000 273.7980 0.3000 273.9000 0.3000 274.0980 0.3000 274.2000 1.0000 274.3980 1.0000 274.5000 1.0000 274.6980 1.0000 274.8000 0.3000 274.9980 0.3000 275.1000 0.3000 275.2980 0.3000 275.4000 1.0000 275.5980 1.0000 275.7000 1.0000 275.8980 1.0000 276.0000 0.3000 276.1980 0.3000 276.3000 0.3000 276.4980 0.3000 276.6000 1.0000 276.7980 1.0000 276.9000 1.0000 277.0980 1.0000 277.2000 0.3000 277.3980 0.3000 277.5000 0.3000 277.6980 0.3000 277.8000 1.0000 277.9980 1.0000 278.1000 1.0000 278.2980 1.0000 278.4000 0.3000 278.5980 0.3000 278.7000 0.3000 278.8980 0.3000 279.0000 1.0000 279.1980 1.0000 279.3000 1.0000 279.4980 1.0000 279.6000 0.3000 279.7980 0.3000 279.9000 0.3000 280.0980 0.3000 280.2000 1.0000 280.3980 1.0000 280.5000 1.0000 280.6980 1.0000 280.8000 0.3000 280.9980 0.3000 281.1000 0.3000 281.2980 0.3000 281.4000 1.0000 281.5980 1.0000 281.7000 1.0000 281.8980 1.0000 282.0000 0.3000 282.1980 0.3000 282.3000 0.3000 282.4980 0.3000 282.6000 1.0000 282.7980 1.0000 282.9000 1.0000 283.0980 1.0000 283.2000 0.3000 283.3980 0.3000 283.5000 0.3000 283.6980 0.3000 283.8000 1.0000 283.9980 1.0000 284.1000 1.0000 284.2980 1.0000 284.4000 0.3000 284.5980 0.3000 284.7000 0.3000 284.8980 0.3000 285.0000 1.0000 285.1980 1.0000 285.3000 1.0000 285.4980 1.0000 285.6000 0.3000 285.7980 0.3000 285.9000 0.3000 286.0980 0.3000 286.2000 1.0000 286.3980 1.0000 286.5000 1.0000 286.6980 1.0000 286.8000 0.3000 286.9980 0.3000 287.1000 0.3000 287.2980 0.3000 287.4000 1.0000 287.5980 1.0000 287.7000 1.0000 287.8980 1.0000 288.0000 0.3000 288.1980 0.3000 288.3000 0.3000 288.4980 0.3000 288.6000 1.0000 288.7980 1.0000 288.9000 1.0000 289.0980 1.0000 289.2000 0.3000 289.3980 0.3000 289.5000 0.3000 289.6980 0.3000 289.8000 1.0000 289.9980 1.0000 290.1000 1.0000 290.2980 1.0000 290.4000 0.3000 290.5980 0.3000 290.7000 0.3000 290.8980 0.3000 291.0000 1.0000 291.1980 1.0000 291.3000 1.0000 291.4980 1.0000 291.6000 0.3000 291.7980 0.3000 291.9000 0.3000 292.0980 0.3000 292.2000 1.0000 292.3980 1.0000 292.5000 1.0000 292.6980 1.0000 292.8000 0.3000 292.9980 0.3000 293.1000 0.3000 293.2980 0.3000 293.4000 1.0000 293.5980 1.0000 293.7000 1.0000 293.8980 1.0000 294.0000 0.3000 294.1980 0.3000 294.3000 0.3000 294.4980 0.3000 294.6000 1.0000 294.7980 1.0000 294.9000 1.0000 295.0980 1.0000 295.2000 0.3000 295.3980 0.3000 295.5000 0.3000 295.6980 0.3000 295.8000 1.0000 295.9980 1.0000 296.1000 1.0000 296.2980 1.0000 296.4000 0.3000 296.5980 0.3000 296.7000 0.3000 296.8980 0.3000 297.0000 1.0000 297.1980 1.0000 297.3000 1.0000 297.4980 1.0000 297.6000 0.3000 297.7980 0.3000 297.9000 0.3000 298.0980 0.3000 298.2000 1.0000 298.3980 1.0000 298.5000 1.0000 298.6980 1.0000 298.8000 0.3000 298.9980 0.3000 299.1000 0.3000 299.2980 0.3000 299.4000 1.0000 299.5980 1.0000 299.7000 1.0000 299.8980 1.0000 300.0000 0.3000 300.1980 0.3000 300.3000 0.3000 300.4980 0.3000 300.6000 1.0000 300.7980 1.0000 300.9000 1.0000 301.0980 1.0000 301.2000 0.3000 301.3980 0.3000 301.5000 0.3000 301.6980 0.3000 301.8000 1.0000 301.9980 1.0000 302.1000 1.0000 302.2980 1.0000 302.4000 0.3000 302.5980 0.3000 302.7000 0.3000 302.8980 0.3000 303.0000 1.0000 303.1980 1.0000 303.3000 1.0000 303.4980 1.0000 303.6000 0.3000 303.7980 0.3000 303.9000 0.3000 304.0980 0.3000 304.2000 1.0000 304.3980 1.0000 304.5000 1.0000 304.6980 1.0000 304.8000 0.3000 304.9980 0.3000 305.1000 0.3000 305.2980 0.3000 305.4000 1.0000 305.5980 1.0000 305.7000 1.0000 305.8980 1.0000 306.0000 0.3000 306.1980 0.3000 306.3000 0.3000 306.4980 0.3000 306.6000 1.0000 306.7980 1.0000 306.9000 1.0000 307.0980 1.0000 307.2000 0.3000 307.3980 0.3000 307.5000 0.3000 307.6980 0.3000 307.8000 1.0000 307.9980 1.0000 308.1000 1.0000 308.2980 1.0000 308.4000 0.3000 308.5980 0.3000 308.7000 0.3000 308.8980 0.3000 309.0000 1.0000 309.1980 1.0000 309.3000 1.0000 309.4980 1.0000 309.6000 0.3000 309.7980 0.3000 309.9000 0.3000 310.0980 0.3000 310.2000 1.0000 310.3980 1.0000 310.5000 1.0000 310.6980 1.0000 310.8000 0.3000 310.9980 0.3000 311.1000 0.3000 311.2980 0.3000 311.4000 1.0000 311.5980 1.0000 311.7000 1.0000 311.8980 1.0000 312.0000 0.3000 312.1980 0.3000 312.3000 0.3000 312.4980 0.3000 312.6000 1.0000 312.7980 1.0000 312.9000 1.0000 313.0980 1.0000 313.2000 0.3000 313.3980 0.3000 313.5000 0.3000 313.6980 0.3000 313.8000 1.0000 313.9980 1.0000 314.1000 1.0000 314.2980 1.0000 314.4000 0.3000 314.5980 0.3000 314.7000 0.3000 314.8980 0.3000 315.0000 1.0000 315.1980 1.0000 315.3000 1.0000 315.4980 1.0000 315.6000 0.3000 315.7980 0.3000 315.9000 0.3000 316.0980 0.3000 316.2000 1.0000 316.3980 1.0000 316.5000 1.0000 316.6980 1.0000 316.8000 0.3000 316.9980 0.3000 317.1000 0.3000 317.2980 0.3000 317.4000 1.0000 317.5980 1.0000 317.7000 1.0000 317.8980 1.0000 318.0000 0.3000 318.1980 0.3000 318.3000 0.3000 318.4980 0.3000 318.6000 1.0000 318.7980 1.0000 318.9000 1.0000 319.0980 1.0000 319.2000 0.3000 319.3980 0.3000 319.5000 0.3000 319.6980 0.3000 319.8000 1.0000 319.9980 1.0000 320.1000 1.0000 320.2980 1.0000 320.4000 0.3000 320.5980 0.3000 320.7000 0.3000 320.8980 0.3000 321.0000 1.0000 321.1980 1.0000 321.3000 1.0000 321.4980 1.0000 321.6000 0.3000 321.7980 0.3000 321.9000 0.3000 322.0980 0.3000 322.2000 1.0000 322.3980 1.0000 322.5000 1.0000 322.6980 1.0000 322.8000 0.3000 322.9980 0.3000 323.1000 0.3000 323.2980 0.3000 323.4000 1.0000 323.5980 1.0000 323.7000 1.0000 323.8980 1.0000 324.0000 0.3000 324.1980 0.3000 324.3000 0.3000 324.4980 0.3000 324.6000 1.0000 324.7980 1.0000 324.9000 1.0000 325.0980 1.0000 325.2000 0.3000 325.3980 0.3000 325.5000 0.3000 325.6980 0.3000 325.8000 1.0000 325.9980 1.0000 326.1000 1.0000 326.2980 1.0000 326.4000 0.3000 326.5980 0.3000 326.7000 0.3000 326.8980 0.3000 327.0000 1.0000 327.1980 1.0000 327.3000 1.0000 327.4980 1.0000 327.6000 0.3000 327.7980 0.3000 327.9000 0.3000 328.0980 0.3000 328.2000 1.0000 328.3980 1.0000 328.5000 1.0000 328.6980 1.0000 328.8000 0.3000 328.9980 0.3000 329.1000 0.3000 329.2980 0.3000 329.4000 1.0000 329.5980 1.0000 329.7000 1.0000 329.8980 1.0000 330.0000 0.3000 330.1980 0.3000 330.3000 0.3000 330.4980 0.3000 330.6000 1.0000 330.7980 1.0000 330.9000 1.0000 331.0980 1.0000 331.2000 0.3000 331.3980 0.3000 331.5000 0.3000 331.6980 0.3000 331.8000 1.0000 331.9980 1.0000 332.1000 1.0000 332.2980 1.0000 332.4000 0.3000 332.5980 0.3000 332.7000 0.3000 332.8980 0.3000 333.0000 1.0000 333.1980 1.0000 333.3000 1.0000 333.4980 1.0000 333.6000 0.3000 333.7980 0.3000 333.9000 0.3000 334.0980 0.3000 334.2000 1.0000 334.3980 1.0000 334.5000 1.0000 334.6980 1.0000 334.8000 0.3000 334.9980 0.3000 335.1000 0.3000 335.2980 0.3000 335.4000 1.0000 335.5980 1.0000 335.7000 1.0000 335.8980 1.0000 336.0000 0.3000 336.1980 0.3000 336.3000 0.3000 336.4980 0.3000 336.6000 1.0000 336.7980 1.0000 336.9000 1.0000 337.0980 1.0000 337.2000 0.3000 337.3980 0.3000 337.5000 0.3000 337.6980 0.3000 337.8000 1.0000 337.9980 1.0000 338.1000 1.0000 338.2980 1.0000 338.4000 0.3000 338.5980 0.3000 338.7000 0.3000 338.8980 0.3000 339.0000 1.0000 339.1980 1.0000 339.3000 1.0000 339.4980 1.0000 339.6000 0.3000 339.7980 0.3000 339.9000 0.3000 340.0980 0.3000 340.2000 1.0000 340.3980 1.0000 340.5000 1.0000 340.6980 1.0000 340.8000 0.3000 340.9980 0.3000 341.1000 0.3000 341.2980 0.3000 341.4000 1.0000 341.5980 1.0000 341.7000 1.0000 341.8980 1.0000 342.0000 0.3000 342.1980 0.3000 342.3000 0.3000 342.4980 0.3000 342.6000 1.0000 342.7980 1.0000 342.9000 1.0000 343.0980 1.0000 343.2000 0.3000 343.3980 0.3000 343.5000 0.3000 343.6980 0.3000 343.8000 1.0000 343.9980 1.0000 344.1000 1.0000 344.2980 1.0000 344.4000 0.3000 344.5980 0.3000 344.7000 0.3000 344.8980 0.3000 345.0000 1.0000 345.1980 1.0000 345.3000 1.0000 345.4980 1.0000 345.6000 0.3000 345.7980 0.3000 345.9000 0.3000 346.0980 0.3000 346.2000 1.0000 346.3980 1.0000 346.5000 1.0000 346.6980 1.0000 346.8000 0.3000 346.9980 0.3000 347.1000 0.3000 347.2980 0.3000 347.4000 1.0000 347.5980 1.0000 347.7000 1.0000 347.8980 1.0000 348.0000 0.3000 348.1980 0.3000 348.3000 0.3000 348.4980 0.3000 348.6000 1.0000 348.7980 1.0000 348.9000 1.0000 349.0980 1.0000 349.2000 0.3000 349.3980 0.3000 349.5000 0.3000 349.6980 0.3000 349.8000 1.0000 349.9980 1.0000 350.1000 1.0000 350.2980 1.0000 350.4000 0.3000 350.5980 0.3000 350.7000 0.3000 350.8980 0.3000 351.0000 1.0000 351.1980 1.0000 351.3000 1.0000 351.4980 1.0000 351.6000 0.3000 351.7980 0.3000 351.9000 0.3000 352.0980 0.3000 352.2000 1.0000 352.3980 1.0000 352.5000 1.0000 352.6980 1.0000 352.8000 0.3000 352.9980 0.3000 353.1000 0.3000 353.2980 0.3000 353.4000 1.0000 353.5980 1.0000 353.7000 1.0000 353.8980 1.0000 354.0000 0.3000 354.1980 0.3000 354.3000 0.3000 354.4980 0.3000 354.6000 1.0000 354.7980 1.0000 354.9000 1.0000 355.0980 1.0000 355.2000 0.3000 355.3980 0.3000 355.5000 0.3000 355.6980 0.3000 355.8000 1.0000 355.9980 1.0000 356.1000 1.0000 356.2980 1.0000 356.4000 0.3000 356.5980 0.3000 356.7000 0.3000 356.8980 0.3000 357.0000 1.0000 357.1980 1.0000 357.3000 1.0000 357.4980 1.0000 357.6000 0.3000 357.7980 0.3000 357.9000 0.3000 358.0980 0.3000 358.2000 1.0000 358.3980 1.0000 358.5000 1.0000 358.6980 1.0000 358.8000 0.3000 358.9980 0.3000 359.1000 0.3000 359.2980 0.3000 359.4000 1.0000 359.5980 1.0000 359.7000 1.0000 359.8980 1.0000 360.0000 1.0000)
Vau2 au2 0 PWL(0.0000 0.3000 0.1980 0.3000 0.3000 1.0000 0.4980 1.0000 0.6000 0.3000 0.7980 0.3000 0.9000 1.0000 1.0980 1.0000 1.2000 0.3000 1.3980 0.3000 1.5000 1.0000 1.6980 1.0000 1.8000 0.3000 1.9980 0.3000 2.1000 1.0000 2.2980 1.0000 2.4000 0.3000 2.5980 0.3000 2.7000 1.0000 2.8980 1.0000 3.0000 0.3000 3.1980 0.3000 3.3000 1.0000 3.4980 1.0000 3.6000 0.3000 3.7980 0.3000 3.9000 1.0000 4.0980 1.0000 4.2000 0.3000 4.3980 0.3000 4.5000 1.0000 4.6980 1.0000 4.8000 0.3000 4.9980 0.3000 5.1000 1.0000 5.2980 1.0000 5.4000 0.3000 5.5980 0.3000 5.7000 1.0000 5.8980 1.0000 6.0000 0.3000 6.1980 0.3000 6.3000 1.0000 6.4980 1.0000 6.6000 0.3000 6.7980 0.3000 6.9000 1.0000 7.0980 1.0000 7.2000 0.3000 7.3980 0.3000 7.5000 1.0000 7.6980 1.0000 7.8000 0.3000 7.9980 0.3000 8.1000 1.0000 8.2980 1.0000 8.4000 0.3000 8.5980 0.3000 8.7000 1.0000 8.8980 1.0000 9.0000 0.3000 9.1980 0.3000 9.3000 1.0000 9.4980 1.0000 9.6000 0.3000 9.7980 0.3000 9.9000 1.0000 10.0980 1.0000 10.2000 0.3000 10.3980 0.3000 10.5000 1.0000 10.6980 1.0000 10.8000 0.3000 10.9980 0.3000 11.1000 1.0000 11.2980 1.0000 11.4000 0.3000 11.5980 0.3000 11.7000 1.0000 11.8980 1.0000 12.0000 0.3000 12.1980 0.3000 12.3000 1.0000 12.4980 1.0000 12.6000 0.3000 12.7980 0.3000 12.9000 1.0000 13.0980 1.0000 13.2000 0.3000 13.3980 0.3000 13.5000 1.0000 13.6980 1.0000 13.8000 0.3000 13.9980 0.3000 14.1000 1.0000 14.2980 1.0000 14.4000 0.3000 14.5980 0.3000 14.7000 1.0000 14.8980 1.0000 15.0000 0.3000 15.1980 0.3000 15.3000 1.0000 15.4980 1.0000 15.6000 0.3000 15.7980 0.3000 15.9000 1.0000 16.0980 1.0000 16.2000 0.3000 16.3980 0.3000 16.5000 1.0000 16.6980 1.0000 16.8000 0.3000 16.9980 0.3000 17.1000 1.0000 17.2980 1.0000 17.4000 0.3000 17.5980 0.3000 17.7000 1.0000 17.8980 1.0000 18.0000 0.3000 18.1980 0.3000 18.3000 1.0000 18.4980 1.0000 18.6000 0.3000 18.7980 0.3000 18.9000 1.0000 19.0980 1.0000 19.2000 0.3000 19.3980 0.3000 19.5000 1.0000 19.6980 1.0000 19.8000 0.3000 19.9980 0.3000 20.1000 1.0000 20.2980 1.0000 20.4000 0.3000 20.5980 0.3000 20.7000 1.0000 20.8980 1.0000 21.0000 0.3000 21.1980 0.3000 21.3000 1.0000 21.4980 1.0000 21.6000 0.3000 21.7980 0.3000 21.9000 1.0000 22.0980 1.0000 22.2000 0.3000 22.3980 0.3000 22.5000 1.0000 22.6980 1.0000 22.8000 0.3000 22.9980 0.3000 23.1000 1.0000 23.2980 1.0000 23.4000 0.3000 23.5980 0.3000 23.7000 1.0000 23.8980 1.0000 24.0000 0.3000 24.1980 0.3000 24.3000 1.0000 24.4980 1.0000 24.6000 0.3000 24.7980 0.3000 24.9000 1.0000 25.0980 1.0000 25.2000 0.3000 25.3980 0.3000 25.5000 1.0000 25.6980 1.0000 25.8000 0.3000 25.9980 0.3000 26.1000 1.0000 26.2980 1.0000 26.4000 0.3000 26.5980 0.3000 26.7000 1.0000 26.8980 1.0000 27.0000 0.3000 27.1980 0.3000 27.3000 1.0000 27.4980 1.0000 27.6000 0.3000 27.7980 0.3000 27.9000 1.0000 28.0980 1.0000 28.2000 0.3000 28.3980 0.3000 28.5000 1.0000 28.6980 1.0000 28.8000 0.3000 28.9980 0.3000 29.1000 1.0000 29.2980 1.0000 29.4000 0.3000 29.5980 0.3000 29.7000 1.0000 29.8980 1.0000 30.0000 0.3000 30.1980 0.3000 30.3000 1.0000 30.4980 1.0000 30.6000 0.3000 30.7980 0.3000 30.9000 1.0000 31.0980 1.0000 31.2000 0.3000 31.3980 0.3000 31.5000 1.0000 31.6980 1.0000 31.8000 0.3000 31.9980 0.3000 32.1000 1.0000 32.2980 1.0000 32.4000 0.3000 32.5980 0.3000 32.7000 1.0000 32.8980 1.0000 33.0000 0.3000 33.1980 0.3000 33.3000 1.0000 33.4980 1.0000 33.6000 0.3000 33.7980 0.3000 33.9000 1.0000 34.0980 1.0000 34.2000 0.3000 34.3980 0.3000 34.5000 1.0000 34.6980 1.0000 34.8000 0.3000 34.9980 0.3000 35.1000 1.0000 35.2980 1.0000 35.4000 0.3000 35.5980 0.3000 35.7000 1.0000 35.8980 1.0000 36.0000 0.3000 36.1980 0.3000 36.3000 1.0000 36.4980 1.0000 36.6000 0.3000 36.7980 0.3000 36.9000 1.0000 37.0980 1.0000 37.2000 0.3000 37.3980 0.3000 37.5000 1.0000 37.6980 1.0000 37.8000 0.3000 37.9980 0.3000 38.1000 1.0000 38.2980 1.0000 38.4000 0.3000 38.5980 0.3000 38.7000 1.0000 38.8980 1.0000 39.0000 0.3000 39.1980 0.3000 39.3000 1.0000 39.4980 1.0000 39.6000 0.3000 39.7980 0.3000 39.9000 1.0000 40.0980 1.0000 40.2000 0.3000 40.3980 0.3000 40.5000 1.0000 40.6980 1.0000 40.8000 0.3000 40.9980 0.3000 41.1000 1.0000 41.2980 1.0000 41.4000 0.3000 41.5980 0.3000 41.7000 1.0000 41.8980 1.0000 42.0000 0.3000 42.1980 0.3000 42.3000 1.0000 42.4980 1.0000 42.6000 0.3000 42.7980 0.3000 42.9000 1.0000 43.0980 1.0000 43.2000 0.3000 43.3980 0.3000 43.5000 1.0000 43.6980 1.0000 43.8000 0.3000 43.9980 0.3000 44.1000 1.0000 44.2980 1.0000 44.4000 0.3000 44.5980 0.3000 44.7000 1.0000 44.8980 1.0000 45.0000 0.3000 45.1980 0.3000 45.3000 1.0000 45.4980 1.0000 45.6000 0.3000 45.7980 0.3000 45.9000 1.0000 46.0980 1.0000 46.2000 0.3000 46.3980 0.3000 46.5000 1.0000 46.6980 1.0000 46.8000 0.3000 46.9980 0.3000 47.1000 1.0000 47.2980 1.0000 47.4000 0.3000 47.5980 0.3000 47.7000 1.0000 47.8980 1.0000 48.0000 0.3000 48.1980 0.3000 48.3000 1.0000 48.4980 1.0000 48.6000 0.3000 48.7980 0.3000 48.9000 1.0000 49.0980 1.0000 49.2000 0.3000 49.3980 0.3000 49.5000 1.0000 49.6980 1.0000 49.8000 0.3000 49.9980 0.3000 50.1000 1.0000 50.2980 1.0000 50.4000 0.3000 50.5980 0.3000 50.7000 1.0000 50.8980 1.0000 51.0000 0.3000 51.1980 0.3000 51.3000 1.0000 51.4980 1.0000 51.6000 0.3000 51.7980 0.3000 51.9000 1.0000 52.0980 1.0000 52.2000 0.3000 52.3980 0.3000 52.5000 1.0000 52.6980 1.0000 52.8000 0.3000 52.9980 0.3000 53.1000 1.0000 53.2980 1.0000 53.4000 0.3000 53.5980 0.3000 53.7000 1.0000 53.8980 1.0000 54.0000 0.3000 54.1980 0.3000 54.3000 1.0000 54.4980 1.0000 54.6000 0.3000 54.7980 0.3000 54.9000 1.0000 55.0980 1.0000 55.2000 0.3000 55.3980 0.3000 55.5000 1.0000 55.6980 1.0000 55.8000 0.3000 55.9980 0.3000 56.1000 1.0000 56.2980 1.0000 56.4000 0.3000 56.5980 0.3000 56.7000 1.0000 56.8980 1.0000 57.0000 0.3000 57.1980 0.3000 57.3000 1.0000 57.4980 1.0000 57.6000 0.3000 57.7980 0.3000 57.9000 1.0000 58.0980 1.0000 58.2000 0.3000 58.3980 0.3000 58.5000 1.0000 58.6980 1.0000 58.8000 0.3000 58.9980 0.3000 59.1000 1.0000 59.2980 1.0000 59.4000 0.3000 59.5980 0.3000 59.7000 1.0000 59.8980 1.0000 60.0000 0.3000 60.1980 0.3000 60.3000 1.0000 60.4980 1.0000 60.6000 0.3000 60.7980 0.3000 60.9000 1.0000 61.0980 1.0000 61.2000 0.3000 61.3980 0.3000 61.5000 1.0000 61.6980 1.0000 61.8000 0.3000 61.9980 0.3000 62.1000 1.0000 62.2980 1.0000 62.4000 0.3000 62.5980 0.3000 62.7000 1.0000 62.8980 1.0000 63.0000 0.3000 63.1980 0.3000 63.3000 1.0000 63.4980 1.0000 63.6000 0.3000 63.7980 0.3000 63.9000 1.0000 64.0980 1.0000 64.2000 0.3000 64.3980 0.3000 64.5000 1.0000 64.6980 1.0000 64.8000 0.3000 64.9980 0.3000 65.1000 1.0000 65.2980 1.0000 65.4000 0.3000 65.5980 0.3000 65.7000 1.0000 65.8980 1.0000 66.0000 0.3000 66.1980 0.3000 66.3000 1.0000 66.4980 1.0000 66.6000 0.3000 66.7980 0.3000 66.9000 1.0000 67.0980 1.0000 67.2000 0.3000 67.3980 0.3000 67.5000 1.0000 67.6980 1.0000 67.8000 0.3000 67.9980 0.3000 68.1000 1.0000 68.2980 1.0000 68.4000 0.3000 68.5980 0.3000 68.7000 1.0000 68.8980 1.0000 69.0000 0.3000 69.1980 0.3000 69.3000 1.0000 69.4980 1.0000 69.6000 0.3000 69.7980 0.3000 69.9000 1.0000 70.0980 1.0000 70.2000 0.3000 70.3980 0.3000 70.5000 1.0000 70.6980 1.0000 70.8000 0.3000 70.9980 0.3000 71.1000 1.0000 71.2980 1.0000 71.4000 0.3000 71.5980 0.3000 71.7000 1.0000 71.8980 1.0000 72.0000 0.3000 72.1980 0.3000 72.3000 1.0000 72.4980 1.0000 72.6000 0.3000 72.7980 0.3000 72.9000 1.0000 73.0980 1.0000 73.2000 0.3000 73.3980 0.3000 73.5000 1.0000 73.6980 1.0000 73.8000 0.3000 73.9980 0.3000 74.1000 1.0000 74.2980 1.0000 74.4000 0.3000 74.5980 0.3000 74.7000 1.0000 74.8980 1.0000 75.0000 0.3000 75.1980 0.3000 75.3000 1.0000 75.4980 1.0000 75.6000 0.3000 75.7980 0.3000 75.9000 1.0000 76.0980 1.0000 76.2000 0.3000 76.3980 0.3000 76.5000 1.0000 76.6980 1.0000 76.8000 0.3000 76.9980 0.3000 77.1000 1.0000 77.2980 1.0000 77.4000 0.3000 77.5980 0.3000 77.7000 1.0000 77.8980 1.0000 78.0000 0.3000 78.1980 0.3000 78.3000 1.0000 78.4980 1.0000 78.6000 0.3000 78.7980 0.3000 78.9000 1.0000 79.0980 1.0000 79.2000 0.3000 79.3980 0.3000 79.5000 1.0000 79.6980 1.0000 79.8000 0.3000 79.9980 0.3000 80.1000 1.0000 80.2980 1.0000 80.4000 0.3000 80.5980 0.3000 80.7000 1.0000 80.8980 1.0000 81.0000 0.3000 81.1980 0.3000 81.3000 1.0000 81.4980 1.0000 81.6000 0.3000 81.7980 0.3000 81.9000 1.0000 82.0980 1.0000 82.2000 0.3000 82.3980 0.3000 82.5000 1.0000 82.6980 1.0000 82.8000 0.3000 82.9980 0.3000 83.1000 1.0000 83.2980 1.0000 83.4000 0.3000 83.5980 0.3000 83.7000 1.0000 83.8980 1.0000 84.0000 0.3000 84.1980 0.3000 84.3000 1.0000 84.4980 1.0000 84.6000 0.3000 84.7980 0.3000 84.9000 1.0000 85.0980 1.0000 85.2000 0.3000 85.3980 0.3000 85.5000 1.0000 85.6980 1.0000 85.8000 0.3000 85.9980 0.3000 86.1000 1.0000 86.2980 1.0000 86.4000 0.3000 86.5980 0.3000 86.7000 1.0000 86.8980 1.0000 87.0000 0.3000 87.1980 0.3000 87.3000 1.0000 87.4980 1.0000 87.6000 0.3000 87.7980 0.3000 87.9000 1.0000 88.0980 1.0000 88.2000 0.3000 88.3980 0.3000 88.5000 1.0000 88.6980 1.0000 88.8000 0.3000 88.9980 0.3000 89.1000 1.0000 89.2980 1.0000 89.4000 0.3000 89.5980 0.3000 89.7000 1.0000 89.8980 1.0000 90.0000 0.3000 90.1980 0.3000 90.3000 1.0000 90.4980 1.0000 90.6000 0.3000 90.7980 0.3000 90.9000 1.0000 91.0980 1.0000 91.2000 0.3000 91.3980 0.3000 91.5000 1.0000 91.6980 1.0000 91.8000 0.3000 91.9980 0.3000 92.1000 1.0000 92.2980 1.0000 92.4000 0.3000 92.5980 0.3000 92.7000 1.0000 92.8980 1.0000 93.0000 0.3000 93.1980 0.3000 93.3000 1.0000 93.4980 1.0000 93.6000 0.3000 93.7980 0.3000 93.9000 1.0000 94.0980 1.0000 94.2000 0.3000 94.3980 0.3000 94.5000 1.0000 94.6980 1.0000 94.8000 0.3000 94.9980 0.3000 95.1000 1.0000 95.2980 1.0000 95.4000 0.3000 95.5980 0.3000 95.7000 1.0000 95.8980 1.0000 96.0000 0.3000 96.1980 0.3000 96.3000 1.0000 96.4980 1.0000 96.6000 0.3000 96.7980 0.3000 96.9000 1.0000 97.0980 1.0000 97.2000 0.3000 97.3980 0.3000 97.5000 1.0000 97.6980 1.0000 97.8000 0.3000 97.9980 0.3000 98.1000 1.0000 98.2980 1.0000 98.4000 0.3000 98.5980 0.3000 98.7000 1.0000 98.8980 1.0000 99.0000 0.3000 99.1980 0.3000 99.3000 1.0000 99.4980 1.0000 99.6000 0.3000 99.7980 0.3000 99.9000 1.0000 100.0980 1.0000 100.2000 0.3000 100.3980 0.3000 100.5000 1.0000 100.6980 1.0000 100.8000 0.3000 100.9980 0.3000 101.1000 1.0000 101.2980 1.0000 101.4000 0.3000 101.5980 0.3000 101.7000 1.0000 101.8980 1.0000 102.0000 0.3000 102.1980 0.3000 102.3000 1.0000 102.4980 1.0000 102.6000 0.3000 102.7980 0.3000 102.9000 1.0000 103.0980 1.0000 103.2000 0.3000 103.3980 0.3000 103.5000 1.0000 103.6980 1.0000 103.8000 0.3000 103.9980 0.3000 104.1000 1.0000 104.2980 1.0000 104.4000 0.3000 104.5980 0.3000 104.7000 1.0000 104.8980 1.0000 105.0000 0.3000 105.1980 0.3000 105.3000 1.0000 105.4980 1.0000 105.6000 0.3000 105.7980 0.3000 105.9000 1.0000 106.0980 1.0000 106.2000 0.3000 106.3980 0.3000 106.5000 1.0000 106.6980 1.0000 106.8000 0.3000 106.9980 0.3000 107.1000 1.0000 107.2980 1.0000 107.4000 0.3000 107.5980 0.3000 107.7000 1.0000 107.8980 1.0000 108.0000 0.3000 108.1980 0.3000 108.3000 1.0000 108.4980 1.0000 108.6000 0.3000 108.7980 0.3000 108.9000 1.0000 109.0980 1.0000 109.2000 0.3000 109.3980 0.3000 109.5000 1.0000 109.6980 1.0000 109.8000 0.3000 109.9980 0.3000 110.1000 1.0000 110.2980 1.0000 110.4000 0.3000 110.5980 0.3000 110.7000 1.0000 110.8980 1.0000 111.0000 0.3000 111.1980 0.3000 111.3000 1.0000 111.4980 1.0000 111.6000 0.3000 111.7980 0.3000 111.9000 1.0000 112.0980 1.0000 112.2000 0.3000 112.3980 0.3000 112.5000 1.0000 112.6980 1.0000 112.8000 0.3000 112.9980 0.3000 113.1000 1.0000 113.2980 1.0000 113.4000 0.3000 113.5980 0.3000 113.7000 1.0000 113.8980 1.0000 114.0000 0.3000 114.1980 0.3000 114.3000 1.0000 114.4980 1.0000 114.6000 0.3000 114.7980 0.3000 114.9000 1.0000 115.0980 1.0000 115.2000 0.3000 115.3980 0.3000 115.5000 1.0000 115.6980 1.0000 115.8000 0.3000 115.9980 0.3000 116.1000 1.0000 116.2980 1.0000 116.4000 0.3000 116.5980 0.3000 116.7000 1.0000 116.8980 1.0000 117.0000 0.3000 117.1980 0.3000 117.3000 1.0000 117.4980 1.0000 117.6000 0.3000 117.7980 0.3000 117.9000 1.0000 118.0980 1.0000 118.2000 0.3000 118.3980 0.3000 118.5000 1.0000 118.6980 1.0000 118.8000 0.3000 118.9980 0.3000 119.1000 1.0000 119.2980 1.0000 119.4000 0.3000 119.5980 0.3000 119.7000 1.0000 119.8980 1.0000 120.0000 0.3000 120.1980 0.3000 120.3000 1.0000 120.4980 1.0000 120.6000 0.3000 120.7980 0.3000 120.9000 1.0000 121.0980 1.0000 121.2000 0.3000 121.3980 0.3000 121.5000 1.0000 121.6980 1.0000 121.8000 0.3000 121.9980 0.3000 122.1000 1.0000 122.2980 1.0000 122.4000 0.3000 122.5980 0.3000 122.7000 1.0000 122.8980 1.0000 123.0000 0.3000 123.1980 0.3000 123.3000 1.0000 123.4980 1.0000 123.6000 0.3000 123.7980 0.3000 123.9000 1.0000 124.0980 1.0000 124.2000 0.3000 124.3980 0.3000 124.5000 1.0000 124.6980 1.0000 124.8000 0.3000 124.9980 0.3000 125.1000 1.0000 125.2980 1.0000 125.4000 0.3000 125.5980 0.3000 125.7000 1.0000 125.8980 1.0000 126.0000 0.3000 126.1980 0.3000 126.3000 1.0000 126.4980 1.0000 126.6000 0.3000 126.7980 0.3000 126.9000 1.0000 127.0980 1.0000 127.2000 0.3000 127.3980 0.3000 127.5000 1.0000 127.6980 1.0000 127.8000 0.3000 127.9980 0.3000 128.1000 1.0000 128.2980 1.0000 128.4000 0.3000 128.5980 0.3000 128.7000 1.0000 128.8980 1.0000 129.0000 0.3000 129.1980 0.3000 129.3000 1.0000 129.4980 1.0000 129.6000 0.3000 129.7980 0.3000 129.9000 1.0000 130.0980 1.0000 130.2000 0.3000 130.3980 0.3000 130.5000 1.0000 130.6980 1.0000 130.8000 0.3000 130.9980 0.3000 131.1000 1.0000 131.2980 1.0000 131.4000 0.3000 131.5980 0.3000 131.7000 1.0000 131.8980 1.0000 132.0000 0.3000 132.1980 0.3000 132.3000 1.0000 132.4980 1.0000 132.6000 0.3000 132.7980 0.3000 132.9000 1.0000 133.0980 1.0000 133.2000 0.3000 133.3980 0.3000 133.5000 1.0000 133.6980 1.0000 133.8000 0.3000 133.9980 0.3000 134.1000 1.0000 134.2980 1.0000 134.4000 0.3000 134.5980 0.3000 134.7000 1.0000 134.8980 1.0000 135.0000 0.3000 135.1980 0.3000 135.3000 1.0000 135.4980 1.0000 135.6000 0.3000 135.7980 0.3000 135.9000 1.0000 136.0980 1.0000 136.2000 0.3000 136.3980 0.3000 136.5000 1.0000 136.6980 1.0000 136.8000 0.3000 136.9980 0.3000 137.1000 1.0000 137.2980 1.0000 137.4000 0.3000 137.5980 0.3000 137.7000 1.0000 137.8980 1.0000 138.0000 0.3000 138.1980 0.3000 138.3000 1.0000 138.4980 1.0000 138.6000 0.3000 138.7980 0.3000 138.9000 1.0000 139.0980 1.0000 139.2000 0.3000 139.3980 0.3000 139.5000 1.0000 139.6980 1.0000 139.8000 0.3000 139.9980 0.3000 140.1000 1.0000 140.2980 1.0000 140.4000 0.3000 140.5980 0.3000 140.7000 1.0000 140.8980 1.0000 141.0000 0.3000 141.1980 0.3000 141.3000 1.0000 141.4980 1.0000 141.6000 0.3000 141.7980 0.3000 141.9000 1.0000 142.0980 1.0000 142.2000 0.3000 142.3980 0.3000 142.5000 1.0000 142.6980 1.0000 142.8000 0.3000 142.9980 0.3000 143.1000 1.0000 143.2980 1.0000 143.4000 0.3000 143.5980 0.3000 143.7000 1.0000 143.8980 1.0000 144.0000 0.3000 144.1980 0.3000 144.3000 1.0000 144.4980 1.0000 144.6000 0.3000 144.7980 0.3000 144.9000 1.0000 145.0980 1.0000 145.2000 0.3000 145.3980 0.3000 145.5000 1.0000 145.6980 1.0000 145.8000 0.3000 145.9980 0.3000 146.1000 1.0000 146.2980 1.0000 146.4000 0.3000 146.5980 0.3000 146.7000 1.0000 146.8980 1.0000 147.0000 0.3000 147.1980 0.3000 147.3000 1.0000 147.4980 1.0000 147.6000 0.3000 147.7980 0.3000 147.9000 1.0000 148.0980 1.0000 148.2000 0.3000 148.3980 0.3000 148.5000 1.0000 148.6980 1.0000 148.8000 0.3000 148.9980 0.3000 149.1000 1.0000 149.2980 1.0000 149.4000 0.3000 149.5980 0.3000 149.7000 1.0000 149.8980 1.0000 150.0000 0.3000 150.1980 0.3000 150.3000 1.0000 150.4980 1.0000 150.6000 0.3000 150.7980 0.3000 150.9000 1.0000 151.0980 1.0000 151.2000 0.3000 151.3980 0.3000 151.5000 1.0000 151.6980 1.0000 151.8000 0.3000 151.9980 0.3000 152.1000 1.0000 152.2980 1.0000 152.4000 0.3000 152.5980 0.3000 152.7000 1.0000 152.8980 1.0000 153.0000 0.3000 153.1980 0.3000 153.3000 1.0000 153.4980 1.0000 153.6000 0.3000 153.7980 0.3000 153.9000 1.0000 154.0980 1.0000 154.2000 0.3000 154.3980 0.3000 154.5000 1.0000 154.6980 1.0000 154.8000 0.3000 154.9980 0.3000 155.1000 1.0000 155.2980 1.0000 155.4000 0.3000 155.5980 0.3000 155.7000 1.0000 155.8980 1.0000 156.0000 0.3000 156.1980 0.3000 156.3000 1.0000 156.4980 1.0000 156.6000 0.3000 156.7980 0.3000 156.9000 1.0000 157.0980 1.0000 157.2000 0.3000 157.3980 0.3000 157.5000 1.0000 157.6980 1.0000 157.8000 0.3000 157.9980 0.3000 158.1000 1.0000 158.2980 1.0000 158.4000 0.3000 158.5980 0.3000 158.7000 1.0000 158.8980 1.0000 159.0000 0.3000 159.1980 0.3000 159.3000 1.0000 159.4980 1.0000 159.6000 0.3000 159.7980 0.3000 159.9000 1.0000 160.0980 1.0000 160.2000 0.3000 160.3980 0.3000 160.5000 1.0000 160.6980 1.0000 160.8000 0.3000 160.9980 0.3000 161.1000 1.0000 161.2980 1.0000 161.4000 0.3000 161.5980 0.3000 161.7000 1.0000 161.8980 1.0000 162.0000 0.3000 162.1980 0.3000 162.3000 1.0000 162.4980 1.0000 162.6000 0.3000 162.7980 0.3000 162.9000 1.0000 163.0980 1.0000 163.2000 0.3000 163.3980 0.3000 163.5000 1.0000 163.6980 1.0000 163.8000 0.3000 163.9980 0.3000 164.1000 1.0000 164.2980 1.0000 164.4000 0.3000 164.5980 0.3000 164.7000 1.0000 164.8980 1.0000 165.0000 0.3000 165.1980 0.3000 165.3000 1.0000 165.4980 1.0000 165.6000 0.3000 165.7980 0.3000 165.9000 1.0000 166.0980 1.0000 166.2000 0.3000 166.3980 0.3000 166.5000 1.0000 166.6980 1.0000 166.8000 0.3000 166.9980 0.3000 167.1000 1.0000 167.2980 1.0000 167.4000 0.3000 167.5980 0.3000 167.7000 1.0000 167.8980 1.0000 168.0000 0.3000 168.1980 0.3000 168.3000 1.0000 168.4980 1.0000 168.6000 0.3000 168.7980 0.3000 168.9000 1.0000 169.0980 1.0000 169.2000 0.3000 169.3980 0.3000 169.5000 1.0000 169.6980 1.0000 169.8000 0.3000 169.9980 0.3000 170.1000 1.0000 170.2980 1.0000 170.4000 0.3000 170.5980 0.3000 170.7000 1.0000 170.8980 1.0000 171.0000 0.3000 171.1980 0.3000 171.3000 1.0000 171.4980 1.0000 171.6000 0.3000 171.7980 0.3000 171.9000 1.0000 172.0980 1.0000 172.2000 0.3000 172.3980 0.3000 172.5000 1.0000 172.6980 1.0000 172.8000 0.3000 172.9980 0.3000 173.1000 1.0000 173.2980 1.0000 173.4000 0.3000 173.5980 0.3000 173.7000 1.0000 173.8980 1.0000 174.0000 0.3000 174.1980 0.3000 174.3000 1.0000 174.4980 1.0000 174.6000 0.3000 174.7980 0.3000 174.9000 1.0000 175.0980 1.0000 175.2000 0.3000 175.3980 0.3000 175.5000 1.0000 175.6980 1.0000 175.8000 0.3000 175.9980 0.3000 176.1000 1.0000 176.2980 1.0000 176.4000 0.3000 176.5980 0.3000 176.7000 1.0000 176.8980 1.0000 177.0000 0.3000 177.1980 0.3000 177.3000 1.0000 177.4980 1.0000 177.6000 0.3000 177.7980 0.3000 177.9000 1.0000 178.0980 1.0000 178.2000 0.3000 178.3980 0.3000 178.5000 1.0000 178.6980 1.0000 178.8000 0.3000 178.9980 0.3000 179.1000 1.0000 179.2980 1.0000 179.4000 0.3000 179.5980 0.3000 179.7000 1.0000 179.8980 1.0000 180.0000 0.3000 180.1980 0.3000 180.3000 1.0000 180.4980 1.0000 180.6000 0.3000 180.7980 0.3000 180.9000 1.0000 181.0980 1.0000 181.2000 0.3000 181.3980 0.3000 181.5000 1.0000 181.6980 1.0000 181.8000 0.3000 181.9980 0.3000 182.1000 1.0000 182.2980 1.0000 182.4000 0.3000 182.5980 0.3000 182.7000 1.0000 182.8980 1.0000 183.0000 0.3000 183.1980 0.3000 183.3000 1.0000 183.4980 1.0000 183.6000 0.3000 183.7980 0.3000 183.9000 1.0000 184.0980 1.0000 184.2000 0.3000 184.3980 0.3000 184.5000 1.0000 184.6980 1.0000 184.8000 0.3000 184.9980 0.3000 185.1000 1.0000 185.2980 1.0000 185.4000 0.3000 185.5980 0.3000 185.7000 1.0000 185.8980 1.0000 186.0000 0.3000 186.1980 0.3000 186.3000 1.0000 186.4980 1.0000 186.6000 0.3000 186.7980 0.3000 186.9000 1.0000 187.0980 1.0000 187.2000 0.3000 187.3980 0.3000 187.5000 1.0000 187.6980 1.0000 187.8000 0.3000 187.9980 0.3000 188.1000 1.0000 188.2980 1.0000 188.4000 0.3000 188.5980 0.3000 188.7000 1.0000 188.8980 1.0000 189.0000 0.3000 189.1980 0.3000 189.3000 1.0000 189.4980 1.0000 189.6000 0.3000 189.7980 0.3000 189.9000 1.0000 190.0980 1.0000 190.2000 0.3000 190.3980 0.3000 190.5000 1.0000 190.6980 1.0000 190.8000 0.3000 190.9980 0.3000 191.1000 1.0000 191.2980 1.0000 191.4000 0.3000 191.5980 0.3000 191.7000 1.0000 191.8980 1.0000 192.0000 0.3000 192.1980 0.3000 192.3000 1.0000 192.4980 1.0000 192.6000 0.3000 192.7980 0.3000 192.9000 1.0000 193.0980 1.0000 193.2000 0.3000 193.3980 0.3000 193.5000 1.0000 193.6980 1.0000 193.8000 0.3000 193.9980 0.3000 194.1000 1.0000 194.2980 1.0000 194.4000 0.3000 194.5980 0.3000 194.7000 1.0000 194.8980 1.0000 195.0000 0.3000 195.1980 0.3000 195.3000 1.0000 195.4980 1.0000 195.6000 0.3000 195.7980 0.3000 195.9000 1.0000 196.0980 1.0000 196.2000 0.3000 196.3980 0.3000 196.5000 1.0000 196.6980 1.0000 196.8000 0.3000 196.9980 0.3000 197.1000 1.0000 197.2980 1.0000 197.4000 0.3000 197.5980 0.3000 197.7000 1.0000 197.8980 1.0000 198.0000 0.3000 198.1980 0.3000 198.3000 1.0000 198.4980 1.0000 198.6000 0.3000 198.7980 0.3000 198.9000 1.0000 199.0980 1.0000 199.2000 0.3000 199.3980 0.3000 199.5000 1.0000 199.6980 1.0000 199.8000 0.3000 199.9980 0.3000 200.1000 1.0000 200.2980 1.0000 200.4000 0.3000 200.5980 0.3000 200.7000 1.0000 200.8980 1.0000 201.0000 0.3000 201.1980 0.3000 201.3000 1.0000 201.4980 1.0000 201.6000 0.3000 201.7980 0.3000 201.9000 1.0000 202.0980 1.0000 202.2000 0.3000 202.3980 0.3000 202.5000 1.0000 202.6980 1.0000 202.8000 0.3000 202.9980 0.3000 203.1000 1.0000 203.2980 1.0000 203.4000 0.3000 203.5980 0.3000 203.7000 1.0000 203.8980 1.0000 204.0000 0.3000 204.1980 0.3000 204.3000 1.0000 204.4980 1.0000 204.6000 0.3000 204.7980 0.3000 204.9000 1.0000 205.0980 1.0000 205.2000 0.3000 205.3980 0.3000 205.5000 1.0000 205.6980 1.0000 205.8000 0.3000 205.9980 0.3000 206.1000 1.0000 206.2980 1.0000 206.4000 0.3000 206.5980 0.3000 206.7000 1.0000 206.8980 1.0000 207.0000 0.3000 207.1980 0.3000 207.3000 1.0000 207.4980 1.0000 207.6000 0.3000 207.7980 0.3000 207.9000 1.0000 208.0980 1.0000 208.2000 0.3000 208.3980 0.3000 208.5000 1.0000 208.6980 1.0000 208.8000 0.3000 208.9980 0.3000 209.1000 1.0000 209.2980 1.0000 209.4000 0.3000 209.5980 0.3000 209.7000 1.0000 209.8980 1.0000 210.0000 0.3000 210.1980 0.3000 210.3000 1.0000 210.4980 1.0000 210.6000 0.3000 210.7980 0.3000 210.9000 1.0000 211.0980 1.0000 211.2000 0.3000 211.3980 0.3000 211.5000 1.0000 211.6980 1.0000 211.8000 0.3000 211.9980 0.3000 212.1000 1.0000 212.2980 1.0000 212.4000 0.3000 212.5980 0.3000 212.7000 1.0000 212.8980 1.0000 213.0000 0.3000 213.1980 0.3000 213.3000 1.0000 213.4980 1.0000 213.6000 0.3000 213.7980 0.3000 213.9000 1.0000 214.0980 1.0000 214.2000 0.3000 214.3980 0.3000 214.5000 1.0000 214.6980 1.0000 214.8000 0.3000 214.9980 0.3000 215.1000 1.0000 215.2980 1.0000 215.4000 0.3000 215.5980 0.3000 215.7000 1.0000 215.8980 1.0000 216.0000 0.3000 216.1980 0.3000 216.3000 1.0000 216.4980 1.0000 216.6000 0.3000 216.7980 0.3000 216.9000 1.0000 217.0980 1.0000 217.2000 0.3000 217.3980 0.3000 217.5000 1.0000 217.6980 1.0000 217.8000 0.3000 217.9980 0.3000 218.1000 1.0000 218.2980 1.0000 218.4000 0.3000 218.5980 0.3000 218.7000 1.0000 218.8980 1.0000 219.0000 0.3000 219.1980 0.3000 219.3000 1.0000 219.4980 1.0000 219.6000 0.3000 219.7980 0.3000 219.9000 1.0000 220.0980 1.0000 220.2000 0.3000 220.3980 0.3000 220.5000 1.0000 220.6980 1.0000 220.8000 0.3000 220.9980 0.3000 221.1000 1.0000 221.2980 1.0000 221.4000 0.3000 221.5980 0.3000 221.7000 1.0000 221.8980 1.0000 222.0000 0.3000 222.1980 0.3000 222.3000 1.0000 222.4980 1.0000 222.6000 0.3000 222.7980 0.3000 222.9000 1.0000 223.0980 1.0000 223.2000 0.3000 223.3980 0.3000 223.5000 1.0000 223.6980 1.0000 223.8000 0.3000 223.9980 0.3000 224.1000 1.0000 224.2980 1.0000 224.4000 0.3000 224.5980 0.3000 224.7000 1.0000 224.8980 1.0000 225.0000 0.3000 225.1980 0.3000 225.3000 1.0000 225.4980 1.0000 225.6000 0.3000 225.7980 0.3000 225.9000 1.0000 226.0980 1.0000 226.2000 0.3000 226.3980 0.3000 226.5000 1.0000 226.6980 1.0000 226.8000 0.3000 226.9980 0.3000 227.1000 1.0000 227.2980 1.0000 227.4000 0.3000 227.5980 0.3000 227.7000 1.0000 227.8980 1.0000 228.0000 0.3000 228.1980 0.3000 228.3000 1.0000 228.4980 1.0000 228.6000 0.3000 228.7980 0.3000 228.9000 1.0000 229.0980 1.0000 229.2000 0.3000 229.3980 0.3000 229.5000 1.0000 229.6980 1.0000 229.8000 0.3000 229.9980 0.3000 230.1000 1.0000 230.2980 1.0000 230.4000 0.3000 230.5980 0.3000 230.7000 1.0000 230.8980 1.0000 231.0000 0.3000 231.1980 0.3000 231.3000 1.0000 231.4980 1.0000 231.6000 0.3000 231.7980 0.3000 231.9000 1.0000 232.0980 1.0000 232.2000 0.3000 232.3980 0.3000 232.5000 1.0000 232.6980 1.0000 232.8000 0.3000 232.9980 0.3000 233.1000 1.0000 233.2980 1.0000 233.4000 0.3000 233.5980 0.3000 233.7000 1.0000 233.8980 1.0000 234.0000 0.3000 234.1980 0.3000 234.3000 1.0000 234.4980 1.0000 234.6000 0.3000 234.7980 0.3000 234.9000 1.0000 235.0980 1.0000 235.2000 0.3000 235.3980 0.3000 235.5000 1.0000 235.6980 1.0000 235.8000 0.3000 235.9980 0.3000 236.1000 1.0000 236.2980 1.0000 236.4000 0.3000 236.5980 0.3000 236.7000 1.0000 236.8980 1.0000 237.0000 0.3000 237.1980 0.3000 237.3000 1.0000 237.4980 1.0000 237.6000 0.3000 237.7980 0.3000 237.9000 1.0000 238.0980 1.0000 238.2000 0.3000 238.3980 0.3000 238.5000 1.0000 238.6980 1.0000 238.8000 0.3000 238.9980 0.3000 239.1000 1.0000 239.2980 1.0000 239.4000 0.3000 239.5980 0.3000 239.7000 1.0000 239.8980 1.0000 240.0000 0.3000 240.1980 0.3000 240.3000 1.0000 240.4980 1.0000 240.6000 0.3000 240.7980 0.3000 240.9000 1.0000 241.0980 1.0000 241.2000 0.3000 241.3980 0.3000 241.5000 1.0000 241.6980 1.0000 241.8000 0.3000 241.9980 0.3000 242.1000 1.0000 242.2980 1.0000 242.4000 0.3000 242.5980 0.3000 242.7000 1.0000 242.8980 1.0000 243.0000 0.3000 243.1980 0.3000 243.3000 1.0000 243.4980 1.0000 243.6000 0.3000 243.7980 0.3000 243.9000 1.0000 244.0980 1.0000 244.2000 0.3000 244.3980 0.3000 244.5000 1.0000 244.6980 1.0000 244.8000 0.3000 244.9980 0.3000 245.1000 1.0000 245.2980 1.0000 245.4000 0.3000 245.5980 0.3000 245.7000 1.0000 245.8980 1.0000 246.0000 0.3000 246.1980 0.3000 246.3000 1.0000 246.4980 1.0000 246.6000 0.3000 246.7980 0.3000 246.9000 1.0000 247.0980 1.0000 247.2000 0.3000 247.3980 0.3000 247.5000 1.0000 247.6980 1.0000 247.8000 0.3000 247.9980 0.3000 248.1000 1.0000 248.2980 1.0000 248.4000 0.3000 248.5980 0.3000 248.7000 1.0000 248.8980 1.0000 249.0000 0.3000 249.1980 0.3000 249.3000 1.0000 249.4980 1.0000 249.6000 0.3000 249.7980 0.3000 249.9000 1.0000 250.0980 1.0000 250.2000 0.3000 250.3980 0.3000 250.5000 1.0000 250.6980 1.0000 250.8000 0.3000 250.9980 0.3000 251.1000 1.0000 251.2980 1.0000 251.4000 0.3000 251.5980 0.3000 251.7000 1.0000 251.8980 1.0000 252.0000 0.3000 252.1980 0.3000 252.3000 1.0000 252.4980 1.0000 252.6000 0.3000 252.7980 0.3000 252.9000 1.0000 253.0980 1.0000 253.2000 0.3000 253.3980 0.3000 253.5000 1.0000 253.6980 1.0000 253.8000 0.3000 253.9980 0.3000 254.1000 1.0000 254.2980 1.0000 254.4000 0.3000 254.5980 0.3000 254.7000 1.0000 254.8980 1.0000 255.0000 0.3000 255.1980 0.3000 255.3000 1.0000 255.4980 1.0000 255.6000 0.3000 255.7980 0.3000 255.9000 1.0000 256.0980 1.0000 256.2000 0.3000 256.3980 0.3000 256.5000 1.0000 256.6980 1.0000 256.8000 0.3000 256.9980 0.3000 257.1000 1.0000 257.2980 1.0000 257.4000 0.3000 257.5980 0.3000 257.7000 1.0000 257.8980 1.0000 258.0000 0.3000 258.1980 0.3000 258.3000 1.0000 258.4980 1.0000 258.6000 0.3000 258.7980 0.3000 258.9000 1.0000 259.0980 1.0000 259.2000 0.3000 259.3980 0.3000 259.5000 1.0000 259.6980 1.0000 259.8000 0.3000 259.9980 0.3000 260.1000 1.0000 260.2980 1.0000 260.4000 0.3000 260.5980 0.3000 260.7000 1.0000 260.8980 1.0000 261.0000 0.3000 261.1980 0.3000 261.3000 1.0000 261.4980 1.0000 261.6000 0.3000 261.7980 0.3000 261.9000 1.0000 262.0980 1.0000 262.2000 0.3000 262.3980 0.3000 262.5000 1.0000 262.6980 1.0000 262.8000 0.3000 262.9980 0.3000 263.1000 1.0000 263.2980 1.0000 263.4000 0.3000 263.5980 0.3000 263.7000 1.0000 263.8980 1.0000 264.0000 0.3000 264.1980 0.3000 264.3000 1.0000 264.4980 1.0000 264.6000 0.3000 264.7980 0.3000 264.9000 1.0000 265.0980 1.0000 265.2000 0.3000 265.3980 0.3000 265.5000 1.0000 265.6980 1.0000 265.8000 0.3000 265.9980 0.3000 266.1000 1.0000 266.2980 1.0000 266.4000 0.3000 266.5980 0.3000 266.7000 1.0000 266.8980 1.0000 267.0000 0.3000 267.1980 0.3000 267.3000 1.0000 267.4980 1.0000 267.6000 0.3000 267.7980 0.3000 267.9000 1.0000 268.0980 1.0000 268.2000 0.3000 268.3980 0.3000 268.5000 1.0000 268.6980 1.0000 268.8000 0.3000 268.9980 0.3000 269.1000 1.0000 269.2980 1.0000 269.4000 0.3000 269.5980 0.3000 269.7000 1.0000 269.8980 1.0000 270.0000 0.3000 270.1980 0.3000 270.3000 1.0000 270.4980 1.0000 270.6000 0.3000 270.7980 0.3000 270.9000 1.0000 271.0980 1.0000 271.2000 0.3000 271.3980 0.3000 271.5000 1.0000 271.6980 1.0000 271.8000 0.3000 271.9980 0.3000 272.1000 1.0000 272.2980 1.0000 272.4000 0.3000 272.5980 0.3000 272.7000 1.0000 272.8980 1.0000 273.0000 0.3000 273.1980 0.3000 273.3000 1.0000 273.4980 1.0000 273.6000 0.3000 273.7980 0.3000 273.9000 1.0000 274.0980 1.0000 274.2000 0.3000 274.3980 0.3000 274.5000 1.0000 274.6980 1.0000 274.8000 0.3000 274.9980 0.3000 275.1000 1.0000 275.2980 1.0000 275.4000 0.3000 275.5980 0.3000 275.7000 1.0000 275.8980 1.0000 276.0000 0.3000 276.1980 0.3000 276.3000 1.0000 276.4980 1.0000 276.6000 0.3000 276.7980 0.3000 276.9000 1.0000 277.0980 1.0000 277.2000 0.3000 277.3980 0.3000 277.5000 1.0000 277.6980 1.0000 277.8000 0.3000 277.9980 0.3000 278.1000 1.0000 278.2980 1.0000 278.4000 0.3000 278.5980 0.3000 278.7000 1.0000 278.8980 1.0000 279.0000 0.3000 279.1980 0.3000 279.3000 1.0000 279.4980 1.0000 279.6000 0.3000 279.7980 0.3000 279.9000 1.0000 280.0980 1.0000 280.2000 0.3000 280.3980 0.3000 280.5000 1.0000 280.6980 1.0000 280.8000 0.3000 280.9980 0.3000 281.1000 1.0000 281.2980 1.0000 281.4000 0.3000 281.5980 0.3000 281.7000 1.0000 281.8980 1.0000 282.0000 0.3000 282.1980 0.3000 282.3000 1.0000 282.4980 1.0000 282.6000 0.3000 282.7980 0.3000 282.9000 1.0000 283.0980 1.0000 283.2000 0.3000 283.3980 0.3000 283.5000 1.0000 283.6980 1.0000 283.8000 0.3000 283.9980 0.3000 284.1000 1.0000 284.2980 1.0000 284.4000 0.3000 284.5980 0.3000 284.7000 1.0000 284.8980 1.0000 285.0000 0.3000 285.1980 0.3000 285.3000 1.0000 285.4980 1.0000 285.6000 0.3000 285.7980 0.3000 285.9000 1.0000 286.0980 1.0000 286.2000 0.3000 286.3980 0.3000 286.5000 1.0000 286.6980 1.0000 286.8000 0.3000 286.9980 0.3000 287.1000 1.0000 287.2980 1.0000 287.4000 0.3000 287.5980 0.3000 287.7000 1.0000 287.8980 1.0000 288.0000 0.3000 288.1980 0.3000 288.3000 1.0000 288.4980 1.0000 288.6000 0.3000 288.7980 0.3000 288.9000 1.0000 289.0980 1.0000 289.2000 0.3000 289.3980 0.3000 289.5000 1.0000 289.6980 1.0000 289.8000 0.3000 289.9980 0.3000 290.1000 1.0000 290.2980 1.0000 290.4000 0.3000 290.5980 0.3000 290.7000 1.0000 290.8980 1.0000 291.0000 0.3000 291.1980 0.3000 291.3000 1.0000 291.4980 1.0000 291.6000 0.3000 291.7980 0.3000 291.9000 1.0000 292.0980 1.0000 292.2000 0.3000 292.3980 0.3000 292.5000 1.0000 292.6980 1.0000 292.8000 0.3000 292.9980 0.3000 293.1000 1.0000 293.2980 1.0000 293.4000 0.3000 293.5980 0.3000 293.7000 1.0000 293.8980 1.0000 294.0000 0.3000 294.1980 0.3000 294.3000 1.0000 294.4980 1.0000 294.6000 0.3000 294.7980 0.3000 294.9000 1.0000 295.0980 1.0000 295.2000 0.3000 295.3980 0.3000 295.5000 1.0000 295.6980 1.0000 295.8000 0.3000 295.9980 0.3000 296.1000 1.0000 296.2980 1.0000 296.4000 0.3000 296.5980 0.3000 296.7000 1.0000 296.8980 1.0000 297.0000 0.3000 297.1980 0.3000 297.3000 1.0000 297.4980 1.0000 297.6000 0.3000 297.7980 0.3000 297.9000 1.0000 298.0980 1.0000 298.2000 0.3000 298.3980 0.3000 298.5000 1.0000 298.6980 1.0000 298.8000 0.3000 298.9980 0.3000 299.1000 1.0000 299.2980 1.0000 299.4000 0.3000 299.5980 0.3000 299.7000 1.0000 299.8980 1.0000 300.0000 0.3000 300.1980 0.3000 300.3000 1.0000 300.4980 1.0000 300.6000 0.3000 300.7980 0.3000 300.9000 1.0000 301.0980 1.0000 301.2000 0.3000 301.3980 0.3000 301.5000 1.0000 301.6980 1.0000 301.8000 0.3000 301.9980 0.3000 302.1000 1.0000 302.2980 1.0000 302.4000 0.3000 302.5980 0.3000 302.7000 1.0000 302.8980 1.0000 303.0000 0.3000 303.1980 0.3000 303.3000 1.0000 303.4980 1.0000 303.6000 0.3000 303.7980 0.3000 303.9000 1.0000 304.0980 1.0000 304.2000 0.3000 304.3980 0.3000 304.5000 1.0000 304.6980 1.0000 304.8000 0.3000 304.9980 0.3000 305.1000 1.0000 305.2980 1.0000 305.4000 0.3000 305.5980 0.3000 305.7000 1.0000 305.8980 1.0000 306.0000 0.3000 306.1980 0.3000 306.3000 1.0000 306.4980 1.0000 306.6000 0.3000 306.7980 0.3000 306.9000 1.0000 307.0980 1.0000 307.2000 0.3000 307.3980 0.3000 307.5000 1.0000 307.6980 1.0000 307.8000 0.3000 307.9980 0.3000 308.1000 1.0000 308.2980 1.0000 308.4000 0.3000 308.5980 0.3000 308.7000 1.0000 308.8980 1.0000 309.0000 0.3000 309.1980 0.3000 309.3000 1.0000 309.4980 1.0000 309.6000 0.3000 309.7980 0.3000 309.9000 1.0000 310.0980 1.0000 310.2000 0.3000 310.3980 0.3000 310.5000 1.0000 310.6980 1.0000 310.8000 0.3000 310.9980 0.3000 311.1000 1.0000 311.2980 1.0000 311.4000 0.3000 311.5980 0.3000 311.7000 1.0000 311.8980 1.0000 312.0000 0.3000 312.1980 0.3000 312.3000 1.0000 312.4980 1.0000 312.6000 0.3000 312.7980 0.3000 312.9000 1.0000 313.0980 1.0000 313.2000 0.3000 313.3980 0.3000 313.5000 1.0000 313.6980 1.0000 313.8000 0.3000 313.9980 0.3000 314.1000 1.0000 314.2980 1.0000 314.4000 0.3000 314.5980 0.3000 314.7000 1.0000 314.8980 1.0000 315.0000 0.3000 315.1980 0.3000 315.3000 1.0000 315.4980 1.0000 315.6000 0.3000 315.7980 0.3000 315.9000 1.0000 316.0980 1.0000 316.2000 0.3000 316.3980 0.3000 316.5000 1.0000 316.6980 1.0000 316.8000 0.3000 316.9980 0.3000 317.1000 1.0000 317.2980 1.0000 317.4000 0.3000 317.5980 0.3000 317.7000 1.0000 317.8980 1.0000 318.0000 0.3000 318.1980 0.3000 318.3000 1.0000 318.4980 1.0000 318.6000 0.3000 318.7980 0.3000 318.9000 1.0000 319.0980 1.0000 319.2000 0.3000 319.3980 0.3000 319.5000 1.0000 319.6980 1.0000 319.8000 0.3000 319.9980 0.3000 320.1000 1.0000 320.2980 1.0000 320.4000 0.3000 320.5980 0.3000 320.7000 1.0000 320.8980 1.0000 321.0000 0.3000 321.1980 0.3000 321.3000 1.0000 321.4980 1.0000 321.6000 0.3000 321.7980 0.3000 321.9000 1.0000 322.0980 1.0000 322.2000 0.3000 322.3980 0.3000 322.5000 1.0000 322.6980 1.0000 322.8000 0.3000 322.9980 0.3000 323.1000 1.0000 323.2980 1.0000 323.4000 0.3000 323.5980 0.3000 323.7000 1.0000 323.8980 1.0000 324.0000 0.3000 324.1980 0.3000 324.3000 1.0000 324.4980 1.0000 324.6000 0.3000 324.7980 0.3000 324.9000 1.0000 325.0980 1.0000 325.2000 0.3000 325.3980 0.3000 325.5000 1.0000 325.6980 1.0000 325.8000 0.3000 325.9980 0.3000 326.1000 1.0000 326.2980 1.0000 326.4000 0.3000 326.5980 0.3000 326.7000 1.0000 326.8980 1.0000 327.0000 0.3000 327.1980 0.3000 327.3000 1.0000 327.4980 1.0000 327.6000 0.3000 327.7980 0.3000 327.9000 1.0000 328.0980 1.0000 328.2000 0.3000 328.3980 0.3000 328.5000 1.0000 328.6980 1.0000 328.8000 0.3000 328.9980 0.3000 329.1000 1.0000 329.2980 1.0000 329.4000 0.3000 329.5980 0.3000 329.7000 1.0000 329.8980 1.0000 330.0000 0.3000 330.1980 0.3000 330.3000 1.0000 330.4980 1.0000 330.6000 0.3000 330.7980 0.3000 330.9000 1.0000 331.0980 1.0000 331.2000 0.3000 331.3980 0.3000 331.5000 1.0000 331.6980 1.0000 331.8000 0.3000 331.9980 0.3000 332.1000 1.0000 332.2980 1.0000 332.4000 0.3000 332.5980 0.3000 332.7000 1.0000 332.8980 1.0000 333.0000 0.3000 333.1980 0.3000 333.3000 1.0000 333.4980 1.0000 333.6000 0.3000 333.7980 0.3000 333.9000 1.0000 334.0980 1.0000 334.2000 0.3000 334.3980 0.3000 334.5000 1.0000 334.6980 1.0000 334.8000 0.3000 334.9980 0.3000 335.1000 1.0000 335.2980 1.0000 335.4000 0.3000 335.5980 0.3000 335.7000 1.0000 335.8980 1.0000 336.0000 0.3000 336.1980 0.3000 336.3000 1.0000 336.4980 1.0000 336.6000 0.3000 336.7980 0.3000 336.9000 1.0000 337.0980 1.0000 337.2000 0.3000 337.3980 0.3000 337.5000 1.0000 337.6980 1.0000 337.8000 0.3000 337.9980 0.3000 338.1000 1.0000 338.2980 1.0000 338.4000 0.3000 338.5980 0.3000 338.7000 1.0000 338.8980 1.0000 339.0000 0.3000 339.1980 0.3000 339.3000 1.0000 339.4980 1.0000 339.6000 0.3000 339.7980 0.3000 339.9000 1.0000 340.0980 1.0000 340.2000 0.3000 340.3980 0.3000 340.5000 1.0000 340.6980 1.0000 340.8000 0.3000 340.9980 0.3000 341.1000 1.0000 341.2980 1.0000 341.4000 0.3000 341.5980 0.3000 341.7000 1.0000 341.8980 1.0000 342.0000 0.3000 342.1980 0.3000 342.3000 1.0000 342.4980 1.0000 342.6000 0.3000 342.7980 0.3000 342.9000 1.0000 343.0980 1.0000 343.2000 0.3000 343.3980 0.3000 343.5000 1.0000 343.6980 1.0000 343.8000 0.3000 343.9980 0.3000 344.1000 1.0000 344.2980 1.0000 344.4000 0.3000 344.5980 0.3000 344.7000 1.0000 344.8980 1.0000 345.0000 0.3000 345.1980 0.3000 345.3000 1.0000 345.4980 1.0000 345.6000 0.3000 345.7980 0.3000 345.9000 1.0000 346.0980 1.0000 346.2000 0.3000 346.3980 0.3000 346.5000 1.0000 346.6980 1.0000 346.8000 0.3000 346.9980 0.3000 347.1000 1.0000 347.2980 1.0000 347.4000 0.3000 347.5980 0.3000 347.7000 1.0000 347.8980 1.0000 348.0000 0.3000 348.1980 0.3000 348.3000 1.0000 348.4980 1.0000 348.6000 0.3000 348.7980 0.3000 348.9000 1.0000 349.0980 1.0000 349.2000 0.3000 349.3980 0.3000 349.5000 1.0000 349.6980 1.0000 349.8000 0.3000 349.9980 0.3000 350.1000 1.0000 350.2980 1.0000 350.4000 0.3000 350.5980 0.3000 350.7000 1.0000 350.8980 1.0000 351.0000 0.3000 351.1980 0.3000 351.3000 1.0000 351.4980 1.0000 351.6000 0.3000 351.7980 0.3000 351.9000 1.0000 352.0980 1.0000 352.2000 0.3000 352.3980 0.3000 352.5000 1.0000 352.6980 1.0000 352.8000 0.3000 352.9980 0.3000 353.1000 1.0000 353.2980 1.0000 353.4000 0.3000 353.5980 0.3000 353.7000 1.0000 353.8980 1.0000 354.0000 0.3000 354.1980 0.3000 354.3000 1.0000 354.4980 1.0000 354.6000 0.3000 354.7980 0.3000 354.9000 1.0000 355.0980 1.0000 355.2000 0.3000 355.3980 0.3000 355.5000 1.0000 355.6980 1.0000 355.8000 0.3000 355.9980 0.3000 356.1000 1.0000 356.2980 1.0000 356.4000 0.3000 356.5980 0.3000 356.7000 1.0000 356.8980 1.0000 357.0000 0.3000 357.1980 0.3000 357.3000 1.0000 357.4980 1.0000 357.6000 0.3000 357.7980 0.3000 357.9000 1.0000 358.0980 1.0000 358.2000 0.3000 358.3980 0.3000 358.5000 1.0000 358.6980 1.0000 358.8000 0.3000 358.9980 0.3000 359.1000 1.0000 359.2980 1.0000 359.4000 0.3000 359.5980 0.3000 359.7000 1.0000 359.8980 1.0000 360.0000 1.0000)
Vaub aub 0 dc 1.0
Vbx bx 0 dc 1.3
C_gp_1_1_1 gp_1_1_1 0 {Cg}
Mp_1_1_1 a1 gp_1_1_1 colp1 0 NSYN W=10u L=1u
Mn_1_1_1 a1 vcn coln1 0 NSYN W=10u L=1u
C_gp_1_1_2 gp_1_1_2 0 {Cg}
Mp_1_1_2 a2 gp_1_1_2 colp1 0 NSYN W=10u L=1u
Mn_1_1_2 a2 vcn coln1 0 NSYN W=10u L=1u
C_gp_1_1_b gp_1_1_b 0 {Cg}
Mp_1_1_b bx gp_1_1_b colp1 0 NSYN W=10u L=1u
Mn_1_1_b bx vcn coln1 0 NSYN W=10u L=1u
Msa_h1 coln1 coln1 0 0 NMIR W=20u L=1u
Msb_h1 z1_1 coln1 0 0 NMIR W=20u L=1u
Msc_h1 colp1 colp1 0 0 NMIR W=20u L=1u
Msd_h1 dpf_h1 colp1 0 0 NMIR W=20u L=1u
Mse_h1 dpf_h1 dpf_h1 vdd vdd PMIR W=60u L=1u
Msf_h1 z1_1 dpf_h1 vdd vdd PMIR W=60u L=1u
R_h1 z1_1 vrefh 8000.0
Mr_1  hdd_1 z1_1 tail_1 0 NREL W=12u L=1u
Mr2_1 dmp_1  vmid  tail_1 0 NREL W=12u L=1u
Mtl_1 tail_1 vtb 0 0 NREL W=32.0u L=1u
Mdm_1 dmp_1 dmp_1 vdd vdd PMIR W=40u L=1u
Mrp1_1 hdd_1 hdd_1 vdd vdd PMIR W=40u L=1u
Mrp2_1 hv_1 hdd_1 vdd vdd PMIR W=40u L=1u
Rhv_1 hv_1 vg0 8000.0
C_gp_1_2_1 gp_1_2_1 0 {Cg}
Mp_1_2_1 a1 gp_1_2_1 colp2 0 NSYN W=10u L=1u
Mn_1_2_1 a1 vcn coln2 0 NSYN W=10u L=1u
C_gp_1_2_2 gp_1_2_2 0 {Cg}
Mp_1_2_2 a2 gp_1_2_2 colp2 0 NSYN W=10u L=1u
Mn_1_2_2 a2 vcn coln2 0 NSYN W=10u L=1u
C_gp_1_2_b gp_1_2_b 0 {Cg}
Mp_1_2_b bx gp_1_2_b colp2 0 NSYN W=10u L=1u
Mn_1_2_b bx vcn coln2 0 NSYN W=10u L=1u
Msa_h2 coln2 coln2 0 0 NMIR W=20u L=1u
Msb_h2 z1_2 coln2 0 0 NMIR W=20u L=1u
Msc_h2 colp2 colp2 0 0 NMIR W=20u L=1u
Msd_h2 dpf_h2 colp2 0 0 NMIR W=20u L=1u
Mse_h2 dpf_h2 dpf_h2 vdd vdd PMIR W=60u L=1u
Msf_h2 z1_2 dpf_h2 vdd vdd PMIR W=60u L=1u
R_h2 z1_2 vrefh 8000.0
Mr_2  hdd_2 z1_2 tail_2 0 NREL W=12u L=1u
Mr2_2 dmp_2  vmid  tail_2 0 NREL W=12u L=1u
Mtl_2 tail_2 vtb 0 0 NREL W=32.0u L=1u
Mdm_2 dmp_2 dmp_2 vdd vdd PMIR W=40u L=1u
Mrp1_2 hdd_2 hdd_2 vdd vdd PMIR W=40u L=1u
Mrp2_2 hv_2 hdd_2 vdd vdd PMIR W=40u L=1u
Rhv_2 hv_2 vg0 8000.0
C_gp_1_3_1 gp_1_3_1 0 {Cg}
Mp_1_3_1 a1 gp_1_3_1 colp3 0 NSYN W=10u L=1u
Mn_1_3_1 a1 vcn coln3 0 NSYN W=10u L=1u
C_gp_1_3_2 gp_1_3_2 0 {Cg}
Mp_1_3_2 a2 gp_1_3_2 colp3 0 NSYN W=10u L=1u
Mn_1_3_2 a2 vcn coln3 0 NSYN W=10u L=1u
C_gp_1_3_b gp_1_3_b 0 {Cg}
Mp_1_3_b bx gp_1_3_b colp3 0 NSYN W=10u L=1u
Mn_1_3_b bx vcn coln3 0 NSYN W=10u L=1u
Msa_h3 coln3 coln3 0 0 NMIR W=20u L=1u
Msb_h3 z1_3 coln3 0 0 NMIR W=20u L=1u
Msc_h3 colp3 colp3 0 0 NMIR W=20u L=1u
Msd_h3 dpf_h3 colp3 0 0 NMIR W=20u L=1u
Mse_h3 dpf_h3 dpf_h3 vdd vdd PMIR W=60u L=1u
Msf_h3 z1_3 dpf_h3 vdd vdd PMIR W=60u L=1u
R_h3 z1_3 vrefh 8000.0
Mr_3  hdd_3 z1_3 tail_3 0 NREL W=12u L=1u
Mr2_3 dmp_3  vmid  tail_3 0 NREL W=12u L=1u
Mtl_3 tail_3 vtb 0 0 NREL W=32.0u L=1u
Mdm_3 dmp_3 dmp_3 vdd vdd PMIR W=40u L=1u
Mrp1_3 hdd_3 hdd_3 vdd vdd PMIR W=40u L=1u
Mrp2_3 hv_3 hdd_3 vdd vdd PMIR W=40u L=1u
Rhv_3 hv_3 vg0 8000.0
C_gp_1_4_1 gp_1_4_1 0 {Cg}
Mp_1_4_1 a1 gp_1_4_1 colp4 0 NSYN W=10u L=1u
Mn_1_4_1 a1 vcn coln4 0 NSYN W=10u L=1u
C_gp_1_4_2 gp_1_4_2 0 {Cg}
Mp_1_4_2 a2 gp_1_4_2 colp4 0 NSYN W=10u L=1u
Mn_1_4_2 a2 vcn coln4 0 NSYN W=10u L=1u
C_gp_1_4_b gp_1_4_b 0 {Cg}
Mp_1_4_b bx gp_1_4_b colp4 0 NSYN W=10u L=1u
Mn_1_4_b bx vcn coln4 0 NSYN W=10u L=1u
Msa_h4 coln4 coln4 0 0 NMIR W=20u L=1u
Msb_h4 z1_4 coln4 0 0 NMIR W=20u L=1u
Msc_h4 colp4 colp4 0 0 NMIR W=20u L=1u
Msd_h4 dpf_h4 colp4 0 0 NMIR W=20u L=1u
Mse_h4 dpf_h4 dpf_h4 vdd vdd PMIR W=60u L=1u
Msf_h4 z1_4 dpf_h4 vdd vdd PMIR W=60u L=1u
R_h4 z1_4 vrefh 8000.0
Mr_4  hdd_4 z1_4 tail_4 0 NREL W=12u L=1u
Mr2_4 dmp_4  vmid  tail_4 0 NREL W=12u L=1u
Mtl_4 tail_4 vtb 0 0 NREL W=32.0u L=1u
Mdm_4 dmp_4 dmp_4 vdd vdd PMIR W=40u L=1u
Mrp1_4 hdd_4 hdd_4 vdd vdd PMIR W=40u L=1u
Mrp2_4 hv_4 hdd_4 vdd vdd PMIR W=40u L=1u
Rhv_4 hv_4 vg0 8000.0
C_gp_1_5_1 gp_1_5_1 0 {Cg}
Mp_1_5_1 a1 gp_1_5_1 colp5 0 NSYN W=10u L=1u
Mn_1_5_1 a1 vcn coln5 0 NSYN W=10u L=1u
C_gp_1_5_2 gp_1_5_2 0 {Cg}
Mp_1_5_2 a2 gp_1_5_2 colp5 0 NSYN W=10u L=1u
Mn_1_5_2 a2 vcn coln5 0 NSYN W=10u L=1u
C_gp_1_5_b gp_1_5_b 0 {Cg}
Mp_1_5_b bx gp_1_5_b colp5 0 NSYN W=10u L=1u
Mn_1_5_b bx vcn coln5 0 NSYN W=10u L=1u
Msa_h5 coln5 coln5 0 0 NMIR W=20u L=1u
Msb_h5 z1_5 coln5 0 0 NMIR W=20u L=1u
Msc_h5 colp5 colp5 0 0 NMIR W=20u L=1u
Msd_h5 dpf_h5 colp5 0 0 NMIR W=20u L=1u
Mse_h5 dpf_h5 dpf_h5 vdd vdd PMIR W=60u L=1u
Msf_h5 z1_5 dpf_h5 vdd vdd PMIR W=60u L=1u
R_h5 z1_5 vrefh 8000.0
Mr_5  hdd_5 z1_5 tail_5 0 NREL W=12u L=1u
Mr2_5 dmp_5  vmid  tail_5 0 NREL W=12u L=1u
Mtl_5 tail_5 vtb 0 0 NREL W=32.0u L=1u
Mdm_5 dmp_5 dmp_5 vdd vdd PMIR W=40u L=1u
Mrp1_5 hdd_5 hdd_5 vdd vdd PMIR W=40u L=1u
Mrp2_5 hv_5 hdd_5 vdd vdd PMIR W=40u L=1u
Rhv_5 hv_5 vg0 8000.0
C_gp_1_6_1 gp_1_6_1 0 {Cg}
Mp_1_6_1 a1 gp_1_6_1 colp6 0 NSYN W=10u L=1u
Mn_1_6_1 a1 vcn coln6 0 NSYN W=10u L=1u
C_gp_1_6_2 gp_1_6_2 0 {Cg}
Mp_1_6_2 a2 gp_1_6_2 colp6 0 NSYN W=10u L=1u
Mn_1_6_2 a2 vcn coln6 0 NSYN W=10u L=1u
C_gp_1_6_b gp_1_6_b 0 {Cg}
Mp_1_6_b bx gp_1_6_b colp6 0 NSYN W=10u L=1u
Mn_1_6_b bx vcn coln6 0 NSYN W=10u L=1u
Msa_h6 coln6 coln6 0 0 NMIR W=20u L=1u
Msb_h6 z1_6 coln6 0 0 NMIR W=20u L=1u
Msc_h6 colp6 colp6 0 0 NMIR W=20u L=1u
Msd_h6 dpf_h6 colp6 0 0 NMIR W=20u L=1u
Mse_h6 dpf_h6 dpf_h6 vdd vdd PMIR W=60u L=1u
Msf_h6 z1_6 dpf_h6 vdd vdd PMIR W=60u L=1u
R_h6 z1_6 vrefh 8000.0
Mr_6  hdd_6 z1_6 tail_6 0 NREL W=12u L=1u
Mr2_6 dmp_6  vmid  tail_6 0 NREL W=12u L=1u
Mtl_6 tail_6 vtb 0 0 NREL W=32.0u L=1u
Mdm_6 dmp_6 dmp_6 vdd vdd PMIR W=40u L=1u
Mrp1_6 hdd_6 hdd_6 vdd vdd PMIR W=40u L=1u
Mrp2_6 hv_6 hdd_6 vdd vdd PMIR W=40u L=1u
Rhv_6 hv_6 vg0 8000.0
C_gp_1_7_1 gp_1_7_1 0 {Cg}
Mp_1_7_1 a1 gp_1_7_1 colp7 0 NSYN W=10u L=1u
Mn_1_7_1 a1 vcn coln7 0 NSYN W=10u L=1u
C_gp_1_7_2 gp_1_7_2 0 {Cg}
Mp_1_7_2 a2 gp_1_7_2 colp7 0 NSYN W=10u L=1u
Mn_1_7_2 a2 vcn coln7 0 NSYN W=10u L=1u
C_gp_1_7_b gp_1_7_b 0 {Cg}
Mp_1_7_b bx gp_1_7_b colp7 0 NSYN W=10u L=1u
Mn_1_7_b bx vcn coln7 0 NSYN W=10u L=1u
Msa_h7 coln7 coln7 0 0 NMIR W=20u L=1u
Msb_h7 z1_7 coln7 0 0 NMIR W=20u L=1u
Msc_h7 colp7 colp7 0 0 NMIR W=20u L=1u
Msd_h7 dpf_h7 colp7 0 0 NMIR W=20u L=1u
Mse_h7 dpf_h7 dpf_h7 vdd vdd PMIR W=60u L=1u
Msf_h7 z1_7 dpf_h7 vdd vdd PMIR W=60u L=1u
R_h7 z1_7 vrefh 8000.0
Mr_7  hdd_7 z1_7 tail_7 0 NREL W=12u L=1u
Mr2_7 dmp_7  vmid  tail_7 0 NREL W=12u L=1u
Mtl_7 tail_7 vtb 0 0 NREL W=32.0u L=1u
Mdm_7 dmp_7 dmp_7 vdd vdd PMIR W=40u L=1u
Mrp1_7 hdd_7 hdd_7 vdd vdd PMIR W=40u L=1u
Mrp2_7 hv_7 hdd_7 vdd vdd PMIR W=40u L=1u
Rhv_7 hv_7 vg0 8000.0
C_gp_1_8_1 gp_1_8_1 0 {Cg}
Mp_1_8_1 a1 gp_1_8_1 colp8 0 NSYN W=10u L=1u
Mn_1_8_1 a1 vcn coln8 0 NSYN W=10u L=1u
C_gp_1_8_2 gp_1_8_2 0 {Cg}
Mp_1_8_2 a2 gp_1_8_2 colp8 0 NSYN W=10u L=1u
Mn_1_8_2 a2 vcn coln8 0 NSYN W=10u L=1u
C_gp_1_8_b gp_1_8_b 0 {Cg}
Mp_1_8_b bx gp_1_8_b colp8 0 NSYN W=10u L=1u
Mn_1_8_b bx vcn coln8 0 NSYN W=10u L=1u
Msa_h8 coln8 coln8 0 0 NMIR W=20u L=1u
Msb_h8 z1_8 coln8 0 0 NMIR W=20u L=1u
Msc_h8 colp8 colp8 0 0 NMIR W=20u L=1u
Msd_h8 dpf_h8 colp8 0 0 NMIR W=20u L=1u
Mse_h8 dpf_h8 dpf_h8 vdd vdd PMIR W=60u L=1u
Msf_h8 z1_8 dpf_h8 vdd vdd PMIR W=60u L=1u
R_h8 z1_8 vrefh 8000.0
Mr_8  hdd_8 z1_8 tail_8 0 NREL W=12u L=1u
Mr2_8 dmp_8  vmid  tail_8 0 NREL W=12u L=1u
Mtl_8 tail_8 vtb 0 0 NREL W=32.0u L=1u
Mdm_8 dmp_8 dmp_8 vdd vdd PMIR W=40u L=1u
Mrp1_8 hdd_8 hdd_8 vdd vdd PMIR W=40u L=1u
Mrp2_8 hv_8 hdd_8 vdd vdd PMIR W=40u L=1u
Rhv_8 hv_8 vg0 8000.0
C_gp_1_9_1 gp_1_9_1 0 {Cg}
Mp_1_9_1 a1 gp_1_9_1 colp9 0 NSYN W=10u L=1u
Mn_1_9_1 a1 vcn coln9 0 NSYN W=10u L=1u
C_gp_1_9_2 gp_1_9_2 0 {Cg}
Mp_1_9_2 a2 gp_1_9_2 colp9 0 NSYN W=10u L=1u
Mn_1_9_2 a2 vcn coln9 0 NSYN W=10u L=1u
C_gp_1_9_b gp_1_9_b 0 {Cg}
Mp_1_9_b bx gp_1_9_b colp9 0 NSYN W=10u L=1u
Mn_1_9_b bx vcn coln9 0 NSYN W=10u L=1u
Msa_h9 coln9 coln9 0 0 NMIR W=20u L=1u
Msb_h9 z1_9 coln9 0 0 NMIR W=20u L=1u
Msc_h9 colp9 colp9 0 0 NMIR W=20u L=1u
Msd_h9 dpf_h9 colp9 0 0 NMIR W=20u L=1u
Mse_h9 dpf_h9 dpf_h9 vdd vdd PMIR W=60u L=1u
Msf_h9 z1_9 dpf_h9 vdd vdd PMIR W=60u L=1u
R_h9 z1_9 vrefh 8000.0
Mr_9  hdd_9 z1_9 tail_9 0 NREL W=12u L=1u
Mr2_9 dmp_9  vmid  tail_9 0 NREL W=12u L=1u
Mtl_9 tail_9 vtb 0 0 NREL W=32.0u L=1u
Mdm_9 dmp_9 dmp_9 vdd vdd PMIR W=40u L=1u
Mrp1_9 hdd_9 hdd_9 vdd vdd PMIR W=40u L=1u
Mrp2_9 hv_9 hdd_9 vdd vdd PMIR W=40u L=1u
Rhv_9 hv_9 vg0 8000.0
C_gp_1_10_1 gp_1_10_1 0 {Cg}
Mp_1_10_1 a1 gp_1_10_1 colp10 0 NSYN W=10u L=1u
Mn_1_10_1 a1 vcn coln10 0 NSYN W=10u L=1u
C_gp_1_10_2 gp_1_10_2 0 {Cg}
Mp_1_10_2 a2 gp_1_10_2 colp10 0 NSYN W=10u L=1u
Mn_1_10_2 a2 vcn coln10 0 NSYN W=10u L=1u
C_gp_1_10_b gp_1_10_b 0 {Cg}
Mp_1_10_b bx gp_1_10_b colp10 0 NSYN W=10u L=1u
Mn_1_10_b bx vcn coln10 0 NSYN W=10u L=1u
Msa_h10 coln10 coln10 0 0 NMIR W=20u L=1u
Msb_h10 z1_10 coln10 0 0 NMIR W=20u L=1u
Msc_h10 colp10 colp10 0 0 NMIR W=20u L=1u
Msd_h10 dpf_h10 colp10 0 0 NMIR W=20u L=1u
Mse_h10 dpf_h10 dpf_h10 vdd vdd PMIR W=60u L=1u
Msf_h10 z1_10 dpf_h10 vdd vdd PMIR W=60u L=1u
R_h10 z1_10 vrefh 8000.0
Mr_10  hdd_10 z1_10 tail_10 0 NREL W=12u L=1u
Mr2_10 dmp_10  vmid  tail_10 0 NREL W=12u L=1u
Mtl_10 tail_10 vtb 0 0 NREL W=32.0u L=1u
Mdm_10 dmp_10 dmp_10 vdd vdd PMIR W=40u L=1u
Mrp1_10 hdd_10 hdd_10 vdd vdd PMIR W=40u L=1u
Mrp2_10 hv_10 hdd_10 vdd vdd PMIR W=40u L=1u
Rhv_10 hv_10 vg0 8000.0
C_gp_1_11_1 gp_1_11_1 0 {Cg}
Mp_1_11_1 a1 gp_1_11_1 colp11 0 NSYN W=10u L=1u
Mn_1_11_1 a1 vcn coln11 0 NSYN W=10u L=1u
C_gp_1_11_2 gp_1_11_2 0 {Cg}
Mp_1_11_2 a2 gp_1_11_2 colp11 0 NSYN W=10u L=1u
Mn_1_11_2 a2 vcn coln11 0 NSYN W=10u L=1u
C_gp_1_11_b gp_1_11_b 0 {Cg}
Mp_1_11_b bx gp_1_11_b colp11 0 NSYN W=10u L=1u
Mn_1_11_b bx vcn coln11 0 NSYN W=10u L=1u
Msa_h11 coln11 coln11 0 0 NMIR W=20u L=1u
Msb_h11 z1_11 coln11 0 0 NMIR W=20u L=1u
Msc_h11 colp11 colp11 0 0 NMIR W=20u L=1u
Msd_h11 dpf_h11 colp11 0 0 NMIR W=20u L=1u
Mse_h11 dpf_h11 dpf_h11 vdd vdd PMIR W=60u L=1u
Msf_h11 z1_11 dpf_h11 vdd vdd PMIR W=60u L=1u
R_h11 z1_11 vrefh 8000.0
Mr_11  hdd_11 z1_11 tail_11 0 NREL W=12u L=1u
Mr2_11 dmp_11  vmid  tail_11 0 NREL W=12u L=1u
Mtl_11 tail_11 vtb 0 0 NREL W=32.0u L=1u
Mdm_11 dmp_11 dmp_11 vdd vdd PMIR W=40u L=1u
Mrp1_11 hdd_11 hdd_11 vdd vdd PMIR W=40u L=1u
Mrp2_11 hv_11 hdd_11 vdd vdd PMIR W=40u L=1u
Rhv_11 hv_11 vg0 8000.0
C_gp_1_12_1 gp_1_12_1 0 {Cg}
Mp_1_12_1 a1 gp_1_12_1 colp12 0 NSYN W=10u L=1u
Mn_1_12_1 a1 vcn coln12 0 NSYN W=10u L=1u
C_gp_1_12_2 gp_1_12_2 0 {Cg}
Mp_1_12_2 a2 gp_1_12_2 colp12 0 NSYN W=10u L=1u
Mn_1_12_2 a2 vcn coln12 0 NSYN W=10u L=1u
C_gp_1_12_b gp_1_12_b 0 {Cg}
Mp_1_12_b bx gp_1_12_b colp12 0 NSYN W=10u L=1u
Mn_1_12_b bx vcn coln12 0 NSYN W=10u L=1u
Msa_h12 coln12 coln12 0 0 NMIR W=20u L=1u
Msb_h12 z1_12 coln12 0 0 NMIR W=20u L=1u
Msc_h12 colp12 colp12 0 0 NMIR W=20u L=1u
Msd_h12 dpf_h12 colp12 0 0 NMIR W=20u L=1u
Mse_h12 dpf_h12 dpf_h12 vdd vdd PMIR W=60u L=1u
Msf_h12 z1_12 dpf_h12 vdd vdd PMIR W=60u L=1u
R_h12 z1_12 vrefh 8000.0
Mr_12  hdd_12 z1_12 tail_12 0 NREL W=12u L=1u
Mr2_12 dmp_12  vmid  tail_12 0 NREL W=12u L=1u
Mtl_12 tail_12 vtb 0 0 NREL W=32.0u L=1u
Mdm_12 dmp_12 dmp_12 vdd vdd PMIR W=40u L=1u
Mrp1_12 hdd_12 hdd_12 vdd vdd PMIR W=40u L=1u
Mrp2_12 hv_12 hdd_12 vdd vdd PMIR W=40u L=1u
Rhv_12 hv_12 vg0 8000.0
C_gp_2_1 gp_2_1 0 {Cg}
Mp_2_1 hv_1 gp_2_1 colpo 0 NSYN W=10u L=1u
Mn_2_1 hv_1 vcn colno 0 NSYN W=10u L=1u
C_gp_2_2 gp_2_2 0 {Cg}
Mp_2_2 hv_2 gp_2_2 colpo 0 NSYN W=10u L=1u
Mn_2_2 hv_2 vcn colno 0 NSYN W=10u L=1u
C_gp_2_3 gp_2_3 0 {Cg}
Mp_2_3 hv_3 gp_2_3 colpo 0 NSYN W=10u L=1u
Mn_2_3 hv_3 vcn colno 0 NSYN W=10u L=1u
C_gp_2_4 gp_2_4 0 {Cg}
Mp_2_4 hv_4 gp_2_4 colpo 0 NSYN W=10u L=1u
Mn_2_4 hv_4 vcn colno 0 NSYN W=10u L=1u
C_gp_2_5 gp_2_5 0 {Cg}
Mp_2_5 hv_5 gp_2_5 colpo 0 NSYN W=10u L=1u
Mn_2_5 hv_5 vcn colno 0 NSYN W=10u L=1u
C_gp_2_6 gp_2_6 0 {Cg}
Mp_2_6 hv_6 gp_2_6 colpo 0 NSYN W=10u L=1u
Mn_2_6 hv_6 vcn colno 0 NSYN W=10u L=1u
C_gp_2_7 gp_2_7 0 {Cg}
Mp_2_7 hv_7 gp_2_7 colpo 0 NSYN W=10u L=1u
Mn_2_7 hv_7 vcn colno 0 NSYN W=10u L=1u
C_gp_2_8 gp_2_8 0 {Cg}
Mp_2_8 hv_8 gp_2_8 colpo 0 NSYN W=10u L=1u
Mn_2_8 hv_8 vcn colno 0 NSYN W=10u L=1u
C_gp_2_9 gp_2_9 0 {Cg}
Mp_2_9 hv_9 gp_2_9 colpo 0 NSYN W=10u L=1u
Mn_2_9 hv_9 vcn colno 0 NSYN W=10u L=1u
C_gp_2_10 gp_2_10 0 {Cg}
Mp_2_10 hv_10 gp_2_10 colpo 0 NSYN W=10u L=1u
Mn_2_10 hv_10 vcn colno 0 NSYN W=10u L=1u
C_gp_2_11 gp_2_11 0 {Cg}
Mp_2_11 hv_11 gp_2_11 colpo 0 NSYN W=10u L=1u
Mn_2_11 hv_11 vcn colno 0 NSYN W=10u L=1u
C_gp_2_12 gp_2_12 0 {Cg}
Mp_2_12 hv_12 gp_2_12 colpo 0 NSYN W=10u L=1u
Mn_2_12 hv_12 vcn colno 0 NSYN W=10u L=1u
C_gp_2_b gp_2_b 0 {Cg}
Mp_2_b bx gp_2_b colpo 0 NSYN W=10u L=1u
Mn_2_b bx vcn colno 0 NSYN W=10u L=1u
Msa_o colno colno 0 0 NMIR W=20u L=1u
Msb_o y colno 0 0 NMIR W=20u L=1u
Msc_o colpo colpo 0 0 NMIR W=20u L=1u
Msd_o dpf_o colpo 0 0 NMIR W=20u L=1u
Mse_o dpf_o dpf_o vdd vdd PMIR W=60u L=1u
Msf_o y dpf_o vdd vdd PMIR W=60u L=1u
R_o y vrefo 7000.0
Vrefd vrefd 0 1.2
Vboff boff 0 1.9
Msf2 d2e dpf_o vdd vdd PMIR W=60u L=1u
Msb2 d2e colno 0 0 NMIR W=20u L=1u
Moff d2e boff vdd vdd PMIR W=10u L=1u
Mtge d2e tg 0 0 NMIR W=10u L=1u
Rde d2e vrefd 7000.0
Mt_o1 ts_o1 hv_1 0 0 NMIR W=20.0u L=1u
Mo1_o1 da_o1 vrefd ts_o1 0 NMIR W=20u L=1u
Mo2_o1 gp_2_1 d2e ts_o1 0 NMIR W=20u L=1u
Mo3_o1 da_o1 da_o1 vdd vdd PMIR W=60u L=1u
Mo4_o1 gp_2_1 da_o1 vdd vdd PMIR W=60u L=1u
Mt_o2 ts_o2 hv_2 0 0 NMIR W=20.0u L=1u
Mo1_o2 da_o2 vrefd ts_o2 0 NMIR W=20u L=1u
Mo2_o2 gp_2_2 d2e ts_o2 0 NMIR W=20u L=1u
Mo3_o2 da_o2 da_o2 vdd vdd PMIR W=60u L=1u
Mo4_o2 gp_2_2 da_o2 vdd vdd PMIR W=60u L=1u
Mt_o3 ts_o3 hv_3 0 0 NMIR W=20.0u L=1u
Mo1_o3 da_o3 vrefd ts_o3 0 NMIR W=20u L=1u
Mo2_o3 gp_2_3 d2e ts_o3 0 NMIR W=20u L=1u
Mo3_o3 da_o3 da_o3 vdd vdd PMIR W=60u L=1u
Mo4_o3 gp_2_3 da_o3 vdd vdd PMIR W=60u L=1u
Mt_o4 ts_o4 hv_4 0 0 NMIR W=20.0u L=1u
Mo1_o4 da_o4 vrefd ts_o4 0 NMIR W=20u L=1u
Mo2_o4 gp_2_4 d2e ts_o4 0 NMIR W=20u L=1u
Mo3_o4 da_o4 da_o4 vdd vdd PMIR W=60u L=1u
Mo4_o4 gp_2_4 da_o4 vdd vdd PMIR W=60u L=1u
Mt_o5 ts_o5 hv_5 0 0 NMIR W=20.0u L=1u
Mo1_o5 da_o5 vrefd ts_o5 0 NMIR W=20u L=1u
Mo2_o5 gp_2_5 d2e ts_o5 0 NMIR W=20u L=1u
Mo3_o5 da_o5 da_o5 vdd vdd PMIR W=60u L=1u
Mo4_o5 gp_2_5 da_o5 vdd vdd PMIR W=60u L=1u
Mt_o6 ts_o6 hv_6 0 0 NMIR W=20.0u L=1u
Mo1_o6 da_o6 vrefd ts_o6 0 NMIR W=20u L=1u
Mo2_o6 gp_2_6 d2e ts_o6 0 NMIR W=20u L=1u
Mo3_o6 da_o6 da_o6 vdd vdd PMIR W=60u L=1u
Mo4_o6 gp_2_6 da_o6 vdd vdd PMIR W=60u L=1u
Mt_o7 ts_o7 hv_7 0 0 NMIR W=20.0u L=1u
Mo1_o7 da_o7 vrefd ts_o7 0 NMIR W=20u L=1u
Mo2_o7 gp_2_7 d2e ts_o7 0 NMIR W=20u L=1u
Mo3_o7 da_o7 da_o7 vdd vdd PMIR W=60u L=1u
Mo4_o7 gp_2_7 da_o7 vdd vdd PMIR W=60u L=1u
Mt_o8 ts_o8 hv_8 0 0 NMIR W=20.0u L=1u
Mo1_o8 da_o8 vrefd ts_o8 0 NMIR W=20u L=1u
Mo2_o8 gp_2_8 d2e ts_o8 0 NMIR W=20u L=1u
Mo3_o8 da_o8 da_o8 vdd vdd PMIR W=60u L=1u
Mo4_o8 gp_2_8 da_o8 vdd vdd PMIR W=60u L=1u
Mt_o9 ts_o9 hv_9 0 0 NMIR W=20.0u L=1u
Mo1_o9 da_o9 vrefd ts_o9 0 NMIR W=20u L=1u
Mo2_o9 gp_2_9 d2e ts_o9 0 NMIR W=20u L=1u
Mo3_o9 da_o9 da_o9 vdd vdd PMIR W=60u L=1u
Mo4_o9 gp_2_9 da_o9 vdd vdd PMIR W=60u L=1u
Mt_o10 ts_o10 hv_10 0 0 NMIR W=20.0u L=1u
Mo1_o10 da_o10 vrefd ts_o10 0 NMIR W=20u L=1u
Mo2_o10 gp_2_10 d2e ts_o10 0 NMIR W=20u L=1u
Mo3_o10 da_o10 da_o10 vdd vdd PMIR W=60u L=1u
Mo4_o10 gp_2_10 da_o10 vdd vdd PMIR W=60u L=1u
Mt_o11 ts_o11 hv_11 0 0 NMIR W=20.0u L=1u
Mo1_o11 da_o11 vrefd ts_o11 0 NMIR W=20u L=1u
Mo2_o11 gp_2_11 d2e ts_o11 0 NMIR W=20u L=1u
Mo3_o11 da_o11 da_o11 vdd vdd PMIR W=60u L=1u
Mo4_o11 gp_2_11 da_o11 vdd vdd PMIR W=60u L=1u
Mt_o12 ts_o12 hv_12 0 0 NMIR W=20.0u L=1u
Mo1_o12 da_o12 vrefd ts_o12 0 NMIR W=20u L=1u
Mo2_o12 gp_2_12 d2e ts_o12 0 NMIR W=20u L=1u
Mo3_o12 da_o12 da_o12 vdd vdd PMIR W=60u L=1u
Mo4_o12 gp_2_12 da_o12 vdd vdd PMIR W=60u L=1u
Mt_ob ts_ob bx 0 0 NMIR W=20.0u L=1u
Mo1_ob da_ob vrefd ts_ob 0 NMIR W=20u L=1u
Mo2_ob gp_2_b d2e ts_ob 0 NMIR W=20u L=1u
Mo3_ob da_ob da_ob vdd vdd PMIR W=60u L=1u
Mo4_ob gp_2_b da_ob vdd vdd PMIR W=60u L=1u
Mqa d2en_ps colno 0 0 NMIR W=20u L=1u
Mqb d2en_ps tg    0 0 NMIR W=10u L=1u
Mpd d2en_ps d2en_ps vdd vdd PMIR W=60u L=1u
Mpm d2e_n   d2en_ps vdd vdd PMIR W=60u L=1u
Mqc d2en_ns dpf_o vdd vdd PMIR W=60u L=1u
Mqd d2en_ns boff  vdd vdd PMIR W=10u L=1u
Mnd d2en_ns d2en_ns 0 0 NMIR W=20u L=1u
Mnm d2e_n   d2en_ns 0 0 NMIR W=20u L=1u
Rden d2e_n vrefd 7000.0
Mbep vdd d2e   d2e_pb 0 NSYN W=200u L=1u
Rbep d2e_pb 0 20e3
Mben vdd d2e_n d2e_nb 0 NSYN W=200u L=1u
Rben d2e_nb 0 20e3
MpTa_1 d2e_pb gp_2_1 ctp_1 0 NSYN W=10u L=1u
MnTb_1 d2e_nb vcn ctp_1 0 NSYN W=10u L=1u
MnTa_1 d2e_pb vcn  ctn_1 0 NSYN W=10u L=1u
MpTb_1 d2e_nb gp_2_1 ctn_1 0 NSYN W=10u L=1u
Msa_bk1 ctn_1 ctn_1 0 0 NMIR W=20u L=1u
Msb_bk1 d1pre_1 ctn_1 0 0 NMIR W=20u L=1u
Msc_bk1 ctp_1 ctp_1 0 0 NMIR W=20u L=1u
Msd_bk1 dpf_bk1 ctp_1 0 0 NMIR W=20u L=1u
Mse_bk1 dpf_bk1 dpf_bk1 vdd vdd PMIR W=60u L=1u
Msf_bk1 d1pre_1 dpf_bk1 vdd vdd PMIR W=60u L=1u
R_bk1 d1pre_1 vrefd 8000.0
MpTa_2 d2e_pb gp_2_2 ctp_2 0 NSYN W=10u L=1u
MnTb_2 d2e_nb vcn ctp_2 0 NSYN W=10u L=1u
MnTa_2 d2e_pb vcn  ctn_2 0 NSYN W=10u L=1u
MpTb_2 d2e_nb gp_2_2 ctn_2 0 NSYN W=10u L=1u
Msa_bk2 ctn_2 ctn_2 0 0 NMIR W=20u L=1u
Msb_bk2 d1pre_2 ctn_2 0 0 NMIR W=20u L=1u
Msc_bk2 ctp_2 ctp_2 0 0 NMIR W=20u L=1u
Msd_bk2 dpf_bk2 ctp_2 0 0 NMIR W=20u L=1u
Mse_bk2 dpf_bk2 dpf_bk2 vdd vdd PMIR W=60u L=1u
Msf_bk2 d1pre_2 dpf_bk2 vdd vdd PMIR W=60u L=1u
R_bk2 d1pre_2 vrefd 8000.0
MpTa_3 d2e_pb gp_2_3 ctp_3 0 NSYN W=10u L=1u
MnTb_3 d2e_nb vcn ctp_3 0 NSYN W=10u L=1u
MnTa_3 d2e_pb vcn  ctn_3 0 NSYN W=10u L=1u
MpTb_3 d2e_nb gp_2_3 ctn_3 0 NSYN W=10u L=1u
Msa_bk3 ctn_3 ctn_3 0 0 NMIR W=20u L=1u
Msb_bk3 d1pre_3 ctn_3 0 0 NMIR W=20u L=1u
Msc_bk3 ctp_3 ctp_3 0 0 NMIR W=20u L=1u
Msd_bk3 dpf_bk3 ctp_3 0 0 NMIR W=20u L=1u
Mse_bk3 dpf_bk3 dpf_bk3 vdd vdd PMIR W=60u L=1u
Msf_bk3 d1pre_3 dpf_bk3 vdd vdd PMIR W=60u L=1u
R_bk3 d1pre_3 vrefd 8000.0
MpTa_4 d2e_pb gp_2_4 ctp_4 0 NSYN W=10u L=1u
MnTb_4 d2e_nb vcn ctp_4 0 NSYN W=10u L=1u
MnTa_4 d2e_pb vcn  ctn_4 0 NSYN W=10u L=1u
MpTb_4 d2e_nb gp_2_4 ctn_4 0 NSYN W=10u L=1u
Msa_bk4 ctn_4 ctn_4 0 0 NMIR W=20u L=1u
Msb_bk4 d1pre_4 ctn_4 0 0 NMIR W=20u L=1u
Msc_bk4 ctp_4 ctp_4 0 0 NMIR W=20u L=1u
Msd_bk4 dpf_bk4 ctp_4 0 0 NMIR W=20u L=1u
Mse_bk4 dpf_bk4 dpf_bk4 vdd vdd PMIR W=60u L=1u
Msf_bk4 d1pre_4 dpf_bk4 vdd vdd PMIR W=60u L=1u
R_bk4 d1pre_4 vrefd 8000.0
MpTa_5 d2e_pb gp_2_5 ctp_5 0 NSYN W=10u L=1u
MnTb_5 d2e_nb vcn ctp_5 0 NSYN W=10u L=1u
MnTa_5 d2e_pb vcn  ctn_5 0 NSYN W=10u L=1u
MpTb_5 d2e_nb gp_2_5 ctn_5 0 NSYN W=10u L=1u
Msa_bk5 ctn_5 ctn_5 0 0 NMIR W=20u L=1u
Msb_bk5 d1pre_5 ctn_5 0 0 NMIR W=20u L=1u
Msc_bk5 ctp_5 ctp_5 0 0 NMIR W=20u L=1u
Msd_bk5 dpf_bk5 ctp_5 0 0 NMIR W=20u L=1u
Mse_bk5 dpf_bk5 dpf_bk5 vdd vdd PMIR W=60u L=1u
Msf_bk5 d1pre_5 dpf_bk5 vdd vdd PMIR W=60u L=1u
R_bk5 d1pre_5 vrefd 8000.0
MpTa_6 d2e_pb gp_2_6 ctp_6 0 NSYN W=10u L=1u
MnTb_6 d2e_nb vcn ctp_6 0 NSYN W=10u L=1u
MnTa_6 d2e_pb vcn  ctn_6 0 NSYN W=10u L=1u
MpTb_6 d2e_nb gp_2_6 ctn_6 0 NSYN W=10u L=1u
Msa_bk6 ctn_6 ctn_6 0 0 NMIR W=20u L=1u
Msb_bk6 d1pre_6 ctn_6 0 0 NMIR W=20u L=1u
Msc_bk6 ctp_6 ctp_6 0 0 NMIR W=20u L=1u
Msd_bk6 dpf_bk6 ctp_6 0 0 NMIR W=20u L=1u
Mse_bk6 dpf_bk6 dpf_bk6 vdd vdd PMIR W=60u L=1u
Msf_bk6 d1pre_6 dpf_bk6 vdd vdd PMIR W=60u L=1u
R_bk6 d1pre_6 vrefd 8000.0
MpTa_7 d2e_pb gp_2_7 ctp_7 0 NSYN W=10u L=1u
MnTb_7 d2e_nb vcn ctp_7 0 NSYN W=10u L=1u
MnTa_7 d2e_pb vcn  ctn_7 0 NSYN W=10u L=1u
MpTb_7 d2e_nb gp_2_7 ctn_7 0 NSYN W=10u L=1u
Msa_bk7 ctn_7 ctn_7 0 0 NMIR W=20u L=1u
Msb_bk7 d1pre_7 ctn_7 0 0 NMIR W=20u L=1u
Msc_bk7 ctp_7 ctp_7 0 0 NMIR W=20u L=1u
Msd_bk7 dpf_bk7 ctp_7 0 0 NMIR W=20u L=1u
Mse_bk7 dpf_bk7 dpf_bk7 vdd vdd PMIR W=60u L=1u
Msf_bk7 d1pre_7 dpf_bk7 vdd vdd PMIR W=60u L=1u
R_bk7 d1pre_7 vrefd 8000.0
MpTa_8 d2e_pb gp_2_8 ctp_8 0 NSYN W=10u L=1u
MnTb_8 d2e_nb vcn ctp_8 0 NSYN W=10u L=1u
MnTa_8 d2e_pb vcn  ctn_8 0 NSYN W=10u L=1u
MpTb_8 d2e_nb gp_2_8 ctn_8 0 NSYN W=10u L=1u
Msa_bk8 ctn_8 ctn_8 0 0 NMIR W=20u L=1u
Msb_bk8 d1pre_8 ctn_8 0 0 NMIR W=20u L=1u
Msc_bk8 ctp_8 ctp_8 0 0 NMIR W=20u L=1u
Msd_bk8 dpf_bk8 ctp_8 0 0 NMIR W=20u L=1u
Mse_bk8 dpf_bk8 dpf_bk8 vdd vdd PMIR W=60u L=1u
Msf_bk8 d1pre_8 dpf_bk8 vdd vdd PMIR W=60u L=1u
R_bk8 d1pre_8 vrefd 8000.0
MpTa_9 d2e_pb gp_2_9 ctp_9 0 NSYN W=10u L=1u
MnTb_9 d2e_nb vcn ctp_9 0 NSYN W=10u L=1u
MnTa_9 d2e_pb vcn  ctn_9 0 NSYN W=10u L=1u
MpTb_9 d2e_nb gp_2_9 ctn_9 0 NSYN W=10u L=1u
Msa_bk9 ctn_9 ctn_9 0 0 NMIR W=20u L=1u
Msb_bk9 d1pre_9 ctn_9 0 0 NMIR W=20u L=1u
Msc_bk9 ctp_9 ctp_9 0 0 NMIR W=20u L=1u
Msd_bk9 dpf_bk9 ctp_9 0 0 NMIR W=20u L=1u
Mse_bk9 dpf_bk9 dpf_bk9 vdd vdd PMIR W=60u L=1u
Msf_bk9 d1pre_9 dpf_bk9 vdd vdd PMIR W=60u L=1u
R_bk9 d1pre_9 vrefd 8000.0
MpTa_10 d2e_pb gp_2_10 ctp_10 0 NSYN W=10u L=1u
MnTb_10 d2e_nb vcn ctp_10 0 NSYN W=10u L=1u
MnTa_10 d2e_pb vcn  ctn_10 0 NSYN W=10u L=1u
MpTb_10 d2e_nb gp_2_10 ctn_10 0 NSYN W=10u L=1u
Msa_bk10 ctn_10 ctn_10 0 0 NMIR W=20u L=1u
Msb_bk10 d1pre_10 ctn_10 0 0 NMIR W=20u L=1u
Msc_bk10 ctp_10 ctp_10 0 0 NMIR W=20u L=1u
Msd_bk10 dpf_bk10 ctp_10 0 0 NMIR W=20u L=1u
Mse_bk10 dpf_bk10 dpf_bk10 vdd vdd PMIR W=60u L=1u
Msf_bk10 d1pre_10 dpf_bk10 vdd vdd PMIR W=60u L=1u
R_bk10 d1pre_10 vrefd 8000.0
MpTa_11 d2e_pb gp_2_11 ctp_11 0 NSYN W=10u L=1u
MnTb_11 d2e_nb vcn ctp_11 0 NSYN W=10u L=1u
MnTa_11 d2e_pb vcn  ctn_11 0 NSYN W=10u L=1u
MpTb_11 d2e_nb gp_2_11 ctn_11 0 NSYN W=10u L=1u
Msa_bk11 ctn_11 ctn_11 0 0 NMIR W=20u L=1u
Msb_bk11 d1pre_11 ctn_11 0 0 NMIR W=20u L=1u
Msc_bk11 ctp_11 ctp_11 0 0 NMIR W=20u L=1u
Msd_bk11 dpf_bk11 ctp_11 0 0 NMIR W=20u L=1u
Mse_bk11 dpf_bk11 dpf_bk11 vdd vdd PMIR W=60u L=1u
Msf_bk11 d1pre_11 dpf_bk11 vdd vdd PMIR W=60u L=1u
R_bk11 d1pre_11 vrefd 8000.0
MpTa_12 d2e_pb gp_2_12 ctp_12 0 NSYN W=10u L=1u
MnTb_12 d2e_nb vcn ctp_12 0 NSYN W=10u L=1u
MnTa_12 d2e_pb vcn  ctn_12 0 NSYN W=10u L=1u
MpTb_12 d2e_nb gp_2_12 ctn_12 0 NSYN W=10u L=1u
Msa_bk12 ctn_12 ctn_12 0 0 NMIR W=20u L=1u
Msb_bk12 d1pre_12 ctn_12 0 0 NMIR W=20u L=1u
Msc_bk12 ctp_12 ctp_12 0 0 NMIR W=20u L=1u
Msd_bk12 dpf_bk12 ctp_12 0 0 NMIR W=20u L=1u
Mse_bk12 dpf_bk12 dpf_bk12 vdd vdd PMIR W=60u L=1u
Msf_bk12 d1pre_12 dpf_bk12 vdd vdd PMIR W=60u L=1u
R_bk12 d1pre_12 vrefd 8000.0
Vthr vthr 0 0.5
Vcbias vcbias 0 1.0
Mct_1 ctail_1 vcbias 0 0 NMIR W=10u L=1u
Mca_1 cna_1 z1_1 ctail_1 0 NSYN W=20u L=1u
Mcb_1 uon_1 vthr   ctail_1 0 NSYN W=20u L=1u
Mcp1_1 cna_1 cna_1 vdd vdd PMIR W=40u L=1u
Mcp2_1 uon_1 cna_1 vdd vdd PMIR W=40u L=1u
Mct_2 ctail_2 vcbias 0 0 NMIR W=10u L=1u
Mca_2 cna_2 z1_2 ctail_2 0 NSYN W=20u L=1u
Mcb_2 uon_2 vthr   ctail_2 0 NSYN W=20u L=1u
Mcp1_2 cna_2 cna_2 vdd vdd PMIR W=40u L=1u
Mcp2_2 uon_2 cna_2 vdd vdd PMIR W=40u L=1u
Mct_3 ctail_3 vcbias 0 0 NMIR W=10u L=1u
Mca_3 cna_3 z1_3 ctail_3 0 NSYN W=20u L=1u
Mcb_3 uon_3 vthr   ctail_3 0 NSYN W=20u L=1u
Mcp1_3 cna_3 cna_3 vdd vdd PMIR W=40u L=1u
Mcp2_3 uon_3 cna_3 vdd vdd PMIR W=40u L=1u
Mct_4 ctail_4 vcbias 0 0 NMIR W=10u L=1u
Mca_4 cna_4 z1_4 ctail_4 0 NSYN W=20u L=1u
Mcb_4 uon_4 vthr   ctail_4 0 NSYN W=20u L=1u
Mcp1_4 cna_4 cna_4 vdd vdd PMIR W=40u L=1u
Mcp2_4 uon_4 cna_4 vdd vdd PMIR W=40u L=1u
Mct_5 ctail_5 vcbias 0 0 NMIR W=10u L=1u
Mca_5 cna_5 z1_5 ctail_5 0 NSYN W=20u L=1u
Mcb_5 uon_5 vthr   ctail_5 0 NSYN W=20u L=1u
Mcp1_5 cna_5 cna_5 vdd vdd PMIR W=40u L=1u
Mcp2_5 uon_5 cna_5 vdd vdd PMIR W=40u L=1u
Mct_6 ctail_6 vcbias 0 0 NMIR W=10u L=1u
Mca_6 cna_6 z1_6 ctail_6 0 NSYN W=20u L=1u
Mcb_6 uon_6 vthr   ctail_6 0 NSYN W=20u L=1u
Mcp1_6 cna_6 cna_6 vdd vdd PMIR W=40u L=1u
Mcp2_6 uon_6 cna_6 vdd vdd PMIR W=40u L=1u
Mct_7 ctail_7 vcbias 0 0 NMIR W=10u L=1u
Mca_7 cna_7 z1_7 ctail_7 0 NSYN W=20u L=1u
Mcb_7 uon_7 vthr   ctail_7 0 NSYN W=20u L=1u
Mcp1_7 cna_7 cna_7 vdd vdd PMIR W=40u L=1u
Mcp2_7 uon_7 cna_7 vdd vdd PMIR W=40u L=1u
Mct_8 ctail_8 vcbias 0 0 NMIR W=10u L=1u
Mca_8 cna_8 z1_8 ctail_8 0 NSYN W=20u L=1u
Mcb_8 uon_8 vthr   ctail_8 0 NSYN W=20u L=1u
Mcp1_8 cna_8 cna_8 vdd vdd PMIR W=40u L=1u
Mcp2_8 uon_8 cna_8 vdd vdd PMIR W=40u L=1u
Mct_9 ctail_9 vcbias 0 0 NMIR W=10u L=1u
Mca_9 cna_9 z1_9 ctail_9 0 NSYN W=20u L=1u
Mcb_9 uon_9 vthr   ctail_9 0 NSYN W=20u L=1u
Mcp1_9 cna_9 cna_9 vdd vdd PMIR W=40u L=1u
Mcp2_9 uon_9 cna_9 vdd vdd PMIR W=40u L=1u
Mct_10 ctail_10 vcbias 0 0 NMIR W=10u L=1u
Mca_10 cna_10 z1_10 ctail_10 0 NSYN W=20u L=1u
Mcb_10 uon_10 vthr   ctail_10 0 NSYN W=20u L=1u
Mcp1_10 cna_10 cna_10 vdd vdd PMIR W=40u L=1u
Mcp2_10 uon_10 cna_10 vdd vdd PMIR W=40u L=1u
Mct_11 ctail_11 vcbias 0 0 NMIR W=10u L=1u
Mca_11 cna_11 z1_11 ctail_11 0 NSYN W=20u L=1u
Mcb_11 uon_11 vthr   ctail_11 0 NSYN W=20u L=1u
Mcp1_11 cna_11 cna_11 vdd vdd PMIR W=40u L=1u
Mcp2_11 uon_11 cna_11 vdd vdd PMIR W=40u L=1u
Mct_12 ctail_12 vcbias 0 0 NMIR W=10u L=1u
Mca_12 cna_12 z1_12 ctail_12 0 NSYN W=20u L=1u
Mcb_12 uon_12 vthr   ctail_12 0 NSYN W=20u L=1u
Mcp1_12 cna_12 cna_12 vdd vdd PMIR W=40u L=1u
Mcp2_12 uon_12 cna_12 vdd vdd PMIR W=40u L=1u
Mtt_u11 ts_u11 uon_1 mid_u11 0 NMIR W=48u L=1u
Mtb_u11 mid_u11 au1 0 0 NMIR W=48u L=1u
Mo1_u11 da_u11 vrefd ts_u11 0 NMIR W=20u L=1u
Mo2_u11 gp_1_1_1 d1pre_1 ts_u11 0 NMIR W=20u L=1u
Mo3_u11 da_u11 da_u11 vdd vdd PMIR W=60u L=1u
Mo4_u11 gp_1_1_1 da_u11 vdd vdd PMIR W=60u L=1u
Mtt_u12 ts_u12 uon_1 mid_u12 0 NMIR W=48u L=1u
Mtb_u12 mid_u12 au2 0 0 NMIR W=48u L=1u
Mo1_u12 da_u12 vrefd ts_u12 0 NMIR W=20u L=1u
Mo2_u12 gp_1_1_2 d1pre_1 ts_u12 0 NMIR W=20u L=1u
Mo3_u12 da_u12 da_u12 vdd vdd PMIR W=60u L=1u
Mo4_u12 gp_1_1_2 da_u12 vdd vdd PMIR W=60u L=1u
Mtt_u1b ts_u1b uon_1 mid_u1b 0 NMIR W=48u L=1u
Mtb_u1b mid_u1b aub 0 0 NMIR W=48u L=1u
Mo1_u1b da_u1b vrefd ts_u1b 0 NMIR W=20u L=1u
Mo2_u1b gp_1_1_b d1pre_1 ts_u1b 0 NMIR W=20u L=1u
Mo3_u1b da_u1b da_u1b vdd vdd PMIR W=60u L=1u
Mo4_u1b gp_1_1_b da_u1b vdd vdd PMIR W=60u L=1u
Mtt_u21 ts_u21 uon_2 mid_u21 0 NMIR W=48u L=1u
Mtb_u21 mid_u21 au1 0 0 NMIR W=48u L=1u
Mo1_u21 da_u21 vrefd ts_u21 0 NMIR W=20u L=1u
Mo2_u21 gp_1_2_1 d1pre_2 ts_u21 0 NMIR W=20u L=1u
Mo3_u21 da_u21 da_u21 vdd vdd PMIR W=60u L=1u
Mo4_u21 gp_1_2_1 da_u21 vdd vdd PMIR W=60u L=1u
Mtt_u22 ts_u22 uon_2 mid_u22 0 NMIR W=48u L=1u
Mtb_u22 mid_u22 au2 0 0 NMIR W=48u L=1u
Mo1_u22 da_u22 vrefd ts_u22 0 NMIR W=20u L=1u
Mo2_u22 gp_1_2_2 d1pre_2 ts_u22 0 NMIR W=20u L=1u
Mo3_u22 da_u22 da_u22 vdd vdd PMIR W=60u L=1u
Mo4_u22 gp_1_2_2 da_u22 vdd vdd PMIR W=60u L=1u
Mtt_u2b ts_u2b uon_2 mid_u2b 0 NMIR W=48u L=1u
Mtb_u2b mid_u2b aub 0 0 NMIR W=48u L=1u
Mo1_u2b da_u2b vrefd ts_u2b 0 NMIR W=20u L=1u
Mo2_u2b gp_1_2_b d1pre_2 ts_u2b 0 NMIR W=20u L=1u
Mo3_u2b da_u2b da_u2b vdd vdd PMIR W=60u L=1u
Mo4_u2b gp_1_2_b da_u2b vdd vdd PMIR W=60u L=1u
Mtt_u31 ts_u31 uon_3 mid_u31 0 NMIR W=48u L=1u
Mtb_u31 mid_u31 au1 0 0 NMIR W=48u L=1u
Mo1_u31 da_u31 vrefd ts_u31 0 NMIR W=20u L=1u
Mo2_u31 gp_1_3_1 d1pre_3 ts_u31 0 NMIR W=20u L=1u
Mo3_u31 da_u31 da_u31 vdd vdd PMIR W=60u L=1u
Mo4_u31 gp_1_3_1 da_u31 vdd vdd PMIR W=60u L=1u
Mtt_u32 ts_u32 uon_3 mid_u32 0 NMIR W=48u L=1u
Mtb_u32 mid_u32 au2 0 0 NMIR W=48u L=1u
Mo1_u32 da_u32 vrefd ts_u32 0 NMIR W=20u L=1u
Mo2_u32 gp_1_3_2 d1pre_3 ts_u32 0 NMIR W=20u L=1u
Mo3_u32 da_u32 da_u32 vdd vdd PMIR W=60u L=1u
Mo4_u32 gp_1_3_2 da_u32 vdd vdd PMIR W=60u L=1u
Mtt_u3b ts_u3b uon_3 mid_u3b 0 NMIR W=48u L=1u
Mtb_u3b mid_u3b aub 0 0 NMIR W=48u L=1u
Mo1_u3b da_u3b vrefd ts_u3b 0 NMIR W=20u L=1u
Mo2_u3b gp_1_3_b d1pre_3 ts_u3b 0 NMIR W=20u L=1u
Mo3_u3b da_u3b da_u3b vdd vdd PMIR W=60u L=1u
Mo4_u3b gp_1_3_b da_u3b vdd vdd PMIR W=60u L=1u
Mtt_u41 ts_u41 uon_4 mid_u41 0 NMIR W=48u L=1u
Mtb_u41 mid_u41 au1 0 0 NMIR W=48u L=1u
Mo1_u41 da_u41 vrefd ts_u41 0 NMIR W=20u L=1u
Mo2_u41 gp_1_4_1 d1pre_4 ts_u41 0 NMIR W=20u L=1u
Mo3_u41 da_u41 da_u41 vdd vdd PMIR W=60u L=1u
Mo4_u41 gp_1_4_1 da_u41 vdd vdd PMIR W=60u L=1u
Mtt_u42 ts_u42 uon_4 mid_u42 0 NMIR W=48u L=1u
Mtb_u42 mid_u42 au2 0 0 NMIR W=48u L=1u
Mo1_u42 da_u42 vrefd ts_u42 0 NMIR W=20u L=1u
Mo2_u42 gp_1_4_2 d1pre_4 ts_u42 0 NMIR W=20u L=1u
Mo3_u42 da_u42 da_u42 vdd vdd PMIR W=60u L=1u
Mo4_u42 gp_1_4_2 da_u42 vdd vdd PMIR W=60u L=1u
Mtt_u4b ts_u4b uon_4 mid_u4b 0 NMIR W=48u L=1u
Mtb_u4b mid_u4b aub 0 0 NMIR W=48u L=1u
Mo1_u4b da_u4b vrefd ts_u4b 0 NMIR W=20u L=1u
Mo2_u4b gp_1_4_b d1pre_4 ts_u4b 0 NMIR W=20u L=1u
Mo3_u4b da_u4b da_u4b vdd vdd PMIR W=60u L=1u
Mo4_u4b gp_1_4_b da_u4b vdd vdd PMIR W=60u L=1u
Mtt_u51 ts_u51 uon_5 mid_u51 0 NMIR W=48u L=1u
Mtb_u51 mid_u51 au1 0 0 NMIR W=48u L=1u
Mo1_u51 da_u51 vrefd ts_u51 0 NMIR W=20u L=1u
Mo2_u51 gp_1_5_1 d1pre_5 ts_u51 0 NMIR W=20u L=1u
Mo3_u51 da_u51 da_u51 vdd vdd PMIR W=60u L=1u
Mo4_u51 gp_1_5_1 da_u51 vdd vdd PMIR W=60u L=1u
Mtt_u52 ts_u52 uon_5 mid_u52 0 NMIR W=48u L=1u
Mtb_u52 mid_u52 au2 0 0 NMIR W=48u L=1u
Mo1_u52 da_u52 vrefd ts_u52 0 NMIR W=20u L=1u
Mo2_u52 gp_1_5_2 d1pre_5 ts_u52 0 NMIR W=20u L=1u
Mo3_u52 da_u52 da_u52 vdd vdd PMIR W=60u L=1u
Mo4_u52 gp_1_5_2 da_u52 vdd vdd PMIR W=60u L=1u
Mtt_u5b ts_u5b uon_5 mid_u5b 0 NMIR W=48u L=1u
Mtb_u5b mid_u5b aub 0 0 NMIR W=48u L=1u
Mo1_u5b da_u5b vrefd ts_u5b 0 NMIR W=20u L=1u
Mo2_u5b gp_1_5_b d1pre_5 ts_u5b 0 NMIR W=20u L=1u
Mo3_u5b da_u5b da_u5b vdd vdd PMIR W=60u L=1u
Mo4_u5b gp_1_5_b da_u5b vdd vdd PMIR W=60u L=1u
Mtt_u61 ts_u61 uon_6 mid_u61 0 NMIR W=48u L=1u
Mtb_u61 mid_u61 au1 0 0 NMIR W=48u L=1u
Mo1_u61 da_u61 vrefd ts_u61 0 NMIR W=20u L=1u
Mo2_u61 gp_1_6_1 d1pre_6 ts_u61 0 NMIR W=20u L=1u
Mo3_u61 da_u61 da_u61 vdd vdd PMIR W=60u L=1u
Mo4_u61 gp_1_6_1 da_u61 vdd vdd PMIR W=60u L=1u
Mtt_u62 ts_u62 uon_6 mid_u62 0 NMIR W=48u L=1u
Mtb_u62 mid_u62 au2 0 0 NMIR W=48u L=1u
Mo1_u62 da_u62 vrefd ts_u62 0 NMIR W=20u L=1u
Mo2_u62 gp_1_6_2 d1pre_6 ts_u62 0 NMIR W=20u L=1u
Mo3_u62 da_u62 da_u62 vdd vdd PMIR W=60u L=1u
Mo4_u62 gp_1_6_2 da_u62 vdd vdd PMIR W=60u L=1u
Mtt_u6b ts_u6b uon_6 mid_u6b 0 NMIR W=48u L=1u
Mtb_u6b mid_u6b aub 0 0 NMIR W=48u L=1u
Mo1_u6b da_u6b vrefd ts_u6b 0 NMIR W=20u L=1u
Mo2_u6b gp_1_6_b d1pre_6 ts_u6b 0 NMIR W=20u L=1u
Mo3_u6b da_u6b da_u6b vdd vdd PMIR W=60u L=1u
Mo4_u6b gp_1_6_b da_u6b vdd vdd PMIR W=60u L=1u
Mtt_u71 ts_u71 uon_7 mid_u71 0 NMIR W=48u L=1u
Mtb_u71 mid_u71 au1 0 0 NMIR W=48u L=1u
Mo1_u71 da_u71 vrefd ts_u71 0 NMIR W=20u L=1u
Mo2_u71 gp_1_7_1 d1pre_7 ts_u71 0 NMIR W=20u L=1u
Mo3_u71 da_u71 da_u71 vdd vdd PMIR W=60u L=1u
Mo4_u71 gp_1_7_1 da_u71 vdd vdd PMIR W=60u L=1u
Mtt_u72 ts_u72 uon_7 mid_u72 0 NMIR W=48u L=1u
Mtb_u72 mid_u72 au2 0 0 NMIR W=48u L=1u
Mo1_u72 da_u72 vrefd ts_u72 0 NMIR W=20u L=1u
Mo2_u72 gp_1_7_2 d1pre_7 ts_u72 0 NMIR W=20u L=1u
Mo3_u72 da_u72 da_u72 vdd vdd PMIR W=60u L=1u
Mo4_u72 gp_1_7_2 da_u72 vdd vdd PMIR W=60u L=1u
Mtt_u7b ts_u7b uon_7 mid_u7b 0 NMIR W=48u L=1u
Mtb_u7b mid_u7b aub 0 0 NMIR W=48u L=1u
Mo1_u7b da_u7b vrefd ts_u7b 0 NMIR W=20u L=1u
Mo2_u7b gp_1_7_b d1pre_7 ts_u7b 0 NMIR W=20u L=1u
Mo3_u7b da_u7b da_u7b vdd vdd PMIR W=60u L=1u
Mo4_u7b gp_1_7_b da_u7b vdd vdd PMIR W=60u L=1u
Mtt_u81 ts_u81 uon_8 mid_u81 0 NMIR W=48u L=1u
Mtb_u81 mid_u81 au1 0 0 NMIR W=48u L=1u
Mo1_u81 da_u81 vrefd ts_u81 0 NMIR W=20u L=1u
Mo2_u81 gp_1_8_1 d1pre_8 ts_u81 0 NMIR W=20u L=1u
Mo3_u81 da_u81 da_u81 vdd vdd PMIR W=60u L=1u
Mo4_u81 gp_1_8_1 da_u81 vdd vdd PMIR W=60u L=1u
Mtt_u82 ts_u82 uon_8 mid_u82 0 NMIR W=48u L=1u
Mtb_u82 mid_u82 au2 0 0 NMIR W=48u L=1u
Mo1_u82 da_u82 vrefd ts_u82 0 NMIR W=20u L=1u
Mo2_u82 gp_1_8_2 d1pre_8 ts_u82 0 NMIR W=20u L=1u
Mo3_u82 da_u82 da_u82 vdd vdd PMIR W=60u L=1u
Mo4_u82 gp_1_8_2 da_u82 vdd vdd PMIR W=60u L=1u
Mtt_u8b ts_u8b uon_8 mid_u8b 0 NMIR W=48u L=1u
Mtb_u8b mid_u8b aub 0 0 NMIR W=48u L=1u
Mo1_u8b da_u8b vrefd ts_u8b 0 NMIR W=20u L=1u
Mo2_u8b gp_1_8_b d1pre_8 ts_u8b 0 NMIR W=20u L=1u
Mo3_u8b da_u8b da_u8b vdd vdd PMIR W=60u L=1u
Mo4_u8b gp_1_8_b da_u8b vdd vdd PMIR W=60u L=1u
Mtt_u91 ts_u91 uon_9 mid_u91 0 NMIR W=48u L=1u
Mtb_u91 mid_u91 au1 0 0 NMIR W=48u L=1u
Mo1_u91 da_u91 vrefd ts_u91 0 NMIR W=20u L=1u
Mo2_u91 gp_1_9_1 d1pre_9 ts_u91 0 NMIR W=20u L=1u
Mo3_u91 da_u91 da_u91 vdd vdd PMIR W=60u L=1u
Mo4_u91 gp_1_9_1 da_u91 vdd vdd PMIR W=60u L=1u
Mtt_u92 ts_u92 uon_9 mid_u92 0 NMIR W=48u L=1u
Mtb_u92 mid_u92 au2 0 0 NMIR W=48u L=1u
Mo1_u92 da_u92 vrefd ts_u92 0 NMIR W=20u L=1u
Mo2_u92 gp_1_9_2 d1pre_9 ts_u92 0 NMIR W=20u L=1u
Mo3_u92 da_u92 da_u92 vdd vdd PMIR W=60u L=1u
Mo4_u92 gp_1_9_2 da_u92 vdd vdd PMIR W=60u L=1u
Mtt_u9b ts_u9b uon_9 mid_u9b 0 NMIR W=48u L=1u
Mtb_u9b mid_u9b aub 0 0 NMIR W=48u L=1u
Mo1_u9b da_u9b vrefd ts_u9b 0 NMIR W=20u L=1u
Mo2_u9b gp_1_9_b d1pre_9 ts_u9b 0 NMIR W=20u L=1u
Mo3_u9b da_u9b da_u9b vdd vdd PMIR W=60u L=1u
Mo4_u9b gp_1_9_b da_u9b vdd vdd PMIR W=60u L=1u
Mtt_u101 ts_u101 uon_10 mid_u101 0 NMIR W=48u L=1u
Mtb_u101 mid_u101 au1 0 0 NMIR W=48u L=1u
Mo1_u101 da_u101 vrefd ts_u101 0 NMIR W=20u L=1u
Mo2_u101 gp_1_10_1 d1pre_10 ts_u101 0 NMIR W=20u L=1u
Mo3_u101 da_u101 da_u101 vdd vdd PMIR W=60u L=1u
Mo4_u101 gp_1_10_1 da_u101 vdd vdd PMIR W=60u L=1u
Mtt_u102 ts_u102 uon_10 mid_u102 0 NMIR W=48u L=1u
Mtb_u102 mid_u102 au2 0 0 NMIR W=48u L=1u
Mo1_u102 da_u102 vrefd ts_u102 0 NMIR W=20u L=1u
Mo2_u102 gp_1_10_2 d1pre_10 ts_u102 0 NMIR W=20u L=1u
Mo3_u102 da_u102 da_u102 vdd vdd PMIR W=60u L=1u
Mo4_u102 gp_1_10_2 da_u102 vdd vdd PMIR W=60u L=1u
Mtt_u10b ts_u10b uon_10 mid_u10b 0 NMIR W=48u L=1u
Mtb_u10b mid_u10b aub 0 0 NMIR W=48u L=1u
Mo1_u10b da_u10b vrefd ts_u10b 0 NMIR W=20u L=1u
Mo2_u10b gp_1_10_b d1pre_10 ts_u10b 0 NMIR W=20u L=1u
Mo3_u10b da_u10b da_u10b vdd vdd PMIR W=60u L=1u
Mo4_u10b gp_1_10_b da_u10b vdd vdd PMIR W=60u L=1u
Mtt_u111 ts_u111 uon_11 mid_u111 0 NMIR W=48u L=1u
Mtb_u111 mid_u111 au1 0 0 NMIR W=48u L=1u
Mo1_u111 da_u111 vrefd ts_u111 0 NMIR W=20u L=1u
Mo2_u111 gp_1_11_1 d1pre_11 ts_u111 0 NMIR W=20u L=1u
Mo3_u111 da_u111 da_u111 vdd vdd PMIR W=60u L=1u
Mo4_u111 gp_1_11_1 da_u111 vdd vdd PMIR W=60u L=1u
Mtt_u112 ts_u112 uon_11 mid_u112 0 NMIR W=48u L=1u
Mtb_u112 mid_u112 au2 0 0 NMIR W=48u L=1u
Mo1_u112 da_u112 vrefd ts_u112 0 NMIR W=20u L=1u
Mo2_u112 gp_1_11_2 d1pre_11 ts_u112 0 NMIR W=20u L=1u
Mo3_u112 da_u112 da_u112 vdd vdd PMIR W=60u L=1u
Mo4_u112 gp_1_11_2 da_u112 vdd vdd PMIR W=60u L=1u
Mtt_u11b ts_u11b uon_11 mid_u11b 0 NMIR W=48u L=1u
Mtb_u11b mid_u11b aub 0 0 NMIR W=48u L=1u
Mo1_u11b da_u11b vrefd ts_u11b 0 NMIR W=20u L=1u
Mo2_u11b gp_1_11_b d1pre_11 ts_u11b 0 NMIR W=20u L=1u
Mo3_u11b da_u11b da_u11b vdd vdd PMIR W=60u L=1u
Mo4_u11b gp_1_11_b da_u11b vdd vdd PMIR W=60u L=1u
Mtt_u121 ts_u121 uon_12 mid_u121 0 NMIR W=48u L=1u
Mtb_u121 mid_u121 au1 0 0 NMIR W=48u L=1u
Mo1_u121 da_u121 vrefd ts_u121 0 NMIR W=20u L=1u
Mo2_u121 gp_1_12_1 d1pre_12 ts_u121 0 NMIR W=20u L=1u
Mo3_u121 da_u121 da_u121 vdd vdd PMIR W=60u L=1u
Mo4_u121 gp_1_12_1 da_u121 vdd vdd PMIR W=60u L=1u
Mtt_u122 ts_u122 uon_12 mid_u122 0 NMIR W=48u L=1u
Mtb_u122 mid_u122 au2 0 0 NMIR W=48u L=1u
Mo1_u122 da_u122 vrefd ts_u122 0 NMIR W=20u L=1u
Mo2_u122 gp_1_12_2 d1pre_12 ts_u122 0 NMIR W=20u L=1u
Mo3_u122 da_u122 da_u122 vdd vdd PMIR W=60u L=1u
Mo4_u122 gp_1_12_2 da_u122 vdd vdd PMIR W=60u L=1u
Mtt_u12b ts_u12b uon_12 mid_u12b 0 NMIR W=48u L=1u
Mtb_u12b mid_u12b aub 0 0 NMIR W=48u L=1u
Mo1_u12b da_u12b vrefd ts_u12b 0 NMIR W=20u L=1u
Mo2_u12b gp_1_12_b d1pre_12 ts_u12b 0 NMIR W=20u L=1u
Mo3_u12b da_u12b da_u12b vdd vdd PMIR W=60u L=1u
Mo4_u12b gp_1_12_b da_u12b vdd vdd PMIR W=60u L=1u
.ic v(gp_1_1_1)=1.9764 v(gp_1_1_2)=2.148 v(gp_1_1_b)=2.2248 v(gp_1_2_1)=2.4372 v(gp_1_2_2)=2.1456 v(gp_1_2_b)=2.4084 v(gp_1_3_1)=1.122 v(gp_1_3_2)=1.7508 v(gp_1_3_b)=2.4384 v(gp_1_4_1)=2.0148 v(gp_1_4_2)=2.3772 v(gp_1_4_b)=1.2432 v(gp_1_5_1)=1.7556 v(gp_1_5_2)=1.4352 v(gp_1_5_b)=1.8636 v(gp_1_6_1)=1.9068 v(gp_1_6_2)=1.0992 v(gp_1_6_b)=1.392 v(gp_1_7_1)=1.482 v(gp_1_7_2)=2.4 v(gp_1_7_b)=2.1828 v(gp_1_8_1)=1.3104 v(gp_1_8_2)=2.2284 v(gp_1_8_b)=1.2804 v(gp_1_9_1)=1.9692 v(gp_1_9_2)=1.2624 v(gp_1_9_b)=1.0824 v(gp_1_10_1)=2.3352 v(gp_1_10_2)=1.3812 v(gp_1_10_b)=1.3908 v(gp_1_11_1)=2.4948 v(gp_1_11_2)=2.3364 v(gp_1_11_b)=1.4964 v(gp_1_12_1)=2.4648 v(gp_1_12_2)=1.8564 v(gp_1_12_b)=2.0556 v(gp_2_1)=1.3752 v(gp_2_2)=2.4348 v(gp_2_3)=2.0748 v(gp_2_4)=2.472 v(gp_2_5)=2.3664 v(gp_2_6)=1.5108 v(gp_2_7)=1.5996 v(gp_2_8)=1.3188 v(gp_2_9)=1.29 v(gp_2_10)=1.1736 v(gp_2_11)=1.5144 v(gp_2_12)=1.9488 v(gp_2_b)=1.0848
.control
  tran 0.10200000000000001 360.0 uic
  wrdata xor_full_trace.txt v(y) v(a1) v(a2) v(tg) v(hv_1) v(hv_2) v(hv_3) v(hv_4) v(hv_5) v(hv_6)
  wrdata weights_full.txt v(gp_1_1_1) v(gp_1_1_2) v(gp_1_1_b) v(gp_1_2_1) v(gp_1_2_2) v(gp_1_2_b) v(gp_1_3_1) v(gp_1_3_2) v(gp_1_3_b) v(gp_1_4_1) v(gp_1_4_2) v(gp_1_4_b) v(gp_1_5_1) v(gp_1_5_2) v(gp_1_5_b) v(gp_1_6_1) v(gp_1_6_2) v(gp_1_6_b) v(gp_1_7_1) v(gp_1_7_2) v(gp_1_7_b) v(gp_1_8_1) v(gp_1_8_2) v(gp_1_8_b) v(gp_1_9_1) v(gp_1_9_2) v(gp_1_9_b) v(gp_1_10_1) v(gp_1_10_2) v(gp_1_10_b) v(gp_1_11_1) v(gp_1_11_2) v(gp_1_11_b) v(gp_1_12_1) v(gp_1_12_2) v(gp_1_12_b) v(gp_2_1) v(gp_2_2) v(gp_2_3) v(gp_2_4) v(gp_2_5) v(gp_2_6) v(gp_2_7) v(gp_2_8) v(gp_2_9) v(gp_2_10) v(gp_2_11) v(gp_2_12) v(gp_2_b)
  echo FULL_OK
.endc
.end
