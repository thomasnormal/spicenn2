fully-differential transistor current-mode EP
.model NNR NMOS (LEVEL=1 VTO=0.2  KP=120u LAMBDA=0.02 GAMMA=0 PHI=0.7)
.model PNR PMOS (LEVEL=1 VTO=-0.2 KP=40u  LAMBDA=0.02 GAMMA=0 PHI=0.7)
.subckt dsyn inp inn outp outn wp wn vdd
M1 outp inp tp 0 NNR W=200u L=100u
M2 outn inn tp 0 NNR W=200u L=100u
Mtp tp wp 0 0 NNR W=200u L=100u
M3 outn inp tn 0 NNR W=200u L=100u
M4 outp inn tn 0 NNR W=200u L=100u
Mtn tn wn 0 0 NNR W=200u L=100u
.ends
.subckt dneuron up un ap an vdd vbn
M1 an up tn 0 NNR W=200u L=100u
M2 ap un tn 0 NNR W=200u L=100u
Mt tn vbn 0 0 NNR W=200u L=100u
RLa vdd ap 1.6M
RLb vdd an 1.6M
.ends
.subckt dneuron2 up un ap an vdd vbn
M1 m2 up t1 0 NNR W=200u L=100u
M2 m1 un t1 0 NNR W=200u L=100u
Mt1 t1 vbn 0 0 NNR W=200u L=100u
RL1 vdd m1 1.6M
RL2 vdd m2 1.6M
M3 an m1 t2 0 NNR W=200u L=100u
M4 ap m2 t2 0 NNR W=200u L=100u
Mt2 t2 vbn 0 0 NNR W=200u L=100u
RL3 vdd ap 1.6M
RL4 vdd an 1.6M
.ends

Vdd vdd 0 1.0
Vbn vbn 0 0.30
Vbp_hi bp_hi 0 0.8
Vbp_lo bp_lo 0 0.2
Vtp vtp 0 0.5
Vtn vtn 0 0.5
Vaxp1 a_xp1 0 0.5
Vaxn1 a_xn1 0 0.5
Vaxp2 a_xp2 0 0.5
Vaxn2 a_xn2 0 0.5
Mlp_h1 up_h1 up_h1 vdd vdd PNR W=3000u L=100u
Mln_h1 un_h1 un_h1 vdd vdd PNR W=3000u L=100u
Vbnh1 bnh1 0 0.3000
Xn_h1 up_h1 un_h1 ap_h1 an_h1 vdd bnh1 dneuron2
Vwp_i11 wp_i11 0 0.4000
Vwn_i11 wn_i11 0 0.4000
X_i11 a_xp1 a_xn1 up_h1 un_h1 wp_i11 wn_i11 vdd dsyn
Vwp_i21 wp_i21 0 0.4119
Vwn_i21 wn_i21 0 0.3881
X_i21 a_xp2 a_xn2 up_h1 un_h1 wp_i21 wn_i21 vdd dsyn
Vwp_bk1 wp_bk1 0 0.3890
Vwn_bk1 wn_bk1 0 0.4110
X_bk1 up_o un_o up_h1 un_h1 wp_bk1 wn_bk1 vdd dsyn
Vwp_bh1 wp_bh1 0 0.3644
Vwn_bh1 wn_bh1 0 0.4356
X_bh1 bp_hi bp_lo up_h1 un_h1 wp_bh1 wn_bh1 vdd dsyn
Mlp_h2 up_h2 up_h2 vdd vdd PNR W=3000u L=100u
Mln_h2 un_h2 un_h2 vdd vdd PNR W=3000u L=100u
Vbnh2 bnh2 0 0.3000
Xn_h2 up_h2 un_h2 ap_h2 an_h2 vdd bnh2 dneuron2
Vwp_i12 wp_i12 0 0.3818
Vwn_i12 wn_i12 0 0.4182
X_i12 a_xp1 a_xn1 up_h2 un_h2 wp_i12 wn_i12 vdd dsyn
Vwp_i22 wp_i22 0 0.3603
Vwn_i22 wn_i22 0 0.4397
X_i22 a_xp2 a_xn2 up_h2 un_h2 wp_i22 wn_i22 vdd dsyn
Vwp_bk2 wp_bk2 0 0.4024
Vwn_bk2 wn_bk2 0 0.3976
X_bk2 up_o un_o up_h2 un_h2 wp_bk2 wn_bk2 vdd dsyn
Vwp_bh2 wp_bh2 0 0.4536
Vwn_bh2 wn_bh2 0 0.3464
X_bh2 bp_hi bp_lo up_h2 un_h2 wp_bh2 wn_bh2 vdd dsyn
Mlp_h3 up_h3 up_h3 vdd vdd PNR W=3000u L=100u
Mln_h3 un_h3 un_h3 vdd vdd PNR W=3000u L=100u
Vbnh3 bnh3 0 0.3000
Xn_h3 up_h3 un_h3 ap_h3 an_h3 vdd bnh3 dneuron2
Vwp_i13 wp_i13 0 0.3803
Vwn_i13 wn_i13 0 0.4197
X_i13 a_xp1 a_xn1 up_h3 un_h3 wp_i13 wn_i13 vdd dsyn
Vwp_i23 wp_i23 0 0.3752
Vwn_i23 wn_i23 0 0.4248
X_i23 a_xp2 a_xn2 up_h3 un_h3 wp_i23 wn_i23 vdd dsyn
Vwp_bk3 wp_bk3 0 0.4196
Vwn_bk3 wn_bk3 0 0.3804
X_bk3 up_o un_o up_h3 un_h3 wp_bk3 wn_bk3 vdd dsyn
Vwp_bh3 wp_bh3 0 0.4143
Vwn_bh3 wn_bh3 0 0.3857
X_bh3 bp_hi bp_lo up_h3 un_h3 wp_bh3 wn_bh3 vdd dsyn
Mlp_h4 up_h4 up_h4 vdd vdd PNR W=3000u L=100u
Mln_h4 un_h4 un_h4 vdd vdd PNR W=3000u L=100u
Vbnh4 bnh4 0 0.3000
Xn_h4 up_h4 un_h4 ap_h4 an_h4 vdd bnh4 dneuron2
Vwp_i14 wp_i14 0 0.4042
Vwn_i14 wn_i14 0 0.3958
X_i14 a_xp1 a_xn1 up_h4 un_h4 wp_i14 wn_i14 vdd dsyn
Vwp_i24 wp_i24 0 0.3628
Vwn_i24 wn_i24 0 0.4372
X_i24 a_xp2 a_xn2 up_h4 un_h4 wp_i24 wn_i24 vdd dsyn
Vwp_bk4 wp_bk4 0 0.3988
Vwn_bk4 wn_bk4 0 0.4012
X_bk4 up_o un_o up_h4 un_h4 wp_bk4 wn_bk4 vdd dsyn
Vwp_bh4 wp_bh4 0 0.4278
Vwn_bh4 wn_bh4 0 0.3722
X_bh4 bp_hi bp_lo up_h4 un_h4 wp_bh4 wn_bh4 vdd dsyn
Mlp_h5 up_h5 up_h5 vdd vdd PNR W=3000u L=100u
Mln_h5 un_h5 un_h5 vdd vdd PNR W=3000u L=100u
Vbnh5 bnh5 0 0.3000
Xn_h5 up_h5 un_h5 ap_h5 an_h5 vdd bnh5 dneuron2
Vwp_i15 wp_i15 0 0.3462
Vwn_i15 wn_i15 0 0.4538
X_i15 a_xp1 a_xn1 up_h5 un_h5 wp_i15 wn_i15 vdd dsyn
Vwp_i25 wp_i25 0 0.3817
Vwn_i25 wn_i25 0 0.4183
X_i25 a_xp2 a_xn2 up_h5 un_h5 wp_i25 wn_i25 vdd dsyn
Vwp_bk5 wp_bk5 0 0.3240
Vwn_bk5 wn_bk5 0 0.4760
X_bk5 up_o un_o up_h5 un_h5 wp_bk5 wn_bk5 vdd dsyn
Vwp_bh5 wp_bh5 0 0.3484
Vwn_bh5 wn_bh5 0 0.4516
X_bh5 bp_hi bp_lo up_h5 un_h5 wp_bh5 wn_bh5 vdd dsyn
Mlp_h6 up_h6 up_h6 vdd vdd PNR W=3000u L=100u
Mln_h6 un_h6 un_h6 vdd vdd PNR W=3000u L=100u
Vbnh6 bnh6 0 0.3000
Xn_h6 up_h6 un_h6 ap_h6 an_h6 vdd bnh6 dneuron2
Vwp_i16 wp_i16 0 0.3263
Vwn_i16 wn_i16 0 0.4737
X_i16 a_xp1 a_xn1 up_h6 un_h6 wp_i16 wn_i16 vdd dsyn
Vwp_i26 wp_i26 0 0.3906
Vwn_i26 wn_i26 0 0.4094
X_i26 a_xp2 a_xn2 up_h6 un_h6 wp_i26 wn_i26 vdd dsyn
Vwp_bk6 wp_bk6 0 0.3493
Vwn_bk6 wn_bk6 0 0.4507
X_bk6 up_o un_o up_h6 un_h6 wp_bk6 wn_bk6 vdd dsyn
Vwp_bh6 wp_bh6 0 0.4109
Vwn_bh6 wn_bh6 0 0.3891
X_bh6 bp_hi bp_lo up_h6 un_h6 wp_bh6 wn_bh6 vdd dsyn
Mlp_h7 up_h7 up_h7 vdd vdd PNR W=3000u L=100u
Mln_h7 un_h7 un_h7 vdd vdd PNR W=3000u L=100u
Vbnh7 bnh7 0 0.3000
Xn_h7 up_h7 un_h7 ap_h7 an_h7 vdd bnh7 dneuron2
Vwp_i17 wp_i17 0 0.4063
Vwn_i17 wn_i17 0 0.3937
X_i17 a_xp1 a_xn1 up_h7 un_h7 wp_i17 wn_i17 vdd dsyn
Vwp_i27 wp_i27 0 0.3925
Vwn_i27 wn_i27 0 0.4075
X_i27 a_xp2 a_xn2 up_h7 un_h7 wp_i27 wn_i27 vdd dsyn
Vwp_bk7 wp_bk7 0 0.3000
Vwn_bk7 wn_bk7 0 0.5007
X_bk7 up_o un_o up_h7 un_h7 wp_bk7 wn_bk7 vdd dsyn
Vwp_bh7 wp_bh7 0 0.3785
Vwn_bh7 wn_bh7 0 0.4215
X_bh7 bp_hi bp_lo up_h7 un_h7 wp_bh7 wn_bh7 vdd dsyn
Mlp_h8 up_h8 up_h8 vdd vdd PNR W=3000u L=100u
Mln_h8 un_h8 un_h8 vdd vdd PNR W=3000u L=100u
Vbnh8 bnh8 0 0.3000
Xn_h8 up_h8 un_h8 ap_h8 an_h8 vdd bnh8 dneuron2
Vwp_i18 wp_i18 0 0.3981
Vwn_i18 wn_i18 0 0.4019
X_i18 a_xp1 a_xn1 up_h8 un_h8 wp_i18 wn_i18 vdd dsyn
Vwp_i28 wp_i28 0 0.4045
Vwn_i28 wn_i28 0 0.3955
X_i28 a_xp2 a_xn2 up_h8 un_h8 wp_i28 wn_i28 vdd dsyn
Vwp_bk8 wp_bk8 0 0.3388
Vwn_bk8 wn_bk8 0 0.4612
X_bk8 up_o un_o up_h8 un_h8 wp_bk8 wn_bk8 vdd dsyn
Vwp_bh8 wp_bh8 0 0.3809
Vwn_bh8 wn_bh8 0 0.4191
X_bh8 bp_hi bp_lo up_h8 un_h8 wp_bh8 wn_bh8 vdd dsyn
Mlp_o up_o up_o vdd vdd PNR W=3000u L=100u
Mln_o un_o un_o vdd vdd PNR W=3000u L=100u
Vwp_fo1 wp_fo1 0 0.3890
Vwn_fo1 wn_fo1 0 0.4110
X_fo1 ap_h1 an_h1 up_o un_o wp_fo1 wn_fo1 vdd dsyn
Vwp_fo2 wp_fo2 0 0.4024
Vwn_fo2 wn_fo2 0 0.3976
X_fo2 ap_h2 an_h2 up_o un_o wp_fo2 wn_fo2 vdd dsyn
Vwp_fo3 wp_fo3 0 0.4196
Vwn_fo3 wn_fo3 0 0.3804
X_fo3 ap_h3 an_h3 up_o un_o wp_fo3 wn_fo3 vdd dsyn
Vwp_fo4 wp_fo4 0 0.3988
Vwn_fo4 wn_fo4 0 0.4012
X_fo4 ap_h4 an_h4 up_o un_o wp_fo4 wn_fo4 vdd dsyn
Vwp_fo5 wp_fo5 0 0.3240
Vwn_fo5 wn_fo5 0 0.4760
X_fo5 ap_h5 an_h5 up_o un_o wp_fo5 wn_fo5 vdd dsyn
Vwp_fo6 wp_fo6 0 0.3493
Vwn_fo6 wn_fo6 0 0.4507
X_fo6 ap_h6 an_h6 up_o un_o wp_fo6 wn_fo6 vdd dsyn
Vwp_fo7 wp_fo7 0 0.3000
Vwn_fo7 wn_fo7 0 0.5007
X_fo7 ap_h7 an_h7 up_o un_o wp_fo7 wn_fo7 vdd dsyn
Vwp_fo8 wp_fo8 0 0.3388
Vwn_fo8 wn_fo8 0 0.4612
X_fo8 ap_h8 an_h8 up_o un_o wp_fo8 wn_fo8 vdd dsyn
Vwp_bo_ wp_bo_ 0 0.3991
Vwn_bo_ wn_bo_ 0 0.4009
X_bo_ bp_hi bp_lo up_o un_o wp_bo_ wn_bo_ vdd dsyn
Rbp up_o vtp 1e10
Rbn un_o vtn 1e10
.control
alter Vaxp1 0.2
alter Vaxn1 0.8
alter Vaxp2 0.2
alter Vaxn2 0.8
alter Rbp 1e10
alter Rbn 1e10
op
wrdata gfns4_7_0.dat v(ap_h1) v(an_h1) v(ap_h2) v(an_h2) v(ap_h3) v(an_h3) v(ap_h4) v(an_h4) v(ap_h5) v(an_h5) v(ap_h6) v(an_h6) v(ap_h7) v(an_h7) v(ap_h8) v(an_h8) v(up_o) v(un_o)
alter Vtp 0.4
alter Vtn 0.6
alter Rbp 200000.0
alter Rbn 200000.0
op
wrdata gnns4_7_0.dat v(ap_h1) v(an_h1) v(ap_h2) v(an_h2) v(ap_h3) v(an_h3) v(ap_h4) v(an_h4) v(ap_h5) v(an_h5) v(ap_h6) v(an_h6) v(ap_h7) v(an_h7) v(ap_h8) v(an_h8) v(up_o) v(un_o)
alter Vaxp1 0.2
alter Vaxn1 0.8
alter Vaxp2 0.8
alter Vaxn2 0.2
alter Rbp 1e10
alter Rbn 1e10
op
wrdata gfns4_7_1.dat v(ap_h1) v(an_h1) v(ap_h2) v(an_h2) v(ap_h3) v(an_h3) v(ap_h4) v(an_h4) v(ap_h5) v(an_h5) v(ap_h6) v(an_h6) v(ap_h7) v(an_h7) v(ap_h8) v(an_h8) v(up_o) v(un_o)
alter Vtp 0.6
alter Vtn 0.4
alter Rbp 200000.0
alter Rbn 200000.0
op
wrdata gnns4_7_1.dat v(ap_h1) v(an_h1) v(ap_h2) v(an_h2) v(ap_h3) v(an_h3) v(ap_h4) v(an_h4) v(ap_h5) v(an_h5) v(ap_h6) v(an_h6) v(ap_h7) v(an_h7) v(ap_h8) v(an_h8) v(up_o) v(un_o)
alter Vaxp1 0.8
alter Vaxn1 0.2
alter Vaxp2 0.2
alter Vaxn2 0.8
alter Rbp 1e10
alter Rbn 1e10
op
wrdata gfns4_7_2.dat v(ap_h1) v(an_h1) v(ap_h2) v(an_h2) v(ap_h3) v(an_h3) v(ap_h4) v(an_h4) v(ap_h5) v(an_h5) v(ap_h6) v(an_h6) v(ap_h7) v(an_h7) v(ap_h8) v(an_h8) v(up_o) v(un_o)
alter Vtp 0.6
alter Vtn 0.4
alter Rbp 200000.0
alter Rbn 200000.0
op
wrdata gnns4_7_2.dat v(ap_h1) v(an_h1) v(ap_h2) v(an_h2) v(ap_h3) v(an_h3) v(ap_h4) v(an_h4) v(ap_h5) v(an_h5) v(ap_h6) v(an_h6) v(ap_h7) v(an_h7) v(ap_h8) v(an_h8) v(up_o) v(un_o)
alter Vaxp1 0.8
alter Vaxn1 0.2
alter Vaxp2 0.8
alter Vaxn2 0.2
alter Rbp 1e10
alter Rbn 1e10
op
wrdata gfns4_7_3.dat v(ap_h1) v(an_h1) v(ap_h2) v(an_h2) v(ap_h3) v(an_h3) v(ap_h4) v(an_h4) v(ap_h5) v(an_h5) v(ap_h6) v(an_h6) v(ap_h7) v(an_h7) v(ap_h8) v(an_h8) v(up_o) v(un_o)
alter Vtp 0.4
alter Vtn 0.6
alter Rbp 200000.0
alter Rbn 200000.0
op
wrdata gnns4_7_3.dat v(ap_h1) v(an_h1) v(ap_h2) v(an_h2) v(ap_h3) v(an_h3) v(ap_h4) v(an_h4) v(ap_h5) v(an_h5) v(ap_h6) v(an_h6) v(ap_h7) v(an_h7) v(ap_h8) v(an_h8) v(up_o) v(un_o)
.endc
.end
