physical EP update cell bank
.model NNR NMOS (LEVEL=1 VTO=0.2  KP=120u LAMBDA=0.02 GAMMA=0 PHI=0.7)
.model PNR PMOS (LEVEL=1 VTO=-0.2 KP=40u  LAMBDA=0.02 GAMMA=0 PHI=0.7)
.subckt gupd3 xp xn yp yn wp wn psig psigb vdd vbn
Mtail nt vbn 0 0 NNR W=400u L=100u
M5 na yp nt 0 NNR W=200u L=100u
M6 nb yn nt 0 NNR W=200u L=100u
M1 iop xp na 0 NNR W=200u L=100u
M2 ion xn na 0 NNR W=200u L=100u
M3 ion xp nb 0 NNR W=200u L=100u
M4 iop xn nb 0 NNR W=200u L=100u
Mlp iop iop vdd vdd PNR W=200u L=100u
Mln ion ion vdd vdd PNR W=200u L=100u
Mpu_A nA iop vdd vdd PNR W=200u L=100u
MpRn nrn ion vdd vdd PNR W=200u L=100u
MnRn nrn nrn 0 0 NNR W=200u L=100u
Mpd_A nA nrn 0 0 NNR W=200u L=100u
Mpu_B nB ion vdd vdd PNR W=200u L=100u
MpRp nrp iop vdd vdd PNR W=200u L=100u
MnRp nrp nrp 0 0 NNR W=200u L=100u
Mpd_B nB nrp 0 0 NNR W=200u L=100u
Msw1 nA psigb wp 0 NNR W=400u L=100u
Msw2 nB psigb wn 0 NNR W=400u L=100u
Msw3 nA psig  wn 0 NNR W=400u L=100u
Msw4 nB psig  wp 0 NNR W=400u L=100u
.ends
Vdd vdd 0 1.0
Vgbn gbn 0 0.95
Vvsref vsref 0 0.0500
Vpsig psig 0 PWL(0.0n 0.0 799.5n 0.0 800.5n 2.0 1599.5n 2.0 1600.5n 0.0 2399.5n 0.0 2400.5n 2.0 3199.5n 2.0 3200.5n 0.0 3999.5n 0.0 4000.5n 2.0 4799.5n 2.0 4800.5n 0.0 5599.5n 0.0 5600.5n 2.0 6399.5n 2.0 6400.5n 0.0)
Vpsigb psigb 0 PWL(0.0n 2.0 799.5n 2.0 800.5n 0.0 1599.5n 0.0 1600.5n 2.0 2399.5n 2.0 2400.5n 0.0 3199.5n 0.0 3200.5n 2.0 3999.5n 2.0 4000.5n 0.0 4799.5n 0.0 4800.5n 2.0 5599.5n 2.0 5600.5n 0.0 6399.5n 0.0 6400.5n 2.0)
Cwp_w11 wp_w11 0 200p
Cwn_w11 wn_w11 0 200p
Rcp_w11 wp_w11 cm_w11 2g
Rcn_w11 wn_w11 cm_w11 2g
Msp_w11 wp_w11 cm_w11 0 0 NNR W=4u L=100u
Msn_w11 wn_w11 cm_w11 0 0 NNR W=4u L=100u
Vxp_w11 xp_w11 0 PWL(0.0n 0.2000 799.5n 0.2000 800.5n 0.2000 1600.0n 0.2000 1600.0n 0.2000 2399.5n 0.2000 2400.5n 0.2000 3200.0n 0.2000 3200.0n 0.8000 3999.5n 0.8000 4000.5n 0.8000 4800.0n 0.8000 4800.0n 0.8000 5599.5n 0.8000 5600.5n 0.8000 6400.0n 0.8000)
Vxn_w11 xn_w11 0 PWL(0.0n 0.8000 799.5n 0.8000 800.5n 0.8000 1600.0n 0.8000 1600.0n 0.8000 2399.5n 0.8000 2400.5n 0.8000 3200.0n 0.8000 3200.0n 0.2000 3999.5n 0.2000 4000.5n 0.2000 4800.0n 0.2000 4800.0n 0.2000 5599.5n 0.2000 5600.5n 0.2000 6400.0n 0.2000)
Vyp_w11 yp_w11 0 PWL(0.0n 0.3626 799.5n 0.3626 800.5n 0.3627 1600.0n 0.3627 1600.0n 0.2462 2399.5n 0.2462 2400.5n 0.2461 3200.0n 0.2461 3200.0n 0.4048 3999.5n 0.4048 4000.5n 0.4049 4800.0n 0.4049 4800.0n 0.2582 5599.5n 0.2582 5600.5n 0.2582 6400.0n 0.2582)
Vyn_w11 yn_w11 0 PWL(0.0n 0.6374 799.5n 0.6374 800.5n 0.6373 1600.0n 0.6373 1600.0n 0.7538 2399.5n 0.7538 2400.5n 0.7539 3200.0n 0.7539 3200.0n 0.5952 3999.5n 0.5952 4000.5n 0.5951 4800.0n 0.5951 4800.0n 0.7418 5599.5n 0.7418 5600.5n 0.7418 6400.0n 0.7418)
Xu_w11 xp_w11 xn_w11 yp_w11 yn_w11 wp_w11 wn_w11 psig psigb vdd gbn gupd3
Cwp_w21 wp_w21 0 200p
Cwn_w21 wn_w21 0 200p
Rcp_w21 wp_w21 cm_w21 2g
Rcn_w21 wn_w21 cm_w21 2g
Msp_w21 wp_w21 cm_w21 0 0 NNR W=4u L=100u
Msn_w21 wn_w21 cm_w21 0 0 NNR W=4u L=100u
Vxp_w21 xp_w21 0 PWL(0.0n 0.2000 799.5n 0.2000 800.5n 0.2000 1600.0n 0.2000 1600.0n 0.8000 2399.5n 0.8000 2400.5n 0.8000 3200.0n 0.8000 3200.0n 0.2000 3999.5n 0.2000 4000.5n 0.2000 4800.0n 0.2000 4800.0n 0.8000 5599.5n 0.8000 5600.5n 0.8000 6400.0n 0.8000)
Vxn_w21 xn_w21 0 PWL(0.0n 0.8000 799.5n 0.8000 800.5n 0.8000 1600.0n 0.8000 1600.0n 0.2000 2399.5n 0.2000 2400.5n 0.2000 3200.0n 0.2000 3200.0n 0.8000 3999.5n 0.8000 4000.5n 0.8000 4800.0n 0.8000 4800.0n 0.2000 5599.5n 0.2000 5600.5n 0.2000 6400.0n 0.2000)
Vyp_w21 yp_w21 0 PWL(0.0n 0.3626 799.5n 0.3626 800.5n 0.3627 1600.0n 0.3627 1600.0n 0.2462 2399.5n 0.2462 2400.5n 0.2461 3200.0n 0.2461 3200.0n 0.4048 3999.5n 0.4048 4000.5n 0.4049 4800.0n 0.4049 4800.0n 0.2582 5599.5n 0.2582 5600.5n 0.2582 6400.0n 0.2582)
Vyn_w21 yn_w21 0 PWL(0.0n 0.6374 799.5n 0.6374 800.5n 0.6373 1600.0n 0.6373 1600.0n 0.7538 2399.5n 0.7538 2400.5n 0.7539 3200.0n 0.7539 3200.0n 0.5952 3999.5n 0.5952 4000.5n 0.5951 4800.0n 0.5951 4800.0n 0.7418 5599.5n 0.7418 5600.5n 0.7418 6400.0n 0.7418)
Xu_w21 xp_w21 xn_w21 yp_w21 yn_w21 wp_w21 wn_w21 psig psigb vdd gbn gupd3
Cwp_o1 wp_o1 0 200p
Cwn_o1 wn_o1 0 200p
Rcp_o1 wp_o1 cm_o1 2g
Rcn_o1 wn_o1 cm_o1 2g
Msp_o1 wp_o1 cm_o1 0 0 NNR W=4u L=100u
Msn_o1 wn_o1 cm_o1 0 0 NNR W=4u L=100u
Vxp_o1 xp_o1 0 PWL(0.0n 0.3626 799.5n 0.3626 800.5n 0.3627 1600.0n 0.3627 1600.0n 0.2462 2399.5n 0.2462 2400.5n 0.2461 3200.0n 0.2461 3200.0n 0.4048 3999.5n 0.4048 4000.5n 0.4049 4800.0n 0.4049 4800.0n 0.2582 5599.5n 0.2582 5600.5n 0.2582 6400.0n 0.2582)
Vxn_o1 xn_o1 0 PWL(0.0n 0.6374 799.5n 0.6374 800.5n 0.6373 1600.0n 0.6373 1600.0n 0.7538 2399.5n 0.7538 2400.5n 0.7539 3200.0n 0.7539 3200.0n 0.5952 3999.5n 0.5952 4000.5n 0.5951 4800.0n 0.5951 4800.0n 0.7418 5599.5n 0.7418 5600.5n 0.7418 6400.0n 0.7418)
Vyp_o1 yp_o1 0 PWL(0.0n 0.5072 799.5n 0.5072 800.5n 0.5065 1600.0n 0.5065 1600.0n 0.5022 2399.5n 0.5022 2400.5n 0.5029 3200.0n 0.5029 3200.0n 0.5032 3999.5n 0.5032 4000.5n 0.5039 4800.0n 0.5039 4800.0n 0.4956 5599.5n 0.4956 5600.5n 0.4949 6400.0n 0.4949)
Vyn_o1 yn_o1 0 PWL(0.0n 0.4928 799.5n 0.4928 800.5n 0.4935 1600.0n 0.4935 1600.0n 0.4978 2399.5n 0.4978 2400.5n 0.4971 3200.0n 0.4971 3200.0n 0.4968 3999.5n 0.4968 4000.5n 0.4961 4800.0n 0.4961 4800.0n 0.5044 5599.5n 0.5044 5600.5n 0.5051 6400.0n 0.5051)
Xu_o1 xp_o1 xn_o1 yp_o1 yn_o1 wp_o1 wn_o1 psig psigb vdd gbn gupd3
Cwp_bh1 wp_bh1 0 200p
Cwn_bh1 wn_bh1 0 200p
Rcp_bh1 wp_bh1 cm_bh1 2g
Rcn_bh1 wn_bh1 cm_bh1 2g
Msp_bh1 wp_bh1 cm_bh1 0 0 NNR W=4u L=100u
Msn_bh1 wn_bh1 cm_bh1 0 0 NNR W=4u L=100u
Vxp_bh1 xp_bh1 0 PWL(0.0n 0.8000 799.5n 0.8000 800.5n 0.8000 1600.0n 0.8000 1600.0n 0.8000 2399.5n 0.8000 2400.5n 0.8000 3200.0n 0.8000 3200.0n 0.8000 3999.5n 0.8000 4000.5n 0.8000 4800.0n 0.8000 4800.0n 0.8000 5599.5n 0.8000 5600.5n 0.8000 6400.0n 0.8000)
Vxn_bh1 xn_bh1 0 PWL(0.0n 0.2000 799.5n 0.2000 800.5n 0.2000 1600.0n 0.2000 1600.0n 0.2000 2399.5n 0.2000 2400.5n 0.2000 3200.0n 0.2000 3200.0n 0.2000 3999.5n 0.2000 4000.5n 0.2000 4800.0n 0.2000 4800.0n 0.2000 5599.5n 0.2000 5600.5n 0.2000 6400.0n 0.2000)
Vyp_bh1 yp_bh1 0 PWL(0.0n 0.3626 799.5n 0.3626 800.5n 0.3627 1600.0n 0.3627 1600.0n 0.2462 2399.5n 0.2462 2400.5n 0.2461 3200.0n 0.2461 3200.0n 0.4048 3999.5n 0.4048 4000.5n 0.4049 4800.0n 0.4049 4800.0n 0.2582 5599.5n 0.2582 5600.5n 0.2582 6400.0n 0.2582)
Vyn_bh1 yn_bh1 0 PWL(0.0n 0.6374 799.5n 0.6374 800.5n 0.6373 1600.0n 0.6373 1600.0n 0.7538 2399.5n 0.7538 2400.5n 0.7539 3200.0n 0.7539 3200.0n 0.5952 3999.5n 0.5952 4000.5n 0.5951 4800.0n 0.5951 4800.0n 0.7418 5599.5n 0.7418 5600.5n 0.7418 6400.0n 0.7418)
Xu_bh1 xp_bh1 xn_bh1 yp_bh1 yn_bh1 wp_bh1 wn_bh1 psig psigb vdd gbn gupd3
Cwp_w12 wp_w12 0 200p
Cwn_w12 wn_w12 0 200p
Rcp_w12 wp_w12 cm_w12 2g
Rcn_w12 wn_w12 cm_w12 2g
Msp_w12 wp_w12 cm_w12 0 0 NNR W=4u L=100u
Msn_w12 wn_w12 cm_w12 0 0 NNR W=4u L=100u
Vxp_w12 xp_w12 0 PWL(0.0n 0.2000 799.5n 0.2000 800.5n 0.2000 1600.0n 0.2000 1600.0n 0.2000 2399.5n 0.2000 2400.5n 0.2000 3200.0n 0.2000 3200.0n 0.8000 3999.5n 0.8000 4000.5n 0.8000 4800.0n 0.8000 4800.0n 0.8000 5599.5n 0.8000 5600.5n 0.8000 6400.0n 0.8000)
Vxn_w12 xn_w12 0 PWL(0.0n 0.8000 799.5n 0.8000 800.5n 0.8000 1600.0n 0.8000 1600.0n 0.8000 2399.5n 0.8000 2400.5n 0.8000 3200.0n 0.8000 3200.0n 0.2000 3999.5n 0.2000 4000.5n 0.2000 4800.0n 0.2000 4800.0n 0.2000 5599.5n 0.2000 5600.5n 0.2000 6400.0n 0.2000)
Vyp_w12 yp_w12 0 PWL(0.0n 0.7399 799.5n 0.7399 800.5n 0.7398 1600.0n 0.7398 1600.0n 0.4475 2399.5n 0.4475 2400.5n 0.4477 3200.0n 0.4477 3200.0n 0.5942 3999.5n 0.5942 4000.5n 0.5942 4800.0n 0.5942 4800.0n 0.2894 5599.5n 0.2894 5600.5n 0.2895 6400.0n 0.2895)
Vyn_w12 yn_w12 0 PWL(0.0n 0.2601 799.5n 0.2601 800.5n 0.2602 1600.0n 0.2602 1600.0n 0.5525 2399.5n 0.5525 2400.5n 0.5523 3200.0n 0.5523 3200.0n 0.4058 3999.5n 0.4058 4000.5n 0.4058 4800.0n 0.4058 4800.0n 0.7106 5599.5n 0.7106 5600.5n 0.7105 6400.0n 0.7105)
Xu_w12 xp_w12 xn_w12 yp_w12 yn_w12 wp_w12 wn_w12 psig psigb vdd gbn gupd3
Cwp_w22 wp_w22 0 200p
Cwn_w22 wn_w22 0 200p
Rcp_w22 wp_w22 cm_w22 2g
Rcn_w22 wn_w22 cm_w22 2g
Msp_w22 wp_w22 cm_w22 0 0 NNR W=4u L=100u
Msn_w22 wn_w22 cm_w22 0 0 NNR W=4u L=100u
Vxp_w22 xp_w22 0 PWL(0.0n 0.2000 799.5n 0.2000 800.5n 0.2000 1600.0n 0.2000 1600.0n 0.8000 2399.5n 0.8000 2400.5n 0.8000 3200.0n 0.8000 3200.0n 0.2000 3999.5n 0.2000 4000.5n 0.2000 4800.0n 0.2000 4800.0n 0.8000 5599.5n 0.8000 5600.5n 0.8000 6400.0n 0.8000)
Vxn_w22 xn_w22 0 PWL(0.0n 0.8000 799.5n 0.8000 800.5n 0.8000 1600.0n 0.8000 1600.0n 0.2000 2399.5n 0.2000 2400.5n 0.2000 3200.0n 0.2000 3200.0n 0.8000 3999.5n 0.8000 4000.5n 0.8000 4800.0n 0.8000 4800.0n 0.2000 5599.5n 0.2000 5600.5n 0.2000 6400.0n 0.2000)
Vyp_w22 yp_w22 0 PWL(0.0n 0.7399 799.5n 0.7399 800.5n 0.7398 1600.0n 0.7398 1600.0n 0.4475 2399.5n 0.4475 2400.5n 0.4477 3200.0n 0.4477 3200.0n 0.5942 3999.5n 0.5942 4000.5n 0.5942 4800.0n 0.5942 4800.0n 0.2894 5599.5n 0.2894 5600.5n 0.2895 6400.0n 0.2895)
Vyn_w22 yn_w22 0 PWL(0.0n 0.2601 799.5n 0.2601 800.5n 0.2602 1600.0n 0.2602 1600.0n 0.5525 2399.5n 0.5525 2400.5n 0.5523 3200.0n 0.5523 3200.0n 0.4058 3999.5n 0.4058 4000.5n 0.4058 4800.0n 0.4058 4800.0n 0.7106 5599.5n 0.7106 5600.5n 0.7105 6400.0n 0.7105)
Xu_w22 xp_w22 xn_w22 yp_w22 yn_w22 wp_w22 wn_w22 psig psigb vdd gbn gupd3
Cwp_o2 wp_o2 0 200p
Cwn_o2 wn_o2 0 200p
Rcp_o2 wp_o2 cm_o2 2g
Rcn_o2 wn_o2 cm_o2 2g
Msp_o2 wp_o2 cm_o2 0 0 NNR W=4u L=100u
Msn_o2 wn_o2 cm_o2 0 0 NNR W=4u L=100u
Vxp_o2 xp_o2 0 PWL(0.0n 0.7399 799.5n 0.7399 800.5n 0.7398 1600.0n 0.7398 1600.0n 0.4475 2399.5n 0.4475 2400.5n 0.4477 3200.0n 0.4477 3200.0n 0.5942 3999.5n 0.5942 4000.5n 0.5942 4800.0n 0.5942 4800.0n 0.2894 5599.5n 0.2894 5600.5n 0.2895 6400.0n 0.2895)
Vxn_o2 xn_o2 0 PWL(0.0n 0.2601 799.5n 0.2601 800.5n 0.2602 1600.0n 0.2602 1600.0n 0.5525 2399.5n 0.5525 2400.5n 0.5523 3200.0n 0.5523 3200.0n 0.4058 3999.5n 0.4058 4000.5n 0.4058 4800.0n 0.4058 4800.0n 0.7106 5599.5n 0.7106 5600.5n 0.7105 6400.0n 0.7105)
Vyp_o2 yp_o2 0 PWL(0.0n 0.5072 799.5n 0.5072 800.5n 0.5065 1600.0n 0.5065 1600.0n 0.5022 2399.5n 0.5022 2400.5n 0.5029 3200.0n 0.5029 3200.0n 0.5032 3999.5n 0.5032 4000.5n 0.5039 4800.0n 0.5039 4800.0n 0.4956 5599.5n 0.4956 5600.5n 0.4949 6400.0n 0.4949)
Vyn_o2 yn_o2 0 PWL(0.0n 0.4928 799.5n 0.4928 800.5n 0.4935 1600.0n 0.4935 1600.0n 0.4978 2399.5n 0.4978 2400.5n 0.4971 3200.0n 0.4971 3200.0n 0.4968 3999.5n 0.4968 4000.5n 0.4961 4800.0n 0.4961 4800.0n 0.5044 5599.5n 0.5044 5600.5n 0.5051 6400.0n 0.5051)
Xu_o2 xp_o2 xn_o2 yp_o2 yn_o2 wp_o2 wn_o2 psig psigb vdd gbn gupd3
Cwp_bh2 wp_bh2 0 200p
Cwn_bh2 wn_bh2 0 200p
Rcp_bh2 wp_bh2 cm_bh2 2g
Rcn_bh2 wn_bh2 cm_bh2 2g
Msp_bh2 wp_bh2 cm_bh2 0 0 NNR W=4u L=100u
Msn_bh2 wn_bh2 cm_bh2 0 0 NNR W=4u L=100u
Vxp_bh2 xp_bh2 0 PWL(0.0n 0.8000 799.5n 0.8000 800.5n 0.8000 1600.0n 0.8000 1600.0n 0.8000 2399.5n 0.8000 2400.5n 0.8000 3200.0n 0.8000 3200.0n 0.8000 3999.5n 0.8000 4000.5n 0.8000 4800.0n 0.8000 4800.0n 0.8000 5599.5n 0.8000 5600.5n 0.8000 6400.0n 0.8000)
Vxn_bh2 xn_bh2 0 PWL(0.0n 0.2000 799.5n 0.2000 800.5n 0.2000 1600.0n 0.2000 1600.0n 0.2000 2399.5n 0.2000 2400.5n 0.2000 3200.0n 0.2000 3200.0n 0.2000 3999.5n 0.2000 4000.5n 0.2000 4800.0n 0.2000 4800.0n 0.2000 5599.5n 0.2000 5600.5n 0.2000 6400.0n 0.2000)
Vyp_bh2 yp_bh2 0 PWL(0.0n 0.7399 799.5n 0.7399 800.5n 0.7398 1600.0n 0.7398 1600.0n 0.4475 2399.5n 0.4475 2400.5n 0.4477 3200.0n 0.4477 3200.0n 0.5942 3999.5n 0.5942 4000.5n 0.5942 4800.0n 0.5942 4800.0n 0.2894 5599.5n 0.2894 5600.5n 0.2895 6400.0n 0.2895)
Vyn_bh2 yn_bh2 0 PWL(0.0n 0.2601 799.5n 0.2601 800.5n 0.2602 1600.0n 0.2602 1600.0n 0.5525 2399.5n 0.5525 2400.5n 0.5523 3200.0n 0.5523 3200.0n 0.4058 3999.5n 0.4058 4000.5n 0.4058 4800.0n 0.4058 4800.0n 0.7106 5599.5n 0.7106 5600.5n 0.7105 6400.0n 0.7105)
Xu_bh2 xp_bh2 xn_bh2 yp_bh2 yn_bh2 wp_bh2 wn_bh2 psig psigb vdd gbn gupd3
Cwp_w13 wp_w13 0 200p
Cwn_w13 wn_w13 0 200p
Rcp_w13 wp_w13 cm_w13 2g
Rcn_w13 wn_w13 cm_w13 2g
Msp_w13 wp_w13 cm_w13 0 0 NNR W=4u L=100u
Msn_w13 wn_w13 cm_w13 0 0 NNR W=4u L=100u
Vxp_w13 xp_w13 0 PWL(0.0n 0.2000 799.5n 0.2000 800.5n 0.2000 1600.0n 0.2000 1600.0n 0.2000 2399.5n 0.2000 2400.5n 0.2000 3200.0n 0.2000 3200.0n 0.8000 3999.5n 0.8000 4000.5n 0.8000 4800.0n 0.8000 4800.0n 0.8000 5599.5n 0.8000 5600.5n 0.8000 6400.0n 0.8000)
Vxn_w13 xn_w13 0 PWL(0.0n 0.8000 799.5n 0.8000 800.5n 0.8000 1600.0n 0.8000 1600.0n 0.8000 2399.5n 0.8000 2400.5n 0.8000 3200.0n 0.8000 3200.0n 0.2000 3999.5n 0.2000 4000.5n 0.2000 4800.0n 0.2000 4800.0n 0.2000 5599.5n 0.2000 5600.5n 0.2000 6400.0n 0.2000)
Vyp_w13 yp_w13 0 PWL(0.0n 0.6141 799.5n 0.6141 800.5n 0.6141 1600.0n 0.6141 1600.0n 0.2789 2399.5n 0.2789 2400.5n 0.2791 3200.0n 0.2791 3200.0n 0.7507 3999.5n 0.7507 4000.5n 0.7508 4800.0n 0.7508 4800.0n 0.4514 5599.5n 0.4514 5600.5n 0.4514 6400.0n 0.4514)
Vyn_w13 yn_w13 0 PWL(0.0n 0.3859 799.5n 0.3859 800.5n 0.3859 1600.0n 0.3859 1600.0n 0.7211 2399.5n 0.7211 2400.5n 0.7209 3200.0n 0.7209 3200.0n 0.2493 3999.5n 0.2493 4000.5n 0.2492 4800.0n 0.2492 4800.0n 0.5486 5599.5n 0.5486 5600.5n 0.5486 6400.0n 0.5486)
Xu_w13 xp_w13 xn_w13 yp_w13 yn_w13 wp_w13 wn_w13 psig psigb vdd gbn gupd3
Cwp_w23 wp_w23 0 200p
Cwn_w23 wn_w23 0 200p
Rcp_w23 wp_w23 cm_w23 2g
Rcn_w23 wn_w23 cm_w23 2g
Msp_w23 wp_w23 cm_w23 0 0 NNR W=4u L=100u
Msn_w23 wn_w23 cm_w23 0 0 NNR W=4u L=100u
Vxp_w23 xp_w23 0 PWL(0.0n 0.2000 799.5n 0.2000 800.5n 0.2000 1600.0n 0.2000 1600.0n 0.8000 2399.5n 0.8000 2400.5n 0.8000 3200.0n 0.8000 3200.0n 0.2000 3999.5n 0.2000 4000.5n 0.2000 4800.0n 0.2000 4800.0n 0.8000 5599.5n 0.8000 5600.5n 0.8000 6400.0n 0.8000)
Vxn_w23 xn_w23 0 PWL(0.0n 0.8000 799.5n 0.8000 800.5n 0.8000 1600.0n 0.8000 1600.0n 0.2000 2399.5n 0.2000 2400.5n 0.2000 3200.0n 0.2000 3200.0n 0.8000 3999.5n 0.8000 4000.5n 0.8000 4800.0n 0.8000 4800.0n 0.2000 5599.5n 0.2000 5600.5n 0.2000 6400.0n 0.2000)
Vyp_w23 yp_w23 0 PWL(0.0n 0.6141 799.5n 0.6141 800.5n 0.6141 1600.0n 0.6141 1600.0n 0.2789 2399.5n 0.2789 2400.5n 0.2791 3200.0n 0.2791 3200.0n 0.7507 3999.5n 0.7507 4000.5n 0.7508 4800.0n 0.7508 4800.0n 0.4514 5599.5n 0.4514 5600.5n 0.4514 6400.0n 0.4514)
Vyn_w23 yn_w23 0 PWL(0.0n 0.3859 799.5n 0.3859 800.5n 0.3859 1600.0n 0.3859 1600.0n 0.7211 2399.5n 0.7211 2400.5n 0.7209 3200.0n 0.7209 3200.0n 0.2493 3999.5n 0.2493 4000.5n 0.2492 4800.0n 0.2492 4800.0n 0.5486 5599.5n 0.5486 5600.5n 0.5486 6400.0n 0.5486)
Xu_w23 xp_w23 xn_w23 yp_w23 yn_w23 wp_w23 wn_w23 psig psigb vdd gbn gupd3
Cwp_o3 wp_o3 0 200p
Cwn_o3 wn_o3 0 200p
Rcp_o3 wp_o3 cm_o3 2g
Rcn_o3 wn_o3 cm_o3 2g
Msp_o3 wp_o3 cm_o3 0 0 NNR W=4u L=100u
Msn_o3 wn_o3 cm_o3 0 0 NNR W=4u L=100u
Vxp_o3 xp_o3 0 PWL(0.0n 0.6141 799.5n 0.6141 800.5n 0.6141 1600.0n 0.6141 1600.0n 0.2789 2399.5n 0.2789 2400.5n 0.2791 3200.0n 0.2791 3200.0n 0.7507 3999.5n 0.7507 4000.5n 0.7508 4800.0n 0.7508 4800.0n 0.4514 5599.5n 0.4514 5600.5n 0.4514 6400.0n 0.4514)
Vxn_o3 xn_o3 0 PWL(0.0n 0.3859 799.5n 0.3859 800.5n 0.3859 1600.0n 0.3859 1600.0n 0.7211 2399.5n 0.7211 2400.5n 0.7209 3200.0n 0.7209 3200.0n 0.2493 3999.5n 0.2493 4000.5n 0.2492 4800.0n 0.2492 4800.0n 0.5486 5599.5n 0.5486 5600.5n 0.5486 6400.0n 0.5486)
Vyp_o3 yp_o3 0 PWL(0.0n 0.5072 799.5n 0.5072 800.5n 0.5065 1600.0n 0.5065 1600.0n 0.5022 2399.5n 0.5022 2400.5n 0.5029 3200.0n 0.5029 3200.0n 0.5032 3999.5n 0.5032 4000.5n 0.5039 4800.0n 0.5039 4800.0n 0.4956 5599.5n 0.4956 5600.5n 0.4949 6400.0n 0.4949)
Vyn_o3 yn_o3 0 PWL(0.0n 0.4928 799.5n 0.4928 800.5n 0.4935 1600.0n 0.4935 1600.0n 0.4978 2399.5n 0.4978 2400.5n 0.4971 3200.0n 0.4971 3200.0n 0.4968 3999.5n 0.4968 4000.5n 0.4961 4800.0n 0.4961 4800.0n 0.5044 5599.5n 0.5044 5600.5n 0.5051 6400.0n 0.5051)
Xu_o3 xp_o3 xn_o3 yp_o3 yn_o3 wp_o3 wn_o3 psig psigb vdd gbn gupd3
Cwp_bh3 wp_bh3 0 200p
Cwn_bh3 wn_bh3 0 200p
Rcp_bh3 wp_bh3 cm_bh3 2g
Rcn_bh3 wn_bh3 cm_bh3 2g
Msp_bh3 wp_bh3 cm_bh3 0 0 NNR W=4u L=100u
Msn_bh3 wn_bh3 cm_bh3 0 0 NNR W=4u L=100u
Vxp_bh3 xp_bh3 0 PWL(0.0n 0.8000 799.5n 0.8000 800.5n 0.8000 1600.0n 0.8000 1600.0n 0.8000 2399.5n 0.8000 2400.5n 0.8000 3200.0n 0.8000 3200.0n 0.8000 3999.5n 0.8000 4000.5n 0.8000 4800.0n 0.8000 4800.0n 0.8000 5599.5n 0.8000 5600.5n 0.8000 6400.0n 0.8000)
Vxn_bh3 xn_bh3 0 PWL(0.0n 0.2000 799.5n 0.2000 800.5n 0.2000 1600.0n 0.2000 1600.0n 0.2000 2399.5n 0.2000 2400.5n 0.2000 3200.0n 0.2000 3200.0n 0.2000 3999.5n 0.2000 4000.5n 0.2000 4800.0n 0.2000 4800.0n 0.2000 5599.5n 0.2000 5600.5n 0.2000 6400.0n 0.2000)
Vyp_bh3 yp_bh3 0 PWL(0.0n 0.6141 799.5n 0.6141 800.5n 0.6141 1600.0n 0.6141 1600.0n 0.2789 2399.5n 0.2789 2400.5n 0.2791 3200.0n 0.2791 3200.0n 0.7507 3999.5n 0.7507 4000.5n 0.7508 4800.0n 0.7508 4800.0n 0.4514 5599.5n 0.4514 5600.5n 0.4514 6400.0n 0.4514)
Vyn_bh3 yn_bh3 0 PWL(0.0n 0.3859 799.5n 0.3859 800.5n 0.3859 1600.0n 0.3859 1600.0n 0.7211 2399.5n 0.7211 2400.5n 0.7209 3200.0n 0.7209 3200.0n 0.2493 3999.5n 0.2493 4000.5n 0.2492 4800.0n 0.2492 4800.0n 0.5486 5599.5n 0.5486 5600.5n 0.5486 6400.0n 0.5486)
Xu_bh3 xp_bh3 xn_bh3 yp_bh3 yn_bh3 wp_bh3 wn_bh3 psig psigb vdd gbn gupd3
Cwp_w14 wp_w14 0 200p
Cwn_w14 wn_w14 0 200p
Rcp_w14 wp_w14 cm_w14 2g
Rcn_w14 wn_w14 cm_w14 2g
Msp_w14 wp_w14 cm_w14 0 0 NNR W=4u L=100u
Msn_w14 wn_w14 cm_w14 0 0 NNR W=4u L=100u
Vxp_w14 xp_w14 0 PWL(0.0n 0.2000 799.5n 0.2000 800.5n 0.2000 1600.0n 0.2000 1600.0n 0.2000 2399.5n 0.2000 2400.5n 0.2000 3200.0n 0.2000 3200.0n 0.8000 3999.5n 0.8000 4000.5n 0.8000 4800.0n 0.8000 4800.0n 0.8000 5599.5n 0.8000 5600.5n 0.8000 6400.0n 0.8000)
Vxn_w14 xn_w14 0 PWL(0.0n 0.8000 799.5n 0.8000 800.5n 0.8000 1600.0n 0.8000 1600.0n 0.8000 2399.5n 0.8000 2400.5n 0.8000 3200.0n 0.8000 3200.0n 0.2000 3999.5n 0.2000 4000.5n 0.2000 4800.0n 0.2000 4800.0n 0.2000 5599.5n 0.2000 5600.5n 0.2000 6400.0n 0.2000)
Vyp_w14 yp_w14 0 PWL(0.0n 0.6047 799.5n 0.6047 800.5n 0.6046 1600.0n 0.6046 1600.0n 0.5012 2399.5n 0.5012 2400.5n 0.5012 3200.0n 0.5012 3200.0n 0.6976 3999.5n 0.6976 4000.5n 0.6975 4800.0n 0.6975 4800.0n 0.5970 5599.5n 0.5970 5600.5n 0.5969 6400.0n 0.5969)
Vyn_w14 yn_w14 0 PWL(0.0n 0.3953 799.5n 0.3953 800.5n 0.3954 1600.0n 0.3954 1600.0n 0.4988 2399.5n 0.4988 2400.5n 0.4988 3200.0n 0.4988 3200.0n 0.3024 3999.5n 0.3024 4000.5n 0.3025 4800.0n 0.3025 4800.0n 0.4030 5599.5n 0.4030 5600.5n 0.4031 6400.0n 0.4031)
Xu_w14 xp_w14 xn_w14 yp_w14 yn_w14 wp_w14 wn_w14 psig psigb vdd gbn gupd3
Cwp_w24 wp_w24 0 200p
Cwn_w24 wn_w24 0 200p
Rcp_w24 wp_w24 cm_w24 2g
Rcn_w24 wn_w24 cm_w24 2g
Msp_w24 wp_w24 cm_w24 0 0 NNR W=4u L=100u
Msn_w24 wn_w24 cm_w24 0 0 NNR W=4u L=100u
Vxp_w24 xp_w24 0 PWL(0.0n 0.2000 799.5n 0.2000 800.5n 0.2000 1600.0n 0.2000 1600.0n 0.8000 2399.5n 0.8000 2400.5n 0.8000 3200.0n 0.8000 3200.0n 0.2000 3999.5n 0.2000 4000.5n 0.2000 4800.0n 0.2000 4800.0n 0.8000 5599.5n 0.8000 5600.5n 0.8000 6400.0n 0.8000)
Vxn_w24 xn_w24 0 PWL(0.0n 0.8000 799.5n 0.8000 800.5n 0.8000 1600.0n 0.8000 1600.0n 0.2000 2399.5n 0.2000 2400.5n 0.2000 3200.0n 0.2000 3200.0n 0.8000 3999.5n 0.8000 4000.5n 0.8000 4800.0n 0.8000 4800.0n 0.2000 5599.5n 0.2000 5600.5n 0.2000 6400.0n 0.2000)
Vyp_w24 yp_w24 0 PWL(0.0n 0.6047 799.5n 0.6047 800.5n 0.6046 1600.0n 0.6046 1600.0n 0.5012 2399.5n 0.5012 2400.5n 0.5012 3200.0n 0.5012 3200.0n 0.6976 3999.5n 0.6976 4000.5n 0.6975 4800.0n 0.6975 4800.0n 0.5970 5599.5n 0.5970 5600.5n 0.5969 6400.0n 0.5969)
Vyn_w24 yn_w24 0 PWL(0.0n 0.3953 799.5n 0.3953 800.5n 0.3954 1600.0n 0.3954 1600.0n 0.4988 2399.5n 0.4988 2400.5n 0.4988 3200.0n 0.4988 3200.0n 0.3024 3999.5n 0.3024 4000.5n 0.3025 4800.0n 0.3025 4800.0n 0.4030 5599.5n 0.4030 5600.5n 0.4031 6400.0n 0.4031)
Xu_w24 xp_w24 xn_w24 yp_w24 yn_w24 wp_w24 wn_w24 psig psigb vdd gbn gupd3
Cwp_o4 wp_o4 0 200p
Cwn_o4 wn_o4 0 200p
Rcp_o4 wp_o4 cm_o4 2g
Rcn_o4 wn_o4 cm_o4 2g
Msp_o4 wp_o4 cm_o4 0 0 NNR W=4u L=100u
Msn_o4 wn_o4 cm_o4 0 0 NNR W=4u L=100u
Vxp_o4 xp_o4 0 PWL(0.0n 0.6047 799.5n 0.6047 800.5n 0.6046 1600.0n 0.6046 1600.0n 0.5012 2399.5n 0.5012 2400.5n 0.5012 3200.0n 0.5012 3200.0n 0.6976 3999.5n 0.6976 4000.5n 0.6975 4800.0n 0.6975 4800.0n 0.5970 5599.5n 0.5970 5600.5n 0.5969 6400.0n 0.5969)
Vxn_o4 xn_o4 0 PWL(0.0n 0.3953 799.5n 0.3953 800.5n 0.3954 1600.0n 0.3954 1600.0n 0.4988 2399.5n 0.4988 2400.5n 0.4988 3200.0n 0.4988 3200.0n 0.3024 3999.5n 0.3024 4000.5n 0.3025 4800.0n 0.3025 4800.0n 0.4030 5599.5n 0.4030 5600.5n 0.4031 6400.0n 0.4031)
Vyp_o4 yp_o4 0 PWL(0.0n 0.5072 799.5n 0.5072 800.5n 0.5065 1600.0n 0.5065 1600.0n 0.5022 2399.5n 0.5022 2400.5n 0.5029 3200.0n 0.5029 3200.0n 0.5032 3999.5n 0.5032 4000.5n 0.5039 4800.0n 0.5039 4800.0n 0.4956 5599.5n 0.4956 5600.5n 0.4949 6400.0n 0.4949)
Vyn_o4 yn_o4 0 PWL(0.0n 0.4928 799.5n 0.4928 800.5n 0.4935 1600.0n 0.4935 1600.0n 0.4978 2399.5n 0.4978 2400.5n 0.4971 3200.0n 0.4971 3200.0n 0.4968 3999.5n 0.4968 4000.5n 0.4961 4800.0n 0.4961 4800.0n 0.5044 5599.5n 0.5044 5600.5n 0.5051 6400.0n 0.5051)
Xu_o4 xp_o4 xn_o4 yp_o4 yn_o4 wp_o4 wn_o4 psig psigb vdd gbn gupd3
Cwp_bh4 wp_bh4 0 200p
Cwn_bh4 wn_bh4 0 200p
Rcp_bh4 wp_bh4 cm_bh4 2g
Rcn_bh4 wn_bh4 cm_bh4 2g
Msp_bh4 wp_bh4 cm_bh4 0 0 NNR W=4u L=100u
Msn_bh4 wn_bh4 cm_bh4 0 0 NNR W=4u L=100u
Vxp_bh4 xp_bh4 0 PWL(0.0n 0.8000 799.5n 0.8000 800.5n 0.8000 1600.0n 0.8000 1600.0n 0.8000 2399.5n 0.8000 2400.5n 0.8000 3200.0n 0.8000 3200.0n 0.8000 3999.5n 0.8000 4000.5n 0.8000 4800.0n 0.8000 4800.0n 0.8000 5599.5n 0.8000 5600.5n 0.8000 6400.0n 0.8000)
Vxn_bh4 xn_bh4 0 PWL(0.0n 0.2000 799.5n 0.2000 800.5n 0.2000 1600.0n 0.2000 1600.0n 0.2000 2399.5n 0.2000 2400.5n 0.2000 3200.0n 0.2000 3200.0n 0.2000 3999.5n 0.2000 4000.5n 0.2000 4800.0n 0.2000 4800.0n 0.2000 5599.5n 0.2000 5600.5n 0.2000 6400.0n 0.2000)
Vyp_bh4 yp_bh4 0 PWL(0.0n 0.6047 799.5n 0.6047 800.5n 0.6046 1600.0n 0.6046 1600.0n 0.5012 2399.5n 0.5012 2400.5n 0.5012 3200.0n 0.5012 3200.0n 0.6976 3999.5n 0.6976 4000.5n 0.6975 4800.0n 0.6975 4800.0n 0.5970 5599.5n 0.5970 5600.5n 0.5969 6400.0n 0.5969)
Vyn_bh4 yn_bh4 0 PWL(0.0n 0.3953 799.5n 0.3953 800.5n 0.3954 1600.0n 0.3954 1600.0n 0.4988 2399.5n 0.4988 2400.5n 0.4988 3200.0n 0.4988 3200.0n 0.3024 3999.5n 0.3024 4000.5n 0.3025 4800.0n 0.3025 4800.0n 0.4030 5599.5n 0.4030 5600.5n 0.4031 6400.0n 0.4031)
Xu_bh4 xp_bh4 xn_bh4 yp_bh4 yn_bh4 wp_bh4 wn_bh4 psig psigb vdd gbn gupd3
Cwp_w15 wp_w15 0 200p
Cwn_w15 wn_w15 0 200p
Rcp_w15 wp_w15 cm_w15 2g
Rcn_w15 wn_w15 cm_w15 2g
Msp_w15 wp_w15 cm_w15 0 0 NNR W=4u L=100u
Msn_w15 wn_w15 cm_w15 0 0 NNR W=4u L=100u
Vxp_w15 xp_w15 0 PWL(0.0n 0.2000 799.5n 0.2000 800.5n 0.2000 1600.0n 0.2000 1600.0n 0.2000 2399.5n 0.2000 2400.5n 0.2000 3200.0n 0.2000 3200.0n 0.8000 3999.5n 0.8000 4000.5n 0.8000 4800.0n 0.8000 4800.0n 0.8000 5599.5n 0.8000 5600.5n 0.8000 6400.0n 0.8000)
Vxn_w15 xn_w15 0 PWL(0.0n 0.8000 799.5n 0.8000 800.5n 0.8000 1600.0n 0.8000 1600.0n 0.8000 2399.5n 0.8000 2400.5n 0.8000 3200.0n 0.8000 3200.0n 0.2000 3999.5n 0.2000 4000.5n 0.2000 4800.0n 0.2000 4800.0n 0.2000 5599.5n 0.2000 5600.5n 0.2000 6400.0n 0.2000)
Vyp_w15 yp_w15 0 PWL(0.0n 0.7671 799.5n 0.7671 800.5n 0.7671 1600.0n 0.7671 1600.0n 0.3391 2399.5n 0.3391 2400.5n 0.3393 3200.0n 0.3393 3200.0n 0.7473 3999.5n 0.7473 4000.5n 0.7473 4800.0n 0.7473 4800.0n 0.2575 5599.5n 0.2575 5600.5n 0.2574 6400.0n 0.2574)
Vyn_w15 yn_w15 0 PWL(0.0n 0.2329 799.5n 0.2329 800.5n 0.2329 1600.0n 0.2329 1600.0n 0.6609 2399.5n 0.6609 2400.5n 0.6607 3200.0n 0.6607 3200.0n 0.2527 3999.5n 0.2527 4000.5n 0.2527 4800.0n 0.2527 4800.0n 0.7425 5599.5n 0.7425 5600.5n 0.7426 6400.0n 0.7426)
Xu_w15 xp_w15 xn_w15 yp_w15 yn_w15 wp_w15 wn_w15 psig psigb vdd gbn gupd3
Cwp_w25 wp_w25 0 200p
Cwn_w25 wn_w25 0 200p
Rcp_w25 wp_w25 cm_w25 2g
Rcn_w25 wn_w25 cm_w25 2g
Msp_w25 wp_w25 cm_w25 0 0 NNR W=4u L=100u
Msn_w25 wn_w25 cm_w25 0 0 NNR W=4u L=100u
Vxp_w25 xp_w25 0 PWL(0.0n 0.2000 799.5n 0.2000 800.5n 0.2000 1600.0n 0.2000 1600.0n 0.8000 2399.5n 0.8000 2400.5n 0.8000 3200.0n 0.8000 3200.0n 0.2000 3999.5n 0.2000 4000.5n 0.2000 4800.0n 0.2000 4800.0n 0.8000 5599.5n 0.8000 5600.5n 0.8000 6400.0n 0.8000)
Vxn_w25 xn_w25 0 PWL(0.0n 0.8000 799.5n 0.8000 800.5n 0.8000 1600.0n 0.8000 1600.0n 0.2000 2399.5n 0.2000 2400.5n 0.2000 3200.0n 0.2000 3200.0n 0.8000 3999.5n 0.8000 4000.5n 0.8000 4800.0n 0.8000 4800.0n 0.2000 5599.5n 0.2000 5600.5n 0.2000 6400.0n 0.2000)
Vyp_w25 yp_w25 0 PWL(0.0n 0.7671 799.5n 0.7671 800.5n 0.7671 1600.0n 0.7671 1600.0n 0.3391 2399.5n 0.3391 2400.5n 0.3393 3200.0n 0.3393 3200.0n 0.7473 3999.5n 0.7473 4000.5n 0.7473 4800.0n 0.7473 4800.0n 0.2575 5599.5n 0.2575 5600.5n 0.2574 6400.0n 0.2574)
Vyn_w25 yn_w25 0 PWL(0.0n 0.2329 799.5n 0.2329 800.5n 0.2329 1600.0n 0.2329 1600.0n 0.6609 2399.5n 0.6609 2400.5n 0.6607 3200.0n 0.6607 3200.0n 0.2527 3999.5n 0.2527 4000.5n 0.2527 4800.0n 0.2527 4800.0n 0.7425 5599.5n 0.7425 5600.5n 0.7426 6400.0n 0.7426)
Xu_w25 xp_w25 xn_w25 yp_w25 yn_w25 wp_w25 wn_w25 psig psigb vdd gbn gupd3
Cwp_o5 wp_o5 0 200p
Cwn_o5 wn_o5 0 200p
Rcp_o5 wp_o5 cm_o5 2g
Rcn_o5 wn_o5 cm_o5 2g
Msp_o5 wp_o5 cm_o5 0 0 NNR W=4u L=100u
Msn_o5 wn_o5 cm_o5 0 0 NNR W=4u L=100u
Vxp_o5 xp_o5 0 PWL(0.0n 0.7671 799.5n 0.7671 800.5n 0.7671 1600.0n 0.7671 1600.0n 0.3391 2399.5n 0.3391 2400.5n 0.3393 3200.0n 0.3393 3200.0n 0.7473 3999.5n 0.7473 4000.5n 0.7473 4800.0n 0.7473 4800.0n 0.2575 5599.5n 0.2575 5600.5n 0.2574 6400.0n 0.2574)
Vxn_o5 xn_o5 0 PWL(0.0n 0.2329 799.5n 0.2329 800.5n 0.2329 1600.0n 0.2329 1600.0n 0.6609 2399.5n 0.6609 2400.5n 0.6607 3200.0n 0.6607 3200.0n 0.2527 3999.5n 0.2527 4000.5n 0.2527 4800.0n 0.2527 4800.0n 0.7425 5599.5n 0.7425 5600.5n 0.7426 6400.0n 0.7426)
Vyp_o5 yp_o5 0 PWL(0.0n 0.5072 799.5n 0.5072 800.5n 0.5065 1600.0n 0.5065 1600.0n 0.5022 2399.5n 0.5022 2400.5n 0.5029 3200.0n 0.5029 3200.0n 0.5032 3999.5n 0.5032 4000.5n 0.5039 4800.0n 0.5039 4800.0n 0.4956 5599.5n 0.4956 5600.5n 0.4949 6400.0n 0.4949)
Vyn_o5 yn_o5 0 PWL(0.0n 0.4928 799.5n 0.4928 800.5n 0.4935 1600.0n 0.4935 1600.0n 0.4978 2399.5n 0.4978 2400.5n 0.4971 3200.0n 0.4971 3200.0n 0.4968 3999.5n 0.4968 4000.5n 0.4961 4800.0n 0.4961 4800.0n 0.5044 5599.5n 0.5044 5600.5n 0.5051 6400.0n 0.5051)
Xu_o5 xp_o5 xn_o5 yp_o5 yn_o5 wp_o5 wn_o5 psig psigb vdd gbn gupd3
Cwp_bh5 wp_bh5 0 200p
Cwn_bh5 wn_bh5 0 200p
Rcp_bh5 wp_bh5 cm_bh5 2g
Rcn_bh5 wn_bh5 cm_bh5 2g
Msp_bh5 wp_bh5 cm_bh5 0 0 NNR W=4u L=100u
Msn_bh5 wn_bh5 cm_bh5 0 0 NNR W=4u L=100u
Vxp_bh5 xp_bh5 0 PWL(0.0n 0.8000 799.5n 0.8000 800.5n 0.8000 1600.0n 0.8000 1600.0n 0.8000 2399.5n 0.8000 2400.5n 0.8000 3200.0n 0.8000 3200.0n 0.8000 3999.5n 0.8000 4000.5n 0.8000 4800.0n 0.8000 4800.0n 0.8000 5599.5n 0.8000 5600.5n 0.8000 6400.0n 0.8000)
Vxn_bh5 xn_bh5 0 PWL(0.0n 0.2000 799.5n 0.2000 800.5n 0.2000 1600.0n 0.2000 1600.0n 0.2000 2399.5n 0.2000 2400.5n 0.2000 3200.0n 0.2000 3200.0n 0.2000 3999.5n 0.2000 4000.5n 0.2000 4800.0n 0.2000 4800.0n 0.2000 5599.5n 0.2000 5600.5n 0.2000 6400.0n 0.2000)
Vyp_bh5 yp_bh5 0 PWL(0.0n 0.7671 799.5n 0.7671 800.5n 0.7671 1600.0n 0.7671 1600.0n 0.3391 2399.5n 0.3391 2400.5n 0.3393 3200.0n 0.3393 3200.0n 0.7473 3999.5n 0.7473 4000.5n 0.7473 4800.0n 0.7473 4800.0n 0.2575 5599.5n 0.2575 5600.5n 0.2574 6400.0n 0.2574)
Vyn_bh5 yn_bh5 0 PWL(0.0n 0.2329 799.5n 0.2329 800.5n 0.2329 1600.0n 0.2329 1600.0n 0.6609 2399.5n 0.6609 2400.5n 0.6607 3200.0n 0.6607 3200.0n 0.2527 3999.5n 0.2527 4000.5n 0.2527 4800.0n 0.2527 4800.0n 0.7425 5599.5n 0.7425 5600.5n 0.7426 6400.0n 0.7426)
Xu_bh5 xp_bh5 xn_bh5 yp_bh5 yn_bh5 wp_bh5 wn_bh5 psig psigb vdd gbn gupd3
Cwp_w16 wp_w16 0 200p
Cwn_w16 wn_w16 0 200p
Rcp_w16 wp_w16 cm_w16 2g
Rcn_w16 wn_w16 cm_w16 2g
Msp_w16 wp_w16 cm_w16 0 0 NNR W=4u L=100u
Msn_w16 wn_w16 cm_w16 0 0 NNR W=4u L=100u
Vxp_w16 xp_w16 0 PWL(0.0n 0.2000 799.5n 0.2000 800.5n 0.2000 1600.0n 0.2000 1600.0n 0.2000 2399.5n 0.2000 2400.5n 0.2000 3200.0n 0.2000 3200.0n 0.8000 3999.5n 0.8000 4000.5n 0.8000 4800.0n 0.8000 4800.0n 0.8000 5599.5n 0.8000 5600.5n 0.8000 6400.0n 0.8000)
Vxn_w16 xn_w16 0 PWL(0.0n 0.8000 799.5n 0.8000 800.5n 0.8000 1600.0n 0.8000 1600.0n 0.8000 2399.5n 0.8000 2400.5n 0.8000 3200.0n 0.8000 3200.0n 0.2000 3999.5n 0.2000 4000.5n 0.2000 4800.0n 0.2000 4800.0n 0.2000 5599.5n 0.2000 5600.5n 0.2000 6400.0n 0.2000)
Vyp_w16 yp_w16 0 PWL(0.0n 0.2337 799.5n 0.2337 800.5n 0.2336 1600.0n 0.2336 1600.0n 0.4263 2399.5n 0.4263 2400.5n 0.4263 3200.0n 0.4263 3200.0n 0.3860 3999.5n 0.3860 4000.5n 0.3860 4800.0n 0.3860 4800.0n 0.6879 5599.5n 0.6879 5600.5n 0.6878 6400.0n 0.6878)
Vyn_w16 yn_w16 0 PWL(0.0n 0.7663 799.5n 0.7663 800.5n 0.7664 1600.0n 0.7664 1600.0n 0.5737 2399.5n 0.5737 2400.5n 0.5737 3200.0n 0.5737 3200.0n 0.6140 3999.5n 0.6140 4000.5n 0.6140 4800.0n 0.6140 4800.0n 0.3121 5599.5n 0.3121 5600.5n 0.3122 6400.0n 0.3122)
Xu_w16 xp_w16 xn_w16 yp_w16 yn_w16 wp_w16 wn_w16 psig psigb vdd gbn gupd3
Cwp_w26 wp_w26 0 200p
Cwn_w26 wn_w26 0 200p
Rcp_w26 wp_w26 cm_w26 2g
Rcn_w26 wn_w26 cm_w26 2g
Msp_w26 wp_w26 cm_w26 0 0 NNR W=4u L=100u
Msn_w26 wn_w26 cm_w26 0 0 NNR W=4u L=100u
Vxp_w26 xp_w26 0 PWL(0.0n 0.2000 799.5n 0.2000 800.5n 0.2000 1600.0n 0.2000 1600.0n 0.8000 2399.5n 0.8000 2400.5n 0.8000 3200.0n 0.8000 3200.0n 0.2000 3999.5n 0.2000 4000.5n 0.2000 4800.0n 0.2000 4800.0n 0.8000 5599.5n 0.8000 5600.5n 0.8000 6400.0n 0.8000)
Vxn_w26 xn_w26 0 PWL(0.0n 0.8000 799.5n 0.8000 800.5n 0.8000 1600.0n 0.8000 1600.0n 0.2000 2399.5n 0.2000 2400.5n 0.2000 3200.0n 0.2000 3200.0n 0.8000 3999.5n 0.8000 4000.5n 0.8000 4800.0n 0.8000 4800.0n 0.2000 5599.5n 0.2000 5600.5n 0.2000 6400.0n 0.2000)
Vyp_w26 yp_w26 0 PWL(0.0n 0.2337 799.5n 0.2337 800.5n 0.2336 1600.0n 0.2336 1600.0n 0.4263 2399.5n 0.4263 2400.5n 0.4263 3200.0n 0.4263 3200.0n 0.3860 3999.5n 0.3860 4000.5n 0.3860 4800.0n 0.3860 4800.0n 0.6879 5599.5n 0.6879 5600.5n 0.6878 6400.0n 0.6878)
Vyn_w26 yn_w26 0 PWL(0.0n 0.7663 799.5n 0.7663 800.5n 0.7664 1600.0n 0.7664 1600.0n 0.5737 2399.5n 0.5737 2400.5n 0.5737 3200.0n 0.5737 3200.0n 0.6140 3999.5n 0.6140 4000.5n 0.6140 4800.0n 0.6140 4800.0n 0.3121 5599.5n 0.3121 5600.5n 0.3122 6400.0n 0.3122)
Xu_w26 xp_w26 xn_w26 yp_w26 yn_w26 wp_w26 wn_w26 psig psigb vdd gbn gupd3
Cwp_o6 wp_o6 0 200p
Cwn_o6 wn_o6 0 200p
Rcp_o6 wp_o6 cm_o6 2g
Rcn_o6 wn_o6 cm_o6 2g
Msp_o6 wp_o6 cm_o6 0 0 NNR W=4u L=100u
Msn_o6 wn_o6 cm_o6 0 0 NNR W=4u L=100u
Vxp_o6 xp_o6 0 PWL(0.0n 0.2337 799.5n 0.2337 800.5n 0.2336 1600.0n 0.2336 1600.0n 0.4263 2399.5n 0.4263 2400.5n 0.4263 3200.0n 0.4263 3200.0n 0.3860 3999.5n 0.3860 4000.5n 0.3860 4800.0n 0.3860 4800.0n 0.6879 5599.5n 0.6879 5600.5n 0.6878 6400.0n 0.6878)
Vxn_o6 xn_o6 0 PWL(0.0n 0.7663 799.5n 0.7663 800.5n 0.7664 1600.0n 0.7664 1600.0n 0.5737 2399.5n 0.5737 2400.5n 0.5737 3200.0n 0.5737 3200.0n 0.6140 3999.5n 0.6140 4000.5n 0.6140 4800.0n 0.6140 4800.0n 0.3121 5599.5n 0.3121 5600.5n 0.3122 6400.0n 0.3122)
Vyp_o6 yp_o6 0 PWL(0.0n 0.5072 799.5n 0.5072 800.5n 0.5065 1600.0n 0.5065 1600.0n 0.5022 2399.5n 0.5022 2400.5n 0.5029 3200.0n 0.5029 3200.0n 0.5032 3999.5n 0.5032 4000.5n 0.5039 4800.0n 0.5039 4800.0n 0.4956 5599.5n 0.4956 5600.5n 0.4949 6400.0n 0.4949)
Vyn_o6 yn_o6 0 PWL(0.0n 0.4928 799.5n 0.4928 800.5n 0.4935 1600.0n 0.4935 1600.0n 0.4978 2399.5n 0.4978 2400.5n 0.4971 3200.0n 0.4971 3200.0n 0.4968 3999.5n 0.4968 4000.5n 0.4961 4800.0n 0.4961 4800.0n 0.5044 5599.5n 0.5044 5600.5n 0.5051 6400.0n 0.5051)
Xu_o6 xp_o6 xn_o6 yp_o6 yn_o6 wp_o6 wn_o6 psig psigb vdd gbn gupd3
Cwp_bh6 wp_bh6 0 200p
Cwn_bh6 wn_bh6 0 200p
Rcp_bh6 wp_bh6 cm_bh6 2g
Rcn_bh6 wn_bh6 cm_bh6 2g
Msp_bh6 wp_bh6 cm_bh6 0 0 NNR W=4u L=100u
Msn_bh6 wn_bh6 cm_bh6 0 0 NNR W=4u L=100u
Vxp_bh6 xp_bh6 0 PWL(0.0n 0.8000 799.5n 0.8000 800.5n 0.8000 1600.0n 0.8000 1600.0n 0.8000 2399.5n 0.8000 2400.5n 0.8000 3200.0n 0.8000 3200.0n 0.8000 3999.5n 0.8000 4000.5n 0.8000 4800.0n 0.8000 4800.0n 0.8000 5599.5n 0.8000 5600.5n 0.8000 6400.0n 0.8000)
Vxn_bh6 xn_bh6 0 PWL(0.0n 0.2000 799.5n 0.2000 800.5n 0.2000 1600.0n 0.2000 1600.0n 0.2000 2399.5n 0.2000 2400.5n 0.2000 3200.0n 0.2000 3200.0n 0.2000 3999.5n 0.2000 4000.5n 0.2000 4800.0n 0.2000 4800.0n 0.2000 5599.5n 0.2000 5600.5n 0.2000 6400.0n 0.2000)
Vyp_bh6 yp_bh6 0 PWL(0.0n 0.2337 799.5n 0.2337 800.5n 0.2336 1600.0n 0.2336 1600.0n 0.4263 2399.5n 0.4263 2400.5n 0.4263 3200.0n 0.4263 3200.0n 0.3860 3999.5n 0.3860 4000.5n 0.3860 4800.0n 0.3860 4800.0n 0.6879 5599.5n 0.6879 5600.5n 0.6878 6400.0n 0.6878)
Vyn_bh6 yn_bh6 0 PWL(0.0n 0.7663 799.5n 0.7663 800.5n 0.7664 1600.0n 0.7664 1600.0n 0.5737 2399.5n 0.5737 2400.5n 0.5737 3200.0n 0.5737 3200.0n 0.6140 3999.5n 0.6140 4000.5n 0.6140 4800.0n 0.6140 4800.0n 0.3121 5599.5n 0.3121 5600.5n 0.3122 6400.0n 0.3122)
Xu_bh6 xp_bh6 xn_bh6 yp_bh6 yn_bh6 wp_bh6 wn_bh6 psig psigb vdd gbn gupd3
Cwp_bo wp_bo 0 200p
Cwn_bo wn_bo 0 200p
Rcp_bo wp_bo cm_bo 2g
Rcn_bo wn_bo cm_bo 2g
Msp_bo wp_bo cm_bo 0 0 NNR W=4u L=100u
Msn_bo wn_bo cm_bo 0 0 NNR W=4u L=100u
Vxp_bo xp_bo 0 PWL(0.0n 0.8000 799.5n 0.8000 800.5n 0.8000 1600.0n 0.8000 1600.0n 0.8000 2399.5n 0.8000 2400.5n 0.8000 3200.0n 0.8000 3200.0n 0.8000 3999.5n 0.8000 4000.5n 0.8000 4800.0n 0.8000 4800.0n 0.8000 5599.5n 0.8000 5600.5n 0.8000 6400.0n 0.8000)
Vxn_bo xn_bo 0 PWL(0.0n 0.2000 799.5n 0.2000 800.5n 0.2000 1600.0n 0.2000 1600.0n 0.2000 2399.5n 0.2000 2400.5n 0.2000 3200.0n 0.2000 3200.0n 0.2000 3999.5n 0.2000 4000.5n 0.2000 4800.0n 0.2000 4800.0n 0.2000 5599.5n 0.2000 5600.5n 0.2000 6400.0n 0.2000)
Vyp_bo yp_bo 0 PWL(0.0n 0.5072 799.5n 0.5072 800.5n 0.5065 1600.0n 0.5065 1600.0n 0.5022 2399.5n 0.5022 2400.5n 0.5029 3200.0n 0.5029 3200.0n 0.5032 3999.5n 0.5032 4000.5n 0.5039 4800.0n 0.5039 4800.0n 0.4956 5599.5n 0.4956 5600.5n 0.4949 6400.0n 0.4949)
Vyn_bo yn_bo 0 PWL(0.0n 0.4928 799.5n 0.4928 800.5n 0.4935 1600.0n 0.4935 1600.0n 0.4978 2399.5n 0.4978 2400.5n 0.4971 3200.0n 0.4971 3200.0n 0.4968 3999.5n 0.4968 4000.5n 0.4961 4800.0n 0.4961 4800.0n 0.5044 5599.5n 0.5044 5600.5n 0.5051 6400.0n 0.5051)
Xu_bo xp_bo xn_bo yp_bo yn_bo wp_bo wn_bo psig psigb vdd gbn gupd3
.ic v(wp_w11)=0.5 v(wn_w11)=0.5 v(cm_w11)=0.5
.ic v(wp_w21)=0.5 v(wn_w21)=0.5 v(cm_w21)=0.5
.ic v(wp_o1)=0.5 v(wn_o1)=0.5 v(cm_o1)=0.5
.ic v(wp_bh1)=0.5 v(wn_bh1)=0.5 v(cm_bh1)=0.5
.ic v(wp_w12)=0.5 v(wn_w12)=0.5 v(cm_w12)=0.5
.ic v(wp_w22)=0.5 v(wn_w22)=0.5 v(cm_w22)=0.5
.ic v(wp_o2)=0.5 v(wn_o2)=0.5 v(cm_o2)=0.5
.ic v(wp_bh2)=0.5 v(wn_bh2)=0.5 v(cm_bh2)=0.5
.ic v(wp_w13)=0.5 v(wn_w13)=0.5 v(cm_w13)=0.5
.ic v(wp_w23)=0.5 v(wn_w23)=0.5 v(cm_w23)=0.5
.ic v(wp_o3)=0.5 v(wn_o3)=0.5 v(cm_o3)=0.5
.ic v(wp_bh3)=0.5 v(wn_bh3)=0.5 v(cm_bh3)=0.5
.ic v(wp_w14)=0.5 v(wn_w14)=0.5 v(cm_w14)=0.5
.ic v(wp_w24)=0.5 v(wn_w24)=0.5 v(cm_w24)=0.5
.ic v(wp_o4)=0.5 v(wn_o4)=0.5 v(cm_o4)=0.5
.ic v(wp_bh4)=0.5 v(wn_bh4)=0.5 v(cm_bh4)=0.5
.ic v(wp_w15)=0.5 v(wn_w15)=0.5 v(cm_w15)=0.5
.ic v(wp_w25)=0.5 v(wn_w25)=0.5 v(cm_w25)=0.5
.ic v(wp_o5)=0.5 v(wn_o5)=0.5 v(cm_o5)=0.5
.ic v(wp_bh5)=0.5 v(wn_bh5)=0.5 v(cm_bh5)=0.5
.ic v(wp_w16)=0.5 v(wn_w16)=0.5 v(cm_w16)=0.5
.ic v(wp_w26)=0.5 v(wn_w26)=0.5 v(cm_w26)=0.5
.ic v(wp_o6)=0.5 v(wn_o6)=0.5 v(cm_o6)=0.5
.ic v(wp_bh6)=0.5 v(wn_bh6)=0.5 v(cm_bh6)=0.5
.ic v(wp_bo)=0.5 v(wn_bo)=0.5 v(cm_bo)=0.5
.tran 1n 6400n uic
.control
run
wrdata pug3.dat v(wp_w11) v(wn_w11) v(wp_w21) v(wn_w21) v(wp_o1) v(wn_o1) v(wp_bh1) v(wn_bh1) v(wp_w12) v(wn_w12) v(wp_w22) v(wn_w22) v(wp_o2) v(wn_o2) v(wp_bh2) v(wn_bh2) v(wp_w13) v(wn_w13) v(wp_w23) v(wn_w23) v(wp_o3) v(wn_o3) v(wp_bh3) v(wn_bh3) v(wp_w14) v(wn_w14) v(wp_w24) v(wn_w24) v(wp_o4) v(wn_o4) v(wp_bh4) v(wn_bh4) v(wp_w15) v(wn_w15) v(wp_w25) v(wn_w25) v(wp_o5) v(wn_o5) v(wp_bh5) v(wn_bh5) v(wp_w16) v(wn_w16) v(wp_w26) v(wn_w26) v(wp_o6) v(wn_o6) v(wp_bh6) v(wn_bh6) v(wp_bo) v(wn_bo)
.endc
.end
