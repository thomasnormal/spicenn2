pc orchestrated
.model NNR NMOS (LEVEL=1 VTO=0.2 KP=120u LAMBDA=0.02 GAMMA=0 PHI=0.7)
.model PNR PMOS (LEVEL=1 VTO=-0.2 KP=40u LAMBDA=0.02 GAMMA=0 PHI=0.7)
.subckt gsyn inp inn wp wn outp outn vdd vbn
Mtail nt vbn 0 0 NNR W=400u L=100u
M5 na wp nt 0 NNR W=200u L=100u
M6 nb wn nt 0 NNR W=200u L=100u
M1 outp inp na 0 NNR W=200u L=100u
M2 outn inn na 0 NNR W=200u L=100u
M3 outn inp nb 0 NNR W=200u L=100u
M4 outp inn nb 0 NNR W=200u L=100u
.ends
.subckt cmld p n vdd
Rcs1 p cmx 300k
Rcs2 n cmx 300k
MLp p cmx vdd vdd PNR W=4000u L=100u
MLn n cmx vdd vdd PNR W=4000u L=100u
.ends
.subckt dneuron up un ap an vdd vbn
M1 an up tn 0 NNR W=200u L=100u
M2 ap un tn 0 NNR W=200u L=100u
Mt tn vbn 0 0 NNR W=200u L=100u
Xcm ap an vdd cmld
.ends
.subckt esub xp xn mp mn ep en vdd vbn
Mt nt vbn 0 0 NNR W=400u L=100u
M1x ep xn nt 0 NNR W=200u L=100u
M2x en xp nt 0 NNR W=200u L=100u
M1m ep mp nt 0 NNR W=200u L=100u
M2m en mn nt 0 NNR W=200u L=100u
RLp vdd ep 50k
RLn vdd en 50k
.ends
Vdd vdd 0 1.0
Vbsyn vbsyn 0 0.45
Vbbk vbbk 0 0.25
Vbneu vbneu 0 0.35
Vgm gm 0 0.6
Vwcm wcm 0 0.5
Vref vref 0 0.5
Vbg vbg 0 0.35
Vxp0 a_xp0 0 0.5
Vxn0 a_xn0 0 0.5
Vxp1 a_xp1 0 0.5
Vxn1 a_xn1 0 0.5
Vxp2 a_xp2 0 0.5
Vxn2 a_xn2 0 0.5
Vxp3 a_xp3 0 0.5
Vxn3 a_xn3 0 0.5
Vxp4 a_xp4 0 0.5
Vxn4 a_xn4 0 0.5
Vxp5 a_xp5 0 0.5
Vxn5 a_xn5 0 0.5
Vxp6 a_xp6 0 0.5
Vxn6 a_xn6 0 0.5
Vxp7 a_xp7 0 0.5
Vxn7 a_xn7 0 0.5
Vxp8 a_xp8 0 0.5
Vxn8 a_xn8 0 0.5
Vxp9 a_xp9 0 0.5
Vxn9 a_xn9 0 0.5
Vxp10 a_xp10 0 0.5
Vxn10 a_xn10 0 0.5
Vxp11 a_xp11 0 0.5
Vxn11 a_xn11 0 0.5
Vxp12 a_xp12 0 0.5
Vxn12 a_xn12 0 0.5
Vxp13 a_xp13 0 0.5
Vxn13 a_xn13 0 0.5
Vxp14 a_xp14 0 0.5
Vxn14 a_xn14 0 0.5
Vxp15 a_xp15 0 0.5
Vxn15 a_xn15 0 0.5
Vxp16 a_xp16 0 0.5
Vxn16 a_xn16 0 0.5
Vxp17 a_xp17 0 0.5
Vxn17 a_xn17 0 0.5
Vxp18 a_xp18 0 0.5
Vxn18 a_xn18 0 0.5
Vxp19 a_xp19 0 0.5
Vxn19 a_xn19 0 0.5
Vxp20 a_xp20 0 0.5
Vxn20 a_xn20 0 0.5
Vxp21 a_xp21 0 0.5
Vxn21 a_xn21 0 0.5
Vxp22 a_xp22 0 0.5
Vxn22 a_xn22 0 0.5
Vxp23 a_xp23 0 0.5
Vxn23 a_xn23 0 0.5
Vxp24 a_xp24 0 0.5
Vxn24 a_xn24 0 0.5
Vxp25 a_xp25 0 0.5
Vxn25 a_xn25 0 0.5
Vxp26 a_xp26 0 0.5
Vxn26 a_xn26 0 0.5
Vxp27 a_xp27 0 0.5
Vxn27 a_xn27 0 0.5
Vxp28 a_xp28 0 0.5
Vxn28 a_xn28 0 0.5
Vxp29 a_xp29 0 0.5
Vxn29 a_xn29 0 0.5
Vxp30 a_xp30 0 0.5
Vxn30 a_xn30 0 0.5
Vxp31 a_xp31 0 0.5
Vxn31 a_xn31 0 0.5
Vxp32 a_xp32 0 0.5
Vxn32 a_xn32 0 0.5
Vxp33 a_xp33 0 0.5
Vxn33 a_xn33 0 0.5
Vxp34 a_xp34 0 0.5
Vxn34 a_xn34 0 0.5
Vxp35 a_xp35 0 0.5
Vxn35 a_xn35 0 0.5
Vxp36 a_xp36 0 0.5
Vxn36 a_xn36 0 0.5
Vxp37 a_xp37 0 0.5
Vxn37 a_xn37 0 0.5
Vxp38 a_xp38 0 0.5
Vxn38 a_xn38 0 0.5
Vxp39 a_xp39 0 0.5
Vxn39 a_xn39 0 0.5
Vxp40 a_xp40 0 0.5
Vxn40 a_xn40 0 0.5
Vxp41 a_xp41 0 0.5
Vxn41 a_xn41 0 0.5
Vxp42 a_xp42 0 0.5
Vxn42 a_xn42 0 0.5
Vxp43 a_xp43 0 0.5
Vxn43 a_xn43 0 0.5
Vxp44 a_xp44 0 0.5
Vxn44 a_xn44 0 0.5
Vxp45 a_xp45 0 0.5
Vxn45 a_xn45 0 0.5
Vxp46 a_xp46 0 0.5
Vxn46 a_xn46 0 0.5
Vxp47 a_xp47 0 0.5
Vxn47 a_xn47 0 0.5
Vxp48 a_xp48 0 0.5
Vxn48 a_xn48 0 0.5
Vxp49 a_xp49 0 0.5
Vxn49 a_xn49 0 0.5
Vxp50 a_xp50 0 0.5
Vxn50 a_xn50 0 0.5
Vxp51 a_xp51 0 0.5
Vxn51 a_xn51 0 0.5
Vxp52 a_xp52 0 0.5
Vxn52 a_xn52 0 0.5
Vxp53 a_xp53 0 0.5
Vxn53 a_xn53 0 0.5
Vxp54 a_xp54 0 0.5
Vxn54 a_xn54 0 0.5
Vxp55 a_xp55 0 0.5
Vxn55 a_xn55 0 0.5
Vxp56 a_xp56 0 0.5
Vxn56 a_xn56 0 0.5
Vxp57 a_xp57 0 0.5
Vxn57 a_xn57 0 0.5
Vxp58 a_xp58 0 0.5
Vxn58 a_xn58 0 0.5
Vxp59 a_xp59 0 0.5
Vxn59 a_xn59 0 0.5
Vxp60 a_xp60 0 0.5
Vxn60 a_xn60 0 0.5
Vxp61 a_xp61 0 0.5
Vxn61 a_xn61 0 0.5
Vxp62 a_xp62 0 0.5
Vxn62 a_xn62 0 0.5
Vxp63 a_xp63 0 0.5
Vxn63 a_xn63 0 0.5
Vwp_ih_0_0 wp_ih_0_0 0 0.5570783526649328
Vwn_ih_0_0 wn_ih_0_0 0 0.4429216473350672
Vwp_ih_1_0 wp_ih_1_0 0 0.6435230651246137
Vwn_ih_1_0 wn_ih_1_0 0 0.35647693487538634
Vwp_ih_2_0 wp_ih_2_0 0 0.6759169974666841
Vwn_ih_2_0 wn_ih_2_0 0 0.3240830025333159
Vwp_ih_3_0 wp_ih_3_0 0 0.4841104590761077
Vwn_ih_3_0 wn_ih_3_0 0 0.5158895409238923
Vwp_ih_4_0 wp_ih_4_0 0 0.5910765484983147
Vwn_ih_4_0 wn_ih_4_0 0 0.40892345150168535
Vwp_ih_5_0 wp_ih_5_0 0 0.5958943530745943
Vwn_ih_5_0 wn_ih_5_0 0 0.40410564692540574
Vwp_ih_6_0 wp_ih_6_0 0 0.4090448277904214
Vwn_ih_6_0 wn_ih_6_0 0 0.5909551722095786
Vwp_ih_7_0 wp_ih_7_0 0 0.3
Vwn_ih_7_0 wn_ih_7_0 0 0.7076452402596285
Vwp_ih_8_0 wp_ih_8_0 0 0.5018671768720961
Vwn_ih_8_0 wn_ih_8_0 0 0.49813282312790386
Vwp_ih_9_0 wp_ih_9_0 0 0.3
Vwn_ih_9_0 wn_ih_9_0 0 0.7394979629803213
Vwp_ih_10_0 wp_ih_10_0 0 0.4502886805560437
Vwn_ih_10_0 wn_ih_10_0 0 0.5497113194439563
Vwp_ih_11_0 wp_ih_11_0 0 0.5645387561604333
Vwn_ih_11_0 wn_ih_11_0 0 0.43546124383956675
Vwp_ih_12_0 wp_ih_12_0 0 0.37365544674337203
Vwn_ih_12_0 wn_ih_12_0 0 0.626344553256628
Vwp_ih_13_0 wp_ih_13_0 0 0.5198864137366626
Vwn_ih_13_0 wn_ih_13_0 0 0.4801135862633375
Vwp_ih_14_0 wp_ih_14_0 0 0.6353766256667399
Vwn_ih_14_0 wn_ih_14_0 0 0.3646233743332601
Vwp_ih_15_0 wp_ih_15_0 0 0.538420838516631
Vwn_ih_15_0 wn_ih_15_0 0 0.46157916148336897
Vwp_ih_16_0 wp_ih_16_0 0 0.5612892691044279
Vwn_ih_16_0 wn_ih_16_0 0 0.43871073089557205
Vwp_ih_17_0 wp_ih_17_0 0 0.6174693649118714
Vwn_ih_17_0 wn_ih_17_0 0 0.3825306350881285
Vwp_ih_18_0 wp_ih_18_0 0 0.7233606489540638
Vwn_ih_18_0 wn_ih_18_0 0 0.3
Vwp_ih_19_0 wp_ih_19_0 0 0.5447962778598961
Vwn_ih_19_0 wn_ih_19_0 0 0.45520372214010385
Vwp_ih_20_0 wp_ih_20_0 0 0.6371456165233833
Vwn_ih_20_0 wn_ih_20_0 0 0.36285438347661675
Vwp_ih_21_0 wp_ih_21_0 0 0.5108802462290617
Vwn_ih_21_0 wn_ih_21_0 0 0.48911975377093825
Vwp_ih_22_0 wp_ih_22_0 0 0.44677212215846784
Vwn_ih_22_0 wn_ih_22_0 0 0.5532278778415322
Vwp_ih_23_0 wp_ih_23_0 0 0.5319031492539483
Vwn_ih_23_0 wn_ih_23_0 0 0.4680968507460517
Vwp_ih_24_0 wp_ih_24_0 0 0.4262632448328185
Vwn_ih_24_0 wn_ih_24_0 0 0.5737367551671815
Vwp_ih_25_0 wp_ih_25_0 0 0.45444958414688574
Vwn_ih_25_0 wn_ih_25_0 0 0.5455504158531143
Vwp_ih_26_0 wp_ih_26_0 0 0.45645549377367806
Vwn_ih_26_0 wn_ih_26_0 0 0.543544506226322
Vwp_ih_27_0 wp_ih_27_0 0 0.3
Vwn_ih_27_0 wn_ih_27_0 0 0.7783024453159562
Vwp_ih_28_0 wp_ih_28_0 0 0.46513765597740625
Vwn_ih_28_0 wn_ih_28_0 0 0.5348623440225938
Vwp_ih_29_0 wp_ih_29_0 0 0.3622226685825954
Vwn_ih_29_0 wn_ih_29_0 0 0.6377773314174047
Vwp_ih_30_0 wp_ih_30_0 0 0.520053942254272
Vwn_ih_30_0 wn_ih_30_0 0 0.479946057745728
Vwp_ih_31_0 wp_ih_31_0 0 0.672525751620159
Vwn_ih_31_0 wn_ih_31_0 0 0.32747424837984096
Vwp_ih_32_0 wp_ih_32_0 0 0.4374799612271252
Vwn_ih_32_0 wn_ih_32_0 0 0.5625200387728748
Vwp_ih_33_0 wp_ih_33_0 0 0.43248306312358226
Vwn_ih_33_0 wn_ih_33_0 0 0.5675169368764178
Vwp_ih_34_0 wp_ih_34_0 0 0.690094569588926
Vwn_ih_34_0 wn_ih_34_0 0 0.309905430411074
Vwp_ih_35_0 wp_ih_35_0 0 0.53777744429682
Vwn_ih_35_0 wn_ih_35_0 0 0.46222255570318005
Vwp_ih_36_0 wp_ih_36_0 0 0.5687973570304905
Vwn_ih_36_0 wn_ih_36_0 0 0.43120264296950944
Vwp_ih_37_0 wp_ih_37_0 0 0.44650849679011106
Vwn_ih_37_0 wn_ih_37_0 0 0.5534915032098889
Vwp_ih_38_0 wp_ih_38_0 0 0.6007024549993905
Vwn_ih_38_0 wn_ih_38_0 0 0.3992975450006095
Vwp_ih_39_0 wp_ih_39_0 0 0.4176597693011837
Vwn_ih_39_0 wn_ih_39_0 0 0.5823402306988162
Vwp_ih_40_0 wp_ih_40_0 0 0.4224523370176736
Vwn_ih_40_0 wn_ih_40_0 0 0.5775476629823264
Vwp_ih_41_0 wp_ih_41_0 0 0.5569394129367687
Vwn_ih_41_0 wn_ih_41_0 0 0.44306058706323126
Vwp_ih_42_0 wp_ih_42_0 0 0.44968933832134167
Vwn_ih_42_0 wn_ih_42_0 0 0.5503106616786583
Vwp_ih_43_0 wp_ih_43_0 0 0.5593117475649382
Vwn_ih_43_0 wn_ih_43_0 0 0.4406882524350618
Vwp_ih_44_0 wp_ih_44_0 0 0.7603409464572017
Vwn_ih_44_0 wn_ih_44_0 0 0.3
Vwp_ih_45_0 wp_ih_45_0 0 0.3043421061350867
Vwn_ih_45_0 wn_ih_45_0 0 0.6956578938649133
Vwp_ih_46_0 wp_ih_46_0 0 0.4246245030295428
Vwn_ih_46_0 wn_ih_46_0 0 0.5753754969704572
Vwp_ih_47_0 wp_ih_47_0 0 0.6316546688327291
Vwn_ih_47_0 wn_ih_47_0 0 0.36834533116727086
Vwp_ih_48_0 wp_ih_48_0 0 0.47714922846959135
Vwn_ih_48_0 wn_ih_48_0 0 0.5228507715304087
Vwp_ih_49_0 wp_ih_49_0 0 0.6098971974027887
Vwn_ih_49_0 wn_ih_49_0 0 0.3901028025972113
Vwp_ih_50_0 wp_ih_50_0 0 0.393290102276712
Vwn_ih_50_0 wn_ih_50_0 0 0.606709897723288
Vwp_ih_51_0 wp_ih_51_0 0 0.530303176277032
Vwn_ih_51_0 wn_ih_51_0 0 0.46969682372296795
Vwp_ih_52_0 wp_ih_52_0 0 0.47597856503470565
Vwn_ih_52_0 wn_ih_52_0 0 0.5240214349652943
Vwp_ih_53_0 wp_ih_53_0 0 0.5362230943547517
Vwn_ih_53_0 wn_ih_53_0 0 0.46377690564524826
Vwp_ih_54_0 wp_ih_54_0 0 0.5447254010540642
Vwn_ih_54_0 wn_ih_54_0 0 0.45527459894593575
Vwp_ih_55_0 wp_ih_55_0 0 0.37588700452092555
Vwn_ih_55_0 wn_ih_55_0 0 0.6241129954790745
Vwp_ih_56_0 wp_ih_56_0 0 0.370368880629969
Vwn_ih_56_0 wn_ih_56_0 0 0.629631119370031
Vwp_ih_57_0 wp_ih_57_0 0 0.6286014511670861
Vwn_ih_57_0 wn_ih_57_0 0 0.3713985488329139
Vwp_ih_58_0 wp_ih_58_0 0 0.49587633836140327
Vwn_ih_58_0 wn_ih_58_0 0 0.5041236616385968
Vwp_ih_59_0 wp_ih_59_0 0 0.4837770423229224
Vwn_ih_59_0 wn_ih_59_0 0 0.5162229576770776
Vwp_ih_60_0 wp_ih_60_0 0 0.5129389583871661
Vwn_ih_60_0 wn_ih_60_0 0 0.4870610416128339
Vwp_ih_61_0 wp_ih_61_0 0 0.5676291691632818
Vwn_ih_61_0 wn_ih_61_0 0 0.4323708308367182
Vwp_ih_62_0 wp_ih_62_0 0 0.385083172237431
Vwn_ih_62_0 wn_ih_62_0 0 0.614916827762569
Vwp_ih_63_0 wp_ih_63_0 0 0.3988261509929055
Vwn_ih_63_0 wn_ih_63_0 0 0.6011738490070945
Vwp_ho_0_0 wp_ho_0_0 0 0.663615199019677
Vwn_ho_0_0 wn_ho_0_0 0 0.336384800980323
Vwp_ho_0_1 wp_ho_0_1 0 0.4610927565370139
Vwn_ho_0_1 wn_ho_0_1 0 0.5389072434629861
Vwp_ho_0_2 wp_ho_0_2 0 0.3463654005492698
Vwn_ho_0_2 wn_ho_0_2 0 0.6536345994507302
Vwp_ho_0_3 wp_ho_0_3 0 0.3
Vwn_ho_0_3 wn_ho_0_3 0 0.7242324849411608
Vwp_ho_0_4 wp_ho_0_4 0 0.3913804896078745
Vwn_ho_0_4 wn_ho_0_4 0 0.6086195103921255
Vwp_ih_0_1 wp_ih_0_1 0 0.656540989664772
Vwn_ih_0_1 wn_ih_0_1 0 0.343459010335228
Vwp_ih_1_1 wp_ih_1_1 0 0.5443767413477756
Vwn_ih_1_1 wn_ih_1_1 0 0.4556232586522244
Vwp_ih_2_1 wp_ih_2_1 0 0.6389875803659133
Vwn_ih_2_1 wn_ih_2_1 0 0.3610124196340867
Vwp_ih_3_1 wp_ih_3_1 0 0.4223308168520516
Vwn_ih_3_1 wn_ih_3_1 0 0.5776691831479485
Vwp_ih_4_1 wp_ih_4_1 0 0.6094474813156864
Vwn_ih_4_1 wn_ih_4_1 0 0.3905525186843137
Vwp_ih_5_1 wp_ih_5_1 0 0.5495922049292543
Vwn_ih_5_1 wn_ih_5_1 0 0.45040779507074563
Vwp_ih_6_1 wp_ih_6_1 0 0.5646555419794845
Vwn_ih_6_1 wn_ih_6_1 0 0.43534445802051547
Vwp_ih_7_1 wp_ih_7_1 0 0.5625814387038637
Vwn_ih_7_1 wn_ih_7_1 0 0.4374185612961363
Vwp_ih_8_1 wp_ih_8_1 0 0.4028155721147272
Vwn_ih_8_1 wn_ih_8_1 0 0.5971844278852728
Vwp_ih_9_1 wp_ih_9_1 0 0.33147813169404683
Vwn_ih_9_1 wn_ih_9_1 0 0.6685218683059532
Vwp_ih_10_1 wp_ih_10_1 0 0.40082612092632885
Vwn_ih_10_1 wn_ih_10_1 0 0.5991738790736711
Vwp_ih_11_1 wp_ih_11_1 0 0.6435371351219986
Vwn_ih_11_1 wn_ih_11_1 0 0.3564628648780014
Vwp_ih_12_1 wp_ih_12_1 0 0.6562279144449249
Vwn_ih_12_1 wn_ih_12_1 0 0.3437720855550751
Vwp_ih_13_1 wp_ih_13_1 0 0.47312689726104473
Vwn_ih_13_1 wn_ih_13_1 0 0.5268731027389553
Vwp_ih_14_1 wp_ih_14_1 0 0.4643659379233367
Vwn_ih_14_1 wn_ih_14_1 0 0.5356340620766633
Vwp_ih_15_1 wp_ih_15_1 0 0.6175252924302665
Vwn_ih_15_1 wn_ih_15_1 0 0.38247470756973345
Vwp_ih_16_1 wp_ih_16_1 0 0.4786250535054344
Vwn_ih_16_1 wn_ih_16_1 0 0.5213749464945656
Vwp_ih_17_1 wp_ih_17_1 0 0.39315441711156895
Vwn_ih_17_1 wn_ih_17_1 0 0.606845582888431
Vwp_ih_18_1 wp_ih_18_1 0 0.6378157514739964
Vwn_ih_18_1 wn_ih_18_1 0 0.3621842485260036
Vwp_ih_19_1 wp_ih_19_1 0 0.5139090227798808
Vwn_ih_19_1 wn_ih_19_1 0 0.4860909772201192
Vwp_ih_20_1 wp_ih_20_1 0 0.3
Vwn_ih_20_1 wn_ih_20_1 0 0.7532109094477923
Vwp_ih_21_1 wp_ih_21_1 0 0.47426187908876005
Vwn_ih_21_1 wn_ih_21_1 0 0.52573812091124
Vwp_ih_22_1 wp_ih_22_1 0 0.48179092933952417
Vwn_ih_22_1 wn_ih_22_1 0 0.5182090706604758
Vwp_ih_23_1 wp_ih_23_1 0 0.5458472496127582
Vwn_ih_23_1 wn_ih_23_1 0 0.45415275038724173
Vwp_ih_24_1 wp_ih_24_1 0 0.5173861606046238
Vwn_ih_24_1 wn_ih_24_1 0 0.48261383939537617
Vwp_ih_25_1 wp_ih_25_1 0 0.407338579035855
Vwn_ih_25_1 wn_ih_25_1 0 0.592661420964145
Vwp_ih_26_1 wp_ih_26_1 0 0.43083230606900225
Vwn_ih_26_1 wn_ih_26_1 0 0.5691676939309978
Vwp_ih_27_1 wp_ih_27_1 0 0.49386268913582543
Vwn_ih_27_1 wn_ih_27_1 0 0.5061373108641746
Vwp_ih_28_1 wp_ih_28_1 0 0.5087915633541364
Vwn_ih_28_1 wn_ih_28_1 0 0.4912084366458636
Vwp_ih_29_1 wp_ih_29_1 0 0.4487472177992908
Vwn_ih_29_1 wn_ih_29_1 0 0.5512527822007093
Vwp_ih_30_1 wp_ih_30_1 0 0.5974230504011144
Vwn_ih_30_1 wn_ih_30_1 0 0.4025769495988856
Vwp_ih_31_1 wp_ih_31_1 0 0.38517321043701935
Vwn_ih_31_1 wn_ih_31_1 0 0.6148267895629806
Vwp_ih_32_1 wp_ih_32_1 0 0.45806438346681055
Vwn_ih_32_1 wn_ih_32_1 0 0.5419356165331894
Vwp_ih_33_1 wp_ih_33_1 0 0.3
Vwn_ih_33_1 wn_ih_33_1 0 0.7944228424514397
Vwp_ih_34_1 wp_ih_34_1 0 0.5074793846184062
Vwn_ih_34_1 wn_ih_34_1 0 0.49252061538159375
Vwp_ih_35_1 wp_ih_35_1 0 0.5550573174295949
Vwn_ih_35_1 wn_ih_35_1 0 0.44494268257040515
Vwp_ih_36_1 wp_ih_36_1 0 0.5731325499462369
Vwn_ih_36_1 wn_ih_36_1 0 0.42686745005376314
Vwp_ih_37_1 wp_ih_37_1 0 0.5819407604740802
Vwn_ih_37_1 wn_ih_37_1 0 0.4180592395259198
Vwp_ih_38_1 wp_ih_38_1 0 0.5056024571625337
Vwn_ih_38_1 wn_ih_38_1 0 0.4943975428374663
Vwp_ih_39_1 wp_ih_39_1 0 0.5411018469144094
Vwn_ih_39_1 wn_ih_39_1 0 0.4588981530855905
Vwp_ih_40_1 wp_ih_40_1 0 0.5475060891787141
Vwn_ih_40_1 wn_ih_40_1 0 0.45249391082128587
Vwp_ih_41_1 wp_ih_41_1 0 0.44019320853041705
Vwn_ih_41_1 wn_ih_41_1 0 0.559806791469583
Vwp_ih_42_1 wp_ih_42_1 0 0.6121959827242395
Vwn_ih_42_1 wn_ih_42_1 0 0.3878040172757606
Vwp_ih_43_1 wp_ih_43_1 0 0.44692788883350076
Vwn_ih_43_1 wn_ih_43_1 0 0.5530721111664992
Vwp_ih_44_1 wp_ih_44_1 0 0.326731273349798
Vwn_ih_44_1 wn_ih_44_1 0 0.673268726650202
Vwp_ih_45_1 wp_ih_45_1 0 0.5668733741411133
Vwn_ih_45_1 wn_ih_45_1 0 0.4331266258588867
Vwp_ih_46_1 wp_ih_46_1 0 0.7058547084257671
Vwn_ih_46_1 wn_ih_46_1 0 0.3
Vwp_ih_47_1 wp_ih_47_1 0 0.38246359707275457
Vwn_ih_47_1 wn_ih_47_1 0 0.6175364029272454
Vwp_ih_48_1 wp_ih_48_1 0 0.4892296070162084
Vwn_ih_48_1 wn_ih_48_1 0 0.5107703929837916
Vwp_ih_49_1 wp_ih_49_1 0 0.4056077663528038
Vwn_ih_49_1 wn_ih_49_1 0 0.5943922336471962
Vwp_ih_50_1 wp_ih_50_1 0 0.46391987747188407
Vwn_ih_50_1 wn_ih_50_1 0 0.536080122528116
Vwp_ih_51_1 wp_ih_51_1 0 0.5206809173265514
Vwn_ih_51_1 wn_ih_51_1 0 0.4793190826734486
Vwp_ih_52_1 wp_ih_52_1 0 0.354409244374433
Vwn_ih_52_1 wn_ih_52_1 0 0.645590755625567
Vwp_ih_53_1 wp_ih_53_1 0 0.48241151191638393
Vwn_ih_53_1 wn_ih_53_1 0 0.5175884880836161
Vwp_ih_54_1 wp_ih_54_1 0 0.38544328506142517
Vwn_ih_54_1 wn_ih_54_1 0 0.6145567149385749
Vwp_ih_55_1 wp_ih_55_1 0 0.46439214776313076
Vwn_ih_55_1 wn_ih_55_1 0 0.5356078522368692
Vwp_ih_56_1 wp_ih_56_1 0 0.3570552363854941
Vwn_ih_56_1 wn_ih_56_1 0 0.6429447636145059
Vwp_ih_57_1 wp_ih_57_1 0 0.40055150807123735
Vwn_ih_57_1 wn_ih_57_1 0 0.5994484919287626
Vwp_ih_58_1 wp_ih_58_1 0 0.3248338859263259
Vwn_ih_58_1 wn_ih_58_1 0 0.6751661140736741
Vwp_ih_59_1 wp_ih_59_1 0 0.6334997563607401
Vwn_ih_59_1 wn_ih_59_1 0 0.3665002436392599
Vwp_ih_60_1 wp_ih_60_1 0 0.5404091054288569
Vwn_ih_60_1 wn_ih_60_1 0 0.45959089457114316
Vwp_ih_61_1 wp_ih_61_1 0 0.3198848519955422
Vwn_ih_61_1 wn_ih_61_1 0 0.6801151480044578
Vwp_ih_62_1 wp_ih_62_1 0 0.5104120232068469
Vwn_ih_62_1 wn_ih_62_1 0 0.48958797679315313
Vwp_ih_63_1 wp_ih_63_1 0 0.4464756302941264
Vwn_ih_63_1 wn_ih_63_1 0 0.5535243697058736
Vwp_ho_1_0 wp_ho_1_0 0 0.6109226344913326
Vwn_ho_1_0 wn_ho_1_0 0 0.3890773655086674
Vwp_ho_1_1 wp_ho_1_1 0 0.30283434344126503
Vwn_ho_1_1 wn_ho_1_1 0 0.697165656558735
Vwp_ho_1_2 wp_ho_1_2 0 0.3059451597142293
Vwn_ho_1_2 wn_ho_1_2 0 0.6940548402857707
Vwp_ho_1_3 wp_ho_1_3 0 0.575060481598217
Vwn_ho_1_3 wn_ho_1_3 0 0.424939518401783
Vwp_ho_1_4 wp_ho_1_4 0 0.4577072050331914
Vwn_ho_1_4 wn_ho_1_4 0 0.5422927949668086
Vwp_ih_0_2 wp_ih_0_2 0 0.4170867046197684
Vwn_ih_0_2 wn_ih_0_2 0 0.5829132953802316
Vwp_ih_1_2 wp_ih_1_2 0 0.3411098854333976
Vwn_ih_1_2 wn_ih_1_2 0 0.6588901145666024
Vwp_ih_2_2 wp_ih_2_2 0 0.5993307932827339
Vwn_ih_2_2 wn_ih_2_2 0 0.4006692067172662
Vwp_ih_3_2 wp_ih_3_2 0 0.4590708143617624
Vwn_ih_3_2 wn_ih_3_2 0 0.5409291856382377
Vwp_ih_4_2 wp_ih_4_2 0 0.534740734583718
Vwn_ih_4_2 wn_ih_4_2 0 0.46525926541628204
Vwp_ih_5_2 wp_ih_5_2 0 0.5315649723139237
Vwn_ih_5_2 wn_ih_5_2 0 0.4684350276860763
Vwp_ih_6_2 wp_ih_6_2 0 0.6536394362133409
Vwn_ih_6_2 wn_ih_6_2 0 0.34636056378665914
Vwp_ih_7_2 wp_ih_7_2 0 0.3
Vwn_ih_7_2 wn_ih_7_2 0 0.7200646312104308
Vwp_ih_8_2 wp_ih_8_2 0 0.7075549066065
Vwn_ih_8_2 wn_ih_8_2 0 0.3
Vwp_ih_9_2 wp_ih_9_2 0 0.6636432892095847
Vwn_ih_9_2 wn_ih_9_2 0 0.3363567107904153
Vwp_ih_10_2 wp_ih_10_2 0 0.5435071092018654
Vwn_ih_10_2 wn_ih_10_2 0 0.45649289079813454
Vwp_ih_11_2 wp_ih_11_2 0 0.8040943577865188
Vwn_ih_11_2 wn_ih_11_2 0 0.3
Vwp_ih_12_2 wp_ih_12_2 0 0.5513064914093112
Vwn_ih_12_2 wn_ih_12_2 0 0.4486935085906888
Vwp_ih_13_2 wp_ih_13_2 0 0.554266527930504
Vwn_ih_13_2 wn_ih_13_2 0 0.44573347206949604
Vwp_ih_14_2 wp_ih_14_2 0 0.40844134363713225
Vwn_ih_14_2 wn_ih_14_2 0 0.5915586563628678
Vwp_ih_15_2 wp_ih_15_2 0 0.6334591041185814
Vwn_ih_15_2 wn_ih_15_2 0 0.3665408958814186
Vwp_ih_16_2 wp_ih_16_2 0 0.5193253315729724
Vwn_ih_16_2 wn_ih_16_2 0 0.48067466842702755
Vwp_ih_17_2 wp_ih_17_2 0 0.4363485767539943
Vwn_ih_17_2 wn_ih_17_2 0 0.5636514232460057
Vwp_ih_18_2 wp_ih_18_2 0 0.7410329648615743
Vwn_ih_18_2 wn_ih_18_2 0 0.3
Vwp_ih_19_2 wp_ih_19_2 0 0.5010692468824711
Vwn_ih_19_2 wn_ih_19_2 0 0.4989307531175288
Vwp_ih_20_2 wp_ih_20_2 0 0.5180697147859302
Vwn_ih_20_2 wn_ih_20_2 0 0.4819302852140697
Vwp_ih_21_2 wp_ih_21_2 0 0.4667557956035756
Vwn_ih_21_2 wn_ih_21_2 0 0.5332442043964244
Vwp_ih_22_2 wp_ih_22_2 0 0.41649362152424185
Vwn_ih_22_2 wn_ih_22_2 0 0.5835063784757581
Vwp_ih_23_2 wp_ih_23_2 0 0.5609346755967956
Vwn_ih_23_2 wn_ih_23_2 0 0.4390653244032044
Vwp_ih_24_2 wp_ih_24_2 0 0.588000446788162
Vwn_ih_24_2 wn_ih_24_2 0 0.41199955321183795
Vwp_ih_25_2 wp_ih_25_2 0 0.5433523739389305
Vwn_ih_25_2 wn_ih_25_2 0 0.45664762606106946
Vwp_ih_26_2 wp_ih_26_2 0 0.3
Vwn_ih_26_2 wn_ih_26_2 0 0.7616585341405399
Vwp_ih_27_2 wp_ih_27_2 0 0.6389547013566286
Vwn_ih_27_2 wn_ih_27_2 0 0.3610452986433715
Vwp_ih_28_2 wp_ih_28_2 0 0.4668698238182549
Vwn_ih_28_2 wn_ih_28_2 0 0.5331301761817451
Vwp_ih_29_2 wp_ih_29_2 0 0.35914300025703905
Vwn_ih_29_2 wn_ih_29_2 0 0.640856999742961
Vwp_ih_30_2 wp_ih_30_2 0 0.5752143798681485
Vwn_ih_30_2 wn_ih_30_2 0 0.42478562013185145
Vwp_ih_31_2 wp_ih_31_2 0 0.5666806031119082
Vwn_ih_31_2 wn_ih_31_2 0 0.43331939688809185
Vwp_ih_32_2 wp_ih_32_2 0 0.3748311557262396
Vwn_ih_32_2 wn_ih_32_2 0 0.6251688442737604
Vwp_ih_33_2 wp_ih_33_2 0 0.8138467222853352
Vwn_ih_33_2 wn_ih_33_2 0 0.3
Vwp_ih_34_2 wp_ih_34_2 0 0.3897517202238783
Vwn_ih_34_2 wn_ih_34_2 0 0.6102482797761217
Vwp_ih_35_2 wp_ih_35_2 0 0.3421163522793522
Vwn_ih_35_2 wn_ih_35_2 0 0.6578836477206478
Vwp_ih_36_2 wp_ih_36_2 0 0.38460583403680526
Vwn_ih_36_2 wn_ih_36_2 0 0.6153941659631947
Vwp_ih_37_2 wp_ih_37_2 0 0.643035642341521
Vwn_ih_37_2 wn_ih_37_2 0 0.356964357658479
Vwp_ih_38_2 wp_ih_38_2 0 0.4690244187477411
Vwn_ih_38_2 wn_ih_38_2 0 0.530975581252259
Vwp_ih_39_2 wp_ih_39_2 0 0.455353197458217
Vwn_ih_39_2 wn_ih_39_2 0 0.544646802541783
Vwp_ih_40_2 wp_ih_40_2 0 0.4971600474997867
Vwn_ih_40_2 wn_ih_40_2 0 0.5028399525002133
Vwp_ih_41_2 wp_ih_41_2 0 0.4456744876558056
Vwn_ih_41_2 wn_ih_41_2 0 0.5543255123441945
Vwp_ih_42_2 wp_ih_42_2 0 0.4382449919175977
Vwn_ih_42_2 wn_ih_42_2 0 0.5617550080824023
Vwp_ih_43_2 wp_ih_43_2 0 0.48773383448922825
Vwn_ih_43_2 wn_ih_43_2 0 0.5122661655107718
Vwp_ih_44_2 wp_ih_44_2 0 0.6188442419747148
Vwn_ih_44_2 wn_ih_44_2 0 0.38115575802528523
Vwp_ih_45_2 wp_ih_45_2 0 0.6018856096083508
Vwn_ih_45_2 wn_ih_45_2 0 0.39811439039164925
Vwp_ih_46_2 wp_ih_46_2 0 0.3459501935324896
Vwn_ih_46_2 wn_ih_46_2 0 0.6540498064675104
Vwp_ih_47_2 wp_ih_47_2 0 0.5270890398971322
Vwn_ih_47_2 wn_ih_47_2 0 0.4729109601028678
Vwp_ih_48_2 wp_ih_48_2 0 0.5927540470284376
Vwn_ih_48_2 wn_ih_48_2 0 0.40724595297156235
Vwp_ih_49_2 wp_ih_49_2 0 0.37701069648759433
Vwn_ih_49_2 wn_ih_49_2 0 0.6229893035124057
Vwp_ih_50_2 wp_ih_50_2 0 0.4468711330450794
Vwn_ih_50_2 wn_ih_50_2 0 0.5531288669549206
Vwp_ih_51_2 wp_ih_51_2 0 0.40809650711023315
Vwn_ih_51_2 wn_ih_51_2 0 0.5919034928897668
Vwp_ih_52_2 wp_ih_52_2 0 0.3791980519772769
Vwn_ih_52_2 wn_ih_52_2 0 0.6208019480227231
Vwp_ih_53_2 wp_ih_53_2 0 0.5017123185732341
Vwn_ih_53_2 wn_ih_53_2 0 0.498287681426766
Vwp_ih_54_2 wp_ih_54_2 0 0.4035614379246156
Vwn_ih_54_2 wn_ih_54_2 0 0.5964385620753845
Vwp_ih_55_2 wp_ih_55_2 0 0.575019935784982
Vwn_ih_55_2 wn_ih_55_2 0 0.424980064215018
Vwp_ih_56_2 wp_ih_56_2 0 0.49603907457074053
Vwn_ih_56_2 wn_ih_56_2 0 0.5039609254292595
Vwp_ih_57_2 wp_ih_57_2 0 0.559597325364084
Vwn_ih_57_2 wn_ih_57_2 0 0.440402674635916
Vwp_ih_58_2 wp_ih_58_2 0 0.4777115725913134
Vwn_ih_58_2 wn_ih_58_2 0 0.5222884274086866
Vwp_ih_59_2 wp_ih_59_2 0 0.4256117282613834
Vwn_ih_59_2 wn_ih_59_2 0 0.5743882717386166
Vwp_ih_60_2 wp_ih_60_2 0 0.4888759955351991
Vwn_ih_60_2 wn_ih_60_2 0 0.5111240044648009
Vwp_ih_61_2 wp_ih_61_2 0 0.48412848173526807
Vwn_ih_61_2 wn_ih_61_2 0 0.5158715182647319
Vwp_ih_62_2 wp_ih_62_2 0 0.4145450590506631
Vwn_ih_62_2 wn_ih_62_2 0 0.5854549409493369
Vwp_ih_63_2 wp_ih_63_2 0 0.5435484473810637
Vwn_ih_63_2 wn_ih_63_2 0 0.45645155261893633
Vwp_ho_2_0 wp_ho_2_0 0 0.5022451796004863
Vwn_ho_2_0 wn_ho_2_0 0 0.49775482039951374
Vwp_ho_2_1 wp_ho_2_1 0 0.49444803845360985
Vwn_ho_2_1 wn_ho_2_1 0 0.5055519615463901
Vwp_ho_2_2 wp_ho_2_2 0 0.38864300104055804
Vwn_ho_2_2 wn_ho_2_2 0 0.611356998959442
Vwp_ho_2_3 wp_ho_2_3 0 0.45084418983579144
Vwn_ho_2_3 wn_ho_2_3 0 0.5491558101642086
Vwp_ho_2_4 wp_ho_2_4 0 0.5661523392179733
Vwn_ho_2_4 wn_ho_2_4 0 0.43384766078202674
Vwp_ih_0_3 wp_ih_0_3 0 0.5895913827171763
Vwn_ih_0_3 wn_ih_0_3 0 0.41040861728282374
Vwp_ih_1_3 wp_ih_1_3 0 0.4986492556028188
Vwn_ih_1_3 wn_ih_1_3 0 0.5013507443971812
Vwp_ih_2_3 wp_ih_2_3 0 0.6809461747817567
Vwn_ih_2_3 wn_ih_2_3 0 0.3190538252182433
Vwp_ih_3_3 wp_ih_3_3 0 0.4219635108526225
Vwn_ih_3_3 wn_ih_3_3 0 0.5780364891473775
Vwp_ih_4_3 wp_ih_4_3 0 0.5642938872846165
Vwn_ih_4_3 wn_ih_4_3 0 0.43570611271538356
Vwp_ih_5_3 wp_ih_5_3 0 0.4469009715836773
Vwn_ih_5_3 wn_ih_5_3 0 0.5530990284163226
Vwp_ih_6_3 wp_ih_6_3 0 0.5220382175228062
Vwn_ih_6_3 wn_ih_6_3 0 0.47796178247719373
Vwp_ih_7_3 wp_ih_7_3 0 0.3980828937948838
Vwn_ih_7_3 wn_ih_7_3 0 0.6019171062051162
Vwp_ih_8_3 wp_ih_8_3 0 0.632717032226589
Vwn_ih_8_3 wn_ih_8_3 0 0.36728296777341096
Vwp_ih_9_3 wp_ih_9_3 0 0.48678988394589423
Vwn_ih_9_3 wn_ih_9_3 0 0.5132101160541057
Vwp_ih_10_3 wp_ih_10_3 0 0.624189532307575
Vwn_ih_10_3 wn_ih_10_3 0 0.37581046769242504
Vwp_ih_11_3 wp_ih_11_3 0 0.3860084174073308
Vwn_ih_11_3 wn_ih_11_3 0 0.6139915825926692
Vwp_ih_12_3 wp_ih_12_3 0 0.45230567854724124
Vwn_ih_12_3 wn_ih_12_3 0 0.5476943214527588
Vwp_ih_13_3 wp_ih_13_3 0 0.39578490741219446
Vwn_ih_13_3 wn_ih_13_3 0 0.6042150925878055
Vwp_ih_14_3 wp_ih_14_3 0 0.4416894976034515
Vwn_ih_14_3 wn_ih_14_3 0 0.5583105023965484
Vwp_ih_15_3 wp_ih_15_3 0 0.415646654782086
Vwn_ih_15_3 wn_ih_15_3 0 0.5843533452179139
Vwp_ih_16_3 wp_ih_16_3 0 0.48470587388467623
Vwn_ih_16_3 wn_ih_16_3 0 0.5152941261153238
Vwp_ih_17_3 wp_ih_17_3 0 0.4891396002232645
Vwn_ih_17_3 wn_ih_17_3 0 0.5108603997767355
Vwp_ih_18_3 wp_ih_18_3 0 0.509039691890314
Vwn_ih_18_3 wn_ih_18_3 0 0.4909603081096861
Vwp_ih_19_3 wp_ih_19_3 0 0.4670325777182236
Vwn_ih_19_3 wn_ih_19_3 0 0.5329674222817764
Vwp_ih_20_3 wp_ih_20_3 0 0.5120670797418423
Vwn_ih_20_3 wn_ih_20_3 0 0.4879329202581577
Vwp_ih_21_3 wp_ih_21_3 0 0.6019805386566737
Vwn_ih_21_3 wn_ih_21_3 0 0.39801946134332633
Vwp_ih_22_3 wp_ih_22_3 0 0.4052225227136298
Vwn_ih_22_3 wn_ih_22_3 0 0.5947774772863702
Vwp_ih_23_3 wp_ih_23_3 0 0.5010348495636798
Vwn_ih_23_3 wn_ih_23_3 0 0.4989651504363201
Vwp_ih_24_3 wp_ih_24_3 0 0.49049124669393135
Vwn_ih_24_3 wn_ih_24_3 0 0.5095087533060686
Vwp_ih_25_3 wp_ih_25_3 0 0.5584515961230205
Vwn_ih_25_3 wn_ih_25_3 0 0.4415484038769795
Vwp_ih_26_3 wp_ih_26_3 0 0.5068390436225874
Vwn_ih_26_3 wn_ih_26_3 0 0.49316095637741264
Vwp_ih_27_3 wp_ih_27_3 0 0.5027562847300495
Vwn_ih_27_3 wn_ih_27_3 0 0.49724371526995054
Vwp_ih_28_3 wp_ih_28_3 0 0.36100656538209774
Vwn_ih_28_3 wn_ih_28_3 0 0.6389934346179023
Vwp_ih_29_3 wp_ih_29_3 0 0.49352636168191566
Vwn_ih_29_3 wn_ih_29_3 0 0.5064736383180843
Vwp_ih_30_3 wp_ih_30_3 0 0.4048343603080913
Vwn_ih_30_3 wn_ih_30_3 0 0.5951656396919087
Vwp_ih_31_3 wp_ih_31_3 0 0.5610068518419713
Vwn_ih_31_3 wn_ih_31_3 0 0.43899314815802865
Vwp_ih_32_3 wp_ih_32_3 0 0.4876137278856174
Vwn_ih_32_3 wn_ih_32_3 0 0.5123862721143826
Vwp_ih_33_3 wp_ih_33_3 0 0.5052862273343102
Vwn_ih_33_3 wn_ih_33_3 0 0.49471377266568983
Vwp_ih_34_3 wp_ih_34_3 0 0.40724057054780505
Vwn_ih_34_3 wn_ih_34_3 0 0.592759429452195
Vwp_ih_35_3 wp_ih_35_3 0 0.5952598503042185
Vwn_ih_35_3 wn_ih_35_3 0 0.4047401496957815
Vwp_ih_36_3 wp_ih_36_3 0 0.5663271749262327
Vwn_ih_36_3 wn_ih_36_3 0 0.4336728250737673
Vwp_ih_37_3 wp_ih_37_3 0 0.5740491176832689
Vwn_ih_37_3 wn_ih_37_3 0 0.4259508823167311
Vwp_ih_38_3 wp_ih_38_3 0 0.7589755186508409
Vwn_ih_38_3 wn_ih_38_3 0 0.3
Vwp_ih_39_3 wp_ih_39_3 0 0.4936976741248312
Vwn_ih_39_3 wn_ih_39_3 0 0.5063023258751689
Vwp_ih_40_3 wp_ih_40_3 0 0.639068805861839
Vwn_ih_40_3 wn_ih_40_3 0 0.36093119413816094
Vwp_ih_41_3 wp_ih_41_3 0 0.48384421114740234
Vwn_ih_41_3 wn_ih_41_3 0 0.5161557888525976
Vwp_ih_42_3 wp_ih_42_3 0 0.5631148541897543
Vwn_ih_42_3 wn_ih_42_3 0 0.4368851458102457
Vwp_ih_43_3 wp_ih_43_3 0 0.5485240915006657
Vwn_ih_43_3 wn_ih_43_3 0 0.4514759084993342
Vwp_ih_44_3 wp_ih_44_3 0 0.5339058792243986
Vwn_ih_44_3 wn_ih_44_3 0 0.4660941207756014
Vwp_ih_45_3 wp_ih_45_3 0 0.5629907096104385
Vwn_ih_45_3 wn_ih_45_3 0 0.43700929038956154
Vwp_ih_46_3 wp_ih_46_3 0 0.44757982921604095
Vwn_ih_46_3 wn_ih_46_3 0 0.552420170783959
Vwp_ih_47_3 wp_ih_47_3 0 0.5032628740968333
Vwn_ih_47_3 wn_ih_47_3 0 0.4967371259031667
Vwp_ih_48_3 wp_ih_48_3 0 0.5621222623700128
Vwn_ih_48_3 wn_ih_48_3 0 0.4378777376299871
Vwp_ih_49_3 wp_ih_49_3 0 0.7005087911201561
Vwn_ih_49_3 wn_ih_49_3 0 0.3
Vwp_ih_50_3 wp_ih_50_3 0 0.4223211170210353
Vwn_ih_50_3 wn_ih_50_3 0 0.5776788829789647
Vwp_ih_51_3 wp_ih_51_3 0 0.31194987327685253
Vwn_ih_51_3 wn_ih_51_3 0 0.6880501267231475
Vwp_ih_52_3 wp_ih_52_3 0 0.46174879174407135
Vwn_ih_52_3 wn_ih_52_3 0 0.5382512082559286
Vwp_ih_53_3 wp_ih_53_3 0 0.5072802286428076
Vwn_ih_53_3 wn_ih_53_3 0 0.4927197713571923
Vwp_ih_54_3 wp_ih_54_3 0 0.5087475991273168
Vwn_ih_54_3 wn_ih_54_3 0 0.4912524008726832
Vwp_ih_55_3 wp_ih_55_3 0 0.5134896364782554
Vwn_ih_55_3 wn_ih_55_3 0 0.4865103635217446
Vwp_ih_56_3 wp_ih_56_3 0 0.6414963616988923
Vwn_ih_56_3 wn_ih_56_3 0 0.35850363830110765
Vwp_ih_57_3 wp_ih_57_3 0 0.6002694230054678
Vwn_ih_57_3 wn_ih_57_3 0 0.3997305769945322
Vwp_ih_58_3 wp_ih_58_3 0 0.47201782004501786
Vwn_ih_58_3 wn_ih_58_3 0 0.5279821799549821
Vwp_ih_59_3 wp_ih_59_3 0 0.44282491351214065
Vwn_ih_59_3 wn_ih_59_3 0 0.5571750864878594
Vwp_ih_60_3 wp_ih_60_3 0 0.4770102863955422
Vwn_ih_60_3 wn_ih_60_3 0 0.5229897136044578
Vwp_ih_61_3 wp_ih_61_3 0 0.4642913430617312
Vwn_ih_61_3 wn_ih_61_3 0 0.5357086569382687
Vwp_ih_62_3 wp_ih_62_3 0 0.48322714890861873
Vwn_ih_62_3 wn_ih_62_3 0 0.5167728510913813
Vwp_ih_63_3 wp_ih_63_3 0 0.3168663292369238
Vwn_ih_63_3 wn_ih_63_3 0 0.6831336707630762
Vwp_ho_3_0 wp_ho_3_0 0 0.4794273027125816
Vwn_ho_3_0 wn_ho_3_0 0 0.5205726972874184
Vwp_ho_3_1 wp_ho_3_1 0 0.46261478211145757
Vwn_ho_3_1 wn_ho_3_1 0 0.5373852178885424
Vwp_ho_3_2 wp_ho_3_2 0 0.5410201258301472
Vwn_ho_3_2 wn_ho_3_2 0 0.45897987416985275
Vwp_ho_3_3 wp_ho_3_3 0 0.3655542642860584
Vwn_ho_3_3 wn_ho_3_3 0 0.6344457357139416
Vwp_ho_3_4 wp_ho_3_4 0 0.515024838487757
Vwn_ho_3_4 wn_ho_3_4 0 0.48497516151224296
Vwp_ih_0_4 wp_ih_0_4 0 0.44467511076288524
Vwn_ih_0_4 wn_ih_0_4 0 0.5553248892371148
Vwp_ih_1_4 wp_ih_1_4 0 0.4432269857091745
Vwn_ih_1_4 wn_ih_1_4 0 0.5567730142908255
Vwp_ih_2_4 wp_ih_2_4 0 0.4410405191078546
Vwn_ih_2_4 wn_ih_2_4 0 0.5589594808921454
Vwp_ih_3_4 wp_ih_3_4 0 0.40520889914322594
Vwn_ih_3_4 wn_ih_3_4 0 0.5947911008567741
Vwp_ih_4_4 wp_ih_4_4 0 0.5597975852591079
Vwn_ih_4_4 wn_ih_4_4 0 0.44020241474089206
Vwp_ih_5_4 wp_ih_5_4 0 0.4595392549404158
Vwn_ih_5_4 wn_ih_5_4 0 0.5404607450595842
Vwp_ih_6_4 wp_ih_6_4 0 0.4598892028366599
Vwn_ih_6_4 wn_ih_6_4 0 0.5401107971633401
Vwp_ih_7_4 wp_ih_7_4 0 0.5624397656233036
Vwn_ih_7_4 wn_ih_7_4 0 0.4375602343766964
Vwp_ih_8_4 wp_ih_8_4 0 0.4705370044424859
Vwn_ih_8_4 wn_ih_8_4 0 0.5294629955575141
Vwp_ih_9_4 wp_ih_9_4 0 0.5224382724506011
Vwn_ih_9_4 wn_ih_9_4 0 0.47756172754939885
Vwp_ih_10_4 wp_ih_10_4 0 0.5448838110061859
Vwn_ih_10_4 wn_ih_10_4 0 0.4551161889938141
Vwp_ih_11_4 wp_ih_11_4 0 0.5323861309473003
Vwn_ih_11_4 wn_ih_11_4 0 0.46761386905269975
Vwp_ih_12_4 wp_ih_12_4 0 0.550025762781284
Vwn_ih_12_4 wn_ih_12_4 0 0.44997423721871604
Vwp_ih_13_4 wp_ih_13_4 0 0.4854743789703855
Vwn_ih_13_4 wn_ih_13_4 0 0.5145256210296145
Vwp_ih_14_4 wp_ih_14_4 0 0.5842534449978998
Vwn_ih_14_4 wn_ih_14_4 0 0.41574655500210017
Vwp_ih_15_4 wp_ih_15_4 0 0.51678043525889
Vwn_ih_15_4 wn_ih_15_4 0 0.48321956474111
Vwp_ih_16_4 wp_ih_16_4 0 0.4384921921035377
Vwn_ih_16_4 wn_ih_16_4 0 0.5615078078964623
Vwp_ih_17_4 wp_ih_17_4 0 0.5022498269330387
Vwn_ih_17_4 wn_ih_17_4 0 0.49775017306696134
Vwp_ih_18_4 wp_ih_18_4 0 0.3761696498878536
Vwn_ih_18_4 wn_ih_18_4 0 0.6238303501121464
Vwp_ih_19_4 wp_ih_19_4 0 0.41264170216691165
Vwn_ih_19_4 wn_ih_19_4 0 0.5873582978330883
Vwp_ih_20_4 wp_ih_20_4 0 0.3
Vwn_ih_20_4 wn_ih_20_4 0 0.7026780430740813
Vwp_ih_21_4 wp_ih_21_4 0 0.43793806816369213
Vwn_ih_21_4 wn_ih_21_4 0 0.5620619318363079
Vwp_ih_22_4 wp_ih_22_4 0 0.6528000871801406
Vwn_ih_22_4 wn_ih_22_4 0 0.3471999128198594
Vwp_ih_23_4 wp_ih_23_4 0 0.42677866428893046
Vwn_ih_23_4 wn_ih_23_4 0 0.5732213357110695
Vwp_ih_24_4 wp_ih_24_4 0 0.593812646783489
Vwn_ih_24_4 wn_ih_24_4 0 0.40618735321651106
Vwp_ih_25_4 wp_ih_25_4 0 0.5093994746306316
Vwn_ih_25_4 wn_ih_25_4 0 0.49060052536936843
Vwp_ih_26_4 wp_ih_26_4 0 0.4289216155489591
Vwn_ih_26_4 wn_ih_26_4 0 0.5710783844510409
Vwp_ih_27_4 wp_ih_27_4 0 0.6437829163014843
Vwn_ih_27_4 wn_ih_27_4 0 0.3562170836985157
Vwp_ih_28_4 wp_ih_28_4 0 0.5697640470013967
Vwn_ih_28_4 wn_ih_28_4 0 0.43023595299860334
Vwp_ih_29_4 wp_ih_29_4 0 0.32923554227543717
Vwn_ih_29_4 wn_ih_29_4 0 0.6707644577245628
Vwp_ih_30_4 wp_ih_30_4 0 0.6176387162318692
Vwn_ih_30_4 wn_ih_30_4 0 0.38236128376813083
Vwp_ih_31_4 wp_ih_31_4 0 0.37004547499226287
Vwn_ih_31_4 wn_ih_31_4 0 0.6299545250077372
Vwp_ih_32_4 wp_ih_32_4 0 0.47865032641008426
Vwn_ih_32_4 wn_ih_32_4 0 0.5213496735899158
Vwp_ih_33_4 wp_ih_33_4 0 0.578341880294601
Vwn_ih_33_4 wn_ih_33_4 0 0.42165811970539896
Vwp_ih_34_4 wp_ih_34_4 0 0.4527108345197252
Vwn_ih_34_4 wn_ih_34_4 0 0.5472891654802748
Vwp_ih_35_4 wp_ih_35_4 0 0.5918493197759812
Vwn_ih_35_4 wn_ih_35_4 0 0.4081506802240188
Vwp_ih_36_4 wp_ih_36_4 0 0.5959601481540309
Vwn_ih_36_4 wn_ih_36_4 0 0.4040398518459692
Vwp_ih_37_4 wp_ih_37_4 0 0.3480212734025664
Vwn_ih_37_4 wn_ih_37_4 0 0.6519787265974336
Vwp_ih_38_4 wp_ih_38_4 0 0.4561385974114972
Vwn_ih_38_4 wn_ih_38_4 0 0.5438614025885028
Vwp_ih_39_4 wp_ih_39_4 0 0.5338488479865637
Vwn_ih_39_4 wn_ih_39_4 0 0.46615115201343627
Vwp_ih_40_4 wp_ih_40_4 0 0.43101462450972544
Vwn_ih_40_4 wn_ih_40_4 0 0.5689853754902746
Vwp_ih_41_4 wp_ih_41_4 0 0.47398533788190433
Vwn_ih_41_4 wn_ih_41_4 0 0.5260146621180957
Vwp_ih_42_4 wp_ih_42_4 0 0.5773010475292603
Vwn_ih_42_4 wn_ih_42_4 0 0.42269895247073974
Vwp_ih_43_4 wp_ih_43_4 0 0.5217820345920949
Vwn_ih_43_4 wn_ih_43_4 0 0.47821796540790507
Vwp_ih_44_4 wp_ih_44_4 0 0.41574264997032434
Vwn_ih_44_4 wn_ih_44_4 0 0.5842573500296757
Vwp_ih_45_4 wp_ih_45_4 0 0.5451953290668183
Vwn_ih_45_4 wn_ih_45_4 0 0.45480467093318167
Vwp_ih_46_4 wp_ih_46_4 0 0.4422759172782035
Vwn_ih_46_4 wn_ih_46_4 0 0.5577240827217965
Vwp_ih_47_4 wp_ih_47_4 0 0.352336484199137
Vwn_ih_47_4 wn_ih_47_4 0 0.647663515800863
Vwp_ih_48_4 wp_ih_48_4 0 0.3659033290417687
Vwn_ih_48_4 wn_ih_48_4 0 0.6340966709582313
Vwp_ih_49_4 wp_ih_49_4 0 0.5168057481709372
Vwn_ih_49_4 wn_ih_49_4 0 0.4831942518290628
Vwp_ih_50_4 wp_ih_50_4 0 0.45889895584205287
Vwn_ih_50_4 wn_ih_50_4 0 0.5411010441579471
Vwp_ih_51_4 wp_ih_51_4 0 0.49290990104185345
Vwn_ih_51_4 wn_ih_51_4 0 0.5070900989581465
Vwp_ih_52_4 wp_ih_52_4 0 0.39382820714740335
Vwn_ih_52_4 wn_ih_52_4 0 0.6061717928525967
Vwp_ih_53_4 wp_ih_53_4 0 0.5040856434654477
Vwn_ih_53_4 wn_ih_53_4 0 0.4959143565345523
Vwp_ih_54_4 wp_ih_54_4 0 0.4141850950892233
Vwn_ih_54_4 wn_ih_54_4 0 0.5858149049107767
Vwp_ih_55_4 wp_ih_55_4 0 0.4012419208819857
Vwn_ih_55_4 wn_ih_55_4 0 0.5987580791180143
Vwp_ih_56_4 wp_ih_56_4 0 0.47969543598471986
Vwn_ih_56_4 wn_ih_56_4 0 0.5203045640152801
Vwp_ih_57_4 wp_ih_57_4 0 0.33491616291739135
Vwn_ih_57_4 wn_ih_57_4 0 0.6650838370826087
Vwp_ih_58_4 wp_ih_58_4 0 0.5388985545153178
Vwn_ih_58_4 wn_ih_58_4 0 0.46110144548468224
Vwp_ih_59_4 wp_ih_59_4 0 0.732611851193359
Vwn_ih_59_4 wn_ih_59_4 0 0.3
Vwp_ih_60_4 wp_ih_60_4 0 0.5480643671881508
Vwn_ih_60_4 wn_ih_60_4 0 0.4519356328118493
Vwp_ih_61_4 wp_ih_61_4 0 0.4095085522776947
Vwn_ih_61_4 wn_ih_61_4 0 0.5904914477223053
Vwp_ih_62_4 wp_ih_62_4 0 0.505613712810651
Vwn_ih_62_4 wn_ih_62_4 0 0.49438628718934896
Vwp_ih_63_4 wp_ih_63_4 0 0.3258218435397171
Vwn_ih_63_4 wn_ih_63_4 0 0.6741781564602829
Vwp_ho_4_0 wp_ho_4_0 0 0.46160537876195246
Vwn_ho_4_0 wn_ho_4_0 0 0.5383946212380476
Vwp_ho_4_1 wp_ho_4_1 0 0.3365793047940002
Vwn_ho_4_1 wn_ho_4_1 0 0.6634206952059998
Vwp_ho_4_2 wp_ho_4_2 0 0.37126206353651275
Vwn_ho_4_2 wn_ho_4_2 0 0.6287379364634873
Vwp_ho_4_3 wp_ho_4_3 0 0.5873507192170286
Vwn_ho_4_3 wn_ho_4_3 0 0.41264928078297136
Vwp_ho_4_4 wp_ho_4_4 0 0.4702051040770315
Vwn_ho_4_4 wn_ho_4_4 0 0.5297948959229686
Vwp_ih_0_5 wp_ih_0_5 0 0.4546860342449334
Vwn_ih_0_5 wn_ih_0_5 0 0.5453139657550665
Vwp_ih_1_5 wp_ih_1_5 0 0.551538174641617
Vwn_ih_1_5 wn_ih_1_5 0 0.4484618253583829
Vwp_ih_2_5 wp_ih_2_5 0 0.5521024704532564
Vwn_ih_2_5 wn_ih_2_5 0 0.4478975295467436
Vwp_ih_3_5 wp_ih_3_5 0 0.3722628809175579
Vwn_ih_3_5 wn_ih_3_5 0 0.6277371190824421
Vwp_ih_4_5 wp_ih_4_5 0 0.5347285981761429
Vwn_ih_4_5 wn_ih_4_5 0 0.46527140182385707
Vwp_ih_5_5 wp_ih_5_5 0 0.6123999401585489
Vwn_ih_5_5 wn_ih_5_5 0 0.387600059841451
Vwp_ih_6_5 wp_ih_6_5 0 0.7034672611188886
Vwn_ih_6_5 wn_ih_6_5 0 0.3
Vwp_ih_7_5 wp_ih_7_5 0 0.4170159370674478
Vwn_ih_7_5 wn_ih_7_5 0 0.5829840629325522
Vwp_ih_8_5 wp_ih_8_5 0 0.39682113115877776
Vwn_ih_8_5 wn_ih_8_5 0 0.6031788688412223
Vwp_ih_9_5 wp_ih_9_5 0 0.49864557772398777
Vwn_ih_9_5 wn_ih_9_5 0 0.5013544222760122
Vwp_ih_10_5 wp_ih_10_5 0 0.3
Vwn_ih_10_5 wn_ih_10_5 0 0.8795338723615018
Vwp_ih_11_5 wp_ih_11_5 0 0.47780696240640663
Vwn_ih_11_5 wn_ih_11_5 0 0.5221930375935934
Vwp_ih_12_5 wp_ih_12_5 0 0.48993939826651256
Vwn_ih_12_5 wn_ih_12_5 0 0.5100606017334874
Vwp_ih_13_5 wp_ih_13_5 0 0.391118271774327
Vwn_ih_13_5 wn_ih_13_5 0 0.608881728225673
Vwp_ih_14_5 wp_ih_14_5 0 0.3052658437765502
Vwn_ih_14_5 wn_ih_14_5 0 0.6947341562234498
Vwp_ih_15_5 wp_ih_15_5 0 0.4739318821485443
Vwn_ih_15_5 wn_ih_15_5 0 0.5260681178514557
Vwp_ih_16_5 wp_ih_16_5 0 0.4072036298293809
Vwn_ih_16_5 wn_ih_16_5 0 0.5927963701706191
Vwp_ih_17_5 wp_ih_17_5 0 0.5780362565559983
Vwn_ih_17_5 wn_ih_17_5 0 0.42196374344400167
Vwp_ih_18_5 wp_ih_18_5 0 0.41792602395092776
Vwn_ih_18_5 wn_ih_18_5 0 0.5820739760490722
Vwp_ih_19_5 wp_ih_19_5 0 0.5343866697069081
Vwn_ih_19_5 wn_ih_19_5 0 0.465613330293092
Vwp_ih_20_5 wp_ih_20_5 0 0.4587754778036839
Vwn_ih_20_5 wn_ih_20_5 0 0.5412245221963161
Vwp_ih_21_5 wp_ih_21_5 0 0.5484766167819112
Vwn_ih_21_5 wn_ih_21_5 0 0.4515233832180888
Vwp_ih_22_5 wp_ih_22_5 0 0.3
Vwn_ih_22_5 wn_ih_22_5 0 0.7680265597832867
Vwp_ih_23_5 wp_ih_23_5 0 0.46591052422139156
Vwn_ih_23_5 wn_ih_23_5 0 0.5340894757786084
Vwp_ih_24_5 wp_ih_24_5 0 0.5914505201458912
Vwn_ih_24_5 wn_ih_24_5 0 0.40854947985410883
Vwp_ih_25_5 wp_ih_25_5 0 0.49396750298120135
Vwn_ih_25_5 wn_ih_25_5 0 0.5060324970187986
Vwp_ih_26_5 wp_ih_26_5 0 0.3945417880133089
Vwn_ih_26_5 wn_ih_26_5 0 0.605458211986691
Vwp_ih_27_5 wp_ih_27_5 0 0.585190740257854
Vwn_ih_27_5 wn_ih_27_5 0 0.414809259742146
Vwp_ih_28_5 wp_ih_28_5 0 0.5147283094683287
Vwn_ih_28_5 wn_ih_28_5 0 0.4852716905316713
Vwp_ih_29_5 wp_ih_29_5 0 0.49604652226465007
Vwn_ih_29_5 wn_ih_29_5 0 0.5039534777353499
Vwp_ih_30_5 wp_ih_30_5 0 0.4110281054230203
Vwn_ih_30_5 wn_ih_30_5 0 0.5889718945769797
Vwp_ih_31_5 wp_ih_31_5 0 0.4115388204977988
Vwn_ih_31_5 wn_ih_31_5 0 0.5884611795022012
Vwp_ih_32_5 wp_ih_32_5 0 0.46234921892762876
Vwn_ih_32_5 wn_ih_32_5 0 0.5376507810723712
Vwp_ih_33_5 wp_ih_33_5 0 0.4486934768940245
Vwn_ih_33_5 wn_ih_33_5 0 0.5513065231059755
Vwp_ih_34_5 wp_ih_34_5 0 0.33171380802409545
Vwn_ih_34_5 wn_ih_34_5 0 0.6682861919759046
Vwp_ih_35_5 wp_ih_35_5 0 0.4702366234228731
Vwn_ih_35_5 wn_ih_35_5 0 0.5297633765771269
Vwp_ih_36_5 wp_ih_36_5 0 0.5132565498423403
Vwn_ih_36_5 wn_ih_36_5 0 0.48674345015765974
Vwp_ih_37_5 wp_ih_37_5 0 0.4587130382360717
Vwn_ih_37_5 wn_ih_37_5 0 0.5412869617639283
Vwp_ih_38_5 wp_ih_38_5 0 0.5160575590162146
Vwn_ih_38_5 wn_ih_38_5 0 0.48394244098378536
Vwp_ih_39_5 wp_ih_39_5 0 0.5100389574755508
Vwn_ih_39_5 wn_ih_39_5 0 0.48996104252444916
Vwp_ih_40_5 wp_ih_40_5 0 0.6210791416641162
Vwn_ih_40_5 wn_ih_40_5 0 0.37892085833588385
Vwp_ih_41_5 wp_ih_41_5 0 0.7674126078415834
Vwn_ih_41_5 wn_ih_41_5 0 0.3
Vwp_ih_42_5 wp_ih_42_5 0 0.5891440876507572
Vwn_ih_42_5 wn_ih_42_5 0 0.41085591234924285
Vwp_ih_43_5 wp_ih_43_5 0 0.3836418094623095
Vwn_ih_43_5 wn_ih_43_5 0 0.6163581905376905
Vwp_ih_44_5 wp_ih_44_5 0 0.3
Vwn_ih_44_5 wn_ih_44_5 0 0.7762283424146519
Vwp_ih_45_5 wp_ih_45_5 0 0.5092181040653657
Vwn_ih_45_5 wn_ih_45_5 0 0.4907818959346343
Vwp_ih_46_5 wp_ih_46_5 0 0.4951732289937177
Vwn_ih_46_5 wn_ih_46_5 0 0.5048267710062824
Vwp_ih_47_5 wp_ih_47_5 0 0.3613640216299802
Vwn_ih_47_5 wn_ih_47_5 0 0.6386359783700197
Vwp_ih_48_5 wp_ih_48_5 0 0.5274676392581819
Vwn_ih_48_5 wn_ih_48_5 0 0.47253236074181815
Vwp_ih_49_5 wp_ih_49_5 0 0.39119287681602083
Vwn_ih_49_5 wn_ih_49_5 0 0.6088071231839791
Vwp_ih_50_5 wp_ih_50_5 0 0.5149526846868355
Vwn_ih_50_5 wn_ih_50_5 0 0.4850473153131645
Vwp_ih_51_5 wp_ih_51_5 0 0.46721322609032134
Vwn_ih_51_5 wn_ih_51_5 0 0.5327867739096787
Vwp_ih_52_5 wp_ih_52_5 0 0.5823282581289119
Vwn_ih_52_5 wn_ih_52_5 0 0.41767174187108813
Vwp_ih_53_5 wp_ih_53_5 0 0.3
Vwn_ih_53_5 wn_ih_53_5 0 0.7031938888313403
Vwp_ih_54_5 wp_ih_54_5 0 0.4222561230599937
Vwn_ih_54_5 wn_ih_54_5 0 0.5777438769400063
Vwp_ih_55_5 wp_ih_55_5 0 0.47180145884510166
Vwn_ih_55_5 wn_ih_55_5 0 0.5281985411548984
Vwp_ih_56_5 wp_ih_56_5 0 0.32922477213021495
Vwn_ih_56_5 wn_ih_56_5 0 0.670775227869785
Vwp_ih_57_5 wp_ih_57_5 0 0.7056303297560689
Vwn_ih_57_5 wn_ih_57_5 0 0.3
Vwp_ih_58_5 wp_ih_58_5 0 0.41943639470993144
Vwn_ih_58_5 wn_ih_58_5 0 0.5805636052900686
Vwp_ih_59_5 wp_ih_59_5 0 0.6590171238408634
Vwn_ih_59_5 wn_ih_59_5 0 0.3409828761591366
Vwp_ih_60_5 wp_ih_60_5 0 0.42352868630978835
Vwn_ih_60_5 wn_ih_60_5 0 0.5764713136902117
Vwp_ih_61_5 wp_ih_61_5 0 0.43383593495359524
Vwn_ih_61_5 wn_ih_61_5 0 0.5661640650464048
Vwp_ih_62_5 wp_ih_62_5 0 0.5939582616904463
Vwn_ih_62_5 wn_ih_62_5 0 0.4060417383095537
Vwp_ih_63_5 wp_ih_63_5 0 0.5229100178677313
Vwn_ih_63_5 wn_ih_63_5 0 0.47708998213226866
Vwp_ho_5_0 wp_ho_5_0 0 0.42752559202988316
Vwn_ho_5_0 wn_ho_5_0 0 0.5724744079701168
Vwp_ho_5_1 wp_ho_5_1 0 0.6709143968871663
Vwn_ho_5_1 wn_ho_5_1 0 0.32908560311283375
Vwp_ho_5_2 wp_ho_5_2 0 0.33404506119769983
Vwn_ho_5_2 wn_ho_5_2 0 0.6659549388023002
Vwp_ho_5_3 wp_ho_5_3 0 0.37359462573596997
Vwn_ho_5_3 wn_ho_5_3 0 0.6264053742640301
Vwp_ho_5_4 wp_ho_5_4 0 0.5699351178876334
Vwn_ho_5_4 wn_ho_5_4 0 0.43006488211236654
Vwp_ih_0_6 wp_ih_0_6 0 0.5230465220347833
Vwn_ih_0_6 wn_ih_0_6 0 0.4769534779652167
Vwp_ih_1_6 wp_ih_1_6 0 0.5623852116583544
Vwn_ih_1_6 wn_ih_1_6 0 0.43761478834164563
Vwp_ih_2_6 wp_ih_2_6 0 0.39383131691054096
Vwn_ih_2_6 wn_ih_2_6 0 0.606168683089459
Vwp_ih_3_6 wp_ih_3_6 0 0.5066403220766929
Vwn_ih_3_6 wn_ih_3_6 0 0.49335967792330715
Vwp_ih_4_6 wp_ih_4_6 0 0.376200808903974
Vwn_ih_4_6 wn_ih_4_6 0 0.623799191096026
Vwp_ih_5_6 wp_ih_5_6 0 0.4942115926465661
Vwn_ih_5_6 wn_ih_5_6 0 0.5057884073534339
Vwp_ih_6_6 wp_ih_6_6 0 0.4232787607525362
Vwn_ih_6_6 wn_ih_6_6 0 0.5767212392474639
Vwp_ih_7_6 wp_ih_7_6 0 0.4953095462620337
Vwn_ih_7_6 wn_ih_7_6 0 0.5046904537379663
Vwp_ih_8_6 wp_ih_8_6 0 0.49100682265221607
Vwn_ih_8_6 wn_ih_8_6 0 0.5089931773477839
Vwp_ih_9_6 wp_ih_9_6 0 0.5289954721041403
Vwn_ih_9_6 wn_ih_9_6 0 0.4710045278958596
Vwp_ih_10_6 wp_ih_10_6 0 0.5177154221767797
Vwn_ih_10_6 wn_ih_10_6 0 0.48228457782322026
Vwp_ih_11_6 wp_ih_11_6 0 0.438953825054181
Vwn_ih_11_6 wn_ih_11_6 0 0.561046174945819
Vwp_ih_12_6 wp_ih_12_6 0 0.41689058368282156
Vwn_ih_12_6 wn_ih_12_6 0 0.5831094163171785
Vwp_ih_13_6 wp_ih_13_6 0 0.3934104751065845
Vwn_ih_13_6 wn_ih_13_6 0 0.6065895248934156
Vwp_ih_14_6 wp_ih_14_6 0 0.6095761110682605
Vwn_ih_14_6 wn_ih_14_6 0 0.39042388893173957
Vwp_ih_15_6 wp_ih_15_6 0 0.543750374879038
Vwn_ih_15_6 wn_ih_15_6 0 0.45624962512096207
Vwp_ih_16_6 wp_ih_16_6 0 0.5706476021368724
Vwn_ih_16_6 wn_ih_16_6 0 0.4293523978631276
Vwp_ih_17_6 wp_ih_17_6 0 0.6631735608661044
Vwn_ih_17_6 wn_ih_17_6 0 0.33682643913389565
Vwp_ih_18_6 wp_ih_18_6 0 0.3468741123577963
Vwn_ih_18_6 wn_ih_18_6 0 0.6531258876422037
Vwp_ih_19_6 wp_ih_19_6 0 0.5735000664029468
Vwn_ih_19_6 wn_ih_19_6 0 0.4264999335970531
Vwp_ih_20_6 wp_ih_20_6 0 0.4132389562146606
Vwn_ih_20_6 wn_ih_20_6 0 0.5867610437853394
Vwp_ih_21_6 wp_ih_21_6 0 0.4418330330265405
Vwn_ih_21_6 wn_ih_21_6 0 0.5581669669734595
Vwp_ih_22_6 wp_ih_22_6 0 0.5288550734742219
Vwn_ih_22_6 wn_ih_22_6 0 0.47114492652577805
Vwp_ih_23_6 wp_ih_23_6 0 0.6897003076413438
Vwn_ih_23_6 wn_ih_23_6 0 0.3102996923586562
Vwp_ih_24_6 wp_ih_24_6 0 0.40629949873041027
Vwn_ih_24_6 wn_ih_24_6 0 0.5937005012695897
Vwp_ih_25_6 wp_ih_25_6 0 0.47751277766481487
Vwn_ih_25_6 wn_ih_25_6 0 0.5224872223351851
Vwp_ih_26_6 wp_ih_26_6 0 0.6303065062250879
Vwn_ih_26_6 wn_ih_26_6 0 0.3696934937749121
Vwp_ih_27_6 wp_ih_27_6 0 0.3604277486267484
Vwn_ih_27_6 wn_ih_27_6 0 0.6395722513732516
Vwp_ih_28_6 wp_ih_28_6 0 0.5783270473180634
Vwn_ih_28_6 wn_ih_28_6 0 0.4216729526819366
Vwp_ih_29_6 wp_ih_29_6 0 0.4408891238858092
Vwn_ih_29_6 wn_ih_29_6 0 0.5591108761141907
Vwp_ih_30_6 wp_ih_30_6 0 0.3634812594384238
Vwn_ih_30_6 wn_ih_30_6 0 0.6365187405615762
Vwp_ih_31_6 wp_ih_31_6 0 0.5178210990138993
Vwn_ih_31_6 wn_ih_31_6 0 0.4821789009861008
Vwp_ih_32_6 wp_ih_32_6 0 0.5713911034216189
Vwn_ih_32_6 wn_ih_32_6 0 0.42860889657838114
Vwp_ih_33_6 wp_ih_33_6 0 0.3553729945129524
Vwn_ih_33_6 wn_ih_33_6 0 0.6446270054870475
Vwp_ih_34_6 wp_ih_34_6 0 0.5444135581780307
Vwn_ih_34_6 wn_ih_34_6 0 0.4555864418219693
Vwp_ih_35_6 wp_ih_35_6 0 0.5836172877275544
Vwn_ih_35_6 wn_ih_35_6 0 0.4163827122724456
Vwp_ih_36_6 wp_ih_36_6 0 0.38187688069380776
Vwn_ih_36_6 wn_ih_36_6 0 0.6181231193061922
Vwp_ih_37_6 wp_ih_37_6 0 0.6347188826190758
Vwn_ih_37_6 wn_ih_37_6 0 0.36528111738092417
Vwp_ih_38_6 wp_ih_38_6 0 0.5725977094439114
Vwn_ih_38_6 wn_ih_38_6 0 0.4274022905560886
Vwp_ih_39_6 wp_ih_39_6 0 0.39680879025330584
Vwn_ih_39_6 wn_ih_39_6 0 0.6031912097466942
Vwp_ih_40_6 wp_ih_40_6 0 0.43016628122281797
Vwn_ih_40_6 wn_ih_40_6 0 0.569833718777182
Vwp_ih_41_6 wp_ih_41_6 0 0.5476713209928668
Vwn_ih_41_6 wn_ih_41_6 0 0.45232867900713325
Vwp_ih_42_6 wp_ih_42_6 0 0.42898427476766793
Vwn_ih_42_6 wn_ih_42_6 0 0.5710157252323321
Vwp_ih_43_6 wp_ih_43_6 0 0.3360232951051625
Vwn_ih_43_6 wn_ih_43_6 0 0.6639767048948375
Vwp_ih_44_6 wp_ih_44_6 0 0.6406826569545246
Vwn_ih_44_6 wn_ih_44_6 0 0.35931734304547536
Vwp_ih_45_6 wp_ih_45_6 0 0.4519278585827215
Vwn_ih_45_6 wn_ih_45_6 0 0.5480721414172786
Vwp_ih_46_6 wp_ih_46_6 0 0.6873511169704378
Vwn_ih_46_6 wn_ih_46_6 0 0.3126488830295622
Vwp_ih_47_6 wp_ih_47_6 0 0.5433195511322513
Vwn_ih_47_6 wn_ih_47_6 0 0.4566804488677488
Vwp_ih_48_6 wp_ih_48_6 0 0.5199009344294913
Vwn_ih_48_6 wn_ih_48_6 0 0.48009906557050874
Vwp_ih_49_6 wp_ih_49_6 0 0.8247921818281345
Vwn_ih_49_6 wn_ih_49_6 0 0.3
Vwp_ih_50_6 wp_ih_50_6 0 0.4908182207288129
Vwn_ih_50_6 wn_ih_50_6 0 0.509181779271187
Vwp_ih_51_6 wp_ih_51_6 0 0.4219099112479781
Vwn_ih_51_6 wn_ih_51_6 0 0.578090088752022
Vwp_ih_52_6 wp_ih_52_6 0 0.535776049773926
Vwn_ih_52_6 wn_ih_52_6 0 0.464223950226074
Vwp_ih_53_6 wp_ih_53_6 0 0.6208230335914457
Vwn_ih_53_6 wn_ih_53_6 0 0.37917696640855425
Vwp_ih_54_6 wp_ih_54_6 0 0.3645626655867884
Vwn_ih_54_6 wn_ih_54_6 0 0.6354373344132116
Vwp_ih_55_6 wp_ih_55_6 0 0.40709047635824636
Vwn_ih_55_6 wn_ih_55_6 0 0.5929095236417536
Vwp_ih_56_6 wp_ih_56_6 0 0.5540858553771193
Vwn_ih_56_6 wn_ih_56_6 0 0.44591414462288065
Vwp_ih_57_6 wp_ih_57_6 0 0.3
Vwn_ih_57_6 wn_ih_57_6 0 0.8645167348848914
Vwp_ih_58_6 wp_ih_58_6 0 0.42592212086540193
Vwn_ih_58_6 wn_ih_58_6 0 0.5740778791345981
Vwp_ih_59_6 wp_ih_59_6 0 0.635416059353668
Vwn_ih_59_6 wn_ih_59_6 0 0.3645839406463321
Vwp_ih_60_6 wp_ih_60_6 0 0.43130264744608904
Vwn_ih_60_6 wn_ih_60_6 0 0.568697352553911
Vwp_ih_61_6 wp_ih_61_6 0 0.30423250053450884
Vwn_ih_61_6 wn_ih_61_6 0 0.6957674994654912
Vwp_ih_62_6 wp_ih_62_6 0 0.7359994675239748
Vwn_ih_62_6 wn_ih_62_6 0 0.3
Vwp_ih_63_6 wp_ih_63_6 0 0.3399628316409615
Vwn_ih_63_6 wn_ih_63_6 0 0.6600371683590385
Vwp_ho_6_0 wp_ho_6_0 0 0.5407061775997699
Vwn_ho_6_0 wn_ho_6_0 0 0.4592938224002301
Vwp_ho_6_1 wp_ho_6_1 0 0.683515886161632
Vwn_ho_6_1 wn_ho_6_1 0 0.31648411383836805
Vwp_ho_6_2 wp_ho_6_2 0 0.45709300778182277
Vwn_ho_6_2 wn_ho_6_2 0 0.5429069922181773
Vwp_ho_6_3 wp_ho_6_3 0 0.4002445680250312
Vwn_ho_6_3 wn_ho_6_3 0 0.5997554319749687
Vwp_ho_6_4 wp_ho_6_4 0 0.545028339362569
Vwn_ho_6_4 wn_ho_6_4 0 0.454971660637431
Vwp_ih_0_7 wp_ih_0_7 0 0.4371961343648113
Vwn_ih_0_7 wn_ih_0_7 0 0.5628038656351887
Vwp_ih_1_7 wp_ih_1_7 0 0.44388488690732386
Vwn_ih_1_7 wn_ih_1_7 0 0.5561151130926761
Vwp_ih_2_7 wp_ih_2_7 0 0.5069785798974701
Vwn_ih_2_7 wn_ih_2_7 0 0.4930214201025299
Vwp_ih_3_7 wp_ih_3_7 0 0.47532090758780543
Vwn_ih_3_7 wn_ih_3_7 0 0.5246790924121946
Vwp_ih_4_7 wp_ih_4_7 0 0.495475462142467
Vwn_ih_4_7 wn_ih_4_7 0 0.5045245378575329
Vwp_ih_5_7 wp_ih_5_7 0 0.5149897369162494
Vwn_ih_5_7 wn_ih_5_7 0 0.4850102630837506
Vwp_ih_6_7 wp_ih_6_7 0 0.48504872580611613
Vwn_ih_6_7 wn_ih_6_7 0 0.5149512741938839
Vwp_ih_7_7 wp_ih_7_7 0 0.5102164894390744
Vwn_ih_7_7 wn_ih_7_7 0 0.4897835105609256
Vwp_ih_8_7 wp_ih_8_7 0 0.3
Vwn_ih_8_7 wn_ih_8_7 0 0.7859324465942514
Vwp_ih_9_7 wp_ih_9_7 0 0.5437828859482386
Vwn_ih_9_7 wn_ih_9_7 0 0.4562171140517613
Vwp_ih_10_7 wp_ih_10_7 0 0.37684571620937213
Vwn_ih_10_7 wn_ih_10_7 0 0.6231542837906279
Vwp_ih_11_7 wp_ih_11_7 0 0.3
Vwn_ih_11_7 wn_ih_11_7 0 0.7566014474049096
Vwp_ih_12_7 wp_ih_12_7 0 0.6298679407310798
Vwn_ih_12_7 wn_ih_12_7 0 0.37013205926892023
Vwp_ih_13_7 wp_ih_13_7 0 0.38767199946102576
Vwn_ih_13_7 wn_ih_13_7 0 0.6123280005389742
Vwp_ih_14_7 wp_ih_14_7 0 0.5172547118583471
Vwn_ih_14_7 wn_ih_14_7 0 0.48274528814165285
Vwp_ih_15_7 wp_ih_15_7 0 0.40584104015914335
Vwn_ih_15_7 wn_ih_15_7 0 0.5941589598408566
Vwp_ih_16_7 wp_ih_16_7 0 0.4182355580813115
Vwn_ih_16_7 wn_ih_16_7 0 0.5817644419186885
Vwp_ih_17_7 wp_ih_17_7 0 0.5754608033532489
Vwn_ih_17_7 wn_ih_17_7 0 0.42453919664675105
Vwp_ih_18_7 wp_ih_18_7 0 0.39752065867729747
Vwn_ih_18_7 wn_ih_18_7 0 0.6024793413227025
Vwp_ih_19_7 wp_ih_19_7 0 0.49330028477267
Vwn_ih_19_7 wn_ih_19_7 0 0.5066997152273299
Vwp_ih_20_7 wp_ih_20_7 0 0.5061511539506981
Vwn_ih_20_7 wn_ih_20_7 0 0.49384884604930196
Vwp_ih_21_7 wp_ih_21_7 0 0.6472352940727355
Vwn_ih_21_7 wn_ih_21_7 0 0.3527647059272645
Vwp_ih_22_7 wp_ih_22_7 0 0.46129587659818555
Vwn_ih_22_7 wn_ih_22_7 0 0.5387041234018144
Vwp_ih_23_7 wp_ih_23_7 0 0.6235818630855047
Vwn_ih_23_7 wn_ih_23_7 0 0.37641813691449527
Vwp_ih_24_7 wp_ih_24_7 0 0.7062226920883133
Vwn_ih_24_7 wn_ih_24_7 0 0.3
Vwp_ih_25_7 wp_ih_25_7 0 0.6774583198098809
Vwn_ih_25_7 wn_ih_25_7 0 0.32254168019011914
Vwp_ih_26_7 wp_ih_26_7 0 0.5413148682563028
Vwn_ih_26_7 wn_ih_26_7 0 0.4586851317436971
Vwp_ih_27_7 wp_ih_27_7 0 0.49815031294460677
Vwn_ih_27_7 wn_ih_27_7 0 0.5018496870553932
Vwp_ih_28_7 wp_ih_28_7 0 0.7964850712134641
Vwn_ih_28_7 wn_ih_28_7 0 0.3
Vwp_ih_29_7 wp_ih_29_7 0 0.7417429932547339
Vwn_ih_29_7 wn_ih_29_7 0 0.3
Vwp_ih_30_7 wp_ih_30_7 0 0.4239073795761647
Vwn_ih_30_7 wn_ih_30_7 0 0.5760926204238354
Vwp_ih_31_7 wp_ih_31_7 0 0.6104642286745913
Vwn_ih_31_7 wn_ih_31_7 0 0.38953577132540873
Vwp_ih_32_7 wp_ih_32_7 0 0.5722351078476282
Vwn_ih_32_7 wn_ih_32_7 0 0.42776489215237185
Vwp_ih_33_7 wp_ih_33_7 0 0.4910245631392507
Vwn_ih_33_7 wn_ih_33_7 0 0.5089754368607493
Vwp_ih_34_7 wp_ih_34_7 0 0.4889572457173755
Vwn_ih_34_7 wn_ih_34_7 0 0.5110427542826246
Vwp_ih_35_7 wp_ih_35_7 0 0.47943531296817
Vwn_ih_35_7 wn_ih_35_7 0 0.52056468703183
Vwp_ih_36_7 wp_ih_36_7 0 0.5370007416113664
Vwn_ih_36_7 wn_ih_36_7 0 0.46299925838863365
Vwp_ih_37_7 wp_ih_37_7 0 0.5118178396004281
Vwn_ih_37_7 wn_ih_37_7 0 0.48818216039957185
Vwp_ih_38_7 wp_ih_38_7 0 0.5766917173816964
Vwn_ih_38_7 wn_ih_38_7 0 0.42330828261830356
Vwp_ih_39_7 wp_ih_39_7 0 0.6670568376971169
Vwn_ih_39_7 wn_ih_39_7 0 0.33294316230288307
Vwp_ih_40_7 wp_ih_40_7 0 0.5273554940469306
Vwn_ih_40_7 wn_ih_40_7 0 0.4726445059530694
Vwp_ih_41_7 wp_ih_41_7 0 0.5618091127402418
Vwn_ih_41_7 wn_ih_41_7 0 0.4381908872597582
Vwp_ih_42_7 wp_ih_42_7 0 0.6358127282503658
Vwn_ih_42_7 wn_ih_42_7 0 0.36418727174963417
Vwp_ih_43_7 wp_ih_43_7 0 0.6250673220483562
Vwn_ih_43_7 wn_ih_43_7 0 0.37493267795164376
Vwp_ih_44_7 wp_ih_44_7 0 0.5730412594429084
Vwn_ih_44_7 wn_ih_44_7 0 0.4269587405570916
Vwp_ih_45_7 wp_ih_45_7 0 0.5377447469189955
Vwn_ih_45_7 wn_ih_45_7 0 0.46225525308100446
Vwp_ih_46_7 wp_ih_46_7 0 0.5703819106881601
Vwn_ih_46_7 wn_ih_46_7 0 0.42961808931183987
Vwp_ih_47_7 wp_ih_47_7 0 0.3524745410902189
Vwn_ih_47_7 wn_ih_47_7 0 0.6475254589097811
Vwp_ih_48_7 wp_ih_48_7 0 0.5349633702177742
Vwn_ih_48_7 wn_ih_48_7 0 0.4650366297822258
Vwp_ih_49_7 wp_ih_49_7 0 0.3911659226269206
Vwn_ih_49_7 wn_ih_49_7 0 0.6088340773730794
Vwp_ih_50_7 wp_ih_50_7 0 0.4288133989758923
Vwn_ih_50_7 wn_ih_50_7 0 0.5711866010241077
Vwp_ih_51_7 wp_ih_51_7 0 0.577052379158266
Vwn_ih_51_7 wn_ih_51_7 0 0.422947620841734
Vwp_ih_52_7 wp_ih_52_7 0 0.4508246921431126
Vwn_ih_52_7 wn_ih_52_7 0 0.5491753078568874
Vwp_ih_53_7 wp_ih_53_7 0 0.5747698743990519
Vwn_ih_53_7 wn_ih_53_7 0 0.4252301256009481
Vwp_ih_54_7 wp_ih_54_7 0 0.44895182763223196
Vwn_ih_54_7 wn_ih_54_7 0 0.551048172367768
Vwp_ih_55_7 wp_ih_55_7 0 0.639068431784276
Vwn_ih_55_7 wn_ih_55_7 0 0.36093156821572403
Vwp_ih_56_7 wp_ih_56_7 0 0.5170683917673152
Vwn_ih_56_7 wn_ih_56_7 0 0.48293160823268483
Vwp_ih_57_7 wp_ih_57_7 0 0.6387541163418132
Vwn_ih_57_7 wn_ih_57_7 0 0.3612458836581868
Vwp_ih_58_7 wp_ih_58_7 0 0.5739401709839348
Vwn_ih_58_7 wn_ih_58_7 0 0.4260598290160652
Vwp_ih_59_7 wp_ih_59_7 0 0.5436023705733737
Vwn_ih_59_7 wn_ih_59_7 0 0.45639762942662637
Vwp_ih_60_7 wp_ih_60_7 0 0.46284865160720184
Vwn_ih_60_7 wn_ih_60_7 0 0.5371513483927982
Vwp_ih_61_7 wp_ih_61_7 0 0.5297695885851657
Vwn_ih_61_7 wn_ih_61_7 0 0.47023041141483435
Vwp_ih_62_7 wp_ih_62_7 0 0.6179895197307701
Vwn_ih_62_7 wn_ih_62_7 0 0.3820104802692299
Vwp_ih_63_7 wp_ih_63_7 0 0.5864785454328688
Vwn_ih_63_7 wn_ih_63_7 0 0.4135214545671312
Vwp_ho_7_0 wp_ho_7_0 0 0.47840974642971357
Vwn_ho_7_0 wn_ho_7_0 0 0.5215902535702864
Vwp_ho_7_1 wp_ho_7_1 0 0.433439983581918
Vwn_ho_7_1 wn_ho_7_1 0 0.566560016418082
Vwp_ho_7_2 wp_ho_7_2 0 0.5418348044121074
Vwn_ho_7_2 wn_ho_7_2 0 0.4581651955878926
Vwp_ho_7_3 wp_ho_7_3 0 0.6818839928924548
Vwn_ho_7_3 wn_ho_7_3 0 0.3181160071075452
Vwp_ho_7_4 wp_ho_7_4 0 0.3739435842363369
Vwn_ho_7_4 wn_ho_7_4 0 0.6260564157636631
Vwp_ih_0_8 wp_ih_0_8 0 0.35652984169955093
Vwn_ih_0_8 wn_ih_0_8 0 0.6434701583004491
Vwp_ih_1_8 wp_ih_1_8 0 0.6128439830429443
Vwn_ih_1_8 wn_ih_1_8 0 0.38715601695705565
Vwp_ih_2_8 wp_ih_2_8 0 0.46626122569133943
Vwn_ih_2_8 wn_ih_2_8 0 0.5337387743086606
Vwp_ih_3_8 wp_ih_3_8 0 0.5835388331051812
Vwn_ih_3_8 wn_ih_3_8 0 0.4164611668948188
Vwp_ih_4_8 wp_ih_4_8 0 0.3973544134470791
Vwn_ih_4_8 wn_ih_4_8 0 0.6026455865529209
Vwp_ih_5_8 wp_ih_5_8 0 0.5460257422309032
Vwn_ih_5_8 wn_ih_5_8 0 0.4539742577690968
Vwp_ih_6_8 wp_ih_6_8 0 0.39162275756437787
Vwn_ih_6_8 wn_ih_6_8 0 0.6083772424356221
Vwp_ih_7_8 wp_ih_7_8 0 0.5151153843766594
Vwn_ih_7_8 wn_ih_7_8 0 0.48488461562334056
Vwp_ih_8_8 wp_ih_8_8 0 0.4640438980431887
Vwn_ih_8_8 wn_ih_8_8 0 0.5359561019568113
Vwp_ih_9_8 wp_ih_9_8 0 0.46478352097089504
Vwn_ih_9_8 wn_ih_9_8 0 0.535216479029105
Vwp_ih_10_8 wp_ih_10_8 0 0.41148886416049824
Vwn_ih_10_8 wn_ih_10_8 0 0.5885111358395018
Vwp_ih_11_8 wp_ih_11_8 0 0.4978008325460415
Vwn_ih_11_8 wn_ih_11_8 0 0.5021991674539585
Vwp_ih_12_8 wp_ih_12_8 0 0.3697162508546051
Vwn_ih_12_8 wn_ih_12_8 0 0.630283749145395
Vwp_ih_13_8 wp_ih_13_8 0 0.5534019485804893
Vwn_ih_13_8 wn_ih_13_8 0 0.44659805141951076
Vwp_ih_14_8 wp_ih_14_8 0 0.5794878018305671
Vwn_ih_14_8 wn_ih_14_8 0 0.42051219816943286
Vwp_ih_15_8 wp_ih_15_8 0 0.4468194472815603
Vwn_ih_15_8 wn_ih_15_8 0 0.5531805527184397
Vwp_ih_16_8 wp_ih_16_8 0 0.33428401906808125
Vwn_ih_16_8 wn_ih_16_8 0 0.6657159809319187
Vwp_ih_17_8 wp_ih_17_8 0 0.4353237445869037
Vwn_ih_17_8 wn_ih_17_8 0 0.5646762554130963
Vwp_ih_18_8 wp_ih_18_8 0 0.6151795227504817
Vwn_ih_18_8 wn_ih_18_8 0 0.38482047724951823
Vwp_ih_19_8 wp_ih_19_8 0 0.645533061152469
Vwn_ih_19_8 wn_ih_19_8 0 0.354466938847531
Vwp_ih_20_8 wp_ih_20_8 0 0.5082785513616283
Vwn_ih_20_8 wn_ih_20_8 0 0.4917214486383718
Vwp_ih_21_8 wp_ih_21_8 0 0.5600404453704654
Vwn_ih_21_8 wn_ih_21_8 0 0.43995955462953457
Vwp_ih_22_8 wp_ih_22_8 0 0.37018157450429046
Vwn_ih_22_8 wn_ih_22_8 0 0.6298184254957095
Vwp_ih_23_8 wp_ih_23_8 0 0.4270841366603559
Vwn_ih_23_8 wn_ih_23_8 0 0.5729158633396442
Vwp_ih_24_8 wp_ih_24_8 0 0.5568440920453486
Vwn_ih_24_8 wn_ih_24_8 0 0.4431559079546514
Vwp_ih_25_8 wp_ih_25_8 0 0.48855590086058703
Vwn_ih_25_8 wn_ih_25_8 0 0.511444099139413
Vwp_ih_26_8 wp_ih_26_8 0 0.4529978556769753
Vwn_ih_26_8 wn_ih_26_8 0 0.5470021443230247
Vwp_ih_27_8 wp_ih_27_8 0 0.3
Vwn_ih_27_8 wn_ih_27_8 0 0.7244149434803278
Vwp_ih_28_8 wp_ih_28_8 0 0.5787752841486705
Vwn_ih_28_8 wn_ih_28_8 0 0.4212247158513295
Vwp_ih_29_8 wp_ih_29_8 0 0.5222092658111904
Vwn_ih_29_8 wn_ih_29_8 0 0.4777907341888096
Vwp_ih_30_8 wp_ih_30_8 0 0.3042952719936446
Vwn_ih_30_8 wn_ih_30_8 0 0.6957047280063554
Vwp_ih_31_8 wp_ih_31_8 0 0.5718851605133902
Vwn_ih_31_8 wn_ih_31_8 0 0.4281148394866098
Vwp_ih_32_8 wp_ih_32_8 0 0.4982763489489696
Vwn_ih_32_8 wn_ih_32_8 0 0.5017236510510305
Vwp_ih_33_8 wp_ih_33_8 0 0.5046787304062207
Vwn_ih_33_8 wn_ih_33_8 0 0.49532126959377926
Vwp_ih_34_8 wp_ih_34_8 0 0.6310560826085911
Vwn_ih_34_8 wn_ih_34_8 0 0.36894391739140886
Vwp_ih_35_8 wp_ih_35_8 0 0.48088555271013483
Vwn_ih_35_8 wn_ih_35_8 0 0.5191144472898651
Vwp_ih_36_8 wp_ih_36_8 0 0.5908640530583829
Vwn_ih_36_8 wn_ih_36_8 0 0.40913594694161715
Vwp_ih_37_8 wp_ih_37_8 0 0.5518615361851977
Vwn_ih_37_8 wn_ih_37_8 0 0.44813846381480227
Vwp_ih_38_8 wp_ih_38_8 0 0.5720199148611866
Vwn_ih_38_8 wn_ih_38_8 0 0.42798008513881336
Vwp_ih_39_8 wp_ih_39_8 0 0.6963146933967408
Vwn_ih_39_8 wn_ih_39_8 0 0.30368530660325926
Vwp_ih_40_8 wp_ih_40_8 0 0.5904547708047045
Vwn_ih_40_8 wn_ih_40_8 0 0.4095452291952954
Vwp_ih_41_8 wp_ih_41_8 0 0.40013431816346146
Vwn_ih_41_8 wn_ih_41_8 0 0.5998656818365385
Vwp_ih_42_8 wp_ih_42_8 0 0.7117242068135702
Vwn_ih_42_8 wn_ih_42_8 0 0.3
Vwp_ih_43_8 wp_ih_43_8 0 0.41248653671607605
Vwn_ih_43_8 wn_ih_43_8 0 0.587513463283924
Vwp_ih_44_8 wp_ih_44_8 0 0.45807071307245784
Vwn_ih_44_8 wn_ih_44_8 0 0.5419292869275422
Vwp_ih_45_8 wp_ih_45_8 0 0.34984508415897675
Vwn_ih_45_8 wn_ih_45_8 0 0.6501549158410233
Vwp_ih_46_8 wp_ih_46_8 0 0.48149296516340623
Vwn_ih_46_8 wn_ih_46_8 0 0.5185070348365938
Vwp_ih_47_8 wp_ih_47_8 0 0.6295771158564452
Vwn_ih_47_8 wn_ih_47_8 0 0.37042288414355484
Vwp_ih_48_8 wp_ih_48_8 0 0.6466872224689219
Vwn_ih_48_8 wn_ih_48_8 0 0.35331277753107815
Vwp_ih_49_8 wp_ih_49_8 0 0.5472270683820858
Vwn_ih_49_8 wn_ih_49_8 0 0.45277293161791415
Vwp_ih_50_8 wp_ih_50_8 0 0.42127077422930254
Vwn_ih_50_8 wn_ih_50_8 0 0.5787292257706975
Vwp_ih_51_8 wp_ih_51_8 0 0.45469620286144075
Vwn_ih_51_8 wn_ih_51_8 0 0.5453037971385593
Vwp_ih_52_8 wp_ih_52_8 0 0.4492516271410197
Vwn_ih_52_8 wn_ih_52_8 0 0.5507483728589803
Vwp_ih_53_8 wp_ih_53_8 0 0.6183674033076085
Vwn_ih_53_8 wn_ih_53_8 0 0.3816325966923915
Vwp_ih_54_8 wp_ih_54_8 0 0.405087395772157
Vwn_ih_54_8 wn_ih_54_8 0 0.594912604227843
Vwp_ih_55_8 wp_ih_55_8 0 0.616538232674255
Vwn_ih_55_8 wn_ih_55_8 0 0.38346176732574494
Vwp_ih_56_8 wp_ih_56_8 0 0.4960118164279508
Vwn_ih_56_8 wn_ih_56_8 0 0.5039881835720492
Vwp_ih_57_8 wp_ih_57_8 0 0.5008460696130335
Vwn_ih_57_8 wn_ih_57_8 0 0.49915393038696654
Vwp_ih_58_8 wp_ih_58_8 0 0.6719239000222874
Vwn_ih_58_8 wn_ih_58_8 0 0.32807609997771264
Vwp_ih_59_8 wp_ih_59_8 0 0.41827182470606084
Vwn_ih_59_8 wn_ih_59_8 0 0.5817281752939392
Vwp_ih_60_8 wp_ih_60_8 0 0.7257011751907487
Vwn_ih_60_8 wn_ih_60_8 0 0.3
Vwp_ih_61_8 wp_ih_61_8 0 0.3607006147027525
Vwn_ih_61_8 wn_ih_61_8 0 0.6392993852972475
Vwp_ih_62_8 wp_ih_62_8 0 0.4255773804786868
Vwn_ih_62_8 wn_ih_62_8 0 0.5744226195213131
Vwp_ih_63_8 wp_ih_63_8 0 0.32344558546400193
Vwn_ih_63_8 wn_ih_63_8 0 0.6765544145359981
Vwp_ho_8_0 wp_ho_8_0 0 0.4561733673995519
Vwn_ho_8_0 wn_ho_8_0 0 0.5438266326004482
Vwp_ho_8_1 wp_ho_8_1 0 0.5619168738971946
Vwn_ho_8_1 wn_ho_8_1 0 0.4380831261028054
Vwp_ho_8_2 wp_ho_8_2 0 0.4196498168776607
Vwn_ho_8_2 wn_ho_8_2 0 0.5803501831223393
Vwp_ho_8_3 wp_ho_8_3 0 0.378553303264685
Vwn_ho_8_3 wn_ho_8_3 0 0.6214466967353149
Vwp_ho_8_4 wp_ho_8_4 0 0.3
Vwn_ho_8_4 wn_ho_8_4 0 0.7274797344920668
Vwp_ih_0_9 wp_ih_0_9 0 0.4103861739140136
Vwn_ih_0_9 wn_ih_0_9 0 0.5896138260859864
Vwp_ih_1_9 wp_ih_1_9 0 0.5556269080973597
Vwn_ih_1_9 wn_ih_1_9 0 0.44437309190264024
Vwp_ih_2_9 wp_ih_2_9 0 0.5743079860540492
Vwn_ih_2_9 wn_ih_2_9 0 0.4256920139459508
Vwp_ih_3_9 wp_ih_3_9 0 0.5267256560053932
Vwn_ih_3_9 wn_ih_3_9 0 0.4732743439946068
Vwp_ih_4_9 wp_ih_4_9 0 0.525728230657747
Vwn_ih_4_9 wn_ih_4_9 0 0.47427176934225296
Vwp_ih_5_9 wp_ih_5_9 0 0.3594126566058745
Vwn_ih_5_9 wn_ih_5_9 0 0.6405873433941255
Vwp_ih_6_9 wp_ih_6_9 0 0.35197681143367365
Vwn_ih_6_9 wn_ih_6_9 0 0.6480231885663263
Vwp_ih_7_9 wp_ih_7_9 0 0.5380405885032591
Vwn_ih_7_9 wn_ih_7_9 0 0.4619594114967409
Vwp_ih_8_9 wp_ih_8_9 0 0.6624804979372936
Vwn_ih_8_9 wn_ih_8_9 0 0.3375195020627064
Vwp_ih_9_9 wp_ih_9_9 0 0.451716866694241
Vwn_ih_9_9 wn_ih_9_9 0 0.548283133305759
Vwp_ih_10_9 wp_ih_10_9 0 0.33152794691344345
Vwn_ih_10_9 wn_ih_10_9 0 0.6684720530865566
Vwp_ih_11_9 wp_ih_11_9 0 0.3487804364624968
Vwn_ih_11_9 wn_ih_11_9 0 0.6512195635375032
Vwp_ih_12_9 wp_ih_12_9 0 0.4382286480030988
Vwn_ih_12_9 wn_ih_12_9 0 0.5617713519969012
Vwp_ih_13_9 wp_ih_13_9 0 0.6622731427035657
Vwn_ih_13_9 wn_ih_13_9 0 0.3377268572964342
Vwp_ih_14_9 wp_ih_14_9 0 0.4886314864491624
Vwn_ih_14_9 wn_ih_14_9 0 0.5113685135508376
Vwp_ih_15_9 wp_ih_15_9 0 0.3768743442272786
Vwn_ih_15_9 wn_ih_15_9 0 0.6231256557727214
Vwp_ih_16_9 wp_ih_16_9 0 0.42742523031464297
Vwn_ih_16_9 wn_ih_16_9 0 0.572574769685357
Vwp_ih_17_9 wp_ih_17_9 0 0.4481965367707528
Vwn_ih_17_9 wn_ih_17_9 0 0.5518034632292472
Vwp_ih_18_9 wp_ih_18_9 0 0.54942093977842
Vwn_ih_18_9 wn_ih_18_9 0 0.45057906022158
Vwp_ih_19_9 wp_ih_19_9 0 0.4730324695438838
Vwn_ih_19_9 wn_ih_19_9 0 0.5269675304561162
Vwp_ih_20_9 wp_ih_20_9 0 0.40482123531497965
Vwn_ih_20_9 wn_ih_20_9 0 0.5951787646850203
Vwp_ih_21_9 wp_ih_21_9 0 0.4773091030901161
Vwn_ih_21_9 wn_ih_21_9 0 0.5226908969098839
Vwp_ih_22_9 wp_ih_22_9 0 0.548655500839503
Vwn_ih_22_9 wn_ih_22_9 0 0.451344499160497
Vwp_ih_23_9 wp_ih_23_9 0 0.5869305793258683
Vwn_ih_23_9 wn_ih_23_9 0 0.41306942067413166
Vwp_ih_24_9 wp_ih_24_9 0 0.5664840134956695
Vwn_ih_24_9 wn_ih_24_9 0 0.43351598650433054
Vwp_ih_25_9 wp_ih_25_9 0 0.4759322935266575
Vwn_ih_25_9 wn_ih_25_9 0 0.5240677064733426
Vwp_ih_26_9 wp_ih_26_9 0 0.3367571855028919
Vwn_ih_26_9 wn_ih_26_9 0 0.6632428144971081
Vwp_ih_27_9 wp_ih_27_9 0 0.43231106287548926
Vwn_ih_27_9 wn_ih_27_9 0 0.5676889371245107
Vwp_ih_28_9 wp_ih_28_9 0 0.5545665177727308
Vwn_ih_28_9 wn_ih_28_9 0 0.44543348222726925
Vwp_ih_29_9 wp_ih_29_9 0 0.36325177790015584
Vwn_ih_29_9 wn_ih_29_9 0 0.6367482220998442
Vwp_ih_30_9 wp_ih_30_9 0 0.5109857608748885
Vwn_ih_30_9 wn_ih_30_9 0 0.4890142391251116
Vwp_ih_31_9 wp_ih_31_9 0 0.4297974349241348
Vwn_ih_31_9 wn_ih_31_9 0 0.5702025650758652
Vwp_ih_32_9 wp_ih_32_9 0 0.43014032557963
Vwn_ih_32_9 wn_ih_32_9 0 0.56985967442037
Vwp_ih_33_9 wp_ih_33_9 0 0.6279424987350752
Vwn_ih_33_9 wn_ih_33_9 0 0.37205750126492476
Vwp_ih_34_9 wp_ih_34_9 0 0.5355888731975756
Vwn_ih_34_9 wn_ih_34_9 0 0.46441112680242436
Vwp_ih_35_9 wp_ih_35_9 0 0.6942346123424648
Vwn_ih_35_9 wn_ih_35_9 0 0.30576538765753525
Vwp_ih_36_9 wp_ih_36_9 0 0.43243202355513877
Vwn_ih_36_9 wn_ih_36_9 0 0.5675679764448612
Vwp_ih_37_9 wp_ih_37_9 0 0.6329971531394889
Vwn_ih_37_9 wn_ih_37_9 0 0.36700284686051116
Vwp_ih_38_9 wp_ih_38_9 0 0.5663007200876927
Vwn_ih_38_9 wn_ih_38_9 0 0.4336992799123073
Vwp_ih_39_9 wp_ih_39_9 0 0.3
Vwn_ih_39_9 wn_ih_39_9 0 0.8594003335837674
Vwp_ih_40_9 wp_ih_40_9 0 0.48896485841465415
Vwn_ih_40_9 wn_ih_40_9 0 0.5110351415853459
Vwp_ih_41_9 wp_ih_41_9 0 0.6489829993701529
Vwn_ih_41_9 wn_ih_41_9 0 0.3510170006298471
Vwp_ih_42_9 wp_ih_42_9 0 0.5575573742171228
Vwn_ih_42_9 wn_ih_42_9 0 0.4424426257828772
Vwp_ih_43_9 wp_ih_43_9 0 0.48013825825680095
Vwn_ih_43_9 wn_ih_43_9 0 0.519861741743199
Vwp_ih_44_9 wp_ih_44_9 0 0.5221332727225001
Vwn_ih_44_9 wn_ih_44_9 0 0.47786672727749985
Vwp_ih_45_9 wp_ih_45_9 0 0.34769016189350976
Vwn_ih_45_9 wn_ih_45_9 0 0.6523098381064902
Vwp_ih_46_9 wp_ih_46_9 0 0.48210925396750326
Vwn_ih_46_9 wn_ih_46_9 0 0.5178907460324967
Vwp_ih_47_9 wp_ih_47_9 0 0.3
Vwn_ih_47_9 wn_ih_47_9 0 0.7140635735053692
Vwp_ih_48_9 wp_ih_48_9 0 0.37734857778572567
Vwn_ih_48_9 wn_ih_48_9 0 0.6226514222142744
Vwp_ih_49_9 wp_ih_49_9 0 0.5901693370574274
Vwn_ih_49_9 wn_ih_49_9 0 0.4098306629425727
Vwp_ih_50_9 wp_ih_50_9 0 0.4568710697406997
Vwn_ih_50_9 wn_ih_50_9 0 0.5431289302593003
Vwp_ih_51_9 wp_ih_51_9 0 0.4675858586664046
Vwn_ih_51_9 wn_ih_51_9 0 0.5324141413335954
Vwp_ih_52_9 wp_ih_52_9 0 0.5152956119652816
Vwn_ih_52_9 wn_ih_52_9 0 0.4847043880347184
Vwp_ih_53_9 wp_ih_53_9 0 0.8035516186781735
Vwn_ih_53_9 wn_ih_53_9 0 0.3
Vwp_ih_54_9 wp_ih_54_9 0 0.6107539495556846
Vwn_ih_54_9 wn_ih_54_9 0 0.38924605044431543
Vwp_ih_55_9 wp_ih_55_9 0 0.4245434315936223
Vwn_ih_55_9 wn_ih_55_9 0 0.5754565684063777
Vwp_ih_56_9 wp_ih_56_9 0 0.7003069897955315
Vwn_ih_56_9 wn_ih_56_9 0 0.3
Vwp_ih_57_9 wp_ih_57_9 0 0.4735031392665306
Vwn_ih_57_9 wn_ih_57_9 0 0.5264968607334694
Vwp_ih_58_9 wp_ih_58_9 0 0.5769326908461937
Vwn_ih_58_9 wn_ih_58_9 0 0.4230673091538063
Vwp_ih_59_9 wp_ih_59_9 0 0.4180535008572619
Vwn_ih_59_9 wn_ih_59_9 0 0.5819464991427381
Vwp_ih_60_9 wp_ih_60_9 0 0.3694508910951992
Vwn_ih_60_9 wn_ih_60_9 0 0.6305491089048008
Vwp_ih_61_9 wp_ih_61_9 0 0.5676022549803716
Vwn_ih_61_9 wn_ih_61_9 0 0.4323977450196283
Vwp_ih_62_9 wp_ih_62_9 0 0.40722194796214284
Vwn_ih_62_9 wn_ih_62_9 0 0.5927780520378572
Vwp_ih_63_9 wp_ih_63_9 0 0.42051538897140067
Vwn_ih_63_9 wn_ih_63_9 0 0.5794846110285994
Vwp_ho_9_0 wp_ho_9_0 0 0.5329138692806104
Vwn_ho_9_0 wn_ho_9_0 0 0.46708613071938965
Vwp_ho_9_1 wp_ho_9_1 0 0.4817181427315881
Vwn_ho_9_1 wn_ho_9_1 0 0.5182818572684119
Vwp_ho_9_2 wp_ho_9_2 0 0.34774218839653004
Vwn_ho_9_2 wn_ho_9_2 0 0.65225781160347
Vwp_ho_9_3 wp_ho_9_3 0 0.4261380039436031
Vwn_ho_9_3 wn_ho_9_3 0 0.5738619960563969
Vwp_ho_9_4 wp_ho_9_4 0 0.5594474118563935
Vwn_ho_9_4 wn_ho_9_4 0 0.44055258814360654
Vwp_ih_0_10 wp_ih_0_10 0 0.6077401158991046
Vwn_ih_0_10 wn_ih_0_10 0 0.3922598841008954
Vwp_ih_1_10 wp_ih_1_10 0 0.38374209324236097
Vwn_ih_1_10 wn_ih_1_10 0 0.616257906757639
Vwp_ih_2_10 wp_ih_2_10 0 0.3376481744134383
Vwn_ih_2_10 wn_ih_2_10 0 0.6623518255865617
Vwp_ih_3_10 wp_ih_3_10 0 0.5567053841816311
Vwn_ih_3_10 wn_ih_3_10 0 0.44329461581836893
Vwp_ih_4_10 wp_ih_4_10 0 0.3
Vwn_ih_4_10 wn_ih_4_10 0 0.7267639071212731
Vwp_ih_5_10 wp_ih_5_10 0 0.4022536607229059
Vwn_ih_5_10 wn_ih_5_10 0 0.5977463392770941
Vwp_ih_6_10 wp_ih_6_10 0 0.4629485275969965
Vwn_ih_6_10 wn_ih_6_10 0 0.5370514724030035
Vwp_ih_7_10 wp_ih_7_10 0 0.34204048177297697
Vwn_ih_7_10 wn_ih_7_10 0 0.657959518227023
Vwp_ih_8_10 wp_ih_8_10 0 0.3675562730748089
Vwn_ih_8_10 wn_ih_8_10 0 0.632443726925191
Vwp_ih_9_10 wp_ih_9_10 0 0.5927428403303727
Vwn_ih_9_10 wn_ih_9_10 0 0.4072571596696273
Vwp_ih_10_10 wp_ih_10_10 0 0.497222151390958
Vwn_ih_10_10 wn_ih_10_10 0 0.5027778486090421
Vwp_ih_11_10 wp_ih_11_10 0 0.4151724511122566
Vwn_ih_11_10 wn_ih_11_10 0 0.5848275488877435
Vwp_ih_12_10 wp_ih_12_10 0 0.5898882430081569
Vwn_ih_12_10 wn_ih_12_10 0 0.4101117569918431
Vwp_ih_13_10 wp_ih_13_10 0 0.6174571094527114
Vwn_ih_13_10 wn_ih_13_10 0 0.3825428905472886
Vwp_ih_14_10 wp_ih_14_10 0 0.35186096026367386
Vwn_ih_14_10 wn_ih_14_10 0 0.6481390397363261
Vwp_ih_15_10 wp_ih_15_10 0 0.511977293803241
Vwn_ih_15_10 wn_ih_15_10 0 0.4880227061967591
Vwp_ih_16_10 wp_ih_16_10 0 0.7384393208596682
Vwn_ih_16_10 wn_ih_16_10 0 0.3
Vwp_ih_17_10 wp_ih_17_10 0 0.5544172669228495
Vwn_ih_17_10 wn_ih_17_10 0 0.4455827330771504
Vwp_ih_18_10 wp_ih_18_10 0 0.5803428882409387
Vwn_ih_18_10 wn_ih_18_10 0 0.4196571117590613
Vwp_ih_19_10 wp_ih_19_10 0 0.5445878196235455
Vwn_ih_19_10 wn_ih_19_10 0 0.4554121803764544
Vwp_ih_20_10 wp_ih_20_10 0 0.4273009169019396
Vwn_ih_20_10 wn_ih_20_10 0 0.5726990830980604
Vwp_ih_21_10 wp_ih_21_10 0 0.5977134334185314
Vwn_ih_21_10 wn_ih_21_10 0 0.4022865665814686
Vwp_ih_22_10 wp_ih_22_10 0 0.5762095540718949
Vwn_ih_22_10 wn_ih_22_10 0 0.4237904459281051
Vwp_ih_23_10 wp_ih_23_10 0 0.49956860971049083
Vwn_ih_23_10 wn_ih_23_10 0 0.5004313902895091
Vwp_ih_24_10 wp_ih_24_10 0 0.44508809188573817
Vwn_ih_24_10 wn_ih_24_10 0 0.5549119081142618
Vwp_ih_25_10 wp_ih_25_10 0 0.30264490544692263
Vwn_ih_25_10 wn_ih_25_10 0 0.6973550945530773
Vwp_ih_26_10 wp_ih_26_10 0 0.5575878224922975
Vwn_ih_26_10 wn_ih_26_10 0 0.44241217750770245
Vwp_ih_27_10 wp_ih_27_10 0 0.48763598027497734
Vwn_ih_27_10 wn_ih_27_10 0 0.5123640197250227
Vwp_ih_28_10 wp_ih_28_10 0 0.5119875628300368
Vwn_ih_28_10 wn_ih_28_10 0 0.48801243716996323
Vwp_ih_29_10 wp_ih_29_10 0 0.5873750460612152
Vwn_ih_29_10 wn_ih_29_10 0 0.41262495393878484
Vwp_ih_30_10 wp_ih_30_10 0 0.5878520989903983
Vwn_ih_30_10 wn_ih_30_10 0 0.41214790100960175
Vwp_ih_31_10 wp_ih_31_10 0 0.5875937858375104
Vwn_ih_31_10 wn_ih_31_10 0 0.41240621416248957
Vwp_ih_32_10 wp_ih_32_10 0 0.7706077198646331
Vwn_ih_32_10 wn_ih_32_10 0 0.3
Vwp_ih_33_10 wp_ih_33_10 0 0.6494859633400136
Vwn_ih_33_10 wn_ih_33_10 0 0.35051403665998637
Vwp_ih_34_10 wp_ih_34_10 0 0.43582441552125367
Vwn_ih_34_10 wn_ih_34_10 0 0.5641755844787464
Vwp_ih_35_10 wp_ih_35_10 0 0.49108272424610716
Vwn_ih_35_10 wn_ih_35_10 0 0.5089172757538928
Vwp_ih_36_10 wp_ih_36_10 0 0.8341514260364055
Vwn_ih_36_10 wn_ih_36_10 0 0.3
Vwp_ih_37_10 wp_ih_37_10 0 0.43127059571997217
Vwn_ih_37_10 wn_ih_37_10 0 0.5687294042800278
Vwp_ih_38_10 wp_ih_38_10 0 0.46574528272221183
Vwn_ih_38_10 wn_ih_38_10 0 0.5342547172777882
Vwp_ih_39_10 wp_ih_39_10 0 0.7093830905307631
Vwn_ih_39_10 wn_ih_39_10 0 0.3
Vwp_ih_40_10 wp_ih_40_10 0 0.7157189896145317
Vwn_ih_40_10 wn_ih_40_10 0 0.3
Vwp_ih_41_10 wp_ih_41_10 0 0.475914513873485
Vwn_ih_41_10 wn_ih_41_10 0 0.5240854861265151
Vwp_ih_42_10 wp_ih_42_10 0 0.5009858863605899
Vwn_ih_42_10 wn_ih_42_10 0 0.49901411363941006
Vwp_ih_43_10 wp_ih_43_10 0 0.3720147822602925
Vwn_ih_43_10 wn_ih_43_10 0 0.6279852177397075
Vwp_ih_44_10 wp_ih_44_10 0 0.44711054865268346
Vwn_ih_44_10 wn_ih_44_10 0 0.5528894513473166
Vwp_ih_45_10 wp_ih_45_10 0 0.4663757706231683
Vwn_ih_45_10 wn_ih_45_10 0 0.5336242293768317
Vwp_ih_46_10 wp_ih_46_10 0 0.4579309438427045
Vwn_ih_46_10 wn_ih_46_10 0 0.5420690561572955
Vwp_ih_47_10 wp_ih_47_10 0 0.46366974898715285
Vwn_ih_47_10 wn_ih_47_10 0 0.5363302510128471
Vwp_ih_48_10 wp_ih_48_10 0 0.5157222518429314
Vwn_ih_48_10 wn_ih_48_10 0 0.48427774815706864
Vwp_ih_49_10 wp_ih_49_10 0 0.7478070346992678
Vwn_ih_49_10 wn_ih_49_10 0 0.3
Vwp_ih_50_10 wp_ih_50_10 0 0.5042598511793963
Vwn_ih_50_10 wn_ih_50_10 0 0.49574014882060374
Vwp_ih_51_10 wp_ih_51_10 0 0.5333013158140485
Vwn_ih_51_10 wn_ih_51_10 0 0.46669868418595156
Vwp_ih_52_10 wp_ih_52_10 0 0.5328177317081451
Vwn_ih_52_10 wn_ih_52_10 0 0.467182268291855
Vwp_ih_53_10 wp_ih_53_10 0 0.46164060267939305
Vwn_ih_53_10 wn_ih_53_10 0 0.538359397320607
Vwp_ih_54_10 wp_ih_54_10 0 0.6167816497872947
Vwn_ih_54_10 wn_ih_54_10 0 0.38321835021270534
Vwp_ih_55_10 wp_ih_55_10 0 0.371183653338804
Vwn_ih_55_10 wn_ih_55_10 0 0.628816346661196
Vwp_ih_56_10 wp_ih_56_10 0 0.48558672905544575
Vwn_ih_56_10 wn_ih_56_10 0 0.5144132709445542
Vwp_ih_57_10 wp_ih_57_10 0 0.38100974418750216
Vwn_ih_57_10 wn_ih_57_10 0 0.6189902558124978
Vwp_ih_58_10 wp_ih_58_10 0 0.5210748203614931
Vwn_ih_58_10 wn_ih_58_10 0 0.4789251796385069
Vwp_ih_59_10 wp_ih_59_10 0 0.4994712512578284
Vwn_ih_59_10 wn_ih_59_10 0 0.5005287487421716
Vwp_ih_60_10 wp_ih_60_10 0 0.5996381952616633
Vwn_ih_60_10 wn_ih_60_10 0 0.4003618047383367
Vwp_ih_61_10 wp_ih_61_10 0 0.6028107524788486
Vwn_ih_61_10 wn_ih_61_10 0 0.39718924752115137
Vwp_ih_62_10 wp_ih_62_10 0 0.5378714962731523
Vwn_ih_62_10 wn_ih_62_10 0 0.46212850372684766
Vwp_ih_63_10 wp_ih_63_10 0 0.6786771815629263
Vwn_ih_63_10 wn_ih_63_10 0 0.32132281843707367
Vwp_ho_10_0 wp_ho_10_0 0 0.3
Vwn_ho_10_0 wn_ho_10_0 0 0.7382460362015362
Vwp_ho_10_1 wp_ho_10_1 0 0.5242041463045624
Vwn_ho_10_1 wn_ho_10_1 0 0.47579585369543764
Vwp_ho_10_2 wp_ho_10_2 0 0.3
Vwn_ho_10_2 wn_ho_10_2 0 0.7599522759841273
Vwp_ho_10_3 wp_ho_10_3 0 0.42125507003062324
Vwn_ho_10_3 wn_ho_10_3 0 0.5787449299693768
Vwp_ho_10_4 wp_ho_10_4 0 0.7160996587270676
Vwn_ho_10_4 wn_ho_10_4 0 0.3
Vwp_ih_0_11 wp_ih_0_11 0 0.6906203921567371
Vwn_ih_0_11 wn_ih_0_11 0 0.3093796078432629
Vwp_ih_1_11 wp_ih_1_11 0 0.5502170833329709
Vwn_ih_1_11 wn_ih_1_11 0 0.449782916667029
Vwp_ih_2_11 wp_ih_2_11 0 0.5798546639461901
Vwn_ih_2_11 wn_ih_2_11 0 0.4201453360538099
Vwp_ih_3_11 wp_ih_3_11 0 0.32302870707451553
Vwn_ih_3_11 wn_ih_3_11 0 0.6769712929254845
Vwp_ih_4_11 wp_ih_4_11 0 0.49807637186499903
Vwn_ih_4_11 wn_ih_4_11 0 0.501923628135001
Vwp_ih_5_11 wp_ih_5_11 0 0.47470972690802987
Vwn_ih_5_11 wn_ih_5_11 0 0.5252902730919701
Vwp_ih_6_11 wp_ih_6_11 0 0.3
Vwn_ih_6_11 wn_ih_6_11 0 0.7107673683468704
Vwp_ih_7_11 wp_ih_7_11 0 0.44824038600465554
Vwn_ih_7_11 wn_ih_7_11 0 0.5517596139953445
Vwp_ih_8_11 wp_ih_8_11 0 0.6148940466014738
Vwn_ih_8_11 wn_ih_8_11 0 0.38510595339852616
Vwp_ih_9_11 wp_ih_9_11 0 0.3881517173623439
Vwn_ih_9_11 wn_ih_9_11 0 0.6118482826376561
Vwp_ih_10_11 wp_ih_10_11 0 0.69414401124867
Vwn_ih_10_11 wn_ih_10_11 0 0.30585598875133
Vwp_ih_11_11 wp_ih_11_11 0 0.5501747638153689
Vwn_ih_11_11 wn_ih_11_11 0 0.4498252361846311
Vwp_ih_12_11 wp_ih_12_11 0 0.475895160716326
Vwn_ih_12_11 wn_ih_12_11 0 0.524104839283674
Vwp_ih_13_11 wp_ih_13_11 0 0.4720799450555752
Vwn_ih_13_11 wn_ih_13_11 0 0.5279200549444248
Vwp_ih_14_11 wp_ih_14_11 0 0.5679793760999017
Vwn_ih_14_11 wn_ih_14_11 0 0.43202062390009827
Vwp_ih_15_11 wp_ih_15_11 0 0.3253646021206056
Vwn_ih_15_11 wn_ih_15_11 0 0.6746353978793944
Vwp_ih_16_11 wp_ih_16_11 0 0.744893827724024
Vwn_ih_16_11 wn_ih_16_11 0 0.3
Vwp_ih_17_11 wp_ih_17_11 0 0.4303536246598188
Vwn_ih_17_11 wn_ih_17_11 0 0.5696463753401813
Vwp_ih_18_11 wp_ih_18_11 0 0.4166135486946467
Vwn_ih_18_11 wn_ih_18_11 0 0.5833864513053533
Vwp_ih_19_11 wp_ih_19_11 0 0.6168667143476667
Vwn_ih_19_11 wn_ih_19_11 0 0.38313328565233334
Vwp_ih_20_11 wp_ih_20_11 0 0.6403012330109721
Vwn_ih_20_11 wn_ih_20_11 0 0.359698766989028
Vwp_ih_21_11 wp_ih_21_11 0 0.645048551633328
Vwn_ih_21_11 wn_ih_21_11 0 0.35495144836667203
Vwp_ih_22_11 wp_ih_22_11 0 0.5643318112267899
Vwn_ih_22_11 wn_ih_22_11 0 0.43566818877321006
Vwp_ih_23_11 wp_ih_23_11 0 0.537762833694407
Vwn_ih_23_11 wn_ih_23_11 0 0.462237166305593
Vwp_ih_24_11 wp_ih_24_11 0 0.34683569380185797
Vwn_ih_24_11 wn_ih_24_11 0 0.653164306198142
Vwp_ih_25_11 wp_ih_25_11 0 0.4331283139247188
Vwn_ih_25_11 wn_ih_25_11 0 0.5668716860752812
Vwp_ih_26_11 wp_ih_26_11 0 0.4935619783058913
Vwn_ih_26_11 wn_ih_26_11 0 0.5064380216941087
Vwp_ih_27_11 wp_ih_27_11 0 0.4982835774632616
Vwn_ih_27_11 wn_ih_27_11 0 0.5017164225367384
Vwp_ih_28_11 wp_ih_28_11 0 0.3073119728168815
Vwn_ih_28_11 wn_ih_28_11 0 0.6926880271831185
Vwp_ih_29_11 wp_ih_29_11 0 0.6019428178415933
Vwn_ih_29_11 wn_ih_29_11 0 0.3980571821584067
Vwp_ih_30_11 wp_ih_30_11 0 0.6560895735658107
Vwn_ih_30_11 wn_ih_30_11 0 0.34391042643418934
Vwp_ih_31_11 wp_ih_31_11 0 0.6756939586952346
Vwn_ih_31_11 wn_ih_31_11 0 0.3243060413047654
Vwp_ih_32_11 wp_ih_32_11 0 0.3778568448227747
Vwn_ih_32_11 wn_ih_32_11 0 0.6221431551772253
Vwp_ih_33_11 wp_ih_33_11 0 0.5101727548803382
Vwn_ih_33_11 wn_ih_33_11 0 0.4898272451196618
Vwp_ih_34_11 wp_ih_34_11 0 0.3
Vwn_ih_34_11 wn_ih_34_11 0 0.7778460160505614
Vwp_ih_35_11 wp_ih_35_11 0 0.7048841191702153
Vwn_ih_35_11 wn_ih_35_11 0 0.3
Vwp_ih_36_11 wp_ih_36_11 0 0.3
Vwn_ih_36_11 wn_ih_36_11 0 0.7012148804500905
Vwp_ih_37_11 wp_ih_37_11 0 0.5238205216055656
Vwn_ih_37_11 wn_ih_37_11 0 0.47617947839443436
Vwp_ih_38_11 wp_ih_38_11 0 0.610556239707391
Vwn_ih_38_11 wn_ih_38_11 0 0.38944376029260896
Vwp_ih_39_11 wp_ih_39_11 0 0.6549586077116882
Vwn_ih_39_11 wn_ih_39_11 0 0.34504139228831177
Vwp_ih_40_11 wp_ih_40_11 0 0.5298253991188567
Vwn_ih_40_11 wn_ih_40_11 0 0.4701746008811433
Vwp_ih_41_11 wp_ih_41_11 0 0.30584557239370325
Vwn_ih_41_11 wn_ih_41_11 0 0.6941544276062968
Vwp_ih_42_11 wp_ih_42_11 0 0.47864258561911177
Vwn_ih_42_11 wn_ih_42_11 0 0.5213574143808882
Vwp_ih_43_11 wp_ih_43_11 0 0.4801941129450361
Vwn_ih_43_11 wn_ih_43_11 0 0.5198058870549639
Vwp_ih_44_11 wp_ih_44_11 0 0.5467568482999954
Vwn_ih_44_11 wn_ih_44_11 0 0.45324315170000457
Vwp_ih_45_11 wp_ih_45_11 0 0.570492368295745
Vwn_ih_45_11 wn_ih_45_11 0 0.42950763170425504
Vwp_ih_46_11 wp_ih_46_11 0 0.5822442096372747
Vwn_ih_46_11 wn_ih_46_11 0 0.41775579036272525
Vwp_ih_47_11 wp_ih_47_11 0 0.7545987495622795
Vwn_ih_47_11 wn_ih_47_11 0 0.3
Vwp_ih_48_11 wp_ih_48_11 0 0.5777127808388179
Vwn_ih_48_11 wn_ih_48_11 0 0.42228721916118206
Vwp_ih_49_11 wp_ih_49_11 0 0.44412507316046024
Vwn_ih_49_11 wn_ih_49_11 0 0.5558749268395398
Vwp_ih_50_11 wp_ih_50_11 0 0.705571213948826
Vwn_ih_50_11 wn_ih_50_11 0 0.3
Vwp_ih_51_11 wp_ih_51_11 0 0.5035346031848364
Vwn_ih_51_11 wn_ih_51_11 0 0.49646539681516355
Vwp_ih_52_11 wp_ih_52_11 0 0.5291450310159658
Vwn_ih_52_11 wn_ih_52_11 0 0.4708549689840343
Vwp_ih_53_11 wp_ih_53_11 0 0.504356167478616
Vwn_ih_53_11 wn_ih_53_11 0 0.495643832521384
Vwp_ih_54_11 wp_ih_54_11 0 0.3
Vwn_ih_54_11 wn_ih_54_11 0 0.7295805225020294
Vwp_ih_55_11 wp_ih_55_11 0 0.5575251187047727
Vwn_ih_55_11 wn_ih_55_11 0 0.4424748812952273
Vwp_ih_56_11 wp_ih_56_11 0 0.5347340607603626
Vwn_ih_56_11 wn_ih_56_11 0 0.46526593923963744
Vwp_ih_57_11 wp_ih_57_11 0 0.4798309101900455
Vwn_ih_57_11 wn_ih_57_11 0 0.5201690898099546
Vwp_ih_58_11 wp_ih_58_11 0 0.516186735574086
Vwn_ih_58_11 wn_ih_58_11 0 0.48381326442591394
Vwp_ih_59_11 wp_ih_59_11 0 0.3879801659923887
Vwn_ih_59_11 wn_ih_59_11 0 0.6120198340076113
Vwp_ih_60_11 wp_ih_60_11 0 0.491927182473598
Vwn_ih_60_11 wn_ih_60_11 0 0.508072817526402
Vwp_ih_61_11 wp_ih_61_11 0 0.6826323544441387
Vwn_ih_61_11 wn_ih_61_11 0 0.3173676455558613
Vwp_ih_62_11 wp_ih_62_11 0 0.5102210107723815
Vwn_ih_62_11 wn_ih_62_11 0 0.4897789892276186
Vwp_ih_63_11 wp_ih_63_11 0 0.4524379003914528
Vwn_ih_63_11 wn_ih_63_11 0 0.5475620996085472
Vwp_ho_11_0 wp_ho_11_0 0 0.730173198353846
Vwn_ho_11_0 wn_ho_11_0 0 0.3
Vwp_ho_11_1 wp_ho_11_1 0 0.6795231105829507
Vwn_ho_11_1 wn_ho_11_1 0 0.32047688941704927
Vwp_ho_11_2 wp_ho_11_2 0 0.4084718744087306
Vwn_ho_11_2 wn_ho_11_2 0 0.5915281255912693
Vwp_ho_11_3 wp_ho_11_3 0 0.589660130772743
Vwn_ho_11_3 wn_ho_11_3 0 0.41033986922725696
Vwp_ho_11_4 wp_ho_11_4 0 0.40100425523093697
Vwn_ho_11_4 wn_ho_11_4 0 0.598995744769063
Vwp_ih_0_12 wp_ih_0_12 0 0.42707253262278777
Vwn_ih_0_12 wn_ih_0_12 0 0.5729274673772122
Vwp_ih_1_12 wp_ih_1_12 0 0.7074978707662584
Vwn_ih_1_12 wn_ih_1_12 0 0.3
Vwp_ih_2_12 wp_ih_2_12 0 0.30444159213814725
Vwn_ih_2_12 wn_ih_2_12 0 0.6955584078618527
Vwp_ih_3_12 wp_ih_3_12 0 0.5934070755992801
Vwn_ih_3_12 wn_ih_3_12 0 0.4065929244007199
Vwp_ih_4_12 wp_ih_4_12 0 0.5157378735046819
Vwn_ih_4_12 wn_ih_4_12 0 0.4842621264953181
Vwp_ih_5_12 wp_ih_5_12 0 0.7096784242935792
Vwn_ih_5_12 wn_ih_5_12 0 0.3
Vwp_ih_6_12 wp_ih_6_12 0 0.648366555870589
Vwn_ih_6_12 wn_ih_6_12 0 0.351633444129411
Vwp_ih_7_12 wp_ih_7_12 0 0.48928019625951674
Vwn_ih_7_12 wn_ih_7_12 0 0.5107198037404833
Vwp_ih_8_12 wp_ih_8_12 0 0.3149662847387741
Vwn_ih_8_12 wn_ih_8_12 0 0.6850337152612259
Vwp_ih_9_12 wp_ih_9_12 0 0.6088725491638433
Vwn_ih_9_12 wn_ih_9_12 0 0.39112745083615674
Vwp_ih_10_12 wp_ih_10_12 0 0.657805159365113
Vwn_ih_10_12 wn_ih_10_12 0 0.34219484063488703
Vwp_ih_11_12 wp_ih_11_12 0 0.38975874381688463
Vwn_ih_11_12 wn_ih_11_12 0 0.6102412561831153
Vwp_ih_12_12 wp_ih_12_12 0 0.5554971766349146
Vwn_ih_12_12 wn_ih_12_12 0 0.4445028233650854
Vwp_ih_13_12 wp_ih_13_12 0 0.4113863696104491
Vwn_ih_13_12 wn_ih_13_12 0 0.5886136303895508
Vwp_ih_14_12 wp_ih_14_12 0 0.40134833862860914
Vwn_ih_14_12 wn_ih_14_12 0 0.5986516613713908
Vwp_ih_15_12 wp_ih_15_12 0 0.30891041943869213
Vwn_ih_15_12 wn_ih_15_12 0 0.6910895805613079
Vwp_ih_16_12 wp_ih_16_12 0 0.6119052101421836
Vwn_ih_16_12 wn_ih_16_12 0 0.3880947898578165
Vwp_ih_17_12 wp_ih_17_12 0 0.5027275319043125
Vwn_ih_17_12 wn_ih_17_12 0 0.4972724680956875
Vwp_ih_18_12 wp_ih_18_12 0 0.5711146780913727
Vwn_ih_18_12 wn_ih_18_12 0 0.42888532190862727
Vwp_ih_19_12 wp_ih_19_12 0 0.6794400881112349
Vwn_ih_19_12 wn_ih_19_12 0 0.3205599118887651
Vwp_ih_20_12 wp_ih_20_12 0 0.5348497032472755
Vwn_ih_20_12 wn_ih_20_12 0 0.4651502967527244
Vwp_ih_21_12 wp_ih_21_12 0 0.5722452505239256
Vwn_ih_21_12 wn_ih_21_12 0 0.42775474947607445
Vwp_ih_22_12 wp_ih_22_12 0 0.5942124268122756
Vwn_ih_22_12 wn_ih_22_12 0 0.4057875731877244
Vwp_ih_23_12 wp_ih_23_12 0 0.3776947986370451
Vwn_ih_23_12 wn_ih_23_12 0 0.6223052013629549
Vwp_ih_24_12 wp_ih_24_12 0 0.495831708098416
Vwn_ih_24_12 wn_ih_24_12 0 0.5041682919015841
Vwp_ih_25_12 wp_ih_25_12 0 0.38309522616936414
Vwn_ih_25_12 wn_ih_25_12 0 0.6169047738306359
Vwp_ih_26_12 wp_ih_26_12 0 0.4197730594692
Vwn_ih_26_12 wn_ih_26_12 0 0.5802269405308
Vwp_ih_27_12 wp_ih_27_12 0 0.4772665424340423
Vwn_ih_27_12 wn_ih_27_12 0 0.5227334575659577
Vwp_ih_28_12 wp_ih_28_12 0 0.5965419534888315
Vwn_ih_28_12 wn_ih_28_12 0 0.40345804651116846
Vwp_ih_29_12 wp_ih_29_12 0 0.7345484777853346
Vwn_ih_29_12 wn_ih_29_12 0 0.3
Vwp_ih_30_12 wp_ih_30_12 0 0.3905435217705898
Vwn_ih_30_12 wn_ih_30_12 0 0.6094564782294102
Vwp_ih_31_12 wp_ih_31_12 0 0.5207536963092212
Vwn_ih_31_12 wn_ih_31_12 0 0.47924630369077875
Vwp_ih_32_12 wp_ih_32_12 0 0.49149074765526335
Vwn_ih_32_12 wn_ih_32_12 0 0.5085092523447367
Vwp_ih_33_12 wp_ih_33_12 0 0.5947172864703554
Vwn_ih_33_12 wn_ih_33_12 0 0.4052827135296447
Vwp_ih_34_12 wp_ih_34_12 0 0.5971726548645839
Vwn_ih_34_12 wn_ih_34_12 0 0.4028273451354161
Vwp_ih_35_12 wp_ih_35_12 0 0.5303027523382694
Vwn_ih_35_12 wn_ih_35_12 0 0.4696972476617306
Vwp_ih_36_12 wp_ih_36_12 0 0.37034124464886625
Vwn_ih_36_12 wn_ih_36_12 0 0.6296587553511337
Vwp_ih_37_12 wp_ih_37_12 0 0.5355097635537808
Vwn_ih_37_12 wn_ih_37_12 0 0.4644902364462193
Vwp_ih_38_12 wp_ih_38_12 0 0.6032322876671886
Vwn_ih_38_12 wn_ih_38_12 0 0.3967677123328114
Vwp_ih_39_12 wp_ih_39_12 0 0.4383931001064197
Vwn_ih_39_12 wn_ih_39_12 0 0.5616068998935803
Vwp_ih_40_12 wp_ih_40_12 0 0.7306598224033077
Vwn_ih_40_12 wn_ih_40_12 0 0.3
Vwp_ih_41_12 wp_ih_41_12 0 0.5012350910922605
Vwn_ih_41_12 wn_ih_41_12 0 0.49876490890773956
Vwp_ih_42_12 wp_ih_42_12 0 0.4566512832597366
Vwn_ih_42_12 wn_ih_42_12 0 0.5433487167402634
Vwp_ih_43_12 wp_ih_43_12 0 0.5231838835113265
Vwn_ih_43_12 wn_ih_43_12 0 0.47681611648867345
Vwp_ih_44_12 wp_ih_44_12 0 0.4711261125858384
Vwn_ih_44_12 wn_ih_44_12 0 0.5288738874141616
Vwp_ih_45_12 wp_ih_45_12 0 0.3441640232627328
Vwn_ih_45_12 wn_ih_45_12 0 0.6558359767372672
Vwp_ih_46_12 wp_ih_46_12 0 0.4739123549603207
Vwn_ih_46_12 wn_ih_46_12 0 0.5260876450396793
Vwp_ih_47_12 wp_ih_47_12 0 0.6913979522530458
Vwn_ih_47_12 wn_ih_47_12 0 0.3086020477469542
Vwp_ih_48_12 wp_ih_48_12 0 0.7457035539360908
Vwn_ih_48_12 wn_ih_48_12 0 0.3
Vwp_ih_49_12 wp_ih_49_12 0 0.44633292334602687
Vwn_ih_49_12 wn_ih_49_12 0 0.5536670766539732
Vwp_ih_50_12 wp_ih_50_12 0 0.6260683084472495
Vwn_ih_50_12 wn_ih_50_12 0 0.3739316915527505
Vwp_ih_51_12 wp_ih_51_12 0 0.5146163573256691
Vwn_ih_51_12 wn_ih_51_12 0 0.48538364267433093
Vwp_ih_52_12 wp_ih_52_12 0 0.5197569614218658
Vwn_ih_52_12 wn_ih_52_12 0 0.48024303857813416
Vwp_ih_53_12 wp_ih_53_12 0 0.6077634930978604
Vwn_ih_53_12 wn_ih_53_12 0 0.3922365069021396
Vwp_ih_54_12 wp_ih_54_12 0 0.5539327804363263
Vwn_ih_54_12 wn_ih_54_12 0 0.4460672195636737
Vwp_ih_55_12 wp_ih_55_12 0 0.5235182530771577
Vwn_ih_55_12 wn_ih_55_12 0 0.47648174692284234
Vwp_ih_56_12 wp_ih_56_12 0 0.3885277285751609
Vwn_ih_56_12 wn_ih_56_12 0 0.6114722714248392
Vwp_ih_57_12 wp_ih_57_12 0 0.3476561737882929
Vwn_ih_57_12 wn_ih_57_12 0 0.6523438262117072
Vwp_ih_58_12 wp_ih_58_12 0 0.46300649999705407
Vwn_ih_58_12 wn_ih_58_12 0 0.5369935000029459
Vwp_ih_59_12 wp_ih_59_12 0 0.5415394488257677
Vwn_ih_59_12 wn_ih_59_12 0 0.4584605511742323
Vwp_ih_60_12 wp_ih_60_12 0 0.5522343463082341
Vwn_ih_60_12 wn_ih_60_12 0 0.44776565369176585
Vwp_ih_61_12 wp_ih_61_12 0 0.5579738598234477
Vwn_ih_61_12 wn_ih_61_12 0 0.4420261401765523
Vwp_ih_62_12 wp_ih_62_12 0 0.5970121804086693
Vwn_ih_62_12 wn_ih_62_12 0 0.4029878195913307
Vwp_ih_63_12 wp_ih_63_12 0 0.3
Vwn_ih_63_12 wn_ih_63_12 0 0.778637917128212
Vwp_ho_12_0 wp_ho_12_0 0 0.5763089066200799
Vwn_ho_12_0 wn_ho_12_0 0 0.42369109337992006
Vwp_ho_12_1 wp_ho_12_1 0 0.4672801505218112
Vwn_ho_12_1 wn_ho_12_1 0 0.5327198494781888
Vwp_ho_12_2 wp_ho_12_2 0 0.598622726369621
Vwn_ho_12_2 wn_ho_12_2 0 0.40137727363037895
Vwp_ho_12_3 wp_ho_12_3 0 0.3
Vwn_ho_12_3 wn_ho_12_3 0 0.714245068971517
Vwp_ho_12_4 wp_ho_12_4 0 0.48161084007118066
Vwn_ho_12_4 wn_ho_12_4 0 0.5183891599288193
Vwp_ih_0_13 wp_ih_0_13 0 0.6084128399635557
Vwn_ih_0_13 wn_ih_0_13 0 0.3915871600364443
Vwp_ih_1_13 wp_ih_1_13 0 0.4028547173040984
Vwn_ih_1_13 wn_ih_1_13 0 0.5971452826959016
Vwp_ih_2_13 wp_ih_2_13 0 0.6609762641359234
Vwn_ih_2_13 wn_ih_2_13 0 0.33902373586407664
Vwp_ih_3_13 wp_ih_3_13 0 0.5523516612892551
Vwn_ih_3_13 wn_ih_3_13 0 0.4476483387107449
Vwp_ih_4_13 wp_ih_4_13 0 0.5989440245437623
Vwn_ih_4_13 wn_ih_4_13 0 0.4010559754562378
Vwp_ih_5_13 wp_ih_5_13 0 0.45853675497025975
Vwn_ih_5_13 wn_ih_5_13 0 0.5414632450297403
Vwp_ih_6_13 wp_ih_6_13 0 0.5455361180285285
Vwn_ih_6_13 wn_ih_6_13 0 0.45446388197147153
Vwp_ih_7_13 wp_ih_7_13 0 0.3
Vwn_ih_7_13 wn_ih_7_13 0 0.7197659816365498
Vwp_ih_8_13 wp_ih_8_13 0 0.6334612466502143
Vwn_ih_8_13 wn_ih_8_13 0 0.3665387533497857
Vwp_ih_9_13 wp_ih_9_13 0 0.49212284005669654
Vwn_ih_9_13 wn_ih_9_13 0 0.5078771599433034
Vwp_ih_10_13 wp_ih_10_13 0 0.3
Vwn_ih_10_13 wn_ih_10_13 0 0.7857483357119215
Vwp_ih_11_13 wp_ih_11_13 0 0.6119519881806403
Vwn_ih_11_13 wn_ih_11_13 0 0.3880480118193596
Vwp_ih_12_13 wp_ih_12_13 0 0.6536807983207953
Vwn_ih_12_13 wn_ih_12_13 0 0.3463192016792047
Vwp_ih_13_13 wp_ih_13_13 0 0.39891777674047224
Vwn_ih_13_13 wn_ih_13_13 0 0.6010822232595278
Vwp_ih_14_13 wp_ih_14_13 0 0.6585341057956723
Vwn_ih_14_13 wn_ih_14_13 0 0.3414658942043277
Vwp_ih_15_13 wp_ih_15_13 0 0.4155114309688267
Vwn_ih_15_13 wn_ih_15_13 0 0.5844885690311733
Vwp_ih_16_13 wp_ih_16_13 0 0.3
Vwn_ih_16_13 wn_ih_16_13 0 0.7704478461823001
Vwp_ih_17_13 wp_ih_17_13 0 0.4673046939203184
Vwn_ih_17_13 wn_ih_17_13 0 0.5326953060796816
Vwp_ih_18_13 wp_ih_18_13 0 0.5304801263230854
Vwn_ih_18_13 wn_ih_18_13 0 0.4695198736769146
Vwp_ih_19_13 wp_ih_19_13 0 0.4720911074838444
Vwn_ih_19_13 wn_ih_19_13 0 0.5279088925161556
Vwp_ih_20_13 wp_ih_20_13 0 0.5020248105622753
Vwn_ih_20_13 wn_ih_20_13 0 0.4979751894377246
Vwp_ih_21_13 wp_ih_21_13 0 0.5298034630465505
Vwn_ih_21_13 wn_ih_21_13 0 0.47019653695344954
Vwp_ih_22_13 wp_ih_22_13 0 0.5264527759992599
Vwn_ih_22_13 wn_ih_22_13 0 0.4735472240007402
Vwp_ih_23_13 wp_ih_23_13 0 0.4805720353134231
Vwn_ih_23_13 wn_ih_23_13 0 0.5194279646865769
Vwp_ih_24_13 wp_ih_24_13 0 0.42898212790096224
Vwn_ih_24_13 wn_ih_24_13 0 0.5710178720990378
Vwp_ih_25_13 wp_ih_25_13 0 0.461349560784739
Vwn_ih_25_13 wn_ih_25_13 0 0.538650439215261
Vwp_ih_26_13 wp_ih_26_13 0 0.43626686269674153
Vwn_ih_26_13 wn_ih_26_13 0 0.5637331373032585
Vwp_ih_27_13 wp_ih_27_13 0 0.4576265883693553
Vwn_ih_27_13 wn_ih_27_13 0 0.5423734116306447
Vwp_ih_28_13 wp_ih_28_13 0 0.39321952054852927
Vwn_ih_28_13 wn_ih_28_13 0 0.6067804794514707
Vwp_ih_29_13 wp_ih_29_13 0 0.43607437426719
Vwn_ih_29_13 wn_ih_29_13 0 0.56392562573281
Vwp_ih_30_13 wp_ih_30_13 0 0.496631862408277
Vwn_ih_30_13 wn_ih_30_13 0 0.5033681375917229
Vwp_ih_31_13 wp_ih_31_13 0 0.5387545540346242
Vwn_ih_31_13 wn_ih_31_13 0 0.46124544596537576
Vwp_ih_32_13 wp_ih_32_13 0 0.492316526297758
Vwn_ih_32_13 wn_ih_32_13 0 0.507683473702242
Vwp_ih_33_13 wp_ih_33_13 0 0.4850273145879458
Vwn_ih_33_13 wn_ih_33_13 0 0.5149726854120542
Vwp_ih_34_13 wp_ih_34_13 0 0.5371954631944922
Vwn_ih_34_13 wn_ih_34_13 0 0.4628045368055078
Vwp_ih_35_13 wp_ih_35_13 0 0.5996250360113093
Vwn_ih_35_13 wn_ih_35_13 0 0.40037496398869066
Vwp_ih_36_13 wp_ih_36_13 0 0.6055134828179695
Vwn_ih_36_13 wn_ih_36_13 0 0.3944865171820305
Vwp_ih_37_13 wp_ih_37_13 0 0.33131977103125876
Vwn_ih_37_13 wn_ih_37_13 0 0.6686802289687412
Vwp_ih_38_13 wp_ih_38_13 0 0.45644618421882777
Vwn_ih_38_13 wn_ih_38_13 0 0.5435538157811722
Vwp_ih_39_13 wp_ih_39_13 0 0.584678550444239
Vwn_ih_39_13 wn_ih_39_13 0 0.415321449555761
Vwp_ih_40_13 wp_ih_40_13 0 0.5619303813892528
Vwn_ih_40_13 wn_ih_40_13 0 0.43806961861074717
Vwp_ih_41_13 wp_ih_41_13 0 0.5831702626753213
Vwn_ih_41_13 wn_ih_41_13 0 0.4168297373246786
Vwp_ih_42_13 wp_ih_42_13 0 0.5022960637269847
Vwn_ih_42_13 wn_ih_42_13 0 0.49770393627301535
Vwp_ih_43_13 wp_ih_43_13 0 0.3905710952271842
Vwn_ih_43_13 wn_ih_43_13 0 0.6094289047728157
Vwp_ih_44_13 wp_ih_44_13 0 0.645546771304511
Vwn_ih_44_13 wn_ih_44_13 0 0.354453228695489
Vwp_ih_45_13 wp_ih_45_13 0 0.3651132497033239
Vwn_ih_45_13 wn_ih_45_13 0 0.6348867502966761
Vwp_ih_46_13 wp_ih_46_13 0 0.637231795643092
Vwn_ih_46_13 wn_ih_46_13 0 0.3627682043569081
Vwp_ih_47_13 wp_ih_47_13 0 0.5010867940645952
Vwn_ih_47_13 wn_ih_47_13 0 0.4989132059354048
Vwp_ih_48_13 wp_ih_48_13 0 0.32689578782149087
Vwn_ih_48_13 wn_ih_48_13 0 0.6731042121785091
Vwp_ih_49_13 wp_ih_49_13 0 0.46514369473348266
Vwn_ih_49_13 wn_ih_49_13 0 0.5348563052665173
Vwp_ih_50_13 wp_ih_50_13 0 0.6173365509499092
Vwn_ih_50_13 wn_ih_50_13 0 0.38266344905009075
Vwp_ih_51_13 wp_ih_51_13 0 0.41151984460671287
Vwn_ih_51_13 wn_ih_51_13 0 0.5884801553932871
Vwp_ih_52_13 wp_ih_52_13 0 0.34454610288252974
Vwn_ih_52_13 wn_ih_52_13 0 0.6554538971174703
Vwp_ih_53_13 wp_ih_53_13 0 0.4739881244599367
Vwn_ih_53_13 wn_ih_53_13 0 0.5260118755400632
Vwp_ih_54_13 wp_ih_54_13 0 0.41027810299757556
Vwn_ih_54_13 wn_ih_54_13 0 0.5897218970024244
Vwp_ih_55_13 wp_ih_55_13 0 0.332275271102612
Vwn_ih_55_13 wn_ih_55_13 0 0.667724728897388
Vwp_ih_56_13 wp_ih_56_13 0 0.5533159768931658
Vwn_ih_56_13 wn_ih_56_13 0 0.44668402310683425
Vwp_ih_57_13 wp_ih_57_13 0 0.6174264345439646
Vwn_ih_57_13 wn_ih_57_13 0 0.3825735654560354
Vwp_ih_58_13 wp_ih_58_13 0 0.4592971795461775
Vwn_ih_58_13 wn_ih_58_13 0 0.5407028204538225
Vwp_ih_59_13 wp_ih_59_13 0 0.5789208453734829
Vwn_ih_59_13 wn_ih_59_13 0 0.4210791546265172
Vwp_ih_60_13 wp_ih_60_13 0 0.4389787036282732
Vwn_ih_60_13 wn_ih_60_13 0 0.5610212963717268
Vwp_ih_61_13 wp_ih_61_13 0 0.47504046031233027
Vwn_ih_61_13 wn_ih_61_13 0 0.5249595396876697
Vwp_ih_62_13 wp_ih_62_13 0 0.489220869800343
Vwn_ih_62_13 wn_ih_62_13 0 0.510779130199657
Vwp_ih_63_13 wp_ih_63_13 0 0.6643337588286339
Vwn_ih_63_13 wn_ih_63_13 0 0.3356662411713661
Vwp_ho_13_0 wp_ho_13_0 0 0.33144207325251607
Vwn_ho_13_0 wn_ho_13_0 0 0.6685579267474839
Vwp_ho_13_1 wp_ho_13_1 0 0.7179505073535978
Vwn_ho_13_1 wn_ho_13_1 0 0.3
Vwp_ho_13_2 wp_ho_13_2 0 0.6202061992338326
Vwn_ho_13_2 wn_ho_13_2 0 0.3797938007661675
Vwp_ho_13_3 wp_ho_13_3 0 0.6421004622291655
Vwn_ho_13_3 wn_ho_13_3 0 0.35789953777083455
Vwp_ho_13_4 wp_ho_13_4 0 0.6602886734258516
Vwn_ho_13_4 wn_ho_13_4 0 0.3397113265741484
Vwp_ih_0_14 wp_ih_0_14 0 0.5609070638206435
Vwn_ih_0_14 wn_ih_0_14 0 0.4390929361793565
Vwp_ih_1_14 wp_ih_1_14 0 0.39500991243112643
Vwn_ih_1_14 wn_ih_1_14 0 0.6049900875688735
Vwp_ih_2_14 wp_ih_2_14 0 0.5840735323917642
Vwn_ih_2_14 wn_ih_2_14 0 0.41592646760823576
Vwp_ih_3_14 wp_ih_3_14 0 0.4770613509085194
Vwn_ih_3_14 wn_ih_3_14 0 0.5229386490914806
Vwp_ih_4_14 wp_ih_4_14 0 0.45168526186922275
Vwn_ih_4_14 wn_ih_4_14 0 0.5483147381307772
Vwp_ih_5_14 wp_ih_5_14 0 0.4172677779060969
Vwn_ih_5_14 wn_ih_5_14 0 0.5827322220939031
Vwp_ih_6_14 wp_ih_6_14 0 0.5105416564500397
Vwn_ih_6_14 wn_ih_6_14 0 0.48945834354996026
Vwp_ih_7_14 wp_ih_7_14 0 0.49583133253911793
Vwn_ih_7_14 wn_ih_7_14 0 0.5041686674608821
Vwp_ih_8_14 wp_ih_8_14 0 0.4531780190605138
Vwn_ih_8_14 wn_ih_8_14 0 0.5468219809394862
Vwp_ih_9_14 wp_ih_9_14 0 0.35754407223194096
Vwn_ih_9_14 wn_ih_9_14 0 0.642455927768059
Vwp_ih_10_14 wp_ih_10_14 0 0.31876863563505875
Vwn_ih_10_14 wn_ih_10_14 0 0.6812313643649412
Vwp_ih_11_14 wp_ih_11_14 0 0.5107636167784916
Vwn_ih_11_14 wn_ih_11_14 0 0.4892363832215084
Vwp_ih_12_14 wp_ih_12_14 0 0.47650598383647413
Vwn_ih_12_14 wn_ih_12_14 0 0.5234940161635259
Vwp_ih_13_14 wp_ih_13_14 0 0.7566069239001929
Vwn_ih_13_14 wn_ih_13_14 0 0.3
Vwp_ih_14_14 wp_ih_14_14 0 0.49984460776907585
Vwn_ih_14_14 wn_ih_14_14 0 0.5001553922309242
Vwp_ih_15_14 wp_ih_15_14 0 0.6257425291225185
Vwn_ih_15_14 wn_ih_15_14 0 0.37425747087748146
Vwp_ih_16_14 wp_ih_16_14 0 0.6445120918511055
Vwn_ih_16_14 wn_ih_16_14 0 0.3554879081488945
Vwp_ih_17_14 wp_ih_17_14 0 0.5055161962447883
Vwn_ih_17_14 wn_ih_17_14 0 0.49448380375521167
Vwp_ih_18_14 wp_ih_18_14 0 0.49851763862286297
Vwn_ih_18_14 wn_ih_18_14 0 0.501482361377137
Vwp_ih_19_14 wp_ih_19_14 0 0.4134823305015055
Vwn_ih_19_14 wn_ih_19_14 0 0.5865176694984945
Vwp_ih_20_14 wp_ih_20_14 0 0.6905679554755381
Vwn_ih_20_14 wn_ih_20_14 0 0.30943204452446194
Vwp_ih_21_14 wp_ih_21_14 0 0.3154887338841349
Vwn_ih_21_14 wn_ih_21_14 0 0.6845112661158651
Vwp_ih_22_14 wp_ih_22_14 0 0.49644419894147673
Vwn_ih_22_14 wn_ih_22_14 0 0.5035558010585233
Vwp_ih_23_14 wp_ih_23_14 0 0.6688595055708593
Vwn_ih_23_14 wn_ih_23_14 0 0.3311404944291408
Vwp_ih_24_14 wp_ih_24_14 0 0.4878919438175087
Vwn_ih_24_14 wn_ih_24_14 0 0.5121080561824912
Vwp_ih_25_14 wp_ih_25_14 0 0.4327240988378251
Vwn_ih_25_14 wn_ih_25_14 0 0.5672759011621749
Vwp_ih_26_14 wp_ih_26_14 0 0.5034475913600794
Vwn_ih_26_14 wn_ih_26_14 0 0.4965524086399205
Vwp_ih_27_14 wp_ih_27_14 0 0.5367093596377268
Vwn_ih_27_14 wn_ih_27_14 0 0.46329064036227313
Vwp_ih_28_14 wp_ih_28_14 0 0.5825404231616123
Vwn_ih_28_14 wn_ih_28_14 0 0.4174595768383877
Vwp_ih_29_14 wp_ih_29_14 0 0.5312821756999383
Vwn_ih_29_14 wn_ih_29_14 0 0.46871782430006165
Vwp_ih_30_14 wp_ih_30_14 0 0.5675638250343692
Vwn_ih_30_14 wn_ih_30_14 0 0.43243617496563086
Vwp_ih_31_14 wp_ih_31_14 0 0.6146353137696854
Vwn_ih_31_14 wn_ih_31_14 0 0.38536468623031456
Vwp_ih_32_14 wp_ih_32_14 0 0.36717405051450147
Vwn_ih_32_14 wn_ih_32_14 0 0.6328259494854985
Vwp_ih_33_14 wp_ih_33_14 0 0.4512036535042815
Vwn_ih_33_14 wn_ih_33_14 0 0.5487963464957185
Vwp_ih_34_14 wp_ih_34_14 0 0.5649735056511777
Vwn_ih_34_14 wn_ih_34_14 0 0.43502649434882235
Vwp_ih_35_14 wp_ih_35_14 0 0.5551765719589459
Vwn_ih_35_14 wn_ih_35_14 0 0.4448234280410541
Vwp_ih_36_14 wp_ih_36_14 0 0.5472265773666704
Vwn_ih_36_14 wn_ih_36_14 0 0.45277342263332965
Vwp_ih_37_14 wp_ih_37_14 0 0.580290530719289
Vwn_ih_37_14 wn_ih_37_14 0 0.41970946928071096
Vwp_ih_38_14 wp_ih_38_14 0 0.5788018104593676
Vwn_ih_38_14 wn_ih_38_14 0 0.42119818954063243
Vwp_ih_39_14 wp_ih_39_14 0 0.397034352911986
Vwn_ih_39_14 wn_ih_39_14 0 0.602965647088014
Vwp_ih_40_14 wp_ih_40_14 0 0.35127903042141184
Vwn_ih_40_14 wn_ih_40_14 0 0.6487209695785882
Vwp_ih_41_14 wp_ih_41_14 0 0.3455502656277726
Vwn_ih_41_14 wn_ih_41_14 0 0.6544497343722274
Vwp_ih_42_14 wp_ih_42_14 0 0.6802880503886448
Vwn_ih_42_14 wn_ih_42_14 0 0.3197119496113552
Vwp_ih_43_14 wp_ih_43_14 0 0.3783070788663072
Vwn_ih_43_14 wn_ih_43_14 0 0.6216929211336928
Vwp_ih_44_14 wp_ih_44_14 0 0.4814404434414711
Vwn_ih_44_14 wn_ih_44_14 0 0.5185595565585289
Vwp_ih_45_14 wp_ih_45_14 0 0.47607491551186043
Vwn_ih_45_14 wn_ih_45_14 0 0.5239250844881396
Vwp_ih_46_14 wp_ih_46_14 0 0.5986524429097267
Vwn_ih_46_14 wn_ih_46_14 0 0.40134755709027325
Vwp_ih_47_14 wp_ih_47_14 0 0.3
Vwn_ih_47_14 wn_ih_47_14 0 0.7064356082390646
Vwp_ih_48_14 wp_ih_48_14 0 0.4983476092713639
Vwn_ih_48_14 wn_ih_48_14 0 0.5016523907286361
Vwp_ih_49_14 wp_ih_49_14 0 0.6269013940853204
Vwn_ih_49_14 wn_ih_49_14 0 0.3730986059146796
Vwp_ih_50_14 wp_ih_50_14 0 0.6095887251373909
Vwn_ih_50_14 wn_ih_50_14 0 0.39041127486260907
Vwp_ih_51_14 wp_ih_51_14 0 0.5378093248907728
Vwn_ih_51_14 wn_ih_51_14 0 0.4621906751092272
Vwp_ih_52_14 wp_ih_52_14 0 0.4549950169366761
Vwn_ih_52_14 wn_ih_52_14 0 0.5450049830633239
Vwp_ih_53_14 wp_ih_53_14 0 0.694242231966084
Vwn_ih_53_14 wn_ih_53_14 0 0.30575776803391597
Vwp_ih_54_14 wp_ih_54_14 0 0.30503562856804134
Vwn_ih_54_14 wn_ih_54_14 0 0.6949643714319587
Vwp_ih_55_14 wp_ih_55_14 0 0.6223770522558258
Vwn_ih_55_14 wn_ih_55_14 0 0.3776229477441741
Vwp_ih_56_14 wp_ih_56_14 0 0.5615564470494598
Vwn_ih_56_14 wn_ih_56_14 0 0.43844355295054016
Vwp_ih_57_14 wp_ih_57_14 0 0.5842354619269905
Vwn_ih_57_14 wn_ih_57_14 0 0.4157645380730095
Vwp_ih_58_14 wp_ih_58_14 0 0.5530100738467848
Vwn_ih_58_14 wn_ih_58_14 0 0.4469899261532152
Vwp_ih_59_14 wp_ih_59_14 0 0.5355404030245108
Vwn_ih_59_14 wn_ih_59_14 0 0.4644595969754892
Vwp_ih_60_14 wp_ih_60_14 0 0.5969000064150524
Vwn_ih_60_14 wn_ih_60_14 0 0.40309999358494764
Vwp_ih_61_14 wp_ih_61_14 0 0.3646888236149264
Vwn_ih_61_14 wn_ih_61_14 0 0.6353111763850736
Vwp_ih_62_14 wp_ih_62_14 0 0.3740451634596174
Vwn_ih_62_14 wn_ih_62_14 0 0.6259548365403826
Vwp_ih_63_14 wp_ih_63_14 0 0.5320468429839017
Vwn_ih_63_14 wn_ih_63_14 0 0.4679531570160983
Vwp_ho_14_0 wp_ho_14_0 0 0.5110300343174531
Vwn_ho_14_0 wn_ho_14_0 0 0.4889699656825469
Vwp_ho_14_1 wp_ho_14_1 0 0.46743888692945623
Vwn_ho_14_1 wn_ho_14_1 0 0.5325611130705438
Vwp_ho_14_2 wp_ho_14_2 0 0.5968916145285063
Vwn_ho_14_2 wn_ho_14_2 0 0.4031083854714937
Vwp_ho_14_3 wp_ho_14_3 0 0.4673275274441982
Vwn_ho_14_3 wn_ho_14_3 0 0.5326724725558019
Vwp_ho_14_4 wp_ho_14_4 0 0.7058611828902506
Vwn_ho_14_4 wn_ho_14_4 0 0.3
Vwp_ih_0_15 wp_ih_0_15 0 0.5062580950018695
Vwn_ih_0_15 wn_ih_0_15 0 0.4937419049981306
Vwp_ih_1_15 wp_ih_1_15 0 0.5000462359637349
Vwn_ih_1_15 wn_ih_1_15 0 0.49995376403626507
Vwp_ih_2_15 wp_ih_2_15 0 0.6524075790784541
Vwn_ih_2_15 wn_ih_2_15 0 0.34759242092154585
Vwp_ih_3_15 wp_ih_3_15 0 0.42423571938037136
Vwn_ih_3_15 wn_ih_3_15 0 0.5757642806196286
Vwp_ih_4_15 wp_ih_4_15 0 0.5680380020610705
Vwn_ih_4_15 wn_ih_4_15 0 0.43196199793892953
Vwp_ih_5_15 wp_ih_5_15 0 0.48989413742868
Vwn_ih_5_15 wn_ih_5_15 0 0.5101058625713201
Vwp_ih_6_15 wp_ih_6_15 0 0.7570894206471059
Vwn_ih_6_15 wn_ih_6_15 0 0.3
Vwp_ih_7_15 wp_ih_7_15 0 0.33141847627669585
Vwn_ih_7_15 wn_ih_7_15 0 0.6685815237233041
Vwp_ih_8_15 wp_ih_8_15 0 0.43432834964973815
Vwn_ih_8_15 wn_ih_8_15 0 0.5656716503502618
Vwp_ih_9_15 wp_ih_9_15 0 0.4293003863357797
Vwn_ih_9_15 wn_ih_9_15 0 0.5706996136642203
Vwp_ih_10_15 wp_ih_10_15 0 0.6325334871062601
Vwn_ih_10_15 wn_ih_10_15 0 0.3674665128937399
Vwp_ih_11_15 wp_ih_11_15 0 0.4613943400067825
Vwn_ih_11_15 wn_ih_11_15 0 0.5386056599932175
Vwp_ih_12_15 wp_ih_12_15 0 0.6962238458476402
Vwn_ih_12_15 wn_ih_12_15 0 0.3037761541523598
Vwp_ih_13_15 wp_ih_13_15 0 0.6261648505415268
Vwn_ih_13_15 wn_ih_13_15 0 0.3738351494584732
Vwp_ih_14_15 wp_ih_14_15 0 0.553973605684141
Vwn_ih_14_15 wn_ih_14_15 0 0.446026394315859
Vwp_ih_15_15 wp_ih_15_15 0 0.5536307192052063
Vwn_ih_15_15 wn_ih_15_15 0 0.4463692807947936
Vwp_ih_16_15 wp_ih_16_15 0 0.31314471192756965
Vwn_ih_16_15 wn_ih_16_15 0 0.6868552880724303
Vwp_ih_17_15 wp_ih_17_15 0 0.5309711786321054
Vwn_ih_17_15 wn_ih_17_15 0 0.4690288213678946
Vwp_ih_18_15 wp_ih_18_15 0 0.37645172205012983
Vwn_ih_18_15 wn_ih_18_15 0 0.6235482779498702
Vwp_ih_19_15 wp_ih_19_15 0 0.5120824445600486
Vwn_ih_19_15 wn_ih_19_15 0 0.4879175554399514
Vwp_ih_20_15 wp_ih_20_15 0 0.5035627988614287
Vwn_ih_20_15 wn_ih_20_15 0 0.49643720113857126
Vwp_ih_21_15 wp_ih_21_15 0 0.4205735011646416
Vwn_ih_21_15 wn_ih_21_15 0 0.5794264988353584
Vwp_ih_22_15 wp_ih_22_15 0 0.5950337707178999
Vwn_ih_22_15 wn_ih_22_15 0 0.4049662292821001
Vwp_ih_23_15 wp_ih_23_15 0 0.488018361707276
Vwn_ih_23_15 wn_ih_23_15 0 0.511981638292724
Vwp_ih_24_15 wp_ih_24_15 0 0.3140849330793003
Vwn_ih_24_15 wn_ih_24_15 0 0.6859150669206997
Vwp_ih_25_15 wp_ih_25_15 0 0.4131223151568678
Vwn_ih_25_15 wn_ih_25_15 0 0.5868776848431322
Vwp_ih_26_15 wp_ih_26_15 0 0.41213031801509026
Vwn_ih_26_15 wn_ih_26_15 0 0.5878696819849097
Vwp_ih_27_15 wp_ih_27_15 0 0.4866031039725427
Vwn_ih_27_15 wn_ih_27_15 0 0.5133968960274573
Vwp_ih_28_15 wp_ih_28_15 0 0.6213454847548157
Vwn_ih_28_15 wn_ih_28_15 0 0.37865451524518434
Vwp_ih_29_15 wp_ih_29_15 0 0.5403606367221221
Vwn_ih_29_15 wn_ih_29_15 0 0.45963936327787797
Vwp_ih_30_15 wp_ih_30_15 0 0.5618927744087359
Vwn_ih_30_15 wn_ih_30_15 0 0.4381072255912642
Vwp_ih_31_15 wp_ih_31_15 0 0.3456336728957886
Vwn_ih_31_15 wn_ih_31_15 0 0.6543663271042114
Vwp_ih_32_15 wp_ih_32_15 0 0.7842996623588236
Vwn_ih_32_15 wn_ih_32_15 0 0.3
Vwp_ih_33_15 wp_ih_33_15 0 0.5429462116547527
Vwn_ih_33_15 wn_ih_33_15 0 0.45705378834524735
Vwp_ih_34_15 wp_ih_34_15 0 0.8218960503037193
Vwn_ih_34_15 wn_ih_34_15 0 0.3
Vwp_ih_35_15 wp_ih_35_15 0 0.4339447992595207
Vwn_ih_35_15 wn_ih_35_15 0 0.5660552007404793
Vwp_ih_36_15 wp_ih_36_15 0 0.42197318570169506
Vwn_ih_36_15 wn_ih_36_15 0 0.5780268142983049
Vwp_ih_37_15 wp_ih_37_15 0 0.7884884801573901
Vwn_ih_37_15 wn_ih_37_15 0 0.3
Vwp_ih_38_15 wp_ih_38_15 0 0.41055963821810904
Vwn_ih_38_15 wn_ih_38_15 0 0.589440361781891
Vwp_ih_39_15 wp_ih_39_15 0 0.5502446984830255
Vwn_ih_39_15 wn_ih_39_15 0 0.4497553015169745
Vwp_ih_40_15 wp_ih_40_15 0 0.463265016636303
Vwn_ih_40_15 wn_ih_40_15 0 0.536734983363697
Vwp_ih_41_15 wp_ih_41_15 0 0.41991685929757727
Vwn_ih_41_15 wn_ih_41_15 0 0.5800831407024227
Vwp_ih_42_15 wp_ih_42_15 0 0.7821504429535989
Vwn_ih_42_15 wn_ih_42_15 0 0.3
Vwp_ih_43_15 wp_ih_43_15 0 0.4315061690466875
Vwn_ih_43_15 wn_ih_43_15 0 0.5684938309533125
Vwp_ih_44_15 wp_ih_44_15 0 0.6112427142565088
Vwn_ih_44_15 wn_ih_44_15 0 0.3887572857434912
Vwp_ih_45_15 wp_ih_45_15 0 0.608673630630438
Vwn_ih_45_15 wn_ih_45_15 0 0.39132636936956205
Vwp_ih_46_15 wp_ih_46_15 0 0.3834225124652362
Vwn_ih_46_15 wn_ih_46_15 0 0.6165774875347638
Vwp_ih_47_15 wp_ih_47_15 0 0.3
Vwn_ih_47_15 wn_ih_47_15 0 0.7278935505782044
Vwp_ih_48_15 wp_ih_48_15 0 0.3
Vwn_ih_48_15 wn_ih_48_15 0 0.7103538395547642
Vwp_ih_49_15 wp_ih_49_15 0 0.4132186987032953
Vwn_ih_49_15 wn_ih_49_15 0 0.5867813012967047
Vwp_ih_50_15 wp_ih_50_15 0 0.5239054701024709
Vwn_ih_50_15 wn_ih_50_15 0 0.47609452989752915
Vwp_ih_51_15 wp_ih_51_15 0 0.5639765243755948
Vwn_ih_51_15 wn_ih_51_15 0 0.43602347562440524
Vwp_ih_52_15 wp_ih_52_15 0 0.4784956366604959
Vwn_ih_52_15 wn_ih_52_15 0 0.5215043633395041
Vwp_ih_53_15 wp_ih_53_15 0 0.4606049450340556
Vwn_ih_53_15 wn_ih_53_15 0 0.5393950549659444
Vwp_ih_54_15 wp_ih_54_15 0 0.6009447477311805
Vwn_ih_54_15 wn_ih_54_15 0 0.3990552522688196
Vwp_ih_55_15 wp_ih_55_15 0 0.5782444079738069
Vwn_ih_55_15 wn_ih_55_15 0 0.42175559202619306
Vwp_ih_56_15 wp_ih_56_15 0 0.5453902786961079
Vwn_ih_56_15 wn_ih_56_15 0 0.4546097213038921
Vwp_ih_57_15 wp_ih_57_15 0 0.41433518871338754
Vwn_ih_57_15 wn_ih_57_15 0 0.5856648112866124
Vwp_ih_58_15 wp_ih_58_15 0 0.555866497794557
Vwn_ih_58_15 wn_ih_58_15 0 0.444133502205443
Vwp_ih_59_15 wp_ih_59_15 0 0.5176105276447619
Vwn_ih_59_15 wn_ih_59_15 0 0.4823894723552381
Vwp_ih_60_15 wp_ih_60_15 0 0.4258357199714658
Vwn_ih_60_15 wn_ih_60_15 0 0.5741642800285341
Vwp_ih_61_15 wp_ih_61_15 0 0.41093019214096743
Vwn_ih_61_15 wn_ih_61_15 0 0.5890698078590325
Vwp_ih_62_15 wp_ih_62_15 0 0.6206955612762749
Vwn_ih_62_15 wn_ih_62_15 0 0.3793044387237251
Vwp_ih_63_15 wp_ih_63_15 0 0.708857419180244
Vwn_ih_63_15 wn_ih_63_15 0 0.3
Vwp_ho_15_0 wp_ho_15_0 0 0.36949743894762205
Vwn_ho_15_0 wn_ho_15_0 0 0.630502561052378
Vwp_ho_15_1 wp_ho_15_1 0 0.4857771326671453
Vwn_ho_15_1 wn_ho_15_1 0 0.5142228673328547
Vwp_ho_15_2 wp_ho_15_2 0 0.47772927128539217
Vwn_ho_15_2 wn_ho_15_2 0 0.5222707287146078
Vwp_ho_15_3 wp_ho_15_3 0 0.4687809500373364
Vwn_ho_15_3 wn_ho_15_3 0 0.5312190499626637
Vwp_ho_15_4 wp_ho_15_4 0 0.5085384918268152
Vwn_ho_15_4 wn_ho_15_4 0 0.4914615081731848
Vwp_ih_0_16 wp_ih_0_16 0 0.4364327921083434
Vwn_ih_0_16 wn_ih_0_16 0 0.5635672078916566
Vwp_ih_1_16 wp_ih_1_16 0 0.3
Vwn_ih_1_16 wn_ih_1_16 0 0.7134029298812102
Vwp_ih_2_16 wp_ih_2_16 0 0.6038141026685446
Vwn_ih_2_16 wn_ih_2_16 0 0.3961858973314554
Vwp_ih_3_16 wp_ih_3_16 0 0.42514153186696113
Vwn_ih_3_16 wn_ih_3_16 0 0.5748584681330389
Vwp_ih_4_16 wp_ih_4_16 0 0.6039024554460425
Vwn_ih_4_16 wn_ih_4_16 0 0.3960975445539575
Vwp_ih_5_16 wp_ih_5_16 0 0.4290026713413125
Vwn_ih_5_16 wn_ih_5_16 0 0.5709973286586876
Vwp_ih_6_16 wp_ih_6_16 0 0.7589480129315807
Vwn_ih_6_16 wn_ih_6_16 0 0.3
Vwp_ih_7_16 wp_ih_7_16 0 0.515472472914996
Vwn_ih_7_16 wn_ih_7_16 0 0.484527527085004
Vwp_ih_8_16 wp_ih_8_16 0 0.6092886227044096
Vwn_ih_8_16 wn_ih_8_16 0 0.39071137729559036
Vwp_ih_9_16 wp_ih_9_16 0 0.38234518372645615
Vwn_ih_9_16 wn_ih_9_16 0 0.6176548162735439
Vwp_ih_10_16 wp_ih_10_16 0 0.3
Vwn_ih_10_16 wn_ih_10_16 0 0.827376833517574
Vwp_ih_11_16 wp_ih_11_16 0 0.5445915350642851
Vwn_ih_11_16 wn_ih_11_16 0 0.4554084649357149
Vwp_ih_12_16 wp_ih_12_16 0 0.5327221488086022
Vwn_ih_12_16 wn_ih_12_16 0 0.46727785119139775
Vwp_ih_13_16 wp_ih_13_16 0 0.5505722964037361
Vwn_ih_13_16 wn_ih_13_16 0 0.4494277035962639
Vwp_ih_14_16 wp_ih_14_16 0 0.4368471727628126
Vwn_ih_14_16 wn_ih_14_16 0 0.5631528272371874
Vwp_ih_15_16 wp_ih_15_16 0 0.3496103561772057
Vwn_ih_15_16 wn_ih_15_16 0 0.6503896438227943
Vwp_ih_16_16 wp_ih_16_16 0 0.3086555323975
Vwn_ih_16_16 wn_ih_16_16 0 0.6913444676025
Vwp_ih_17_16 wp_ih_17_16 0 0.5579677910611781
Vwn_ih_17_16 wn_ih_17_16 0 0.4420322089388219
Vwp_ih_18_16 wp_ih_18_16 0 0.5808137125607442
Vwn_ih_18_16 wn_ih_18_16 0 0.41918628743925584
Vwp_ih_19_16 wp_ih_19_16 0 0.40767568271445853
Vwn_ih_19_16 wn_ih_19_16 0 0.5923243172855415
Vwp_ih_20_16 wp_ih_20_16 0 0.40826856103667797
Vwn_ih_20_16 wn_ih_20_16 0 0.591731438963322
Vwp_ih_21_16 wp_ih_21_16 0 0.38672765126575215
Vwn_ih_21_16 wn_ih_21_16 0 0.6132723487342479
Vwp_ih_22_16 wp_ih_22_16 0 0.31517857042968545
Vwn_ih_22_16 wn_ih_22_16 0 0.6848214295703146
Vwp_ih_23_16 wp_ih_23_16 0 0.5322740266773579
Vwn_ih_23_16 wn_ih_23_16 0 0.4677259733226421
Vwp_ih_24_16 wp_ih_24_16 0 0.6020567324487669
Vwn_ih_24_16 wn_ih_24_16 0 0.3979432675512331
Vwp_ih_25_16 wp_ih_25_16 0 0.4866315618954916
Vwn_ih_25_16 wn_ih_25_16 0 0.5133684381045084
Vwp_ih_26_16 wp_ih_26_16 0 0.36159131607672523
Vwn_ih_26_16 wn_ih_26_16 0 0.6384086839232748
Vwp_ih_27_16 wp_ih_27_16 0 0.49355918068864096
Vwn_ih_27_16 wn_ih_27_16 0 0.506440819311359
Vwp_ih_28_16 wp_ih_28_16 0 0.6297430452459345
Vwn_ih_28_16 wn_ih_28_16 0 0.37025695475406545
Vwp_ih_29_16 wp_ih_29_16 0 0.7432901753927357
Vwn_ih_29_16 wn_ih_29_16 0 0.3
Vwp_ih_30_16 wp_ih_30_16 0 0.5787394827689802
Vwn_ih_30_16 wn_ih_30_16 0 0.4212605172310198
Vwp_ih_31_16 wp_ih_31_16 0 0.4060838241233713
Vwn_ih_31_16 wn_ih_31_16 0 0.5939161758766287
Vwp_ih_32_16 wp_ih_32_16 0 0.3
Vwn_ih_32_16 wn_ih_32_16 0 0.7382690552524774
Vwp_ih_33_16 wp_ih_33_16 0 0.36222498163537614
Vwn_ih_33_16 wn_ih_33_16 0 0.6377750183646238
Vwp_ih_34_16 wp_ih_34_16 0 0.5168128823331716
Vwn_ih_34_16 wn_ih_34_16 0 0.4831871176668284
Vwp_ih_35_16 wp_ih_35_16 0 0.5607002583710649
Vwn_ih_35_16 wn_ih_35_16 0 0.4392997416289352
Vwp_ih_36_16 wp_ih_36_16 0 0.5145871932951427
Vwn_ih_36_16 wn_ih_36_16 0 0.48541280670485726
Vwp_ih_37_16 wp_ih_37_16 0 0.4746374122948086
Vwn_ih_37_16 wn_ih_37_16 0 0.5253625877051914
Vwp_ih_38_16 wp_ih_38_16 0 0.35777779424717265
Vwn_ih_38_16 wn_ih_38_16 0 0.6422222057528273
Vwp_ih_39_16 wp_ih_39_16 0 0.3108252884324637
Vwn_ih_39_16 wn_ih_39_16 0 0.6891747115675363
Vwp_ih_40_16 wp_ih_40_16 0 0.5321936494847941
Vwn_ih_40_16 wn_ih_40_16 0 0.4678063505152059
Vwp_ih_41_16 wp_ih_41_16 0 0.4164321074847602
Vwn_ih_41_16 wn_ih_41_16 0 0.5835678925152399
Vwp_ih_42_16 wp_ih_42_16 0 0.6574927236827309
Vwn_ih_42_16 wn_ih_42_16 0 0.34250727631726907
Vwp_ih_43_16 wp_ih_43_16 0 0.34353674714007304
Vwn_ih_43_16 wn_ih_43_16 0 0.656463252859927
Vwp_ih_44_16 wp_ih_44_16 0 0.6881318190750672
Vwn_ih_44_16 wn_ih_44_16 0 0.31186818092493285
Vwp_ih_45_16 wp_ih_45_16 0 0.45179199361336386
Vwn_ih_45_16 wn_ih_45_16 0 0.5482080063866361
Vwp_ih_46_16 wp_ih_46_16 0 0.5381824518772192
Vwn_ih_46_16 wn_ih_46_16 0 0.4618175481227807
Vwp_ih_47_16 wp_ih_47_16 0 0.5282012570954201
Vwn_ih_47_16 wn_ih_47_16 0 0.47179874290457985
Vwp_ih_48_16 wp_ih_48_16 0 0.45845184031582054
Vwn_ih_48_16 wn_ih_48_16 0 0.5415481596841795
Vwp_ih_49_16 wp_ih_49_16 0 0.3
Vwn_ih_49_16 wn_ih_49_16 0 0.718447002150599
Vwp_ih_50_16 wp_ih_50_16 0 0.4534896038649787
Vwn_ih_50_16 wn_ih_50_16 0 0.5465103961350213
Vwp_ih_51_16 wp_ih_51_16 0 0.6719654178426071
Vwn_ih_51_16 wn_ih_51_16 0 0.32803458215739284
Vwp_ih_52_16 wp_ih_52_16 0 0.3522071226915299
Vwn_ih_52_16 wn_ih_52_16 0 0.6477928773084701
Vwp_ih_53_16 wp_ih_53_16 0 0.30574488412647993
Vwn_ih_53_16 wn_ih_53_16 0 0.6942551158735201
Vwp_ih_54_16 wp_ih_54_16 0 0.45837372198293924
Vwn_ih_54_16 wn_ih_54_16 0 0.5416262780170608
Vwp_ih_55_16 wp_ih_55_16 0 0.4308561155776102
Vwn_ih_55_16 wn_ih_55_16 0 0.5691438844223898
Vwp_ih_56_16 wp_ih_56_16 0 0.34523703866130795
Vwn_ih_56_16 wn_ih_56_16 0 0.654762961338692
Vwp_ih_57_16 wp_ih_57_16 0 0.4339967182709732
Vwn_ih_57_16 wn_ih_57_16 0 0.5660032817290268
Vwp_ih_58_16 wp_ih_58_16 0 0.4787260066902632
Vwn_ih_58_16 wn_ih_58_16 0 0.5212739933097368
Vwp_ih_59_16 wp_ih_59_16 0 0.48663412378131116
Vwn_ih_59_16 wn_ih_59_16 0 0.5133658762186889
Vwp_ih_60_16 wp_ih_60_16 0 0.5336752891768235
Vwn_ih_60_16 wn_ih_60_16 0 0.46632471082317656
Vwp_ih_61_16 wp_ih_61_16 0 0.549139042198255
Vwn_ih_61_16 wn_ih_61_16 0 0.450860957801745
Vwp_ih_62_16 wp_ih_62_16 0 0.4942632785760398
Vwn_ih_62_16 wn_ih_62_16 0 0.5057367214239602
Vwp_ih_63_16 wp_ih_63_16 0 0.5185588417801081
Vwn_ih_63_16 wn_ih_63_16 0 0.48144115821989186
Vwp_ho_16_0 wp_ho_16_0 0 0.43753990343463023
Vwn_ho_16_0 wn_ho_16_0 0 0.5624600965653698
Vwp_ho_16_1 wp_ho_16_1 0 0.7247340845293249
Vwn_ho_16_1 wn_ho_16_1 0 0.3
Vwp_ho_16_2 wp_ho_16_2 0 0.5140769556725873
Vwn_ho_16_2 wn_ho_16_2 0 0.48592304432741273
Vwp_ho_16_3 wp_ho_16_3 0 0.3919044962373657
Vwn_ho_16_3 wn_ho_16_3 0 0.6080955037626343
Vwp_ho_16_4 wp_ho_16_4 0 0.6454671725979906
Vwn_ho_16_4 wn_ho_16_4 0 0.3545328274020095
Vwp_ih_0_17 wp_ih_0_17 0 0.7016171546635879
Vwn_ih_0_17 wn_ih_0_17 0 0.3
Vwp_ih_1_17 wp_ih_1_17 0 0.6505137779904142
Vwn_ih_1_17 wn_ih_1_17 0 0.3494862220095858
Vwp_ih_2_17 wp_ih_2_17 0 0.3
Vwn_ih_2_17 wn_ih_2_17 0 0.8259577243691767
Vwp_ih_3_17 wp_ih_3_17 0 0.46330449410214347
Vwn_ih_3_17 wn_ih_3_17 0 0.5366955058978565
Vwp_ih_4_17 wp_ih_4_17 0 0.3564559840032761
Vwn_ih_4_17 wn_ih_4_17 0 0.6435440159967238
Vwp_ih_5_17 wp_ih_5_17 0 0.45135495726180364
Vwn_ih_5_17 wn_ih_5_17 0 0.5486450427381964
Vwp_ih_6_17 wp_ih_6_17 0 0.6087845160165982
Vwn_ih_6_17 wn_ih_6_17 0 0.3912154839834018
Vwp_ih_7_17 wp_ih_7_17 0 0.48075948400893403
Vwn_ih_7_17 wn_ih_7_17 0 0.519240515991066
Vwp_ih_8_17 wp_ih_8_17 0 0.450909541161522
Vwn_ih_8_17 wn_ih_8_17 0 0.549090458838478
Vwp_ih_9_17 wp_ih_9_17 0 0.6656820285035073
Vwn_ih_9_17 wn_ih_9_17 0 0.33431797149649267
Vwp_ih_10_17 wp_ih_10_17 0 0.3242540719628918
Vwn_ih_10_17 wn_ih_10_17 0 0.6757459280371082
Vwp_ih_11_17 wp_ih_11_17 0 0.48255485380020197
Vwn_ih_11_17 wn_ih_11_17 0 0.517445146199798
Vwp_ih_12_17 wp_ih_12_17 0 0.5494562180583258
Vwn_ih_12_17 wn_ih_12_17 0 0.45054378194167427
Vwp_ih_13_17 wp_ih_13_17 0 0.5110991724626873
Vwn_ih_13_17 wn_ih_13_17 0 0.4889008275373126
Vwp_ih_14_17 wp_ih_14_17 0 0.38991369514326774
Vwn_ih_14_17 wn_ih_14_17 0 0.6100863048567323
Vwp_ih_15_17 wp_ih_15_17 0 0.5038695279700011
Vwn_ih_15_17 wn_ih_15_17 0 0.49613047202999894
Vwp_ih_16_17 wp_ih_16_17 0 0.5986510660320463
Vwn_ih_16_17 wn_ih_16_17 0 0.4013489339679537
Vwp_ih_17_17 wp_ih_17_17 0 0.5247293482167616
Vwn_ih_17_17 wn_ih_17_17 0 0.4752706517832383
Vwp_ih_18_17 wp_ih_18_17 0 0.5040207780877025
Vwn_ih_18_17 wn_ih_18_17 0 0.49597922191229743
Vwp_ih_19_17 wp_ih_19_17 0 0.5242083773372899
Vwn_ih_19_17 wn_ih_19_17 0 0.47579162266271013
Vwp_ih_20_17 wp_ih_20_17 0 0.5167073122623017
Vwn_ih_20_17 wn_ih_20_17 0 0.48329268773769835
Vwp_ih_21_17 wp_ih_21_17 0 0.3496323545877297
Vwn_ih_21_17 wn_ih_21_17 0 0.6503676454122703
Vwp_ih_22_17 wp_ih_22_17 0 0.47155776409889116
Vwn_ih_22_17 wn_ih_22_17 0 0.5284422359011088
Vwp_ih_23_17 wp_ih_23_17 0 0.5599516518615247
Vwn_ih_23_17 wn_ih_23_17 0 0.44004834813847526
Vwp_ih_24_17 wp_ih_24_17 0 0.3
Vwn_ih_24_17 wn_ih_24_17 0 0.872432411311845
Vwp_ih_25_17 wp_ih_25_17 0 0.5698256422822647
Vwn_ih_25_17 wn_ih_25_17 0 0.43017435771773527
Vwp_ih_26_17 wp_ih_26_17 0 0.5215214168328154
Vwn_ih_26_17 wn_ih_26_17 0 0.4784785831671846
Vwp_ih_27_17 wp_ih_27_17 0 0.4028199220435964
Vwn_ih_27_17 wn_ih_27_17 0 0.5971800779564036
Vwp_ih_28_17 wp_ih_28_17 0 0.44149436635922507
Vwn_ih_28_17 wn_ih_28_17 0 0.558505633640775
Vwp_ih_29_17 wp_ih_29_17 0 0.4723872565935439
Vwn_ih_29_17 wn_ih_29_17 0 0.5276127434064561
Vwp_ih_30_17 wp_ih_30_17 0 0.5274832878276733
Vwn_ih_30_17 wn_ih_30_17 0 0.4725167121723267
Vwp_ih_31_17 wp_ih_31_17 0 0.4569686219336916
Vwn_ih_31_17 wn_ih_31_17 0 0.5430313780663084
Vwp_ih_32_17 wp_ih_32_17 0 0.6400403729556208
Vwn_ih_32_17 wn_ih_32_17 0 0.3599596270443792
Vwp_ih_33_17 wp_ih_33_17 0 0.535913965919903
Vwn_ih_33_17 wn_ih_33_17 0 0.464086034080097
Vwp_ih_34_17 wp_ih_34_17 0 0.38828593602794054
Vwn_ih_34_17 wn_ih_34_17 0 0.6117140639720595
Vwp_ih_35_17 wp_ih_35_17 0 0.4852742471714208
Vwn_ih_35_17 wn_ih_35_17 0 0.5147257528285791
Vwp_ih_36_17 wp_ih_36_17 0 0.5606943793240015
Vwn_ih_36_17 wn_ih_36_17 0 0.4393056206759986
Vwp_ih_37_17 wp_ih_37_17 0 0.6064237986233403
Vwn_ih_37_17 wn_ih_37_17 0 0.3935762013766597
Vwp_ih_38_17 wp_ih_38_17 0 0.5606375507829325
Vwn_ih_38_17 wn_ih_38_17 0 0.4393624492170675
Vwp_ih_39_17 wp_ih_39_17 0 0.4882887497994712
Vwn_ih_39_17 wn_ih_39_17 0 0.5117112502005288
Vwp_ih_40_17 wp_ih_40_17 0 0.5207756553672926
Vwn_ih_40_17 wn_ih_40_17 0 0.47922434463270736
Vwp_ih_41_17 wp_ih_41_17 0 0.48457364038816947
Vwn_ih_41_17 wn_ih_41_17 0 0.5154263596118306
Vwp_ih_42_17 wp_ih_42_17 0 0.5652486145821654
Vwn_ih_42_17 wn_ih_42_17 0 0.43475138541783465
Vwp_ih_43_17 wp_ih_43_17 0 0.3875400865586165
Vwn_ih_43_17 wn_ih_43_17 0 0.6124599134413835
Vwp_ih_44_17 wp_ih_44_17 0 0.5795928325254777
Vwn_ih_44_17 wn_ih_44_17 0 0.42040716747452234
Vwp_ih_45_17 wp_ih_45_17 0 0.30054939849396334
Vwn_ih_45_17 wn_ih_45_17 0 0.6994506015060367
Vwp_ih_46_17 wp_ih_46_17 0 0.5531756841543592
Vwn_ih_46_17 wn_ih_46_17 0 0.44682431584564075
Vwp_ih_47_17 wp_ih_47_17 0 0.5342248545388311
Vwn_ih_47_17 wn_ih_47_17 0 0.4657751454611689
Vwp_ih_48_17 wp_ih_48_17 0 0.501781455523735
Vwn_ih_48_17 wn_ih_48_17 0 0.49821854447626507
Vwp_ih_49_17 wp_ih_49_17 0 0.3
Vwn_ih_49_17 wn_ih_49_17 0 0.7408167511746602
Vwp_ih_50_17 wp_ih_50_17 0 0.6642114629365883
Vwn_ih_50_17 wn_ih_50_17 0 0.3357885370634117
Vwp_ih_51_17 wp_ih_51_17 0 0.5800795529807338
Vwn_ih_51_17 wn_ih_51_17 0 0.41992044701926623
Vwp_ih_52_17 wp_ih_52_17 0 0.4923110974853846
Vwn_ih_52_17 wn_ih_52_17 0 0.5076889025146154
Vwp_ih_53_17 wp_ih_53_17 0 0.5511635750064259
Vwn_ih_53_17 wn_ih_53_17 0 0.4488364249935741
Vwp_ih_54_17 wp_ih_54_17 0 0.3696379919628695
Vwn_ih_54_17 wn_ih_54_17 0 0.6303620080371305
Vwp_ih_55_17 wp_ih_55_17 0 0.5449483552199108
Vwn_ih_55_17 wn_ih_55_17 0 0.45505164478008925
Vwp_ih_56_17 wp_ih_56_17 0 0.6881355742038889
Vwn_ih_56_17 wn_ih_56_17 0 0.31186442579611107
Vwp_ih_57_17 wp_ih_57_17 0 0.3737173904805244
Vwn_ih_57_17 wn_ih_57_17 0 0.6262826095194756
Vwp_ih_58_17 wp_ih_58_17 0 0.8465416638925471
Vwn_ih_58_17 wn_ih_58_17 0 0.3
Vwp_ih_59_17 wp_ih_59_17 0 0.45664798779876353
Vwn_ih_59_17 wn_ih_59_17 0 0.5433520122012364
Vwp_ih_60_17 wp_ih_60_17 0 0.5949009920323826
Vwn_ih_60_17 wn_ih_60_17 0 0.40509900796761744
Vwp_ih_61_17 wp_ih_61_17 0 0.39230897159160794
Vwn_ih_61_17 wn_ih_61_17 0 0.6076910284083921
Vwp_ih_62_17 wp_ih_62_17 0 0.5172087942939335
Vwn_ih_62_17 wn_ih_62_17 0 0.4827912057060665
Vwp_ih_63_17 wp_ih_63_17 0 0.33688096286192315
Vwn_ih_63_17 wn_ih_63_17 0 0.6631190371380769
Vwp_ho_17_0 wp_ho_17_0 0 0.3916517910016968
Vwn_ho_17_0 wn_ho_17_0 0 0.6083482089983032
Vwp_ho_17_1 wp_ho_17_1 0 0.5327432800731535
Vwn_ho_17_1 wn_ho_17_1 0 0.4672567199268465
Vwp_ho_17_2 wp_ho_17_2 0 0.6505485388851001
Vwn_ho_17_2 wn_ho_17_2 0 0.3494514611148999
Vwp_ho_17_3 wp_ho_17_3 0 0.47940847781383167
Vwn_ho_17_3 wn_ho_17_3 0 0.5205915221861683
Vwp_ho_17_4 wp_ho_17_4 0 0.5868223629301952
Vwn_ho_17_4 wn_ho_17_4 0 0.4131776370698048
Vwp_ih_0_18 wp_ih_0_18 0 0.42092071836809086
Vwn_ih_0_18 wn_ih_0_18 0 0.5790792816319091
Vwp_ih_1_18 wp_ih_1_18 0 0.4465629591929124
Vwn_ih_1_18 wn_ih_1_18 0 0.5534370408070877
Vwp_ih_2_18 wp_ih_2_18 0 0.3844170063441522
Vwn_ih_2_18 wn_ih_2_18 0 0.6155829936558478
Vwp_ih_3_18 wp_ih_3_18 0 0.4404841797681655
Vwn_ih_3_18 wn_ih_3_18 0 0.5595158202318345
Vwp_ih_4_18 wp_ih_4_18 0 0.6006391562300255
Vwn_ih_4_18 wn_ih_4_18 0 0.39936084376997444
Vwp_ih_5_18 wp_ih_5_18 0 0.3691329736515304
Vwn_ih_5_18 wn_ih_5_18 0 0.6308670263484696
Vwp_ih_6_18 wp_ih_6_18 0 0.36784645245669456
Vwn_ih_6_18 wn_ih_6_18 0 0.6321535475433054
Vwp_ih_7_18 wp_ih_7_18 0 0.5030055946310084
Vwn_ih_7_18 wn_ih_7_18 0 0.49699440536899164
Vwp_ih_8_18 wp_ih_8_18 0 0.43104904593204185
Vwn_ih_8_18 wn_ih_8_18 0 0.5689509540679581
Vwp_ih_9_18 wp_ih_9_18 0 0.36564522355055296
Vwn_ih_9_18 wn_ih_9_18 0 0.634354776449447
Vwp_ih_10_18 wp_ih_10_18 0 0.5192863237346139
Vwn_ih_10_18 wn_ih_10_18 0 0.4807136762653861
Vwp_ih_11_18 wp_ih_11_18 0 0.4073214129197399
Vwn_ih_11_18 wn_ih_11_18 0 0.5926785870802601
Vwp_ih_12_18 wp_ih_12_18 0 0.5340514974031711
Vwn_ih_12_18 wn_ih_12_18 0 0.4659485025968289
Vwp_ih_13_18 wp_ih_13_18 0 0.5476264458730379
Vwn_ih_13_18 wn_ih_13_18 0 0.4523735541269621
Vwp_ih_14_18 wp_ih_14_18 0 0.48941941017794144
Vwn_ih_14_18 wn_ih_14_18 0 0.5105805898220586
Vwp_ih_15_18 wp_ih_15_18 0 0.48711616366161115
Vwn_ih_15_18 wn_ih_15_18 0 0.5128838363383889
Vwp_ih_16_18 wp_ih_16_18 0 0.6218460141428714
Vwn_ih_16_18 wn_ih_16_18 0 0.37815398585712856
Vwp_ih_17_18 wp_ih_17_18 0 0.6746003613038272
Vwn_ih_17_18 wn_ih_17_18 0 0.3253996386961729
Vwp_ih_18_18 wp_ih_18_18 0 0.5097825316751284
Vwn_ih_18_18 wn_ih_18_18 0 0.4902174683248716
Vwp_ih_19_18 wp_ih_19_18 0 0.3551520352066434
Vwn_ih_19_18 wn_ih_19_18 0 0.6448479647933566
Vwp_ih_20_18 wp_ih_20_18 0 0.3
Vwn_ih_20_18 wn_ih_20_18 0 0.703570217419413
Vwp_ih_21_18 wp_ih_21_18 0 0.3
Vwn_ih_21_18 wn_ih_21_18 0 0.7181846713673957
Vwp_ih_22_18 wp_ih_22_18 0 0.3785428945268797
Vwn_ih_22_18 wn_ih_22_18 0 0.6214571054731203
Vwp_ih_23_18 wp_ih_23_18 0 0.39030982328060876
Vwn_ih_23_18 wn_ih_23_18 0 0.6096901767193913
Vwp_ih_24_18 wp_ih_24_18 0 0.4929904993027852
Vwn_ih_24_18 wn_ih_24_18 0 0.5070095006972147
Vwp_ih_25_18 wp_ih_25_18 0 0.3
Vwn_ih_25_18 wn_ih_25_18 0 0.7043503229993912
Vwp_ih_26_18 wp_ih_26_18 0 0.6804185387998472
Vwn_ih_26_18 wn_ih_26_18 0 0.3195814612001528
Vwp_ih_27_18 wp_ih_27_18 0 0.5643490900545934
Vwn_ih_27_18 wn_ih_27_18 0 0.4356509099454065
Vwp_ih_28_18 wp_ih_28_18 0 0.6052919060412759
Vwn_ih_28_18 wn_ih_28_18 0 0.394708093958724
Vwp_ih_29_18 wp_ih_29_18 0 0.475995372868051
Vwn_ih_29_18 wn_ih_29_18 0 0.524004627131949
Vwp_ih_30_18 wp_ih_30_18 0 0.5547012331178508
Vwn_ih_30_18 wn_ih_30_18 0 0.44529876688214926
Vwp_ih_31_18 wp_ih_31_18 0 0.38531836425580374
Vwn_ih_31_18 wn_ih_31_18 0 0.6146816357441962
Vwp_ih_32_18 wp_ih_32_18 0 0.6859771478721738
Vwn_ih_32_18 wn_ih_32_18 0 0.3140228521278262
Vwp_ih_33_18 wp_ih_33_18 0 0.36497145854327584
Vwn_ih_33_18 wn_ih_33_18 0 0.6350285414567242
Vwp_ih_34_18 wp_ih_34_18 0 0.44218828027476476
Vwn_ih_34_18 wn_ih_34_18 0 0.5578117197252352
Vwp_ih_35_18 wp_ih_35_18 0 0.5825866400935108
Vwn_ih_35_18 wn_ih_35_18 0 0.4174133599064892
Vwp_ih_36_18 wp_ih_36_18 0 0.7468242725753466
Vwn_ih_36_18 wn_ih_36_18 0 0.3
Vwp_ih_37_18 wp_ih_37_18 0 0.5117957111575704
Vwn_ih_37_18 wn_ih_37_18 0 0.48820428884242956
Vwp_ih_38_18 wp_ih_38_18 0 0.48824527434282744
Vwn_ih_38_18 wn_ih_38_18 0 0.5117547256571726
Vwp_ih_39_18 wp_ih_39_18 0 0.3
Vwn_ih_39_18 wn_ih_39_18 0 0.8008558324377046
Vwp_ih_40_18 wp_ih_40_18 0 0.7012194344344598
Vwn_ih_40_18 wn_ih_40_18 0 0.3
Vwp_ih_41_18 wp_ih_41_18 0 0.5466392790464618
Vwn_ih_41_18 wn_ih_41_18 0 0.4533607209535382
Vwp_ih_42_18 wp_ih_42_18 0 0.3
Vwn_ih_42_18 wn_ih_42_18 0 0.7053309639180043
Vwp_ih_43_18 wp_ih_43_18 0 0.5396467383910868
Vwn_ih_43_18 wn_ih_43_18 0 0.46035326160891316
Vwp_ih_44_18 wp_ih_44_18 0 0.5435127501409974
Vwn_ih_44_18 wn_ih_44_18 0 0.4564872498590026
Vwp_ih_45_18 wp_ih_45_18 0 0.4808582530082889
Vwn_ih_45_18 wn_ih_45_18 0 0.5191417469917111
Vwp_ih_46_18 wp_ih_46_18 0 0.46560125024719107
Vwn_ih_46_18 wn_ih_46_18 0 0.5343987497528089
Vwp_ih_47_18 wp_ih_47_18 0 0.5857400879330881
Vwn_ih_47_18 wn_ih_47_18 0 0.4142599120669119
Vwp_ih_48_18 wp_ih_48_18 0 0.5267902718730325
Vwn_ih_48_18 wn_ih_48_18 0 0.47320972812696754
Vwp_ih_49_18 wp_ih_49_18 0 0.5376590462819687
Vwn_ih_49_18 wn_ih_49_18 0 0.4623409537180313
Vwp_ih_50_18 wp_ih_50_18 0 0.6507518023198884
Vwn_ih_50_18 wn_ih_50_18 0 0.3492481976801116
Vwp_ih_51_18 wp_ih_51_18 0 0.6230721785567164
Vwn_ih_51_18 wn_ih_51_18 0 0.3769278214432837
Vwp_ih_52_18 wp_ih_52_18 0 0.57761458656246
Vwn_ih_52_18 wn_ih_52_18 0 0.42238541343754
Vwp_ih_53_18 wp_ih_53_18 0 0.5942905820402025
Vwn_ih_53_18 wn_ih_53_18 0 0.40570941795979754
Vwp_ih_54_18 wp_ih_54_18 0 0.3747529714098249
Vwn_ih_54_18 wn_ih_54_18 0 0.6252470285901751
Vwp_ih_55_18 wp_ih_55_18 0 0.38340902104758223
Vwn_ih_55_18 wn_ih_55_18 0 0.6165909789524178
Vwp_ih_56_18 wp_ih_56_18 0 0.5977241948646035
Vwn_ih_56_18 wn_ih_56_18 0 0.4022758051353965
Vwp_ih_57_18 wp_ih_57_18 0 0.5588495026273244
Vwn_ih_57_18 wn_ih_57_18 0 0.4411504973726756
Vwp_ih_58_18 wp_ih_58_18 0 0.5242668071466896
Vwn_ih_58_18 wn_ih_58_18 0 0.4757331928533104
Vwp_ih_59_18 wp_ih_59_18 0 0.5721298492801937
Vwn_ih_59_18 wn_ih_59_18 0 0.4278701507198063
Vwp_ih_60_18 wp_ih_60_18 0 0.4287050612379769
Vwn_ih_60_18 wn_ih_60_18 0 0.5712949387620231
Vwp_ih_61_18 wp_ih_61_18 0 0.5922468359983146
Vwn_ih_61_18 wn_ih_61_18 0 0.4077531640016854
Vwp_ih_62_18 wp_ih_62_18 0 0.41362260717050003
Vwn_ih_62_18 wn_ih_62_18 0 0.5863773928295
Vwp_ih_63_18 wp_ih_63_18 0 0.51998465742507
Vwn_ih_63_18 wn_ih_63_18 0 0.48001534257492995
Vwp_ho_18_0 wp_ho_18_0 0 0.6277842811617257
Vwn_ho_18_0 wn_ho_18_0 0 0.3722157188382743
Vwp_ho_18_1 wp_ho_18_1 0 0.3
Vwn_ho_18_1 wn_ho_18_1 0 0.7360525587847349
Vwp_ho_18_2 wp_ho_18_2 0 0.39451675074878584
Vwn_ho_18_2 wn_ho_18_2 0 0.6054832492512141
Vwp_ho_18_3 wp_ho_18_3 0 0.6700961406788304
Vwn_ho_18_3 wn_ho_18_3 0 0.32990385932116967
Vwp_ho_18_4 wp_ho_18_4 0 0.43315706735657655
Vwn_ho_18_4 wn_ho_18_4 0 0.5668429326434234
Vwp_ih_0_19 wp_ih_0_19 0 0.6115191139913168
Vwn_ih_0_19 wn_ih_0_19 0 0.38848088600868325
Vwp_ih_1_19 wp_ih_1_19 0 0.4229142426493902
Vwn_ih_1_19 wn_ih_1_19 0 0.5770857573506099
Vwp_ih_2_19 wp_ih_2_19 0 0.718872986686779
Vwn_ih_2_19 wn_ih_2_19 0 0.3
Vwp_ih_3_19 wp_ih_3_19 0 0.6011498598332301
Vwn_ih_3_19 wn_ih_3_19 0 0.3988501401667699
Vwp_ih_4_19 wp_ih_4_19 0 0.6504131556837301
Vwn_ih_4_19 wn_ih_4_19 0 0.34958684431626985
Vwp_ih_5_19 wp_ih_5_19 0 0.46109056073081034
Vwn_ih_5_19 wn_ih_5_19 0 0.5389094392691897
Vwp_ih_6_19 wp_ih_6_19 0 0.3247472760762721
Vwn_ih_6_19 wn_ih_6_19 0 0.6752527239237279
Vwp_ih_7_19 wp_ih_7_19 0 0.41514756745172726
Vwn_ih_7_19 wn_ih_7_19 0 0.5848524325482728
Vwp_ih_8_19 wp_ih_8_19 0 0.5657172757474846
Vwn_ih_8_19 wn_ih_8_19 0 0.4342827242525154
Vwp_ih_9_19 wp_ih_9_19 0 0.45046120724333416
Vwn_ih_9_19 wn_ih_9_19 0 0.5495387927566658
Vwp_ih_10_19 wp_ih_10_19 0 0.5428399647420448
Vwn_ih_10_19 wn_ih_10_19 0 0.4571600352579552
Vwp_ih_11_19 wp_ih_11_19 0 0.5255975859534303
Vwn_ih_11_19 wn_ih_11_19 0 0.47440241404656974
Vwp_ih_12_19 wp_ih_12_19 0 0.4726601121594583
Vwn_ih_12_19 wn_ih_12_19 0 0.5273398878405416
Vwp_ih_13_19 wp_ih_13_19 0 0.57091637033437
Vwn_ih_13_19 wn_ih_13_19 0 0.42908362966563
Vwp_ih_14_19 wp_ih_14_19 0 0.630400006618101
Vwn_ih_14_19 wn_ih_14_19 0 0.3695999933818989
Vwp_ih_15_19 wp_ih_15_19 0 0.41227552512197063
Vwn_ih_15_19 wn_ih_15_19 0 0.5877244748780294
Vwp_ih_16_19 wp_ih_16_19 0 0.5610642563434199
Vwn_ih_16_19 wn_ih_16_19 0 0.43893574365658006
Vwp_ih_17_19 wp_ih_17_19 0 0.5038081450968598
Vwn_ih_17_19 wn_ih_17_19 0 0.4961918549031402
Vwp_ih_18_19 wp_ih_18_19 0 0.5138258108898668
Vwn_ih_18_19 wn_ih_18_19 0 0.48617418911013316
Vwp_ih_19_19 wp_ih_19_19 0 0.5364280440969943
Vwn_ih_19_19 wn_ih_19_19 0 0.4635719559030057
Vwp_ih_20_19 wp_ih_20_19 0 0.40015141265994547
Vwn_ih_20_19 wn_ih_20_19 0 0.5998485873400545
Vwp_ih_21_19 wp_ih_21_19 0 0.621348241663436
Vwn_ih_21_19 wn_ih_21_19 0 0.37865175833656395
Vwp_ih_22_19 wp_ih_22_19 0 0.3547191960337878
Vwn_ih_22_19 wn_ih_22_19 0 0.6452808039662121
Vwp_ih_23_19 wp_ih_23_19 0 0.39768275235258554
Vwn_ih_23_19 wn_ih_23_19 0 0.6023172476474145
Vwp_ih_24_19 wp_ih_24_19 0 0.5784797090876004
Vwn_ih_24_19 wn_ih_24_19 0 0.4215202909123996
Vwp_ih_25_19 wp_ih_25_19 0 0.49006521405106673
Vwn_ih_25_19 wn_ih_25_19 0 0.5099347859489333
Vwp_ih_26_19 wp_ih_26_19 0 0.3909357159007132
Vwn_ih_26_19 wn_ih_26_19 0 0.6090642840992868
Vwp_ih_27_19 wp_ih_27_19 0 0.47422243320985646
Vwn_ih_27_19 wn_ih_27_19 0 0.5257775667901435
Vwp_ih_28_19 wp_ih_28_19 0 0.5064414563287158
Vwn_ih_28_19 wn_ih_28_19 0 0.49355854367128416
Vwp_ih_29_19 wp_ih_29_19 0 0.4193703523000299
Vwn_ih_29_19 wn_ih_29_19 0 0.5806296476999702
Vwp_ih_30_19 wp_ih_30_19 0 0.562354608102494
Vwn_ih_30_19 wn_ih_30_19 0 0.4376453918975059
Vwp_ih_31_19 wp_ih_31_19 0 0.35990774362040645
Vwn_ih_31_19 wn_ih_31_19 0 0.6400922563795935
Vwp_ih_32_19 wp_ih_32_19 0 0.5435984814980508
Vwn_ih_32_19 wn_ih_32_19 0 0.4564015185019492
Vwp_ih_33_19 wp_ih_33_19 0 0.6607995461197097
Vwn_ih_33_19 wn_ih_33_19 0 0.3392004538802903
Vwp_ih_34_19 wp_ih_34_19 0 0.5247248328547818
Vwn_ih_34_19 wn_ih_34_19 0 0.4752751671452182
Vwp_ih_35_19 wp_ih_35_19 0 0.4432215746519773
Vwn_ih_35_19 wn_ih_35_19 0 0.5567784253480227
Vwp_ih_36_19 wp_ih_36_19 0 0.4349747378280754
Vwn_ih_36_19 wn_ih_36_19 0 0.5650252621719246
Vwp_ih_37_19 wp_ih_37_19 0 0.483787716059596
Vwn_ih_37_19 wn_ih_37_19 0 0.5162122839404041
Vwp_ih_38_19 wp_ih_38_19 0 0.4083102407545515
Vwn_ih_38_19 wn_ih_38_19 0 0.5916897592454484
Vwp_ih_39_19 wp_ih_39_19 0 0.6481522726403828
Vwn_ih_39_19 wn_ih_39_19 0 0.3518477273596172
Vwp_ih_40_19 wp_ih_40_19 0 0.3
Vwn_ih_40_19 wn_ih_40_19 0 0.7147502871471759
Vwp_ih_41_19 wp_ih_41_19 0 0.7107396275405404
Vwn_ih_41_19 wn_ih_41_19 0 0.3
Vwp_ih_42_19 wp_ih_42_19 0 0.3
Vwn_ih_42_19 wn_ih_42_19 0 0.7234891003736647
Vwp_ih_43_19 wp_ih_43_19 0 0.540712812068684
Vwn_ih_43_19 wn_ih_43_19 0 0.4592871879313159
Vwp_ih_44_19 wp_ih_44_19 0 0.3975543912183943
Vwn_ih_44_19 wn_ih_44_19 0 0.6024456087816057
Vwp_ih_45_19 wp_ih_45_19 0 0.5598629758972355
Vwn_ih_45_19 wn_ih_45_19 0 0.4401370241027644
Vwp_ih_46_19 wp_ih_46_19 0 0.3985107613600736
Vwn_ih_46_19 wn_ih_46_19 0 0.6014892386399264
Vwp_ih_47_19 wp_ih_47_19 0 0.36330668789377174
Vwn_ih_47_19 wn_ih_47_19 0 0.6366933121062283
Vwp_ih_48_19 wp_ih_48_19 0 0.4581106437090036
Vwn_ih_48_19 wn_ih_48_19 0 0.5418893562909963
Vwp_ih_49_19 wp_ih_49_19 0 0.48825498317774474
Vwn_ih_49_19 wn_ih_49_19 0 0.5117450168222553
Vwp_ih_50_19 wp_ih_50_19 0 0.3
Vwn_ih_50_19 wn_ih_50_19 0 0.7293923227532696
Vwp_ih_51_19 wp_ih_51_19 0 0.5711022576922968
Vwn_ih_51_19 wn_ih_51_19 0 0.42889774230770317
Vwp_ih_52_19 wp_ih_52_19 0 0.3
Vwn_ih_52_19 wn_ih_52_19 0 0.7611462143660901
Vwp_ih_53_19 wp_ih_53_19 0 0.6254342897820185
Vwn_ih_53_19 wn_ih_53_19 0 0.37456571021798146
Vwp_ih_54_19 wp_ih_54_19 0 0.46743875917666644
Vwn_ih_54_19 wn_ih_54_19 0 0.5325612408233336
Vwp_ih_55_19 wp_ih_55_19 0 0.6099851143951089
Vwn_ih_55_19 wn_ih_55_19 0 0.3900148856048911
Vwp_ih_56_19 wp_ih_56_19 0 0.4277402020186153
Vwn_ih_56_19 wn_ih_56_19 0 0.5722597979813847
Vwp_ih_57_19 wp_ih_57_19 0 0.41192106075051566
Vwn_ih_57_19 wn_ih_57_19 0 0.5880789392494843
Vwp_ih_58_19 wp_ih_58_19 0 0.5590201741475305
Vwn_ih_58_19 wn_ih_58_19 0 0.4409798258524696
Vwp_ih_59_19 wp_ih_59_19 0 0.3922033759092237
Vwn_ih_59_19 wn_ih_59_19 0 0.6077966240907763
Vwp_ih_60_19 wp_ih_60_19 0 0.33770409554740954
Vwn_ih_60_19 wn_ih_60_19 0 0.6622959044525905
Vwp_ih_61_19 wp_ih_61_19 0 0.5240819285194666
Vwn_ih_61_19 wn_ih_61_19 0 0.4759180714805335
Vwp_ih_62_19 wp_ih_62_19 0 0.3633561955851013
Vwn_ih_62_19 wn_ih_62_19 0 0.6366438044148988
Vwp_ih_63_19 wp_ih_63_19 0 0.4981214220704212
Vwn_ih_63_19 wn_ih_63_19 0 0.5018785779295788
Vwp_ho_19_0 wp_ho_19_0 0 0.3
Vwn_ho_19_0 wn_ho_19_0 0 0.723915486586139
Vwp_ho_19_1 wp_ho_19_1 0 0.5244785698265924
Vwn_ho_19_1 wn_ho_19_1 0 0.4755214301734077
Vwp_ho_19_2 wp_ho_19_2 0 0.5487660042874398
Vwn_ho_19_2 wn_ho_19_2 0 0.4512339957125601
Vwp_ho_19_3 wp_ho_19_3 0 0.5333957045925253
Vwn_ho_19_3 wn_ho_19_3 0 0.46660429540747467
Vwp_ho_19_4 wp_ho_19_4 0 0.3
Vwn_ho_19_4 wn_ho_19_4 0 0.7369199450227977
Vxop0 xop0 0 0.5
Vxon0 xon0 0 0.5
Vxop1 xop1 0 0.5
Vxon1 xon1 0 0.5
Vxop2 xop2 0 0.5
Vxon2 xon2 0 0.5
Vxop3 xop3 0 0.5
Vxon3 xon3 0 0.5
Vxop4 xop4 0 0.5
Vxon4 xon4 0 0.5
Xcm_mh0 mhp0 mhn0 vdd cmld
Rnd_mh0 mhp0 mhn0 20k
Xcm_xh0 xhp0 xhn0 vdd cmld
Rnd_xh0 xhp0 xhn0 20k
X_ihm_0_0 a_xp0 a_xn0 wp_ih_0_0 wn_ih_0_0 mhp0 mhn0 vdd vbsyn gsyn
X_ihx_0_0 a_xp0 a_xn0 wp_ih_0_0 wn_ih_0_0 xhp0 xhn0 vdd vbsyn gsyn
X_ihm_1_0 a_xp1 a_xn1 wp_ih_1_0 wn_ih_1_0 mhp0 mhn0 vdd vbsyn gsyn
X_ihx_1_0 a_xp1 a_xn1 wp_ih_1_0 wn_ih_1_0 xhp0 xhn0 vdd vbsyn gsyn
X_ihm_2_0 a_xp2 a_xn2 wp_ih_2_0 wn_ih_2_0 mhp0 mhn0 vdd vbsyn gsyn
X_ihx_2_0 a_xp2 a_xn2 wp_ih_2_0 wn_ih_2_0 xhp0 xhn0 vdd vbsyn gsyn
X_ihm_3_0 a_xp3 a_xn3 wp_ih_3_0 wn_ih_3_0 mhp0 mhn0 vdd vbsyn gsyn
X_ihx_3_0 a_xp3 a_xn3 wp_ih_3_0 wn_ih_3_0 xhp0 xhn0 vdd vbsyn gsyn
X_ihm_4_0 a_xp4 a_xn4 wp_ih_4_0 wn_ih_4_0 mhp0 mhn0 vdd vbsyn gsyn
X_ihx_4_0 a_xp4 a_xn4 wp_ih_4_0 wn_ih_4_0 xhp0 xhn0 vdd vbsyn gsyn
X_ihm_5_0 a_xp5 a_xn5 wp_ih_5_0 wn_ih_5_0 mhp0 mhn0 vdd vbsyn gsyn
X_ihx_5_0 a_xp5 a_xn5 wp_ih_5_0 wn_ih_5_0 xhp0 xhn0 vdd vbsyn gsyn
X_ihm_6_0 a_xp6 a_xn6 wp_ih_6_0 wn_ih_6_0 mhp0 mhn0 vdd vbsyn gsyn
X_ihx_6_0 a_xp6 a_xn6 wp_ih_6_0 wn_ih_6_0 xhp0 xhn0 vdd vbsyn gsyn
X_ihm_7_0 a_xp7 a_xn7 wp_ih_7_0 wn_ih_7_0 mhp0 mhn0 vdd vbsyn gsyn
X_ihx_7_0 a_xp7 a_xn7 wp_ih_7_0 wn_ih_7_0 xhp0 xhn0 vdd vbsyn gsyn
X_ihm_8_0 a_xp8 a_xn8 wp_ih_8_0 wn_ih_8_0 mhp0 mhn0 vdd vbsyn gsyn
X_ihx_8_0 a_xp8 a_xn8 wp_ih_8_0 wn_ih_8_0 xhp0 xhn0 vdd vbsyn gsyn
X_ihm_9_0 a_xp9 a_xn9 wp_ih_9_0 wn_ih_9_0 mhp0 mhn0 vdd vbsyn gsyn
X_ihx_9_0 a_xp9 a_xn9 wp_ih_9_0 wn_ih_9_0 xhp0 xhn0 vdd vbsyn gsyn
X_ihm_10_0 a_xp10 a_xn10 wp_ih_10_0 wn_ih_10_0 mhp0 mhn0 vdd vbsyn gsyn
X_ihx_10_0 a_xp10 a_xn10 wp_ih_10_0 wn_ih_10_0 xhp0 xhn0 vdd vbsyn gsyn
X_ihm_11_0 a_xp11 a_xn11 wp_ih_11_0 wn_ih_11_0 mhp0 mhn0 vdd vbsyn gsyn
X_ihx_11_0 a_xp11 a_xn11 wp_ih_11_0 wn_ih_11_0 xhp0 xhn0 vdd vbsyn gsyn
X_ihm_12_0 a_xp12 a_xn12 wp_ih_12_0 wn_ih_12_0 mhp0 mhn0 vdd vbsyn gsyn
X_ihx_12_0 a_xp12 a_xn12 wp_ih_12_0 wn_ih_12_0 xhp0 xhn0 vdd vbsyn gsyn
X_ihm_13_0 a_xp13 a_xn13 wp_ih_13_0 wn_ih_13_0 mhp0 mhn0 vdd vbsyn gsyn
X_ihx_13_0 a_xp13 a_xn13 wp_ih_13_0 wn_ih_13_0 xhp0 xhn0 vdd vbsyn gsyn
X_ihm_14_0 a_xp14 a_xn14 wp_ih_14_0 wn_ih_14_0 mhp0 mhn0 vdd vbsyn gsyn
X_ihx_14_0 a_xp14 a_xn14 wp_ih_14_0 wn_ih_14_0 xhp0 xhn0 vdd vbsyn gsyn
X_ihm_15_0 a_xp15 a_xn15 wp_ih_15_0 wn_ih_15_0 mhp0 mhn0 vdd vbsyn gsyn
X_ihx_15_0 a_xp15 a_xn15 wp_ih_15_0 wn_ih_15_0 xhp0 xhn0 vdd vbsyn gsyn
X_ihm_16_0 a_xp16 a_xn16 wp_ih_16_0 wn_ih_16_0 mhp0 mhn0 vdd vbsyn gsyn
X_ihx_16_0 a_xp16 a_xn16 wp_ih_16_0 wn_ih_16_0 xhp0 xhn0 vdd vbsyn gsyn
X_ihm_17_0 a_xp17 a_xn17 wp_ih_17_0 wn_ih_17_0 mhp0 mhn0 vdd vbsyn gsyn
X_ihx_17_0 a_xp17 a_xn17 wp_ih_17_0 wn_ih_17_0 xhp0 xhn0 vdd vbsyn gsyn
X_ihm_18_0 a_xp18 a_xn18 wp_ih_18_0 wn_ih_18_0 mhp0 mhn0 vdd vbsyn gsyn
X_ihx_18_0 a_xp18 a_xn18 wp_ih_18_0 wn_ih_18_0 xhp0 xhn0 vdd vbsyn gsyn
X_ihm_19_0 a_xp19 a_xn19 wp_ih_19_0 wn_ih_19_0 mhp0 mhn0 vdd vbsyn gsyn
X_ihx_19_0 a_xp19 a_xn19 wp_ih_19_0 wn_ih_19_0 xhp0 xhn0 vdd vbsyn gsyn
X_ihm_20_0 a_xp20 a_xn20 wp_ih_20_0 wn_ih_20_0 mhp0 mhn0 vdd vbsyn gsyn
X_ihx_20_0 a_xp20 a_xn20 wp_ih_20_0 wn_ih_20_0 xhp0 xhn0 vdd vbsyn gsyn
X_ihm_21_0 a_xp21 a_xn21 wp_ih_21_0 wn_ih_21_0 mhp0 mhn0 vdd vbsyn gsyn
X_ihx_21_0 a_xp21 a_xn21 wp_ih_21_0 wn_ih_21_0 xhp0 xhn0 vdd vbsyn gsyn
X_ihm_22_0 a_xp22 a_xn22 wp_ih_22_0 wn_ih_22_0 mhp0 mhn0 vdd vbsyn gsyn
X_ihx_22_0 a_xp22 a_xn22 wp_ih_22_0 wn_ih_22_0 xhp0 xhn0 vdd vbsyn gsyn
X_ihm_23_0 a_xp23 a_xn23 wp_ih_23_0 wn_ih_23_0 mhp0 mhn0 vdd vbsyn gsyn
X_ihx_23_0 a_xp23 a_xn23 wp_ih_23_0 wn_ih_23_0 xhp0 xhn0 vdd vbsyn gsyn
X_ihm_24_0 a_xp24 a_xn24 wp_ih_24_0 wn_ih_24_0 mhp0 mhn0 vdd vbsyn gsyn
X_ihx_24_0 a_xp24 a_xn24 wp_ih_24_0 wn_ih_24_0 xhp0 xhn0 vdd vbsyn gsyn
X_ihm_25_0 a_xp25 a_xn25 wp_ih_25_0 wn_ih_25_0 mhp0 mhn0 vdd vbsyn gsyn
X_ihx_25_0 a_xp25 a_xn25 wp_ih_25_0 wn_ih_25_0 xhp0 xhn0 vdd vbsyn gsyn
X_ihm_26_0 a_xp26 a_xn26 wp_ih_26_0 wn_ih_26_0 mhp0 mhn0 vdd vbsyn gsyn
X_ihx_26_0 a_xp26 a_xn26 wp_ih_26_0 wn_ih_26_0 xhp0 xhn0 vdd vbsyn gsyn
X_ihm_27_0 a_xp27 a_xn27 wp_ih_27_0 wn_ih_27_0 mhp0 mhn0 vdd vbsyn gsyn
X_ihx_27_0 a_xp27 a_xn27 wp_ih_27_0 wn_ih_27_0 xhp0 xhn0 vdd vbsyn gsyn
X_ihm_28_0 a_xp28 a_xn28 wp_ih_28_0 wn_ih_28_0 mhp0 mhn0 vdd vbsyn gsyn
X_ihx_28_0 a_xp28 a_xn28 wp_ih_28_0 wn_ih_28_0 xhp0 xhn0 vdd vbsyn gsyn
X_ihm_29_0 a_xp29 a_xn29 wp_ih_29_0 wn_ih_29_0 mhp0 mhn0 vdd vbsyn gsyn
X_ihx_29_0 a_xp29 a_xn29 wp_ih_29_0 wn_ih_29_0 xhp0 xhn0 vdd vbsyn gsyn
X_ihm_30_0 a_xp30 a_xn30 wp_ih_30_0 wn_ih_30_0 mhp0 mhn0 vdd vbsyn gsyn
X_ihx_30_0 a_xp30 a_xn30 wp_ih_30_0 wn_ih_30_0 xhp0 xhn0 vdd vbsyn gsyn
X_ihm_31_0 a_xp31 a_xn31 wp_ih_31_0 wn_ih_31_0 mhp0 mhn0 vdd vbsyn gsyn
X_ihx_31_0 a_xp31 a_xn31 wp_ih_31_0 wn_ih_31_0 xhp0 xhn0 vdd vbsyn gsyn
X_ihm_32_0 a_xp32 a_xn32 wp_ih_32_0 wn_ih_32_0 mhp0 mhn0 vdd vbsyn gsyn
X_ihx_32_0 a_xp32 a_xn32 wp_ih_32_0 wn_ih_32_0 xhp0 xhn0 vdd vbsyn gsyn
X_ihm_33_0 a_xp33 a_xn33 wp_ih_33_0 wn_ih_33_0 mhp0 mhn0 vdd vbsyn gsyn
X_ihx_33_0 a_xp33 a_xn33 wp_ih_33_0 wn_ih_33_0 xhp0 xhn0 vdd vbsyn gsyn
X_ihm_34_0 a_xp34 a_xn34 wp_ih_34_0 wn_ih_34_0 mhp0 mhn0 vdd vbsyn gsyn
X_ihx_34_0 a_xp34 a_xn34 wp_ih_34_0 wn_ih_34_0 xhp0 xhn0 vdd vbsyn gsyn
X_ihm_35_0 a_xp35 a_xn35 wp_ih_35_0 wn_ih_35_0 mhp0 mhn0 vdd vbsyn gsyn
X_ihx_35_0 a_xp35 a_xn35 wp_ih_35_0 wn_ih_35_0 xhp0 xhn0 vdd vbsyn gsyn
X_ihm_36_0 a_xp36 a_xn36 wp_ih_36_0 wn_ih_36_0 mhp0 mhn0 vdd vbsyn gsyn
X_ihx_36_0 a_xp36 a_xn36 wp_ih_36_0 wn_ih_36_0 xhp0 xhn0 vdd vbsyn gsyn
X_ihm_37_0 a_xp37 a_xn37 wp_ih_37_0 wn_ih_37_0 mhp0 mhn0 vdd vbsyn gsyn
X_ihx_37_0 a_xp37 a_xn37 wp_ih_37_0 wn_ih_37_0 xhp0 xhn0 vdd vbsyn gsyn
X_ihm_38_0 a_xp38 a_xn38 wp_ih_38_0 wn_ih_38_0 mhp0 mhn0 vdd vbsyn gsyn
X_ihx_38_0 a_xp38 a_xn38 wp_ih_38_0 wn_ih_38_0 xhp0 xhn0 vdd vbsyn gsyn
X_ihm_39_0 a_xp39 a_xn39 wp_ih_39_0 wn_ih_39_0 mhp0 mhn0 vdd vbsyn gsyn
X_ihx_39_0 a_xp39 a_xn39 wp_ih_39_0 wn_ih_39_0 xhp0 xhn0 vdd vbsyn gsyn
X_ihm_40_0 a_xp40 a_xn40 wp_ih_40_0 wn_ih_40_0 mhp0 mhn0 vdd vbsyn gsyn
X_ihx_40_0 a_xp40 a_xn40 wp_ih_40_0 wn_ih_40_0 xhp0 xhn0 vdd vbsyn gsyn
X_ihm_41_0 a_xp41 a_xn41 wp_ih_41_0 wn_ih_41_0 mhp0 mhn0 vdd vbsyn gsyn
X_ihx_41_0 a_xp41 a_xn41 wp_ih_41_0 wn_ih_41_0 xhp0 xhn0 vdd vbsyn gsyn
X_ihm_42_0 a_xp42 a_xn42 wp_ih_42_0 wn_ih_42_0 mhp0 mhn0 vdd vbsyn gsyn
X_ihx_42_0 a_xp42 a_xn42 wp_ih_42_0 wn_ih_42_0 xhp0 xhn0 vdd vbsyn gsyn
X_ihm_43_0 a_xp43 a_xn43 wp_ih_43_0 wn_ih_43_0 mhp0 mhn0 vdd vbsyn gsyn
X_ihx_43_0 a_xp43 a_xn43 wp_ih_43_0 wn_ih_43_0 xhp0 xhn0 vdd vbsyn gsyn
X_ihm_44_0 a_xp44 a_xn44 wp_ih_44_0 wn_ih_44_0 mhp0 mhn0 vdd vbsyn gsyn
X_ihx_44_0 a_xp44 a_xn44 wp_ih_44_0 wn_ih_44_0 xhp0 xhn0 vdd vbsyn gsyn
X_ihm_45_0 a_xp45 a_xn45 wp_ih_45_0 wn_ih_45_0 mhp0 mhn0 vdd vbsyn gsyn
X_ihx_45_0 a_xp45 a_xn45 wp_ih_45_0 wn_ih_45_0 xhp0 xhn0 vdd vbsyn gsyn
X_ihm_46_0 a_xp46 a_xn46 wp_ih_46_0 wn_ih_46_0 mhp0 mhn0 vdd vbsyn gsyn
X_ihx_46_0 a_xp46 a_xn46 wp_ih_46_0 wn_ih_46_0 xhp0 xhn0 vdd vbsyn gsyn
X_ihm_47_0 a_xp47 a_xn47 wp_ih_47_0 wn_ih_47_0 mhp0 mhn0 vdd vbsyn gsyn
X_ihx_47_0 a_xp47 a_xn47 wp_ih_47_0 wn_ih_47_0 xhp0 xhn0 vdd vbsyn gsyn
X_ihm_48_0 a_xp48 a_xn48 wp_ih_48_0 wn_ih_48_0 mhp0 mhn0 vdd vbsyn gsyn
X_ihx_48_0 a_xp48 a_xn48 wp_ih_48_0 wn_ih_48_0 xhp0 xhn0 vdd vbsyn gsyn
X_ihm_49_0 a_xp49 a_xn49 wp_ih_49_0 wn_ih_49_0 mhp0 mhn0 vdd vbsyn gsyn
X_ihx_49_0 a_xp49 a_xn49 wp_ih_49_0 wn_ih_49_0 xhp0 xhn0 vdd vbsyn gsyn
X_ihm_50_0 a_xp50 a_xn50 wp_ih_50_0 wn_ih_50_0 mhp0 mhn0 vdd vbsyn gsyn
X_ihx_50_0 a_xp50 a_xn50 wp_ih_50_0 wn_ih_50_0 xhp0 xhn0 vdd vbsyn gsyn
X_ihm_51_0 a_xp51 a_xn51 wp_ih_51_0 wn_ih_51_0 mhp0 mhn0 vdd vbsyn gsyn
X_ihx_51_0 a_xp51 a_xn51 wp_ih_51_0 wn_ih_51_0 xhp0 xhn0 vdd vbsyn gsyn
X_ihm_52_0 a_xp52 a_xn52 wp_ih_52_0 wn_ih_52_0 mhp0 mhn0 vdd vbsyn gsyn
X_ihx_52_0 a_xp52 a_xn52 wp_ih_52_0 wn_ih_52_0 xhp0 xhn0 vdd vbsyn gsyn
X_ihm_53_0 a_xp53 a_xn53 wp_ih_53_0 wn_ih_53_0 mhp0 mhn0 vdd vbsyn gsyn
X_ihx_53_0 a_xp53 a_xn53 wp_ih_53_0 wn_ih_53_0 xhp0 xhn0 vdd vbsyn gsyn
X_ihm_54_0 a_xp54 a_xn54 wp_ih_54_0 wn_ih_54_0 mhp0 mhn0 vdd vbsyn gsyn
X_ihx_54_0 a_xp54 a_xn54 wp_ih_54_0 wn_ih_54_0 xhp0 xhn0 vdd vbsyn gsyn
X_ihm_55_0 a_xp55 a_xn55 wp_ih_55_0 wn_ih_55_0 mhp0 mhn0 vdd vbsyn gsyn
X_ihx_55_0 a_xp55 a_xn55 wp_ih_55_0 wn_ih_55_0 xhp0 xhn0 vdd vbsyn gsyn
X_ihm_56_0 a_xp56 a_xn56 wp_ih_56_0 wn_ih_56_0 mhp0 mhn0 vdd vbsyn gsyn
X_ihx_56_0 a_xp56 a_xn56 wp_ih_56_0 wn_ih_56_0 xhp0 xhn0 vdd vbsyn gsyn
X_ihm_57_0 a_xp57 a_xn57 wp_ih_57_0 wn_ih_57_0 mhp0 mhn0 vdd vbsyn gsyn
X_ihx_57_0 a_xp57 a_xn57 wp_ih_57_0 wn_ih_57_0 xhp0 xhn0 vdd vbsyn gsyn
X_ihm_58_0 a_xp58 a_xn58 wp_ih_58_0 wn_ih_58_0 mhp0 mhn0 vdd vbsyn gsyn
X_ihx_58_0 a_xp58 a_xn58 wp_ih_58_0 wn_ih_58_0 xhp0 xhn0 vdd vbsyn gsyn
X_ihm_59_0 a_xp59 a_xn59 wp_ih_59_0 wn_ih_59_0 mhp0 mhn0 vdd vbsyn gsyn
X_ihx_59_0 a_xp59 a_xn59 wp_ih_59_0 wn_ih_59_0 xhp0 xhn0 vdd vbsyn gsyn
X_ihm_60_0 a_xp60 a_xn60 wp_ih_60_0 wn_ih_60_0 mhp0 mhn0 vdd vbsyn gsyn
X_ihx_60_0 a_xp60 a_xn60 wp_ih_60_0 wn_ih_60_0 xhp0 xhn0 vdd vbsyn gsyn
X_ihm_61_0 a_xp61 a_xn61 wp_ih_61_0 wn_ih_61_0 mhp0 mhn0 vdd vbsyn gsyn
X_ihx_61_0 a_xp61 a_xn61 wp_ih_61_0 wn_ih_61_0 xhp0 xhn0 vdd vbsyn gsyn
X_ihm_62_0 a_xp62 a_xn62 wp_ih_62_0 wn_ih_62_0 mhp0 mhn0 vdd vbsyn gsyn
X_ihx_62_0 a_xp62 a_xn62 wp_ih_62_0 wn_ih_62_0 xhp0 xhn0 vdd vbsyn gsyn
X_ihm_63_0 a_xp63 a_xn63 wp_ih_63_0 wn_ih_63_0 mhp0 mhn0 vdd vbsyn gsyn
X_ihx_63_0 a_xp63 a_xn63 wp_ih_63_0 wn_ih_63_0 xhp0 xhn0 vdd vbsyn gsyn
X_bk_0_0 eop0 eon0 wp_ho_0_0 wn_ho_0_0 xhp0 xhn0 vdd vbbk gsyn
X_bk_0_1 eop1 eon1 wp_ho_0_1 wn_ho_0_1 xhp0 xhn0 vdd vbbk gsyn
X_bk_0_2 eop2 eon2 wp_ho_0_2 wn_ho_0_2 xhp0 xhn0 vdd vbbk gsyn
X_bk_0_3 eop3 eon3 wp_ho_0_3 wn_ho_0_3 xhp0 xhn0 vdd vbbk gsyn
X_bk_0_4 eop4 eon4 wp_ho_0_4 wn_ho_0_4 xhp0 xhn0 vdd vbbk gsyn
Xn0 xhp0 xhn0 ahp0 ahn0 vdd vbneu dneuron
Xeh0 xhp0 xhn0 mhp0 mhn0 ehp0 ehn0 vdd gm esub
Xcm_mh1 mhp1 mhn1 vdd cmld
Rnd_mh1 mhp1 mhn1 20k
Xcm_xh1 xhp1 xhn1 vdd cmld
Rnd_xh1 xhp1 xhn1 20k
X_ihm_0_1 a_xp0 a_xn0 wp_ih_0_1 wn_ih_0_1 mhp1 mhn1 vdd vbsyn gsyn
X_ihx_0_1 a_xp0 a_xn0 wp_ih_0_1 wn_ih_0_1 xhp1 xhn1 vdd vbsyn gsyn
X_ihm_1_1 a_xp1 a_xn1 wp_ih_1_1 wn_ih_1_1 mhp1 mhn1 vdd vbsyn gsyn
X_ihx_1_1 a_xp1 a_xn1 wp_ih_1_1 wn_ih_1_1 xhp1 xhn1 vdd vbsyn gsyn
X_ihm_2_1 a_xp2 a_xn2 wp_ih_2_1 wn_ih_2_1 mhp1 mhn1 vdd vbsyn gsyn
X_ihx_2_1 a_xp2 a_xn2 wp_ih_2_1 wn_ih_2_1 xhp1 xhn1 vdd vbsyn gsyn
X_ihm_3_1 a_xp3 a_xn3 wp_ih_3_1 wn_ih_3_1 mhp1 mhn1 vdd vbsyn gsyn
X_ihx_3_1 a_xp3 a_xn3 wp_ih_3_1 wn_ih_3_1 xhp1 xhn1 vdd vbsyn gsyn
X_ihm_4_1 a_xp4 a_xn4 wp_ih_4_1 wn_ih_4_1 mhp1 mhn1 vdd vbsyn gsyn
X_ihx_4_1 a_xp4 a_xn4 wp_ih_4_1 wn_ih_4_1 xhp1 xhn1 vdd vbsyn gsyn
X_ihm_5_1 a_xp5 a_xn5 wp_ih_5_1 wn_ih_5_1 mhp1 mhn1 vdd vbsyn gsyn
X_ihx_5_1 a_xp5 a_xn5 wp_ih_5_1 wn_ih_5_1 xhp1 xhn1 vdd vbsyn gsyn
X_ihm_6_1 a_xp6 a_xn6 wp_ih_6_1 wn_ih_6_1 mhp1 mhn1 vdd vbsyn gsyn
X_ihx_6_1 a_xp6 a_xn6 wp_ih_6_1 wn_ih_6_1 xhp1 xhn1 vdd vbsyn gsyn
X_ihm_7_1 a_xp7 a_xn7 wp_ih_7_1 wn_ih_7_1 mhp1 mhn1 vdd vbsyn gsyn
X_ihx_7_1 a_xp7 a_xn7 wp_ih_7_1 wn_ih_7_1 xhp1 xhn1 vdd vbsyn gsyn
X_ihm_8_1 a_xp8 a_xn8 wp_ih_8_1 wn_ih_8_1 mhp1 mhn1 vdd vbsyn gsyn
X_ihx_8_1 a_xp8 a_xn8 wp_ih_8_1 wn_ih_8_1 xhp1 xhn1 vdd vbsyn gsyn
X_ihm_9_1 a_xp9 a_xn9 wp_ih_9_1 wn_ih_9_1 mhp1 mhn1 vdd vbsyn gsyn
X_ihx_9_1 a_xp9 a_xn9 wp_ih_9_1 wn_ih_9_1 xhp1 xhn1 vdd vbsyn gsyn
X_ihm_10_1 a_xp10 a_xn10 wp_ih_10_1 wn_ih_10_1 mhp1 mhn1 vdd vbsyn gsyn
X_ihx_10_1 a_xp10 a_xn10 wp_ih_10_1 wn_ih_10_1 xhp1 xhn1 vdd vbsyn gsyn
X_ihm_11_1 a_xp11 a_xn11 wp_ih_11_1 wn_ih_11_1 mhp1 mhn1 vdd vbsyn gsyn
X_ihx_11_1 a_xp11 a_xn11 wp_ih_11_1 wn_ih_11_1 xhp1 xhn1 vdd vbsyn gsyn
X_ihm_12_1 a_xp12 a_xn12 wp_ih_12_1 wn_ih_12_1 mhp1 mhn1 vdd vbsyn gsyn
X_ihx_12_1 a_xp12 a_xn12 wp_ih_12_1 wn_ih_12_1 xhp1 xhn1 vdd vbsyn gsyn
X_ihm_13_1 a_xp13 a_xn13 wp_ih_13_1 wn_ih_13_1 mhp1 mhn1 vdd vbsyn gsyn
X_ihx_13_1 a_xp13 a_xn13 wp_ih_13_1 wn_ih_13_1 xhp1 xhn1 vdd vbsyn gsyn
X_ihm_14_1 a_xp14 a_xn14 wp_ih_14_1 wn_ih_14_1 mhp1 mhn1 vdd vbsyn gsyn
X_ihx_14_1 a_xp14 a_xn14 wp_ih_14_1 wn_ih_14_1 xhp1 xhn1 vdd vbsyn gsyn
X_ihm_15_1 a_xp15 a_xn15 wp_ih_15_1 wn_ih_15_1 mhp1 mhn1 vdd vbsyn gsyn
X_ihx_15_1 a_xp15 a_xn15 wp_ih_15_1 wn_ih_15_1 xhp1 xhn1 vdd vbsyn gsyn
X_ihm_16_1 a_xp16 a_xn16 wp_ih_16_1 wn_ih_16_1 mhp1 mhn1 vdd vbsyn gsyn
X_ihx_16_1 a_xp16 a_xn16 wp_ih_16_1 wn_ih_16_1 xhp1 xhn1 vdd vbsyn gsyn
X_ihm_17_1 a_xp17 a_xn17 wp_ih_17_1 wn_ih_17_1 mhp1 mhn1 vdd vbsyn gsyn
X_ihx_17_1 a_xp17 a_xn17 wp_ih_17_1 wn_ih_17_1 xhp1 xhn1 vdd vbsyn gsyn
X_ihm_18_1 a_xp18 a_xn18 wp_ih_18_1 wn_ih_18_1 mhp1 mhn1 vdd vbsyn gsyn
X_ihx_18_1 a_xp18 a_xn18 wp_ih_18_1 wn_ih_18_1 xhp1 xhn1 vdd vbsyn gsyn
X_ihm_19_1 a_xp19 a_xn19 wp_ih_19_1 wn_ih_19_1 mhp1 mhn1 vdd vbsyn gsyn
X_ihx_19_1 a_xp19 a_xn19 wp_ih_19_1 wn_ih_19_1 xhp1 xhn1 vdd vbsyn gsyn
X_ihm_20_1 a_xp20 a_xn20 wp_ih_20_1 wn_ih_20_1 mhp1 mhn1 vdd vbsyn gsyn
X_ihx_20_1 a_xp20 a_xn20 wp_ih_20_1 wn_ih_20_1 xhp1 xhn1 vdd vbsyn gsyn
X_ihm_21_1 a_xp21 a_xn21 wp_ih_21_1 wn_ih_21_1 mhp1 mhn1 vdd vbsyn gsyn
X_ihx_21_1 a_xp21 a_xn21 wp_ih_21_1 wn_ih_21_1 xhp1 xhn1 vdd vbsyn gsyn
X_ihm_22_1 a_xp22 a_xn22 wp_ih_22_1 wn_ih_22_1 mhp1 mhn1 vdd vbsyn gsyn
X_ihx_22_1 a_xp22 a_xn22 wp_ih_22_1 wn_ih_22_1 xhp1 xhn1 vdd vbsyn gsyn
X_ihm_23_1 a_xp23 a_xn23 wp_ih_23_1 wn_ih_23_1 mhp1 mhn1 vdd vbsyn gsyn
X_ihx_23_1 a_xp23 a_xn23 wp_ih_23_1 wn_ih_23_1 xhp1 xhn1 vdd vbsyn gsyn
X_ihm_24_1 a_xp24 a_xn24 wp_ih_24_1 wn_ih_24_1 mhp1 mhn1 vdd vbsyn gsyn
X_ihx_24_1 a_xp24 a_xn24 wp_ih_24_1 wn_ih_24_1 xhp1 xhn1 vdd vbsyn gsyn
X_ihm_25_1 a_xp25 a_xn25 wp_ih_25_1 wn_ih_25_1 mhp1 mhn1 vdd vbsyn gsyn
X_ihx_25_1 a_xp25 a_xn25 wp_ih_25_1 wn_ih_25_1 xhp1 xhn1 vdd vbsyn gsyn
X_ihm_26_1 a_xp26 a_xn26 wp_ih_26_1 wn_ih_26_1 mhp1 mhn1 vdd vbsyn gsyn
X_ihx_26_1 a_xp26 a_xn26 wp_ih_26_1 wn_ih_26_1 xhp1 xhn1 vdd vbsyn gsyn
X_ihm_27_1 a_xp27 a_xn27 wp_ih_27_1 wn_ih_27_1 mhp1 mhn1 vdd vbsyn gsyn
X_ihx_27_1 a_xp27 a_xn27 wp_ih_27_1 wn_ih_27_1 xhp1 xhn1 vdd vbsyn gsyn
X_ihm_28_1 a_xp28 a_xn28 wp_ih_28_1 wn_ih_28_1 mhp1 mhn1 vdd vbsyn gsyn
X_ihx_28_1 a_xp28 a_xn28 wp_ih_28_1 wn_ih_28_1 xhp1 xhn1 vdd vbsyn gsyn
X_ihm_29_1 a_xp29 a_xn29 wp_ih_29_1 wn_ih_29_1 mhp1 mhn1 vdd vbsyn gsyn
X_ihx_29_1 a_xp29 a_xn29 wp_ih_29_1 wn_ih_29_1 xhp1 xhn1 vdd vbsyn gsyn
X_ihm_30_1 a_xp30 a_xn30 wp_ih_30_1 wn_ih_30_1 mhp1 mhn1 vdd vbsyn gsyn
X_ihx_30_1 a_xp30 a_xn30 wp_ih_30_1 wn_ih_30_1 xhp1 xhn1 vdd vbsyn gsyn
X_ihm_31_1 a_xp31 a_xn31 wp_ih_31_1 wn_ih_31_1 mhp1 mhn1 vdd vbsyn gsyn
X_ihx_31_1 a_xp31 a_xn31 wp_ih_31_1 wn_ih_31_1 xhp1 xhn1 vdd vbsyn gsyn
X_ihm_32_1 a_xp32 a_xn32 wp_ih_32_1 wn_ih_32_1 mhp1 mhn1 vdd vbsyn gsyn
X_ihx_32_1 a_xp32 a_xn32 wp_ih_32_1 wn_ih_32_1 xhp1 xhn1 vdd vbsyn gsyn
X_ihm_33_1 a_xp33 a_xn33 wp_ih_33_1 wn_ih_33_1 mhp1 mhn1 vdd vbsyn gsyn
X_ihx_33_1 a_xp33 a_xn33 wp_ih_33_1 wn_ih_33_1 xhp1 xhn1 vdd vbsyn gsyn
X_ihm_34_1 a_xp34 a_xn34 wp_ih_34_1 wn_ih_34_1 mhp1 mhn1 vdd vbsyn gsyn
X_ihx_34_1 a_xp34 a_xn34 wp_ih_34_1 wn_ih_34_1 xhp1 xhn1 vdd vbsyn gsyn
X_ihm_35_1 a_xp35 a_xn35 wp_ih_35_1 wn_ih_35_1 mhp1 mhn1 vdd vbsyn gsyn
X_ihx_35_1 a_xp35 a_xn35 wp_ih_35_1 wn_ih_35_1 xhp1 xhn1 vdd vbsyn gsyn
X_ihm_36_1 a_xp36 a_xn36 wp_ih_36_1 wn_ih_36_1 mhp1 mhn1 vdd vbsyn gsyn
X_ihx_36_1 a_xp36 a_xn36 wp_ih_36_1 wn_ih_36_1 xhp1 xhn1 vdd vbsyn gsyn
X_ihm_37_1 a_xp37 a_xn37 wp_ih_37_1 wn_ih_37_1 mhp1 mhn1 vdd vbsyn gsyn
X_ihx_37_1 a_xp37 a_xn37 wp_ih_37_1 wn_ih_37_1 xhp1 xhn1 vdd vbsyn gsyn
X_ihm_38_1 a_xp38 a_xn38 wp_ih_38_1 wn_ih_38_1 mhp1 mhn1 vdd vbsyn gsyn
X_ihx_38_1 a_xp38 a_xn38 wp_ih_38_1 wn_ih_38_1 xhp1 xhn1 vdd vbsyn gsyn
X_ihm_39_1 a_xp39 a_xn39 wp_ih_39_1 wn_ih_39_1 mhp1 mhn1 vdd vbsyn gsyn
X_ihx_39_1 a_xp39 a_xn39 wp_ih_39_1 wn_ih_39_1 xhp1 xhn1 vdd vbsyn gsyn
X_ihm_40_1 a_xp40 a_xn40 wp_ih_40_1 wn_ih_40_1 mhp1 mhn1 vdd vbsyn gsyn
X_ihx_40_1 a_xp40 a_xn40 wp_ih_40_1 wn_ih_40_1 xhp1 xhn1 vdd vbsyn gsyn
X_ihm_41_1 a_xp41 a_xn41 wp_ih_41_1 wn_ih_41_1 mhp1 mhn1 vdd vbsyn gsyn
X_ihx_41_1 a_xp41 a_xn41 wp_ih_41_1 wn_ih_41_1 xhp1 xhn1 vdd vbsyn gsyn
X_ihm_42_1 a_xp42 a_xn42 wp_ih_42_1 wn_ih_42_1 mhp1 mhn1 vdd vbsyn gsyn
X_ihx_42_1 a_xp42 a_xn42 wp_ih_42_1 wn_ih_42_1 xhp1 xhn1 vdd vbsyn gsyn
X_ihm_43_1 a_xp43 a_xn43 wp_ih_43_1 wn_ih_43_1 mhp1 mhn1 vdd vbsyn gsyn
X_ihx_43_1 a_xp43 a_xn43 wp_ih_43_1 wn_ih_43_1 xhp1 xhn1 vdd vbsyn gsyn
X_ihm_44_1 a_xp44 a_xn44 wp_ih_44_1 wn_ih_44_1 mhp1 mhn1 vdd vbsyn gsyn
X_ihx_44_1 a_xp44 a_xn44 wp_ih_44_1 wn_ih_44_1 xhp1 xhn1 vdd vbsyn gsyn
X_ihm_45_1 a_xp45 a_xn45 wp_ih_45_1 wn_ih_45_1 mhp1 mhn1 vdd vbsyn gsyn
X_ihx_45_1 a_xp45 a_xn45 wp_ih_45_1 wn_ih_45_1 xhp1 xhn1 vdd vbsyn gsyn
X_ihm_46_1 a_xp46 a_xn46 wp_ih_46_1 wn_ih_46_1 mhp1 mhn1 vdd vbsyn gsyn
X_ihx_46_1 a_xp46 a_xn46 wp_ih_46_1 wn_ih_46_1 xhp1 xhn1 vdd vbsyn gsyn
X_ihm_47_1 a_xp47 a_xn47 wp_ih_47_1 wn_ih_47_1 mhp1 mhn1 vdd vbsyn gsyn
X_ihx_47_1 a_xp47 a_xn47 wp_ih_47_1 wn_ih_47_1 xhp1 xhn1 vdd vbsyn gsyn
X_ihm_48_1 a_xp48 a_xn48 wp_ih_48_1 wn_ih_48_1 mhp1 mhn1 vdd vbsyn gsyn
X_ihx_48_1 a_xp48 a_xn48 wp_ih_48_1 wn_ih_48_1 xhp1 xhn1 vdd vbsyn gsyn
X_ihm_49_1 a_xp49 a_xn49 wp_ih_49_1 wn_ih_49_1 mhp1 mhn1 vdd vbsyn gsyn
X_ihx_49_1 a_xp49 a_xn49 wp_ih_49_1 wn_ih_49_1 xhp1 xhn1 vdd vbsyn gsyn
X_ihm_50_1 a_xp50 a_xn50 wp_ih_50_1 wn_ih_50_1 mhp1 mhn1 vdd vbsyn gsyn
X_ihx_50_1 a_xp50 a_xn50 wp_ih_50_1 wn_ih_50_1 xhp1 xhn1 vdd vbsyn gsyn
X_ihm_51_1 a_xp51 a_xn51 wp_ih_51_1 wn_ih_51_1 mhp1 mhn1 vdd vbsyn gsyn
X_ihx_51_1 a_xp51 a_xn51 wp_ih_51_1 wn_ih_51_1 xhp1 xhn1 vdd vbsyn gsyn
X_ihm_52_1 a_xp52 a_xn52 wp_ih_52_1 wn_ih_52_1 mhp1 mhn1 vdd vbsyn gsyn
X_ihx_52_1 a_xp52 a_xn52 wp_ih_52_1 wn_ih_52_1 xhp1 xhn1 vdd vbsyn gsyn
X_ihm_53_1 a_xp53 a_xn53 wp_ih_53_1 wn_ih_53_1 mhp1 mhn1 vdd vbsyn gsyn
X_ihx_53_1 a_xp53 a_xn53 wp_ih_53_1 wn_ih_53_1 xhp1 xhn1 vdd vbsyn gsyn
X_ihm_54_1 a_xp54 a_xn54 wp_ih_54_1 wn_ih_54_1 mhp1 mhn1 vdd vbsyn gsyn
X_ihx_54_1 a_xp54 a_xn54 wp_ih_54_1 wn_ih_54_1 xhp1 xhn1 vdd vbsyn gsyn
X_ihm_55_1 a_xp55 a_xn55 wp_ih_55_1 wn_ih_55_1 mhp1 mhn1 vdd vbsyn gsyn
X_ihx_55_1 a_xp55 a_xn55 wp_ih_55_1 wn_ih_55_1 xhp1 xhn1 vdd vbsyn gsyn
X_ihm_56_1 a_xp56 a_xn56 wp_ih_56_1 wn_ih_56_1 mhp1 mhn1 vdd vbsyn gsyn
X_ihx_56_1 a_xp56 a_xn56 wp_ih_56_1 wn_ih_56_1 xhp1 xhn1 vdd vbsyn gsyn
X_ihm_57_1 a_xp57 a_xn57 wp_ih_57_1 wn_ih_57_1 mhp1 mhn1 vdd vbsyn gsyn
X_ihx_57_1 a_xp57 a_xn57 wp_ih_57_1 wn_ih_57_1 xhp1 xhn1 vdd vbsyn gsyn
X_ihm_58_1 a_xp58 a_xn58 wp_ih_58_1 wn_ih_58_1 mhp1 mhn1 vdd vbsyn gsyn
X_ihx_58_1 a_xp58 a_xn58 wp_ih_58_1 wn_ih_58_1 xhp1 xhn1 vdd vbsyn gsyn
X_ihm_59_1 a_xp59 a_xn59 wp_ih_59_1 wn_ih_59_1 mhp1 mhn1 vdd vbsyn gsyn
X_ihx_59_1 a_xp59 a_xn59 wp_ih_59_1 wn_ih_59_1 xhp1 xhn1 vdd vbsyn gsyn
X_ihm_60_1 a_xp60 a_xn60 wp_ih_60_1 wn_ih_60_1 mhp1 mhn1 vdd vbsyn gsyn
X_ihx_60_1 a_xp60 a_xn60 wp_ih_60_1 wn_ih_60_1 xhp1 xhn1 vdd vbsyn gsyn
X_ihm_61_1 a_xp61 a_xn61 wp_ih_61_1 wn_ih_61_1 mhp1 mhn1 vdd vbsyn gsyn
X_ihx_61_1 a_xp61 a_xn61 wp_ih_61_1 wn_ih_61_1 xhp1 xhn1 vdd vbsyn gsyn
X_ihm_62_1 a_xp62 a_xn62 wp_ih_62_1 wn_ih_62_1 mhp1 mhn1 vdd vbsyn gsyn
X_ihx_62_1 a_xp62 a_xn62 wp_ih_62_1 wn_ih_62_1 xhp1 xhn1 vdd vbsyn gsyn
X_ihm_63_1 a_xp63 a_xn63 wp_ih_63_1 wn_ih_63_1 mhp1 mhn1 vdd vbsyn gsyn
X_ihx_63_1 a_xp63 a_xn63 wp_ih_63_1 wn_ih_63_1 xhp1 xhn1 vdd vbsyn gsyn
X_bk_1_0 eop0 eon0 wp_ho_1_0 wn_ho_1_0 xhp1 xhn1 vdd vbbk gsyn
X_bk_1_1 eop1 eon1 wp_ho_1_1 wn_ho_1_1 xhp1 xhn1 vdd vbbk gsyn
X_bk_1_2 eop2 eon2 wp_ho_1_2 wn_ho_1_2 xhp1 xhn1 vdd vbbk gsyn
X_bk_1_3 eop3 eon3 wp_ho_1_3 wn_ho_1_3 xhp1 xhn1 vdd vbbk gsyn
X_bk_1_4 eop4 eon4 wp_ho_1_4 wn_ho_1_4 xhp1 xhn1 vdd vbbk gsyn
Xn1 xhp1 xhn1 ahp1 ahn1 vdd vbneu dneuron
Xeh1 xhp1 xhn1 mhp1 mhn1 ehp1 ehn1 vdd gm esub
Xcm_mh2 mhp2 mhn2 vdd cmld
Rnd_mh2 mhp2 mhn2 20k
Xcm_xh2 xhp2 xhn2 vdd cmld
Rnd_xh2 xhp2 xhn2 20k
X_ihm_0_2 a_xp0 a_xn0 wp_ih_0_2 wn_ih_0_2 mhp2 mhn2 vdd vbsyn gsyn
X_ihx_0_2 a_xp0 a_xn0 wp_ih_0_2 wn_ih_0_2 xhp2 xhn2 vdd vbsyn gsyn
X_ihm_1_2 a_xp1 a_xn1 wp_ih_1_2 wn_ih_1_2 mhp2 mhn2 vdd vbsyn gsyn
X_ihx_1_2 a_xp1 a_xn1 wp_ih_1_2 wn_ih_1_2 xhp2 xhn2 vdd vbsyn gsyn
X_ihm_2_2 a_xp2 a_xn2 wp_ih_2_2 wn_ih_2_2 mhp2 mhn2 vdd vbsyn gsyn
X_ihx_2_2 a_xp2 a_xn2 wp_ih_2_2 wn_ih_2_2 xhp2 xhn2 vdd vbsyn gsyn
X_ihm_3_2 a_xp3 a_xn3 wp_ih_3_2 wn_ih_3_2 mhp2 mhn2 vdd vbsyn gsyn
X_ihx_3_2 a_xp3 a_xn3 wp_ih_3_2 wn_ih_3_2 xhp2 xhn2 vdd vbsyn gsyn
X_ihm_4_2 a_xp4 a_xn4 wp_ih_4_2 wn_ih_4_2 mhp2 mhn2 vdd vbsyn gsyn
X_ihx_4_2 a_xp4 a_xn4 wp_ih_4_2 wn_ih_4_2 xhp2 xhn2 vdd vbsyn gsyn
X_ihm_5_2 a_xp5 a_xn5 wp_ih_5_2 wn_ih_5_2 mhp2 mhn2 vdd vbsyn gsyn
X_ihx_5_2 a_xp5 a_xn5 wp_ih_5_2 wn_ih_5_2 xhp2 xhn2 vdd vbsyn gsyn
X_ihm_6_2 a_xp6 a_xn6 wp_ih_6_2 wn_ih_6_2 mhp2 mhn2 vdd vbsyn gsyn
X_ihx_6_2 a_xp6 a_xn6 wp_ih_6_2 wn_ih_6_2 xhp2 xhn2 vdd vbsyn gsyn
X_ihm_7_2 a_xp7 a_xn7 wp_ih_7_2 wn_ih_7_2 mhp2 mhn2 vdd vbsyn gsyn
X_ihx_7_2 a_xp7 a_xn7 wp_ih_7_2 wn_ih_7_2 xhp2 xhn2 vdd vbsyn gsyn
X_ihm_8_2 a_xp8 a_xn8 wp_ih_8_2 wn_ih_8_2 mhp2 mhn2 vdd vbsyn gsyn
X_ihx_8_2 a_xp8 a_xn8 wp_ih_8_2 wn_ih_8_2 xhp2 xhn2 vdd vbsyn gsyn
X_ihm_9_2 a_xp9 a_xn9 wp_ih_9_2 wn_ih_9_2 mhp2 mhn2 vdd vbsyn gsyn
X_ihx_9_2 a_xp9 a_xn9 wp_ih_9_2 wn_ih_9_2 xhp2 xhn2 vdd vbsyn gsyn
X_ihm_10_2 a_xp10 a_xn10 wp_ih_10_2 wn_ih_10_2 mhp2 mhn2 vdd vbsyn gsyn
X_ihx_10_2 a_xp10 a_xn10 wp_ih_10_2 wn_ih_10_2 xhp2 xhn2 vdd vbsyn gsyn
X_ihm_11_2 a_xp11 a_xn11 wp_ih_11_2 wn_ih_11_2 mhp2 mhn2 vdd vbsyn gsyn
X_ihx_11_2 a_xp11 a_xn11 wp_ih_11_2 wn_ih_11_2 xhp2 xhn2 vdd vbsyn gsyn
X_ihm_12_2 a_xp12 a_xn12 wp_ih_12_2 wn_ih_12_2 mhp2 mhn2 vdd vbsyn gsyn
X_ihx_12_2 a_xp12 a_xn12 wp_ih_12_2 wn_ih_12_2 xhp2 xhn2 vdd vbsyn gsyn
X_ihm_13_2 a_xp13 a_xn13 wp_ih_13_2 wn_ih_13_2 mhp2 mhn2 vdd vbsyn gsyn
X_ihx_13_2 a_xp13 a_xn13 wp_ih_13_2 wn_ih_13_2 xhp2 xhn2 vdd vbsyn gsyn
X_ihm_14_2 a_xp14 a_xn14 wp_ih_14_2 wn_ih_14_2 mhp2 mhn2 vdd vbsyn gsyn
X_ihx_14_2 a_xp14 a_xn14 wp_ih_14_2 wn_ih_14_2 xhp2 xhn2 vdd vbsyn gsyn
X_ihm_15_2 a_xp15 a_xn15 wp_ih_15_2 wn_ih_15_2 mhp2 mhn2 vdd vbsyn gsyn
X_ihx_15_2 a_xp15 a_xn15 wp_ih_15_2 wn_ih_15_2 xhp2 xhn2 vdd vbsyn gsyn
X_ihm_16_2 a_xp16 a_xn16 wp_ih_16_2 wn_ih_16_2 mhp2 mhn2 vdd vbsyn gsyn
X_ihx_16_2 a_xp16 a_xn16 wp_ih_16_2 wn_ih_16_2 xhp2 xhn2 vdd vbsyn gsyn
X_ihm_17_2 a_xp17 a_xn17 wp_ih_17_2 wn_ih_17_2 mhp2 mhn2 vdd vbsyn gsyn
X_ihx_17_2 a_xp17 a_xn17 wp_ih_17_2 wn_ih_17_2 xhp2 xhn2 vdd vbsyn gsyn
X_ihm_18_2 a_xp18 a_xn18 wp_ih_18_2 wn_ih_18_2 mhp2 mhn2 vdd vbsyn gsyn
X_ihx_18_2 a_xp18 a_xn18 wp_ih_18_2 wn_ih_18_2 xhp2 xhn2 vdd vbsyn gsyn
X_ihm_19_2 a_xp19 a_xn19 wp_ih_19_2 wn_ih_19_2 mhp2 mhn2 vdd vbsyn gsyn
X_ihx_19_2 a_xp19 a_xn19 wp_ih_19_2 wn_ih_19_2 xhp2 xhn2 vdd vbsyn gsyn
X_ihm_20_2 a_xp20 a_xn20 wp_ih_20_2 wn_ih_20_2 mhp2 mhn2 vdd vbsyn gsyn
X_ihx_20_2 a_xp20 a_xn20 wp_ih_20_2 wn_ih_20_2 xhp2 xhn2 vdd vbsyn gsyn
X_ihm_21_2 a_xp21 a_xn21 wp_ih_21_2 wn_ih_21_2 mhp2 mhn2 vdd vbsyn gsyn
X_ihx_21_2 a_xp21 a_xn21 wp_ih_21_2 wn_ih_21_2 xhp2 xhn2 vdd vbsyn gsyn
X_ihm_22_2 a_xp22 a_xn22 wp_ih_22_2 wn_ih_22_2 mhp2 mhn2 vdd vbsyn gsyn
X_ihx_22_2 a_xp22 a_xn22 wp_ih_22_2 wn_ih_22_2 xhp2 xhn2 vdd vbsyn gsyn
X_ihm_23_2 a_xp23 a_xn23 wp_ih_23_2 wn_ih_23_2 mhp2 mhn2 vdd vbsyn gsyn
X_ihx_23_2 a_xp23 a_xn23 wp_ih_23_2 wn_ih_23_2 xhp2 xhn2 vdd vbsyn gsyn
X_ihm_24_2 a_xp24 a_xn24 wp_ih_24_2 wn_ih_24_2 mhp2 mhn2 vdd vbsyn gsyn
X_ihx_24_2 a_xp24 a_xn24 wp_ih_24_2 wn_ih_24_2 xhp2 xhn2 vdd vbsyn gsyn
X_ihm_25_2 a_xp25 a_xn25 wp_ih_25_2 wn_ih_25_2 mhp2 mhn2 vdd vbsyn gsyn
X_ihx_25_2 a_xp25 a_xn25 wp_ih_25_2 wn_ih_25_2 xhp2 xhn2 vdd vbsyn gsyn
X_ihm_26_2 a_xp26 a_xn26 wp_ih_26_2 wn_ih_26_2 mhp2 mhn2 vdd vbsyn gsyn
X_ihx_26_2 a_xp26 a_xn26 wp_ih_26_2 wn_ih_26_2 xhp2 xhn2 vdd vbsyn gsyn
X_ihm_27_2 a_xp27 a_xn27 wp_ih_27_2 wn_ih_27_2 mhp2 mhn2 vdd vbsyn gsyn
X_ihx_27_2 a_xp27 a_xn27 wp_ih_27_2 wn_ih_27_2 xhp2 xhn2 vdd vbsyn gsyn
X_ihm_28_2 a_xp28 a_xn28 wp_ih_28_2 wn_ih_28_2 mhp2 mhn2 vdd vbsyn gsyn
X_ihx_28_2 a_xp28 a_xn28 wp_ih_28_2 wn_ih_28_2 xhp2 xhn2 vdd vbsyn gsyn
X_ihm_29_2 a_xp29 a_xn29 wp_ih_29_2 wn_ih_29_2 mhp2 mhn2 vdd vbsyn gsyn
X_ihx_29_2 a_xp29 a_xn29 wp_ih_29_2 wn_ih_29_2 xhp2 xhn2 vdd vbsyn gsyn
X_ihm_30_2 a_xp30 a_xn30 wp_ih_30_2 wn_ih_30_2 mhp2 mhn2 vdd vbsyn gsyn
X_ihx_30_2 a_xp30 a_xn30 wp_ih_30_2 wn_ih_30_2 xhp2 xhn2 vdd vbsyn gsyn
X_ihm_31_2 a_xp31 a_xn31 wp_ih_31_2 wn_ih_31_2 mhp2 mhn2 vdd vbsyn gsyn
X_ihx_31_2 a_xp31 a_xn31 wp_ih_31_2 wn_ih_31_2 xhp2 xhn2 vdd vbsyn gsyn
X_ihm_32_2 a_xp32 a_xn32 wp_ih_32_2 wn_ih_32_2 mhp2 mhn2 vdd vbsyn gsyn
X_ihx_32_2 a_xp32 a_xn32 wp_ih_32_2 wn_ih_32_2 xhp2 xhn2 vdd vbsyn gsyn
X_ihm_33_2 a_xp33 a_xn33 wp_ih_33_2 wn_ih_33_2 mhp2 mhn2 vdd vbsyn gsyn
X_ihx_33_2 a_xp33 a_xn33 wp_ih_33_2 wn_ih_33_2 xhp2 xhn2 vdd vbsyn gsyn
X_ihm_34_2 a_xp34 a_xn34 wp_ih_34_2 wn_ih_34_2 mhp2 mhn2 vdd vbsyn gsyn
X_ihx_34_2 a_xp34 a_xn34 wp_ih_34_2 wn_ih_34_2 xhp2 xhn2 vdd vbsyn gsyn
X_ihm_35_2 a_xp35 a_xn35 wp_ih_35_2 wn_ih_35_2 mhp2 mhn2 vdd vbsyn gsyn
X_ihx_35_2 a_xp35 a_xn35 wp_ih_35_2 wn_ih_35_2 xhp2 xhn2 vdd vbsyn gsyn
X_ihm_36_2 a_xp36 a_xn36 wp_ih_36_2 wn_ih_36_2 mhp2 mhn2 vdd vbsyn gsyn
X_ihx_36_2 a_xp36 a_xn36 wp_ih_36_2 wn_ih_36_2 xhp2 xhn2 vdd vbsyn gsyn
X_ihm_37_2 a_xp37 a_xn37 wp_ih_37_2 wn_ih_37_2 mhp2 mhn2 vdd vbsyn gsyn
X_ihx_37_2 a_xp37 a_xn37 wp_ih_37_2 wn_ih_37_2 xhp2 xhn2 vdd vbsyn gsyn
X_ihm_38_2 a_xp38 a_xn38 wp_ih_38_2 wn_ih_38_2 mhp2 mhn2 vdd vbsyn gsyn
X_ihx_38_2 a_xp38 a_xn38 wp_ih_38_2 wn_ih_38_2 xhp2 xhn2 vdd vbsyn gsyn
X_ihm_39_2 a_xp39 a_xn39 wp_ih_39_2 wn_ih_39_2 mhp2 mhn2 vdd vbsyn gsyn
X_ihx_39_2 a_xp39 a_xn39 wp_ih_39_2 wn_ih_39_2 xhp2 xhn2 vdd vbsyn gsyn
X_ihm_40_2 a_xp40 a_xn40 wp_ih_40_2 wn_ih_40_2 mhp2 mhn2 vdd vbsyn gsyn
X_ihx_40_2 a_xp40 a_xn40 wp_ih_40_2 wn_ih_40_2 xhp2 xhn2 vdd vbsyn gsyn
X_ihm_41_2 a_xp41 a_xn41 wp_ih_41_2 wn_ih_41_2 mhp2 mhn2 vdd vbsyn gsyn
X_ihx_41_2 a_xp41 a_xn41 wp_ih_41_2 wn_ih_41_2 xhp2 xhn2 vdd vbsyn gsyn
X_ihm_42_2 a_xp42 a_xn42 wp_ih_42_2 wn_ih_42_2 mhp2 mhn2 vdd vbsyn gsyn
X_ihx_42_2 a_xp42 a_xn42 wp_ih_42_2 wn_ih_42_2 xhp2 xhn2 vdd vbsyn gsyn
X_ihm_43_2 a_xp43 a_xn43 wp_ih_43_2 wn_ih_43_2 mhp2 mhn2 vdd vbsyn gsyn
X_ihx_43_2 a_xp43 a_xn43 wp_ih_43_2 wn_ih_43_2 xhp2 xhn2 vdd vbsyn gsyn
X_ihm_44_2 a_xp44 a_xn44 wp_ih_44_2 wn_ih_44_2 mhp2 mhn2 vdd vbsyn gsyn
X_ihx_44_2 a_xp44 a_xn44 wp_ih_44_2 wn_ih_44_2 xhp2 xhn2 vdd vbsyn gsyn
X_ihm_45_2 a_xp45 a_xn45 wp_ih_45_2 wn_ih_45_2 mhp2 mhn2 vdd vbsyn gsyn
X_ihx_45_2 a_xp45 a_xn45 wp_ih_45_2 wn_ih_45_2 xhp2 xhn2 vdd vbsyn gsyn
X_ihm_46_2 a_xp46 a_xn46 wp_ih_46_2 wn_ih_46_2 mhp2 mhn2 vdd vbsyn gsyn
X_ihx_46_2 a_xp46 a_xn46 wp_ih_46_2 wn_ih_46_2 xhp2 xhn2 vdd vbsyn gsyn
X_ihm_47_2 a_xp47 a_xn47 wp_ih_47_2 wn_ih_47_2 mhp2 mhn2 vdd vbsyn gsyn
X_ihx_47_2 a_xp47 a_xn47 wp_ih_47_2 wn_ih_47_2 xhp2 xhn2 vdd vbsyn gsyn
X_ihm_48_2 a_xp48 a_xn48 wp_ih_48_2 wn_ih_48_2 mhp2 mhn2 vdd vbsyn gsyn
X_ihx_48_2 a_xp48 a_xn48 wp_ih_48_2 wn_ih_48_2 xhp2 xhn2 vdd vbsyn gsyn
X_ihm_49_2 a_xp49 a_xn49 wp_ih_49_2 wn_ih_49_2 mhp2 mhn2 vdd vbsyn gsyn
X_ihx_49_2 a_xp49 a_xn49 wp_ih_49_2 wn_ih_49_2 xhp2 xhn2 vdd vbsyn gsyn
X_ihm_50_2 a_xp50 a_xn50 wp_ih_50_2 wn_ih_50_2 mhp2 mhn2 vdd vbsyn gsyn
X_ihx_50_2 a_xp50 a_xn50 wp_ih_50_2 wn_ih_50_2 xhp2 xhn2 vdd vbsyn gsyn
X_ihm_51_2 a_xp51 a_xn51 wp_ih_51_2 wn_ih_51_2 mhp2 mhn2 vdd vbsyn gsyn
X_ihx_51_2 a_xp51 a_xn51 wp_ih_51_2 wn_ih_51_2 xhp2 xhn2 vdd vbsyn gsyn
X_ihm_52_2 a_xp52 a_xn52 wp_ih_52_2 wn_ih_52_2 mhp2 mhn2 vdd vbsyn gsyn
X_ihx_52_2 a_xp52 a_xn52 wp_ih_52_2 wn_ih_52_2 xhp2 xhn2 vdd vbsyn gsyn
X_ihm_53_2 a_xp53 a_xn53 wp_ih_53_2 wn_ih_53_2 mhp2 mhn2 vdd vbsyn gsyn
X_ihx_53_2 a_xp53 a_xn53 wp_ih_53_2 wn_ih_53_2 xhp2 xhn2 vdd vbsyn gsyn
X_ihm_54_2 a_xp54 a_xn54 wp_ih_54_2 wn_ih_54_2 mhp2 mhn2 vdd vbsyn gsyn
X_ihx_54_2 a_xp54 a_xn54 wp_ih_54_2 wn_ih_54_2 xhp2 xhn2 vdd vbsyn gsyn
X_ihm_55_2 a_xp55 a_xn55 wp_ih_55_2 wn_ih_55_2 mhp2 mhn2 vdd vbsyn gsyn
X_ihx_55_2 a_xp55 a_xn55 wp_ih_55_2 wn_ih_55_2 xhp2 xhn2 vdd vbsyn gsyn
X_ihm_56_2 a_xp56 a_xn56 wp_ih_56_2 wn_ih_56_2 mhp2 mhn2 vdd vbsyn gsyn
X_ihx_56_2 a_xp56 a_xn56 wp_ih_56_2 wn_ih_56_2 xhp2 xhn2 vdd vbsyn gsyn
X_ihm_57_2 a_xp57 a_xn57 wp_ih_57_2 wn_ih_57_2 mhp2 mhn2 vdd vbsyn gsyn
X_ihx_57_2 a_xp57 a_xn57 wp_ih_57_2 wn_ih_57_2 xhp2 xhn2 vdd vbsyn gsyn
X_ihm_58_2 a_xp58 a_xn58 wp_ih_58_2 wn_ih_58_2 mhp2 mhn2 vdd vbsyn gsyn
X_ihx_58_2 a_xp58 a_xn58 wp_ih_58_2 wn_ih_58_2 xhp2 xhn2 vdd vbsyn gsyn
X_ihm_59_2 a_xp59 a_xn59 wp_ih_59_2 wn_ih_59_2 mhp2 mhn2 vdd vbsyn gsyn
X_ihx_59_2 a_xp59 a_xn59 wp_ih_59_2 wn_ih_59_2 xhp2 xhn2 vdd vbsyn gsyn
X_ihm_60_2 a_xp60 a_xn60 wp_ih_60_2 wn_ih_60_2 mhp2 mhn2 vdd vbsyn gsyn
X_ihx_60_2 a_xp60 a_xn60 wp_ih_60_2 wn_ih_60_2 xhp2 xhn2 vdd vbsyn gsyn
X_ihm_61_2 a_xp61 a_xn61 wp_ih_61_2 wn_ih_61_2 mhp2 mhn2 vdd vbsyn gsyn
X_ihx_61_2 a_xp61 a_xn61 wp_ih_61_2 wn_ih_61_2 xhp2 xhn2 vdd vbsyn gsyn
X_ihm_62_2 a_xp62 a_xn62 wp_ih_62_2 wn_ih_62_2 mhp2 mhn2 vdd vbsyn gsyn
X_ihx_62_2 a_xp62 a_xn62 wp_ih_62_2 wn_ih_62_2 xhp2 xhn2 vdd vbsyn gsyn
X_ihm_63_2 a_xp63 a_xn63 wp_ih_63_2 wn_ih_63_2 mhp2 mhn2 vdd vbsyn gsyn
X_ihx_63_2 a_xp63 a_xn63 wp_ih_63_2 wn_ih_63_2 xhp2 xhn2 vdd vbsyn gsyn
X_bk_2_0 eop0 eon0 wp_ho_2_0 wn_ho_2_0 xhp2 xhn2 vdd vbbk gsyn
X_bk_2_1 eop1 eon1 wp_ho_2_1 wn_ho_2_1 xhp2 xhn2 vdd vbbk gsyn
X_bk_2_2 eop2 eon2 wp_ho_2_2 wn_ho_2_2 xhp2 xhn2 vdd vbbk gsyn
X_bk_2_3 eop3 eon3 wp_ho_2_3 wn_ho_2_3 xhp2 xhn2 vdd vbbk gsyn
X_bk_2_4 eop4 eon4 wp_ho_2_4 wn_ho_2_4 xhp2 xhn2 vdd vbbk gsyn
Xn2 xhp2 xhn2 ahp2 ahn2 vdd vbneu dneuron
Xeh2 xhp2 xhn2 mhp2 mhn2 ehp2 ehn2 vdd gm esub
Xcm_mh3 mhp3 mhn3 vdd cmld
Rnd_mh3 mhp3 mhn3 20k
Xcm_xh3 xhp3 xhn3 vdd cmld
Rnd_xh3 xhp3 xhn3 20k
X_ihm_0_3 a_xp0 a_xn0 wp_ih_0_3 wn_ih_0_3 mhp3 mhn3 vdd vbsyn gsyn
X_ihx_0_3 a_xp0 a_xn0 wp_ih_0_3 wn_ih_0_3 xhp3 xhn3 vdd vbsyn gsyn
X_ihm_1_3 a_xp1 a_xn1 wp_ih_1_3 wn_ih_1_3 mhp3 mhn3 vdd vbsyn gsyn
X_ihx_1_3 a_xp1 a_xn1 wp_ih_1_3 wn_ih_1_3 xhp3 xhn3 vdd vbsyn gsyn
X_ihm_2_3 a_xp2 a_xn2 wp_ih_2_3 wn_ih_2_3 mhp3 mhn3 vdd vbsyn gsyn
X_ihx_2_3 a_xp2 a_xn2 wp_ih_2_3 wn_ih_2_3 xhp3 xhn3 vdd vbsyn gsyn
X_ihm_3_3 a_xp3 a_xn3 wp_ih_3_3 wn_ih_3_3 mhp3 mhn3 vdd vbsyn gsyn
X_ihx_3_3 a_xp3 a_xn3 wp_ih_3_3 wn_ih_3_3 xhp3 xhn3 vdd vbsyn gsyn
X_ihm_4_3 a_xp4 a_xn4 wp_ih_4_3 wn_ih_4_3 mhp3 mhn3 vdd vbsyn gsyn
X_ihx_4_3 a_xp4 a_xn4 wp_ih_4_3 wn_ih_4_3 xhp3 xhn3 vdd vbsyn gsyn
X_ihm_5_3 a_xp5 a_xn5 wp_ih_5_3 wn_ih_5_3 mhp3 mhn3 vdd vbsyn gsyn
X_ihx_5_3 a_xp5 a_xn5 wp_ih_5_3 wn_ih_5_3 xhp3 xhn3 vdd vbsyn gsyn
X_ihm_6_3 a_xp6 a_xn6 wp_ih_6_3 wn_ih_6_3 mhp3 mhn3 vdd vbsyn gsyn
X_ihx_6_3 a_xp6 a_xn6 wp_ih_6_3 wn_ih_6_3 xhp3 xhn3 vdd vbsyn gsyn
X_ihm_7_3 a_xp7 a_xn7 wp_ih_7_3 wn_ih_7_3 mhp3 mhn3 vdd vbsyn gsyn
X_ihx_7_3 a_xp7 a_xn7 wp_ih_7_3 wn_ih_7_3 xhp3 xhn3 vdd vbsyn gsyn
X_ihm_8_3 a_xp8 a_xn8 wp_ih_8_3 wn_ih_8_3 mhp3 mhn3 vdd vbsyn gsyn
X_ihx_8_3 a_xp8 a_xn8 wp_ih_8_3 wn_ih_8_3 xhp3 xhn3 vdd vbsyn gsyn
X_ihm_9_3 a_xp9 a_xn9 wp_ih_9_3 wn_ih_9_3 mhp3 mhn3 vdd vbsyn gsyn
X_ihx_9_3 a_xp9 a_xn9 wp_ih_9_3 wn_ih_9_3 xhp3 xhn3 vdd vbsyn gsyn
X_ihm_10_3 a_xp10 a_xn10 wp_ih_10_3 wn_ih_10_3 mhp3 mhn3 vdd vbsyn gsyn
X_ihx_10_3 a_xp10 a_xn10 wp_ih_10_3 wn_ih_10_3 xhp3 xhn3 vdd vbsyn gsyn
X_ihm_11_3 a_xp11 a_xn11 wp_ih_11_3 wn_ih_11_3 mhp3 mhn3 vdd vbsyn gsyn
X_ihx_11_3 a_xp11 a_xn11 wp_ih_11_3 wn_ih_11_3 xhp3 xhn3 vdd vbsyn gsyn
X_ihm_12_3 a_xp12 a_xn12 wp_ih_12_3 wn_ih_12_3 mhp3 mhn3 vdd vbsyn gsyn
X_ihx_12_3 a_xp12 a_xn12 wp_ih_12_3 wn_ih_12_3 xhp3 xhn3 vdd vbsyn gsyn
X_ihm_13_3 a_xp13 a_xn13 wp_ih_13_3 wn_ih_13_3 mhp3 mhn3 vdd vbsyn gsyn
X_ihx_13_3 a_xp13 a_xn13 wp_ih_13_3 wn_ih_13_3 xhp3 xhn3 vdd vbsyn gsyn
X_ihm_14_3 a_xp14 a_xn14 wp_ih_14_3 wn_ih_14_3 mhp3 mhn3 vdd vbsyn gsyn
X_ihx_14_3 a_xp14 a_xn14 wp_ih_14_3 wn_ih_14_3 xhp3 xhn3 vdd vbsyn gsyn
X_ihm_15_3 a_xp15 a_xn15 wp_ih_15_3 wn_ih_15_3 mhp3 mhn3 vdd vbsyn gsyn
X_ihx_15_3 a_xp15 a_xn15 wp_ih_15_3 wn_ih_15_3 xhp3 xhn3 vdd vbsyn gsyn
X_ihm_16_3 a_xp16 a_xn16 wp_ih_16_3 wn_ih_16_3 mhp3 mhn3 vdd vbsyn gsyn
X_ihx_16_3 a_xp16 a_xn16 wp_ih_16_3 wn_ih_16_3 xhp3 xhn3 vdd vbsyn gsyn
X_ihm_17_3 a_xp17 a_xn17 wp_ih_17_3 wn_ih_17_3 mhp3 mhn3 vdd vbsyn gsyn
X_ihx_17_3 a_xp17 a_xn17 wp_ih_17_3 wn_ih_17_3 xhp3 xhn3 vdd vbsyn gsyn
X_ihm_18_3 a_xp18 a_xn18 wp_ih_18_3 wn_ih_18_3 mhp3 mhn3 vdd vbsyn gsyn
X_ihx_18_3 a_xp18 a_xn18 wp_ih_18_3 wn_ih_18_3 xhp3 xhn3 vdd vbsyn gsyn
X_ihm_19_3 a_xp19 a_xn19 wp_ih_19_3 wn_ih_19_3 mhp3 mhn3 vdd vbsyn gsyn
X_ihx_19_3 a_xp19 a_xn19 wp_ih_19_3 wn_ih_19_3 xhp3 xhn3 vdd vbsyn gsyn
X_ihm_20_3 a_xp20 a_xn20 wp_ih_20_3 wn_ih_20_3 mhp3 mhn3 vdd vbsyn gsyn
X_ihx_20_3 a_xp20 a_xn20 wp_ih_20_3 wn_ih_20_3 xhp3 xhn3 vdd vbsyn gsyn
X_ihm_21_3 a_xp21 a_xn21 wp_ih_21_3 wn_ih_21_3 mhp3 mhn3 vdd vbsyn gsyn
X_ihx_21_3 a_xp21 a_xn21 wp_ih_21_3 wn_ih_21_3 xhp3 xhn3 vdd vbsyn gsyn
X_ihm_22_3 a_xp22 a_xn22 wp_ih_22_3 wn_ih_22_3 mhp3 mhn3 vdd vbsyn gsyn
X_ihx_22_3 a_xp22 a_xn22 wp_ih_22_3 wn_ih_22_3 xhp3 xhn3 vdd vbsyn gsyn
X_ihm_23_3 a_xp23 a_xn23 wp_ih_23_3 wn_ih_23_3 mhp3 mhn3 vdd vbsyn gsyn
X_ihx_23_3 a_xp23 a_xn23 wp_ih_23_3 wn_ih_23_3 xhp3 xhn3 vdd vbsyn gsyn
X_ihm_24_3 a_xp24 a_xn24 wp_ih_24_3 wn_ih_24_3 mhp3 mhn3 vdd vbsyn gsyn
X_ihx_24_3 a_xp24 a_xn24 wp_ih_24_3 wn_ih_24_3 xhp3 xhn3 vdd vbsyn gsyn
X_ihm_25_3 a_xp25 a_xn25 wp_ih_25_3 wn_ih_25_3 mhp3 mhn3 vdd vbsyn gsyn
X_ihx_25_3 a_xp25 a_xn25 wp_ih_25_3 wn_ih_25_3 xhp3 xhn3 vdd vbsyn gsyn
X_ihm_26_3 a_xp26 a_xn26 wp_ih_26_3 wn_ih_26_3 mhp3 mhn3 vdd vbsyn gsyn
X_ihx_26_3 a_xp26 a_xn26 wp_ih_26_3 wn_ih_26_3 xhp3 xhn3 vdd vbsyn gsyn
X_ihm_27_3 a_xp27 a_xn27 wp_ih_27_3 wn_ih_27_3 mhp3 mhn3 vdd vbsyn gsyn
X_ihx_27_3 a_xp27 a_xn27 wp_ih_27_3 wn_ih_27_3 xhp3 xhn3 vdd vbsyn gsyn
X_ihm_28_3 a_xp28 a_xn28 wp_ih_28_3 wn_ih_28_3 mhp3 mhn3 vdd vbsyn gsyn
X_ihx_28_3 a_xp28 a_xn28 wp_ih_28_3 wn_ih_28_3 xhp3 xhn3 vdd vbsyn gsyn
X_ihm_29_3 a_xp29 a_xn29 wp_ih_29_3 wn_ih_29_3 mhp3 mhn3 vdd vbsyn gsyn
X_ihx_29_3 a_xp29 a_xn29 wp_ih_29_3 wn_ih_29_3 xhp3 xhn3 vdd vbsyn gsyn
X_ihm_30_3 a_xp30 a_xn30 wp_ih_30_3 wn_ih_30_3 mhp3 mhn3 vdd vbsyn gsyn
X_ihx_30_3 a_xp30 a_xn30 wp_ih_30_3 wn_ih_30_3 xhp3 xhn3 vdd vbsyn gsyn
X_ihm_31_3 a_xp31 a_xn31 wp_ih_31_3 wn_ih_31_3 mhp3 mhn3 vdd vbsyn gsyn
X_ihx_31_3 a_xp31 a_xn31 wp_ih_31_3 wn_ih_31_3 xhp3 xhn3 vdd vbsyn gsyn
X_ihm_32_3 a_xp32 a_xn32 wp_ih_32_3 wn_ih_32_3 mhp3 mhn3 vdd vbsyn gsyn
X_ihx_32_3 a_xp32 a_xn32 wp_ih_32_3 wn_ih_32_3 xhp3 xhn3 vdd vbsyn gsyn
X_ihm_33_3 a_xp33 a_xn33 wp_ih_33_3 wn_ih_33_3 mhp3 mhn3 vdd vbsyn gsyn
X_ihx_33_3 a_xp33 a_xn33 wp_ih_33_3 wn_ih_33_3 xhp3 xhn3 vdd vbsyn gsyn
X_ihm_34_3 a_xp34 a_xn34 wp_ih_34_3 wn_ih_34_3 mhp3 mhn3 vdd vbsyn gsyn
X_ihx_34_3 a_xp34 a_xn34 wp_ih_34_3 wn_ih_34_3 xhp3 xhn3 vdd vbsyn gsyn
X_ihm_35_3 a_xp35 a_xn35 wp_ih_35_3 wn_ih_35_3 mhp3 mhn3 vdd vbsyn gsyn
X_ihx_35_3 a_xp35 a_xn35 wp_ih_35_3 wn_ih_35_3 xhp3 xhn3 vdd vbsyn gsyn
X_ihm_36_3 a_xp36 a_xn36 wp_ih_36_3 wn_ih_36_3 mhp3 mhn3 vdd vbsyn gsyn
X_ihx_36_3 a_xp36 a_xn36 wp_ih_36_3 wn_ih_36_3 xhp3 xhn3 vdd vbsyn gsyn
X_ihm_37_3 a_xp37 a_xn37 wp_ih_37_3 wn_ih_37_3 mhp3 mhn3 vdd vbsyn gsyn
X_ihx_37_3 a_xp37 a_xn37 wp_ih_37_3 wn_ih_37_3 xhp3 xhn3 vdd vbsyn gsyn
X_ihm_38_3 a_xp38 a_xn38 wp_ih_38_3 wn_ih_38_3 mhp3 mhn3 vdd vbsyn gsyn
X_ihx_38_3 a_xp38 a_xn38 wp_ih_38_3 wn_ih_38_3 xhp3 xhn3 vdd vbsyn gsyn
X_ihm_39_3 a_xp39 a_xn39 wp_ih_39_3 wn_ih_39_3 mhp3 mhn3 vdd vbsyn gsyn
X_ihx_39_3 a_xp39 a_xn39 wp_ih_39_3 wn_ih_39_3 xhp3 xhn3 vdd vbsyn gsyn
X_ihm_40_3 a_xp40 a_xn40 wp_ih_40_3 wn_ih_40_3 mhp3 mhn3 vdd vbsyn gsyn
X_ihx_40_3 a_xp40 a_xn40 wp_ih_40_3 wn_ih_40_3 xhp3 xhn3 vdd vbsyn gsyn
X_ihm_41_3 a_xp41 a_xn41 wp_ih_41_3 wn_ih_41_3 mhp3 mhn3 vdd vbsyn gsyn
X_ihx_41_3 a_xp41 a_xn41 wp_ih_41_3 wn_ih_41_3 xhp3 xhn3 vdd vbsyn gsyn
X_ihm_42_3 a_xp42 a_xn42 wp_ih_42_3 wn_ih_42_3 mhp3 mhn3 vdd vbsyn gsyn
X_ihx_42_3 a_xp42 a_xn42 wp_ih_42_3 wn_ih_42_3 xhp3 xhn3 vdd vbsyn gsyn
X_ihm_43_3 a_xp43 a_xn43 wp_ih_43_3 wn_ih_43_3 mhp3 mhn3 vdd vbsyn gsyn
X_ihx_43_3 a_xp43 a_xn43 wp_ih_43_3 wn_ih_43_3 xhp3 xhn3 vdd vbsyn gsyn
X_ihm_44_3 a_xp44 a_xn44 wp_ih_44_3 wn_ih_44_3 mhp3 mhn3 vdd vbsyn gsyn
X_ihx_44_3 a_xp44 a_xn44 wp_ih_44_3 wn_ih_44_3 xhp3 xhn3 vdd vbsyn gsyn
X_ihm_45_3 a_xp45 a_xn45 wp_ih_45_3 wn_ih_45_3 mhp3 mhn3 vdd vbsyn gsyn
X_ihx_45_3 a_xp45 a_xn45 wp_ih_45_3 wn_ih_45_3 xhp3 xhn3 vdd vbsyn gsyn
X_ihm_46_3 a_xp46 a_xn46 wp_ih_46_3 wn_ih_46_3 mhp3 mhn3 vdd vbsyn gsyn
X_ihx_46_3 a_xp46 a_xn46 wp_ih_46_3 wn_ih_46_3 xhp3 xhn3 vdd vbsyn gsyn
X_ihm_47_3 a_xp47 a_xn47 wp_ih_47_3 wn_ih_47_3 mhp3 mhn3 vdd vbsyn gsyn
X_ihx_47_3 a_xp47 a_xn47 wp_ih_47_3 wn_ih_47_3 xhp3 xhn3 vdd vbsyn gsyn
X_ihm_48_3 a_xp48 a_xn48 wp_ih_48_3 wn_ih_48_3 mhp3 mhn3 vdd vbsyn gsyn
X_ihx_48_3 a_xp48 a_xn48 wp_ih_48_3 wn_ih_48_3 xhp3 xhn3 vdd vbsyn gsyn
X_ihm_49_3 a_xp49 a_xn49 wp_ih_49_3 wn_ih_49_3 mhp3 mhn3 vdd vbsyn gsyn
X_ihx_49_3 a_xp49 a_xn49 wp_ih_49_3 wn_ih_49_3 xhp3 xhn3 vdd vbsyn gsyn
X_ihm_50_3 a_xp50 a_xn50 wp_ih_50_3 wn_ih_50_3 mhp3 mhn3 vdd vbsyn gsyn
X_ihx_50_3 a_xp50 a_xn50 wp_ih_50_3 wn_ih_50_3 xhp3 xhn3 vdd vbsyn gsyn
X_ihm_51_3 a_xp51 a_xn51 wp_ih_51_3 wn_ih_51_3 mhp3 mhn3 vdd vbsyn gsyn
X_ihx_51_3 a_xp51 a_xn51 wp_ih_51_3 wn_ih_51_3 xhp3 xhn3 vdd vbsyn gsyn
X_ihm_52_3 a_xp52 a_xn52 wp_ih_52_3 wn_ih_52_3 mhp3 mhn3 vdd vbsyn gsyn
X_ihx_52_3 a_xp52 a_xn52 wp_ih_52_3 wn_ih_52_3 xhp3 xhn3 vdd vbsyn gsyn
X_ihm_53_3 a_xp53 a_xn53 wp_ih_53_3 wn_ih_53_3 mhp3 mhn3 vdd vbsyn gsyn
X_ihx_53_3 a_xp53 a_xn53 wp_ih_53_3 wn_ih_53_3 xhp3 xhn3 vdd vbsyn gsyn
X_ihm_54_3 a_xp54 a_xn54 wp_ih_54_3 wn_ih_54_3 mhp3 mhn3 vdd vbsyn gsyn
X_ihx_54_3 a_xp54 a_xn54 wp_ih_54_3 wn_ih_54_3 xhp3 xhn3 vdd vbsyn gsyn
X_ihm_55_3 a_xp55 a_xn55 wp_ih_55_3 wn_ih_55_3 mhp3 mhn3 vdd vbsyn gsyn
X_ihx_55_3 a_xp55 a_xn55 wp_ih_55_3 wn_ih_55_3 xhp3 xhn3 vdd vbsyn gsyn
X_ihm_56_3 a_xp56 a_xn56 wp_ih_56_3 wn_ih_56_3 mhp3 mhn3 vdd vbsyn gsyn
X_ihx_56_3 a_xp56 a_xn56 wp_ih_56_3 wn_ih_56_3 xhp3 xhn3 vdd vbsyn gsyn
X_ihm_57_3 a_xp57 a_xn57 wp_ih_57_3 wn_ih_57_3 mhp3 mhn3 vdd vbsyn gsyn
X_ihx_57_3 a_xp57 a_xn57 wp_ih_57_3 wn_ih_57_3 xhp3 xhn3 vdd vbsyn gsyn
X_ihm_58_3 a_xp58 a_xn58 wp_ih_58_3 wn_ih_58_3 mhp3 mhn3 vdd vbsyn gsyn
X_ihx_58_3 a_xp58 a_xn58 wp_ih_58_3 wn_ih_58_3 xhp3 xhn3 vdd vbsyn gsyn
X_ihm_59_3 a_xp59 a_xn59 wp_ih_59_3 wn_ih_59_3 mhp3 mhn3 vdd vbsyn gsyn
X_ihx_59_3 a_xp59 a_xn59 wp_ih_59_3 wn_ih_59_3 xhp3 xhn3 vdd vbsyn gsyn
X_ihm_60_3 a_xp60 a_xn60 wp_ih_60_3 wn_ih_60_3 mhp3 mhn3 vdd vbsyn gsyn
X_ihx_60_3 a_xp60 a_xn60 wp_ih_60_3 wn_ih_60_3 xhp3 xhn3 vdd vbsyn gsyn
X_ihm_61_3 a_xp61 a_xn61 wp_ih_61_3 wn_ih_61_3 mhp3 mhn3 vdd vbsyn gsyn
X_ihx_61_3 a_xp61 a_xn61 wp_ih_61_3 wn_ih_61_3 xhp3 xhn3 vdd vbsyn gsyn
X_ihm_62_3 a_xp62 a_xn62 wp_ih_62_3 wn_ih_62_3 mhp3 mhn3 vdd vbsyn gsyn
X_ihx_62_3 a_xp62 a_xn62 wp_ih_62_3 wn_ih_62_3 xhp3 xhn3 vdd vbsyn gsyn
X_ihm_63_3 a_xp63 a_xn63 wp_ih_63_3 wn_ih_63_3 mhp3 mhn3 vdd vbsyn gsyn
X_ihx_63_3 a_xp63 a_xn63 wp_ih_63_3 wn_ih_63_3 xhp3 xhn3 vdd vbsyn gsyn
X_bk_3_0 eop0 eon0 wp_ho_3_0 wn_ho_3_0 xhp3 xhn3 vdd vbbk gsyn
X_bk_3_1 eop1 eon1 wp_ho_3_1 wn_ho_3_1 xhp3 xhn3 vdd vbbk gsyn
X_bk_3_2 eop2 eon2 wp_ho_3_2 wn_ho_3_2 xhp3 xhn3 vdd vbbk gsyn
X_bk_3_3 eop3 eon3 wp_ho_3_3 wn_ho_3_3 xhp3 xhn3 vdd vbbk gsyn
X_bk_3_4 eop4 eon4 wp_ho_3_4 wn_ho_3_4 xhp3 xhn3 vdd vbbk gsyn
Xn3 xhp3 xhn3 ahp3 ahn3 vdd vbneu dneuron
Xeh3 xhp3 xhn3 mhp3 mhn3 ehp3 ehn3 vdd gm esub
Xcm_mh4 mhp4 mhn4 vdd cmld
Rnd_mh4 mhp4 mhn4 20k
Xcm_xh4 xhp4 xhn4 vdd cmld
Rnd_xh4 xhp4 xhn4 20k
X_ihm_0_4 a_xp0 a_xn0 wp_ih_0_4 wn_ih_0_4 mhp4 mhn4 vdd vbsyn gsyn
X_ihx_0_4 a_xp0 a_xn0 wp_ih_0_4 wn_ih_0_4 xhp4 xhn4 vdd vbsyn gsyn
X_ihm_1_4 a_xp1 a_xn1 wp_ih_1_4 wn_ih_1_4 mhp4 mhn4 vdd vbsyn gsyn
X_ihx_1_4 a_xp1 a_xn1 wp_ih_1_4 wn_ih_1_4 xhp4 xhn4 vdd vbsyn gsyn
X_ihm_2_4 a_xp2 a_xn2 wp_ih_2_4 wn_ih_2_4 mhp4 mhn4 vdd vbsyn gsyn
X_ihx_2_4 a_xp2 a_xn2 wp_ih_2_4 wn_ih_2_4 xhp4 xhn4 vdd vbsyn gsyn
X_ihm_3_4 a_xp3 a_xn3 wp_ih_3_4 wn_ih_3_4 mhp4 mhn4 vdd vbsyn gsyn
X_ihx_3_4 a_xp3 a_xn3 wp_ih_3_4 wn_ih_3_4 xhp4 xhn4 vdd vbsyn gsyn
X_ihm_4_4 a_xp4 a_xn4 wp_ih_4_4 wn_ih_4_4 mhp4 mhn4 vdd vbsyn gsyn
X_ihx_4_4 a_xp4 a_xn4 wp_ih_4_4 wn_ih_4_4 xhp4 xhn4 vdd vbsyn gsyn
X_ihm_5_4 a_xp5 a_xn5 wp_ih_5_4 wn_ih_5_4 mhp4 mhn4 vdd vbsyn gsyn
X_ihx_5_4 a_xp5 a_xn5 wp_ih_5_4 wn_ih_5_4 xhp4 xhn4 vdd vbsyn gsyn
X_ihm_6_4 a_xp6 a_xn6 wp_ih_6_4 wn_ih_6_4 mhp4 mhn4 vdd vbsyn gsyn
X_ihx_6_4 a_xp6 a_xn6 wp_ih_6_4 wn_ih_6_4 xhp4 xhn4 vdd vbsyn gsyn
X_ihm_7_4 a_xp7 a_xn7 wp_ih_7_4 wn_ih_7_4 mhp4 mhn4 vdd vbsyn gsyn
X_ihx_7_4 a_xp7 a_xn7 wp_ih_7_4 wn_ih_7_4 xhp4 xhn4 vdd vbsyn gsyn
X_ihm_8_4 a_xp8 a_xn8 wp_ih_8_4 wn_ih_8_4 mhp4 mhn4 vdd vbsyn gsyn
X_ihx_8_4 a_xp8 a_xn8 wp_ih_8_4 wn_ih_8_4 xhp4 xhn4 vdd vbsyn gsyn
X_ihm_9_4 a_xp9 a_xn9 wp_ih_9_4 wn_ih_9_4 mhp4 mhn4 vdd vbsyn gsyn
X_ihx_9_4 a_xp9 a_xn9 wp_ih_9_4 wn_ih_9_4 xhp4 xhn4 vdd vbsyn gsyn
X_ihm_10_4 a_xp10 a_xn10 wp_ih_10_4 wn_ih_10_4 mhp4 mhn4 vdd vbsyn gsyn
X_ihx_10_4 a_xp10 a_xn10 wp_ih_10_4 wn_ih_10_4 xhp4 xhn4 vdd vbsyn gsyn
X_ihm_11_4 a_xp11 a_xn11 wp_ih_11_4 wn_ih_11_4 mhp4 mhn4 vdd vbsyn gsyn
X_ihx_11_4 a_xp11 a_xn11 wp_ih_11_4 wn_ih_11_4 xhp4 xhn4 vdd vbsyn gsyn
X_ihm_12_4 a_xp12 a_xn12 wp_ih_12_4 wn_ih_12_4 mhp4 mhn4 vdd vbsyn gsyn
X_ihx_12_4 a_xp12 a_xn12 wp_ih_12_4 wn_ih_12_4 xhp4 xhn4 vdd vbsyn gsyn
X_ihm_13_4 a_xp13 a_xn13 wp_ih_13_4 wn_ih_13_4 mhp4 mhn4 vdd vbsyn gsyn
X_ihx_13_4 a_xp13 a_xn13 wp_ih_13_4 wn_ih_13_4 xhp4 xhn4 vdd vbsyn gsyn
X_ihm_14_4 a_xp14 a_xn14 wp_ih_14_4 wn_ih_14_4 mhp4 mhn4 vdd vbsyn gsyn
X_ihx_14_4 a_xp14 a_xn14 wp_ih_14_4 wn_ih_14_4 xhp4 xhn4 vdd vbsyn gsyn
X_ihm_15_4 a_xp15 a_xn15 wp_ih_15_4 wn_ih_15_4 mhp4 mhn4 vdd vbsyn gsyn
X_ihx_15_4 a_xp15 a_xn15 wp_ih_15_4 wn_ih_15_4 xhp4 xhn4 vdd vbsyn gsyn
X_ihm_16_4 a_xp16 a_xn16 wp_ih_16_4 wn_ih_16_4 mhp4 mhn4 vdd vbsyn gsyn
X_ihx_16_4 a_xp16 a_xn16 wp_ih_16_4 wn_ih_16_4 xhp4 xhn4 vdd vbsyn gsyn
X_ihm_17_4 a_xp17 a_xn17 wp_ih_17_4 wn_ih_17_4 mhp4 mhn4 vdd vbsyn gsyn
X_ihx_17_4 a_xp17 a_xn17 wp_ih_17_4 wn_ih_17_4 xhp4 xhn4 vdd vbsyn gsyn
X_ihm_18_4 a_xp18 a_xn18 wp_ih_18_4 wn_ih_18_4 mhp4 mhn4 vdd vbsyn gsyn
X_ihx_18_4 a_xp18 a_xn18 wp_ih_18_4 wn_ih_18_4 xhp4 xhn4 vdd vbsyn gsyn
X_ihm_19_4 a_xp19 a_xn19 wp_ih_19_4 wn_ih_19_4 mhp4 mhn4 vdd vbsyn gsyn
X_ihx_19_4 a_xp19 a_xn19 wp_ih_19_4 wn_ih_19_4 xhp4 xhn4 vdd vbsyn gsyn
X_ihm_20_4 a_xp20 a_xn20 wp_ih_20_4 wn_ih_20_4 mhp4 mhn4 vdd vbsyn gsyn
X_ihx_20_4 a_xp20 a_xn20 wp_ih_20_4 wn_ih_20_4 xhp4 xhn4 vdd vbsyn gsyn
X_ihm_21_4 a_xp21 a_xn21 wp_ih_21_4 wn_ih_21_4 mhp4 mhn4 vdd vbsyn gsyn
X_ihx_21_4 a_xp21 a_xn21 wp_ih_21_4 wn_ih_21_4 xhp4 xhn4 vdd vbsyn gsyn
X_ihm_22_4 a_xp22 a_xn22 wp_ih_22_4 wn_ih_22_4 mhp4 mhn4 vdd vbsyn gsyn
X_ihx_22_4 a_xp22 a_xn22 wp_ih_22_4 wn_ih_22_4 xhp4 xhn4 vdd vbsyn gsyn
X_ihm_23_4 a_xp23 a_xn23 wp_ih_23_4 wn_ih_23_4 mhp4 mhn4 vdd vbsyn gsyn
X_ihx_23_4 a_xp23 a_xn23 wp_ih_23_4 wn_ih_23_4 xhp4 xhn4 vdd vbsyn gsyn
X_ihm_24_4 a_xp24 a_xn24 wp_ih_24_4 wn_ih_24_4 mhp4 mhn4 vdd vbsyn gsyn
X_ihx_24_4 a_xp24 a_xn24 wp_ih_24_4 wn_ih_24_4 xhp4 xhn4 vdd vbsyn gsyn
X_ihm_25_4 a_xp25 a_xn25 wp_ih_25_4 wn_ih_25_4 mhp4 mhn4 vdd vbsyn gsyn
X_ihx_25_4 a_xp25 a_xn25 wp_ih_25_4 wn_ih_25_4 xhp4 xhn4 vdd vbsyn gsyn
X_ihm_26_4 a_xp26 a_xn26 wp_ih_26_4 wn_ih_26_4 mhp4 mhn4 vdd vbsyn gsyn
X_ihx_26_4 a_xp26 a_xn26 wp_ih_26_4 wn_ih_26_4 xhp4 xhn4 vdd vbsyn gsyn
X_ihm_27_4 a_xp27 a_xn27 wp_ih_27_4 wn_ih_27_4 mhp4 mhn4 vdd vbsyn gsyn
X_ihx_27_4 a_xp27 a_xn27 wp_ih_27_4 wn_ih_27_4 xhp4 xhn4 vdd vbsyn gsyn
X_ihm_28_4 a_xp28 a_xn28 wp_ih_28_4 wn_ih_28_4 mhp4 mhn4 vdd vbsyn gsyn
X_ihx_28_4 a_xp28 a_xn28 wp_ih_28_4 wn_ih_28_4 xhp4 xhn4 vdd vbsyn gsyn
X_ihm_29_4 a_xp29 a_xn29 wp_ih_29_4 wn_ih_29_4 mhp4 mhn4 vdd vbsyn gsyn
X_ihx_29_4 a_xp29 a_xn29 wp_ih_29_4 wn_ih_29_4 xhp4 xhn4 vdd vbsyn gsyn
X_ihm_30_4 a_xp30 a_xn30 wp_ih_30_4 wn_ih_30_4 mhp4 mhn4 vdd vbsyn gsyn
X_ihx_30_4 a_xp30 a_xn30 wp_ih_30_4 wn_ih_30_4 xhp4 xhn4 vdd vbsyn gsyn
X_ihm_31_4 a_xp31 a_xn31 wp_ih_31_4 wn_ih_31_4 mhp4 mhn4 vdd vbsyn gsyn
X_ihx_31_4 a_xp31 a_xn31 wp_ih_31_4 wn_ih_31_4 xhp4 xhn4 vdd vbsyn gsyn
X_ihm_32_4 a_xp32 a_xn32 wp_ih_32_4 wn_ih_32_4 mhp4 mhn4 vdd vbsyn gsyn
X_ihx_32_4 a_xp32 a_xn32 wp_ih_32_4 wn_ih_32_4 xhp4 xhn4 vdd vbsyn gsyn
X_ihm_33_4 a_xp33 a_xn33 wp_ih_33_4 wn_ih_33_4 mhp4 mhn4 vdd vbsyn gsyn
X_ihx_33_4 a_xp33 a_xn33 wp_ih_33_4 wn_ih_33_4 xhp4 xhn4 vdd vbsyn gsyn
X_ihm_34_4 a_xp34 a_xn34 wp_ih_34_4 wn_ih_34_4 mhp4 mhn4 vdd vbsyn gsyn
X_ihx_34_4 a_xp34 a_xn34 wp_ih_34_4 wn_ih_34_4 xhp4 xhn4 vdd vbsyn gsyn
X_ihm_35_4 a_xp35 a_xn35 wp_ih_35_4 wn_ih_35_4 mhp4 mhn4 vdd vbsyn gsyn
X_ihx_35_4 a_xp35 a_xn35 wp_ih_35_4 wn_ih_35_4 xhp4 xhn4 vdd vbsyn gsyn
X_ihm_36_4 a_xp36 a_xn36 wp_ih_36_4 wn_ih_36_4 mhp4 mhn4 vdd vbsyn gsyn
X_ihx_36_4 a_xp36 a_xn36 wp_ih_36_4 wn_ih_36_4 xhp4 xhn4 vdd vbsyn gsyn
X_ihm_37_4 a_xp37 a_xn37 wp_ih_37_4 wn_ih_37_4 mhp4 mhn4 vdd vbsyn gsyn
X_ihx_37_4 a_xp37 a_xn37 wp_ih_37_4 wn_ih_37_4 xhp4 xhn4 vdd vbsyn gsyn
X_ihm_38_4 a_xp38 a_xn38 wp_ih_38_4 wn_ih_38_4 mhp4 mhn4 vdd vbsyn gsyn
X_ihx_38_4 a_xp38 a_xn38 wp_ih_38_4 wn_ih_38_4 xhp4 xhn4 vdd vbsyn gsyn
X_ihm_39_4 a_xp39 a_xn39 wp_ih_39_4 wn_ih_39_4 mhp4 mhn4 vdd vbsyn gsyn
X_ihx_39_4 a_xp39 a_xn39 wp_ih_39_4 wn_ih_39_4 xhp4 xhn4 vdd vbsyn gsyn
X_ihm_40_4 a_xp40 a_xn40 wp_ih_40_4 wn_ih_40_4 mhp4 mhn4 vdd vbsyn gsyn
X_ihx_40_4 a_xp40 a_xn40 wp_ih_40_4 wn_ih_40_4 xhp4 xhn4 vdd vbsyn gsyn
X_ihm_41_4 a_xp41 a_xn41 wp_ih_41_4 wn_ih_41_4 mhp4 mhn4 vdd vbsyn gsyn
X_ihx_41_4 a_xp41 a_xn41 wp_ih_41_4 wn_ih_41_4 xhp4 xhn4 vdd vbsyn gsyn
X_ihm_42_4 a_xp42 a_xn42 wp_ih_42_4 wn_ih_42_4 mhp4 mhn4 vdd vbsyn gsyn
X_ihx_42_4 a_xp42 a_xn42 wp_ih_42_4 wn_ih_42_4 xhp4 xhn4 vdd vbsyn gsyn
X_ihm_43_4 a_xp43 a_xn43 wp_ih_43_4 wn_ih_43_4 mhp4 mhn4 vdd vbsyn gsyn
X_ihx_43_4 a_xp43 a_xn43 wp_ih_43_4 wn_ih_43_4 xhp4 xhn4 vdd vbsyn gsyn
X_ihm_44_4 a_xp44 a_xn44 wp_ih_44_4 wn_ih_44_4 mhp4 mhn4 vdd vbsyn gsyn
X_ihx_44_4 a_xp44 a_xn44 wp_ih_44_4 wn_ih_44_4 xhp4 xhn4 vdd vbsyn gsyn
X_ihm_45_4 a_xp45 a_xn45 wp_ih_45_4 wn_ih_45_4 mhp4 mhn4 vdd vbsyn gsyn
X_ihx_45_4 a_xp45 a_xn45 wp_ih_45_4 wn_ih_45_4 xhp4 xhn4 vdd vbsyn gsyn
X_ihm_46_4 a_xp46 a_xn46 wp_ih_46_4 wn_ih_46_4 mhp4 mhn4 vdd vbsyn gsyn
X_ihx_46_4 a_xp46 a_xn46 wp_ih_46_4 wn_ih_46_4 xhp4 xhn4 vdd vbsyn gsyn
X_ihm_47_4 a_xp47 a_xn47 wp_ih_47_4 wn_ih_47_4 mhp4 mhn4 vdd vbsyn gsyn
X_ihx_47_4 a_xp47 a_xn47 wp_ih_47_4 wn_ih_47_4 xhp4 xhn4 vdd vbsyn gsyn
X_ihm_48_4 a_xp48 a_xn48 wp_ih_48_4 wn_ih_48_4 mhp4 mhn4 vdd vbsyn gsyn
X_ihx_48_4 a_xp48 a_xn48 wp_ih_48_4 wn_ih_48_4 xhp4 xhn4 vdd vbsyn gsyn
X_ihm_49_4 a_xp49 a_xn49 wp_ih_49_4 wn_ih_49_4 mhp4 mhn4 vdd vbsyn gsyn
X_ihx_49_4 a_xp49 a_xn49 wp_ih_49_4 wn_ih_49_4 xhp4 xhn4 vdd vbsyn gsyn
X_ihm_50_4 a_xp50 a_xn50 wp_ih_50_4 wn_ih_50_4 mhp4 mhn4 vdd vbsyn gsyn
X_ihx_50_4 a_xp50 a_xn50 wp_ih_50_4 wn_ih_50_4 xhp4 xhn4 vdd vbsyn gsyn
X_ihm_51_4 a_xp51 a_xn51 wp_ih_51_4 wn_ih_51_4 mhp4 mhn4 vdd vbsyn gsyn
X_ihx_51_4 a_xp51 a_xn51 wp_ih_51_4 wn_ih_51_4 xhp4 xhn4 vdd vbsyn gsyn
X_ihm_52_4 a_xp52 a_xn52 wp_ih_52_4 wn_ih_52_4 mhp4 mhn4 vdd vbsyn gsyn
X_ihx_52_4 a_xp52 a_xn52 wp_ih_52_4 wn_ih_52_4 xhp4 xhn4 vdd vbsyn gsyn
X_ihm_53_4 a_xp53 a_xn53 wp_ih_53_4 wn_ih_53_4 mhp4 mhn4 vdd vbsyn gsyn
X_ihx_53_4 a_xp53 a_xn53 wp_ih_53_4 wn_ih_53_4 xhp4 xhn4 vdd vbsyn gsyn
X_ihm_54_4 a_xp54 a_xn54 wp_ih_54_4 wn_ih_54_4 mhp4 mhn4 vdd vbsyn gsyn
X_ihx_54_4 a_xp54 a_xn54 wp_ih_54_4 wn_ih_54_4 xhp4 xhn4 vdd vbsyn gsyn
X_ihm_55_4 a_xp55 a_xn55 wp_ih_55_4 wn_ih_55_4 mhp4 mhn4 vdd vbsyn gsyn
X_ihx_55_4 a_xp55 a_xn55 wp_ih_55_4 wn_ih_55_4 xhp4 xhn4 vdd vbsyn gsyn
X_ihm_56_4 a_xp56 a_xn56 wp_ih_56_4 wn_ih_56_4 mhp4 mhn4 vdd vbsyn gsyn
X_ihx_56_4 a_xp56 a_xn56 wp_ih_56_4 wn_ih_56_4 xhp4 xhn4 vdd vbsyn gsyn
X_ihm_57_4 a_xp57 a_xn57 wp_ih_57_4 wn_ih_57_4 mhp4 mhn4 vdd vbsyn gsyn
X_ihx_57_4 a_xp57 a_xn57 wp_ih_57_4 wn_ih_57_4 xhp4 xhn4 vdd vbsyn gsyn
X_ihm_58_4 a_xp58 a_xn58 wp_ih_58_4 wn_ih_58_4 mhp4 mhn4 vdd vbsyn gsyn
X_ihx_58_4 a_xp58 a_xn58 wp_ih_58_4 wn_ih_58_4 xhp4 xhn4 vdd vbsyn gsyn
X_ihm_59_4 a_xp59 a_xn59 wp_ih_59_4 wn_ih_59_4 mhp4 mhn4 vdd vbsyn gsyn
X_ihx_59_4 a_xp59 a_xn59 wp_ih_59_4 wn_ih_59_4 xhp4 xhn4 vdd vbsyn gsyn
X_ihm_60_4 a_xp60 a_xn60 wp_ih_60_4 wn_ih_60_4 mhp4 mhn4 vdd vbsyn gsyn
X_ihx_60_4 a_xp60 a_xn60 wp_ih_60_4 wn_ih_60_4 xhp4 xhn4 vdd vbsyn gsyn
X_ihm_61_4 a_xp61 a_xn61 wp_ih_61_4 wn_ih_61_4 mhp4 mhn4 vdd vbsyn gsyn
X_ihx_61_4 a_xp61 a_xn61 wp_ih_61_4 wn_ih_61_4 xhp4 xhn4 vdd vbsyn gsyn
X_ihm_62_4 a_xp62 a_xn62 wp_ih_62_4 wn_ih_62_4 mhp4 mhn4 vdd vbsyn gsyn
X_ihx_62_4 a_xp62 a_xn62 wp_ih_62_4 wn_ih_62_4 xhp4 xhn4 vdd vbsyn gsyn
X_ihm_63_4 a_xp63 a_xn63 wp_ih_63_4 wn_ih_63_4 mhp4 mhn4 vdd vbsyn gsyn
X_ihx_63_4 a_xp63 a_xn63 wp_ih_63_4 wn_ih_63_4 xhp4 xhn4 vdd vbsyn gsyn
X_bk_4_0 eop0 eon0 wp_ho_4_0 wn_ho_4_0 xhp4 xhn4 vdd vbbk gsyn
X_bk_4_1 eop1 eon1 wp_ho_4_1 wn_ho_4_1 xhp4 xhn4 vdd vbbk gsyn
X_bk_4_2 eop2 eon2 wp_ho_4_2 wn_ho_4_2 xhp4 xhn4 vdd vbbk gsyn
X_bk_4_3 eop3 eon3 wp_ho_4_3 wn_ho_4_3 xhp4 xhn4 vdd vbbk gsyn
X_bk_4_4 eop4 eon4 wp_ho_4_4 wn_ho_4_4 xhp4 xhn4 vdd vbbk gsyn
Xn4 xhp4 xhn4 ahp4 ahn4 vdd vbneu dneuron
Xeh4 xhp4 xhn4 mhp4 mhn4 ehp4 ehn4 vdd gm esub
Xcm_mh5 mhp5 mhn5 vdd cmld
Rnd_mh5 mhp5 mhn5 20k
Xcm_xh5 xhp5 xhn5 vdd cmld
Rnd_xh5 xhp5 xhn5 20k
X_ihm_0_5 a_xp0 a_xn0 wp_ih_0_5 wn_ih_0_5 mhp5 mhn5 vdd vbsyn gsyn
X_ihx_0_5 a_xp0 a_xn0 wp_ih_0_5 wn_ih_0_5 xhp5 xhn5 vdd vbsyn gsyn
X_ihm_1_5 a_xp1 a_xn1 wp_ih_1_5 wn_ih_1_5 mhp5 mhn5 vdd vbsyn gsyn
X_ihx_1_5 a_xp1 a_xn1 wp_ih_1_5 wn_ih_1_5 xhp5 xhn5 vdd vbsyn gsyn
X_ihm_2_5 a_xp2 a_xn2 wp_ih_2_5 wn_ih_2_5 mhp5 mhn5 vdd vbsyn gsyn
X_ihx_2_5 a_xp2 a_xn2 wp_ih_2_5 wn_ih_2_5 xhp5 xhn5 vdd vbsyn gsyn
X_ihm_3_5 a_xp3 a_xn3 wp_ih_3_5 wn_ih_3_5 mhp5 mhn5 vdd vbsyn gsyn
X_ihx_3_5 a_xp3 a_xn3 wp_ih_3_5 wn_ih_3_5 xhp5 xhn5 vdd vbsyn gsyn
X_ihm_4_5 a_xp4 a_xn4 wp_ih_4_5 wn_ih_4_5 mhp5 mhn5 vdd vbsyn gsyn
X_ihx_4_5 a_xp4 a_xn4 wp_ih_4_5 wn_ih_4_5 xhp5 xhn5 vdd vbsyn gsyn
X_ihm_5_5 a_xp5 a_xn5 wp_ih_5_5 wn_ih_5_5 mhp5 mhn5 vdd vbsyn gsyn
X_ihx_5_5 a_xp5 a_xn5 wp_ih_5_5 wn_ih_5_5 xhp5 xhn5 vdd vbsyn gsyn
X_ihm_6_5 a_xp6 a_xn6 wp_ih_6_5 wn_ih_6_5 mhp5 mhn5 vdd vbsyn gsyn
X_ihx_6_5 a_xp6 a_xn6 wp_ih_6_5 wn_ih_6_5 xhp5 xhn5 vdd vbsyn gsyn
X_ihm_7_5 a_xp7 a_xn7 wp_ih_7_5 wn_ih_7_5 mhp5 mhn5 vdd vbsyn gsyn
X_ihx_7_5 a_xp7 a_xn7 wp_ih_7_5 wn_ih_7_5 xhp5 xhn5 vdd vbsyn gsyn
X_ihm_8_5 a_xp8 a_xn8 wp_ih_8_5 wn_ih_8_5 mhp5 mhn5 vdd vbsyn gsyn
X_ihx_8_5 a_xp8 a_xn8 wp_ih_8_5 wn_ih_8_5 xhp5 xhn5 vdd vbsyn gsyn
X_ihm_9_5 a_xp9 a_xn9 wp_ih_9_5 wn_ih_9_5 mhp5 mhn5 vdd vbsyn gsyn
X_ihx_9_5 a_xp9 a_xn9 wp_ih_9_5 wn_ih_9_5 xhp5 xhn5 vdd vbsyn gsyn
X_ihm_10_5 a_xp10 a_xn10 wp_ih_10_5 wn_ih_10_5 mhp5 mhn5 vdd vbsyn gsyn
X_ihx_10_5 a_xp10 a_xn10 wp_ih_10_5 wn_ih_10_5 xhp5 xhn5 vdd vbsyn gsyn
X_ihm_11_5 a_xp11 a_xn11 wp_ih_11_5 wn_ih_11_5 mhp5 mhn5 vdd vbsyn gsyn
X_ihx_11_5 a_xp11 a_xn11 wp_ih_11_5 wn_ih_11_5 xhp5 xhn5 vdd vbsyn gsyn
X_ihm_12_5 a_xp12 a_xn12 wp_ih_12_5 wn_ih_12_5 mhp5 mhn5 vdd vbsyn gsyn
X_ihx_12_5 a_xp12 a_xn12 wp_ih_12_5 wn_ih_12_5 xhp5 xhn5 vdd vbsyn gsyn
X_ihm_13_5 a_xp13 a_xn13 wp_ih_13_5 wn_ih_13_5 mhp5 mhn5 vdd vbsyn gsyn
X_ihx_13_5 a_xp13 a_xn13 wp_ih_13_5 wn_ih_13_5 xhp5 xhn5 vdd vbsyn gsyn
X_ihm_14_5 a_xp14 a_xn14 wp_ih_14_5 wn_ih_14_5 mhp5 mhn5 vdd vbsyn gsyn
X_ihx_14_5 a_xp14 a_xn14 wp_ih_14_5 wn_ih_14_5 xhp5 xhn5 vdd vbsyn gsyn
X_ihm_15_5 a_xp15 a_xn15 wp_ih_15_5 wn_ih_15_5 mhp5 mhn5 vdd vbsyn gsyn
X_ihx_15_5 a_xp15 a_xn15 wp_ih_15_5 wn_ih_15_5 xhp5 xhn5 vdd vbsyn gsyn
X_ihm_16_5 a_xp16 a_xn16 wp_ih_16_5 wn_ih_16_5 mhp5 mhn5 vdd vbsyn gsyn
X_ihx_16_5 a_xp16 a_xn16 wp_ih_16_5 wn_ih_16_5 xhp5 xhn5 vdd vbsyn gsyn
X_ihm_17_5 a_xp17 a_xn17 wp_ih_17_5 wn_ih_17_5 mhp5 mhn5 vdd vbsyn gsyn
X_ihx_17_5 a_xp17 a_xn17 wp_ih_17_5 wn_ih_17_5 xhp5 xhn5 vdd vbsyn gsyn
X_ihm_18_5 a_xp18 a_xn18 wp_ih_18_5 wn_ih_18_5 mhp5 mhn5 vdd vbsyn gsyn
X_ihx_18_5 a_xp18 a_xn18 wp_ih_18_5 wn_ih_18_5 xhp5 xhn5 vdd vbsyn gsyn
X_ihm_19_5 a_xp19 a_xn19 wp_ih_19_5 wn_ih_19_5 mhp5 mhn5 vdd vbsyn gsyn
X_ihx_19_5 a_xp19 a_xn19 wp_ih_19_5 wn_ih_19_5 xhp5 xhn5 vdd vbsyn gsyn
X_ihm_20_5 a_xp20 a_xn20 wp_ih_20_5 wn_ih_20_5 mhp5 mhn5 vdd vbsyn gsyn
X_ihx_20_5 a_xp20 a_xn20 wp_ih_20_5 wn_ih_20_5 xhp5 xhn5 vdd vbsyn gsyn
X_ihm_21_5 a_xp21 a_xn21 wp_ih_21_5 wn_ih_21_5 mhp5 mhn5 vdd vbsyn gsyn
X_ihx_21_5 a_xp21 a_xn21 wp_ih_21_5 wn_ih_21_5 xhp5 xhn5 vdd vbsyn gsyn
X_ihm_22_5 a_xp22 a_xn22 wp_ih_22_5 wn_ih_22_5 mhp5 mhn5 vdd vbsyn gsyn
X_ihx_22_5 a_xp22 a_xn22 wp_ih_22_5 wn_ih_22_5 xhp5 xhn5 vdd vbsyn gsyn
X_ihm_23_5 a_xp23 a_xn23 wp_ih_23_5 wn_ih_23_5 mhp5 mhn5 vdd vbsyn gsyn
X_ihx_23_5 a_xp23 a_xn23 wp_ih_23_5 wn_ih_23_5 xhp5 xhn5 vdd vbsyn gsyn
X_ihm_24_5 a_xp24 a_xn24 wp_ih_24_5 wn_ih_24_5 mhp5 mhn5 vdd vbsyn gsyn
X_ihx_24_5 a_xp24 a_xn24 wp_ih_24_5 wn_ih_24_5 xhp5 xhn5 vdd vbsyn gsyn
X_ihm_25_5 a_xp25 a_xn25 wp_ih_25_5 wn_ih_25_5 mhp5 mhn5 vdd vbsyn gsyn
X_ihx_25_5 a_xp25 a_xn25 wp_ih_25_5 wn_ih_25_5 xhp5 xhn5 vdd vbsyn gsyn
X_ihm_26_5 a_xp26 a_xn26 wp_ih_26_5 wn_ih_26_5 mhp5 mhn5 vdd vbsyn gsyn
X_ihx_26_5 a_xp26 a_xn26 wp_ih_26_5 wn_ih_26_5 xhp5 xhn5 vdd vbsyn gsyn
X_ihm_27_5 a_xp27 a_xn27 wp_ih_27_5 wn_ih_27_5 mhp5 mhn5 vdd vbsyn gsyn
X_ihx_27_5 a_xp27 a_xn27 wp_ih_27_5 wn_ih_27_5 xhp5 xhn5 vdd vbsyn gsyn
X_ihm_28_5 a_xp28 a_xn28 wp_ih_28_5 wn_ih_28_5 mhp5 mhn5 vdd vbsyn gsyn
X_ihx_28_5 a_xp28 a_xn28 wp_ih_28_5 wn_ih_28_5 xhp5 xhn5 vdd vbsyn gsyn
X_ihm_29_5 a_xp29 a_xn29 wp_ih_29_5 wn_ih_29_5 mhp5 mhn5 vdd vbsyn gsyn
X_ihx_29_5 a_xp29 a_xn29 wp_ih_29_5 wn_ih_29_5 xhp5 xhn5 vdd vbsyn gsyn
X_ihm_30_5 a_xp30 a_xn30 wp_ih_30_5 wn_ih_30_5 mhp5 mhn5 vdd vbsyn gsyn
X_ihx_30_5 a_xp30 a_xn30 wp_ih_30_5 wn_ih_30_5 xhp5 xhn5 vdd vbsyn gsyn
X_ihm_31_5 a_xp31 a_xn31 wp_ih_31_5 wn_ih_31_5 mhp5 mhn5 vdd vbsyn gsyn
X_ihx_31_5 a_xp31 a_xn31 wp_ih_31_5 wn_ih_31_5 xhp5 xhn5 vdd vbsyn gsyn
X_ihm_32_5 a_xp32 a_xn32 wp_ih_32_5 wn_ih_32_5 mhp5 mhn5 vdd vbsyn gsyn
X_ihx_32_5 a_xp32 a_xn32 wp_ih_32_5 wn_ih_32_5 xhp5 xhn5 vdd vbsyn gsyn
X_ihm_33_5 a_xp33 a_xn33 wp_ih_33_5 wn_ih_33_5 mhp5 mhn5 vdd vbsyn gsyn
X_ihx_33_5 a_xp33 a_xn33 wp_ih_33_5 wn_ih_33_5 xhp5 xhn5 vdd vbsyn gsyn
X_ihm_34_5 a_xp34 a_xn34 wp_ih_34_5 wn_ih_34_5 mhp5 mhn5 vdd vbsyn gsyn
X_ihx_34_5 a_xp34 a_xn34 wp_ih_34_5 wn_ih_34_5 xhp5 xhn5 vdd vbsyn gsyn
X_ihm_35_5 a_xp35 a_xn35 wp_ih_35_5 wn_ih_35_5 mhp5 mhn5 vdd vbsyn gsyn
X_ihx_35_5 a_xp35 a_xn35 wp_ih_35_5 wn_ih_35_5 xhp5 xhn5 vdd vbsyn gsyn
X_ihm_36_5 a_xp36 a_xn36 wp_ih_36_5 wn_ih_36_5 mhp5 mhn5 vdd vbsyn gsyn
X_ihx_36_5 a_xp36 a_xn36 wp_ih_36_5 wn_ih_36_5 xhp5 xhn5 vdd vbsyn gsyn
X_ihm_37_5 a_xp37 a_xn37 wp_ih_37_5 wn_ih_37_5 mhp5 mhn5 vdd vbsyn gsyn
X_ihx_37_5 a_xp37 a_xn37 wp_ih_37_5 wn_ih_37_5 xhp5 xhn5 vdd vbsyn gsyn
X_ihm_38_5 a_xp38 a_xn38 wp_ih_38_5 wn_ih_38_5 mhp5 mhn5 vdd vbsyn gsyn
X_ihx_38_5 a_xp38 a_xn38 wp_ih_38_5 wn_ih_38_5 xhp5 xhn5 vdd vbsyn gsyn
X_ihm_39_5 a_xp39 a_xn39 wp_ih_39_5 wn_ih_39_5 mhp5 mhn5 vdd vbsyn gsyn
X_ihx_39_5 a_xp39 a_xn39 wp_ih_39_5 wn_ih_39_5 xhp5 xhn5 vdd vbsyn gsyn
X_ihm_40_5 a_xp40 a_xn40 wp_ih_40_5 wn_ih_40_5 mhp5 mhn5 vdd vbsyn gsyn
X_ihx_40_5 a_xp40 a_xn40 wp_ih_40_5 wn_ih_40_5 xhp5 xhn5 vdd vbsyn gsyn
X_ihm_41_5 a_xp41 a_xn41 wp_ih_41_5 wn_ih_41_5 mhp5 mhn5 vdd vbsyn gsyn
X_ihx_41_5 a_xp41 a_xn41 wp_ih_41_5 wn_ih_41_5 xhp5 xhn5 vdd vbsyn gsyn
X_ihm_42_5 a_xp42 a_xn42 wp_ih_42_5 wn_ih_42_5 mhp5 mhn5 vdd vbsyn gsyn
X_ihx_42_5 a_xp42 a_xn42 wp_ih_42_5 wn_ih_42_5 xhp5 xhn5 vdd vbsyn gsyn
X_ihm_43_5 a_xp43 a_xn43 wp_ih_43_5 wn_ih_43_5 mhp5 mhn5 vdd vbsyn gsyn
X_ihx_43_5 a_xp43 a_xn43 wp_ih_43_5 wn_ih_43_5 xhp5 xhn5 vdd vbsyn gsyn
X_ihm_44_5 a_xp44 a_xn44 wp_ih_44_5 wn_ih_44_5 mhp5 mhn5 vdd vbsyn gsyn
X_ihx_44_5 a_xp44 a_xn44 wp_ih_44_5 wn_ih_44_5 xhp5 xhn5 vdd vbsyn gsyn
X_ihm_45_5 a_xp45 a_xn45 wp_ih_45_5 wn_ih_45_5 mhp5 mhn5 vdd vbsyn gsyn
X_ihx_45_5 a_xp45 a_xn45 wp_ih_45_5 wn_ih_45_5 xhp5 xhn5 vdd vbsyn gsyn
X_ihm_46_5 a_xp46 a_xn46 wp_ih_46_5 wn_ih_46_5 mhp5 mhn5 vdd vbsyn gsyn
X_ihx_46_5 a_xp46 a_xn46 wp_ih_46_5 wn_ih_46_5 xhp5 xhn5 vdd vbsyn gsyn
X_ihm_47_5 a_xp47 a_xn47 wp_ih_47_5 wn_ih_47_5 mhp5 mhn5 vdd vbsyn gsyn
X_ihx_47_5 a_xp47 a_xn47 wp_ih_47_5 wn_ih_47_5 xhp5 xhn5 vdd vbsyn gsyn
X_ihm_48_5 a_xp48 a_xn48 wp_ih_48_5 wn_ih_48_5 mhp5 mhn5 vdd vbsyn gsyn
X_ihx_48_5 a_xp48 a_xn48 wp_ih_48_5 wn_ih_48_5 xhp5 xhn5 vdd vbsyn gsyn
X_ihm_49_5 a_xp49 a_xn49 wp_ih_49_5 wn_ih_49_5 mhp5 mhn5 vdd vbsyn gsyn
X_ihx_49_5 a_xp49 a_xn49 wp_ih_49_5 wn_ih_49_5 xhp5 xhn5 vdd vbsyn gsyn
X_ihm_50_5 a_xp50 a_xn50 wp_ih_50_5 wn_ih_50_5 mhp5 mhn5 vdd vbsyn gsyn
X_ihx_50_5 a_xp50 a_xn50 wp_ih_50_5 wn_ih_50_5 xhp5 xhn5 vdd vbsyn gsyn
X_ihm_51_5 a_xp51 a_xn51 wp_ih_51_5 wn_ih_51_5 mhp5 mhn5 vdd vbsyn gsyn
X_ihx_51_5 a_xp51 a_xn51 wp_ih_51_5 wn_ih_51_5 xhp5 xhn5 vdd vbsyn gsyn
X_ihm_52_5 a_xp52 a_xn52 wp_ih_52_5 wn_ih_52_5 mhp5 mhn5 vdd vbsyn gsyn
X_ihx_52_5 a_xp52 a_xn52 wp_ih_52_5 wn_ih_52_5 xhp5 xhn5 vdd vbsyn gsyn
X_ihm_53_5 a_xp53 a_xn53 wp_ih_53_5 wn_ih_53_5 mhp5 mhn5 vdd vbsyn gsyn
X_ihx_53_5 a_xp53 a_xn53 wp_ih_53_5 wn_ih_53_5 xhp5 xhn5 vdd vbsyn gsyn
X_ihm_54_5 a_xp54 a_xn54 wp_ih_54_5 wn_ih_54_5 mhp5 mhn5 vdd vbsyn gsyn
X_ihx_54_5 a_xp54 a_xn54 wp_ih_54_5 wn_ih_54_5 xhp5 xhn5 vdd vbsyn gsyn
X_ihm_55_5 a_xp55 a_xn55 wp_ih_55_5 wn_ih_55_5 mhp5 mhn5 vdd vbsyn gsyn
X_ihx_55_5 a_xp55 a_xn55 wp_ih_55_5 wn_ih_55_5 xhp5 xhn5 vdd vbsyn gsyn
X_ihm_56_5 a_xp56 a_xn56 wp_ih_56_5 wn_ih_56_5 mhp5 mhn5 vdd vbsyn gsyn
X_ihx_56_5 a_xp56 a_xn56 wp_ih_56_5 wn_ih_56_5 xhp5 xhn5 vdd vbsyn gsyn
X_ihm_57_5 a_xp57 a_xn57 wp_ih_57_5 wn_ih_57_5 mhp5 mhn5 vdd vbsyn gsyn
X_ihx_57_5 a_xp57 a_xn57 wp_ih_57_5 wn_ih_57_5 xhp5 xhn5 vdd vbsyn gsyn
X_ihm_58_5 a_xp58 a_xn58 wp_ih_58_5 wn_ih_58_5 mhp5 mhn5 vdd vbsyn gsyn
X_ihx_58_5 a_xp58 a_xn58 wp_ih_58_5 wn_ih_58_5 xhp5 xhn5 vdd vbsyn gsyn
X_ihm_59_5 a_xp59 a_xn59 wp_ih_59_5 wn_ih_59_5 mhp5 mhn5 vdd vbsyn gsyn
X_ihx_59_5 a_xp59 a_xn59 wp_ih_59_5 wn_ih_59_5 xhp5 xhn5 vdd vbsyn gsyn
X_ihm_60_5 a_xp60 a_xn60 wp_ih_60_5 wn_ih_60_5 mhp5 mhn5 vdd vbsyn gsyn
X_ihx_60_5 a_xp60 a_xn60 wp_ih_60_5 wn_ih_60_5 xhp5 xhn5 vdd vbsyn gsyn
X_ihm_61_5 a_xp61 a_xn61 wp_ih_61_5 wn_ih_61_5 mhp5 mhn5 vdd vbsyn gsyn
X_ihx_61_5 a_xp61 a_xn61 wp_ih_61_5 wn_ih_61_5 xhp5 xhn5 vdd vbsyn gsyn
X_ihm_62_5 a_xp62 a_xn62 wp_ih_62_5 wn_ih_62_5 mhp5 mhn5 vdd vbsyn gsyn
X_ihx_62_5 a_xp62 a_xn62 wp_ih_62_5 wn_ih_62_5 xhp5 xhn5 vdd vbsyn gsyn
X_ihm_63_5 a_xp63 a_xn63 wp_ih_63_5 wn_ih_63_5 mhp5 mhn5 vdd vbsyn gsyn
X_ihx_63_5 a_xp63 a_xn63 wp_ih_63_5 wn_ih_63_5 xhp5 xhn5 vdd vbsyn gsyn
X_bk_5_0 eop0 eon0 wp_ho_5_0 wn_ho_5_0 xhp5 xhn5 vdd vbbk gsyn
X_bk_5_1 eop1 eon1 wp_ho_5_1 wn_ho_5_1 xhp5 xhn5 vdd vbbk gsyn
X_bk_5_2 eop2 eon2 wp_ho_5_2 wn_ho_5_2 xhp5 xhn5 vdd vbbk gsyn
X_bk_5_3 eop3 eon3 wp_ho_5_3 wn_ho_5_3 xhp5 xhn5 vdd vbbk gsyn
X_bk_5_4 eop4 eon4 wp_ho_5_4 wn_ho_5_4 xhp5 xhn5 vdd vbbk gsyn
Xn5 xhp5 xhn5 ahp5 ahn5 vdd vbneu dneuron
Xeh5 xhp5 xhn5 mhp5 mhn5 ehp5 ehn5 vdd gm esub
Xcm_mh6 mhp6 mhn6 vdd cmld
Rnd_mh6 mhp6 mhn6 20k
Xcm_xh6 xhp6 xhn6 vdd cmld
Rnd_xh6 xhp6 xhn6 20k
X_ihm_0_6 a_xp0 a_xn0 wp_ih_0_6 wn_ih_0_6 mhp6 mhn6 vdd vbsyn gsyn
X_ihx_0_6 a_xp0 a_xn0 wp_ih_0_6 wn_ih_0_6 xhp6 xhn6 vdd vbsyn gsyn
X_ihm_1_6 a_xp1 a_xn1 wp_ih_1_6 wn_ih_1_6 mhp6 mhn6 vdd vbsyn gsyn
X_ihx_1_6 a_xp1 a_xn1 wp_ih_1_6 wn_ih_1_6 xhp6 xhn6 vdd vbsyn gsyn
X_ihm_2_6 a_xp2 a_xn2 wp_ih_2_6 wn_ih_2_6 mhp6 mhn6 vdd vbsyn gsyn
X_ihx_2_6 a_xp2 a_xn2 wp_ih_2_6 wn_ih_2_6 xhp6 xhn6 vdd vbsyn gsyn
X_ihm_3_6 a_xp3 a_xn3 wp_ih_3_6 wn_ih_3_6 mhp6 mhn6 vdd vbsyn gsyn
X_ihx_3_6 a_xp3 a_xn3 wp_ih_3_6 wn_ih_3_6 xhp6 xhn6 vdd vbsyn gsyn
X_ihm_4_6 a_xp4 a_xn4 wp_ih_4_6 wn_ih_4_6 mhp6 mhn6 vdd vbsyn gsyn
X_ihx_4_6 a_xp4 a_xn4 wp_ih_4_6 wn_ih_4_6 xhp6 xhn6 vdd vbsyn gsyn
X_ihm_5_6 a_xp5 a_xn5 wp_ih_5_6 wn_ih_5_6 mhp6 mhn6 vdd vbsyn gsyn
X_ihx_5_6 a_xp5 a_xn5 wp_ih_5_6 wn_ih_5_6 xhp6 xhn6 vdd vbsyn gsyn
X_ihm_6_6 a_xp6 a_xn6 wp_ih_6_6 wn_ih_6_6 mhp6 mhn6 vdd vbsyn gsyn
X_ihx_6_6 a_xp6 a_xn6 wp_ih_6_6 wn_ih_6_6 xhp6 xhn6 vdd vbsyn gsyn
X_ihm_7_6 a_xp7 a_xn7 wp_ih_7_6 wn_ih_7_6 mhp6 mhn6 vdd vbsyn gsyn
X_ihx_7_6 a_xp7 a_xn7 wp_ih_7_6 wn_ih_7_6 xhp6 xhn6 vdd vbsyn gsyn
X_ihm_8_6 a_xp8 a_xn8 wp_ih_8_6 wn_ih_8_6 mhp6 mhn6 vdd vbsyn gsyn
X_ihx_8_6 a_xp8 a_xn8 wp_ih_8_6 wn_ih_8_6 xhp6 xhn6 vdd vbsyn gsyn
X_ihm_9_6 a_xp9 a_xn9 wp_ih_9_6 wn_ih_9_6 mhp6 mhn6 vdd vbsyn gsyn
X_ihx_9_6 a_xp9 a_xn9 wp_ih_9_6 wn_ih_9_6 xhp6 xhn6 vdd vbsyn gsyn
X_ihm_10_6 a_xp10 a_xn10 wp_ih_10_6 wn_ih_10_6 mhp6 mhn6 vdd vbsyn gsyn
X_ihx_10_6 a_xp10 a_xn10 wp_ih_10_6 wn_ih_10_6 xhp6 xhn6 vdd vbsyn gsyn
X_ihm_11_6 a_xp11 a_xn11 wp_ih_11_6 wn_ih_11_6 mhp6 mhn6 vdd vbsyn gsyn
X_ihx_11_6 a_xp11 a_xn11 wp_ih_11_6 wn_ih_11_6 xhp6 xhn6 vdd vbsyn gsyn
X_ihm_12_6 a_xp12 a_xn12 wp_ih_12_6 wn_ih_12_6 mhp6 mhn6 vdd vbsyn gsyn
X_ihx_12_6 a_xp12 a_xn12 wp_ih_12_6 wn_ih_12_6 xhp6 xhn6 vdd vbsyn gsyn
X_ihm_13_6 a_xp13 a_xn13 wp_ih_13_6 wn_ih_13_6 mhp6 mhn6 vdd vbsyn gsyn
X_ihx_13_6 a_xp13 a_xn13 wp_ih_13_6 wn_ih_13_6 xhp6 xhn6 vdd vbsyn gsyn
X_ihm_14_6 a_xp14 a_xn14 wp_ih_14_6 wn_ih_14_6 mhp6 mhn6 vdd vbsyn gsyn
X_ihx_14_6 a_xp14 a_xn14 wp_ih_14_6 wn_ih_14_6 xhp6 xhn6 vdd vbsyn gsyn
X_ihm_15_6 a_xp15 a_xn15 wp_ih_15_6 wn_ih_15_6 mhp6 mhn6 vdd vbsyn gsyn
X_ihx_15_6 a_xp15 a_xn15 wp_ih_15_6 wn_ih_15_6 xhp6 xhn6 vdd vbsyn gsyn
X_ihm_16_6 a_xp16 a_xn16 wp_ih_16_6 wn_ih_16_6 mhp6 mhn6 vdd vbsyn gsyn
X_ihx_16_6 a_xp16 a_xn16 wp_ih_16_6 wn_ih_16_6 xhp6 xhn6 vdd vbsyn gsyn
X_ihm_17_6 a_xp17 a_xn17 wp_ih_17_6 wn_ih_17_6 mhp6 mhn6 vdd vbsyn gsyn
X_ihx_17_6 a_xp17 a_xn17 wp_ih_17_6 wn_ih_17_6 xhp6 xhn6 vdd vbsyn gsyn
X_ihm_18_6 a_xp18 a_xn18 wp_ih_18_6 wn_ih_18_6 mhp6 mhn6 vdd vbsyn gsyn
X_ihx_18_6 a_xp18 a_xn18 wp_ih_18_6 wn_ih_18_6 xhp6 xhn6 vdd vbsyn gsyn
X_ihm_19_6 a_xp19 a_xn19 wp_ih_19_6 wn_ih_19_6 mhp6 mhn6 vdd vbsyn gsyn
X_ihx_19_6 a_xp19 a_xn19 wp_ih_19_6 wn_ih_19_6 xhp6 xhn6 vdd vbsyn gsyn
X_ihm_20_6 a_xp20 a_xn20 wp_ih_20_6 wn_ih_20_6 mhp6 mhn6 vdd vbsyn gsyn
X_ihx_20_6 a_xp20 a_xn20 wp_ih_20_6 wn_ih_20_6 xhp6 xhn6 vdd vbsyn gsyn
X_ihm_21_6 a_xp21 a_xn21 wp_ih_21_6 wn_ih_21_6 mhp6 mhn6 vdd vbsyn gsyn
X_ihx_21_6 a_xp21 a_xn21 wp_ih_21_6 wn_ih_21_6 xhp6 xhn6 vdd vbsyn gsyn
X_ihm_22_6 a_xp22 a_xn22 wp_ih_22_6 wn_ih_22_6 mhp6 mhn6 vdd vbsyn gsyn
X_ihx_22_6 a_xp22 a_xn22 wp_ih_22_6 wn_ih_22_6 xhp6 xhn6 vdd vbsyn gsyn
X_ihm_23_6 a_xp23 a_xn23 wp_ih_23_6 wn_ih_23_6 mhp6 mhn6 vdd vbsyn gsyn
X_ihx_23_6 a_xp23 a_xn23 wp_ih_23_6 wn_ih_23_6 xhp6 xhn6 vdd vbsyn gsyn
X_ihm_24_6 a_xp24 a_xn24 wp_ih_24_6 wn_ih_24_6 mhp6 mhn6 vdd vbsyn gsyn
X_ihx_24_6 a_xp24 a_xn24 wp_ih_24_6 wn_ih_24_6 xhp6 xhn6 vdd vbsyn gsyn
X_ihm_25_6 a_xp25 a_xn25 wp_ih_25_6 wn_ih_25_6 mhp6 mhn6 vdd vbsyn gsyn
X_ihx_25_6 a_xp25 a_xn25 wp_ih_25_6 wn_ih_25_6 xhp6 xhn6 vdd vbsyn gsyn
X_ihm_26_6 a_xp26 a_xn26 wp_ih_26_6 wn_ih_26_6 mhp6 mhn6 vdd vbsyn gsyn
X_ihx_26_6 a_xp26 a_xn26 wp_ih_26_6 wn_ih_26_6 xhp6 xhn6 vdd vbsyn gsyn
X_ihm_27_6 a_xp27 a_xn27 wp_ih_27_6 wn_ih_27_6 mhp6 mhn6 vdd vbsyn gsyn
X_ihx_27_6 a_xp27 a_xn27 wp_ih_27_6 wn_ih_27_6 xhp6 xhn6 vdd vbsyn gsyn
X_ihm_28_6 a_xp28 a_xn28 wp_ih_28_6 wn_ih_28_6 mhp6 mhn6 vdd vbsyn gsyn
X_ihx_28_6 a_xp28 a_xn28 wp_ih_28_6 wn_ih_28_6 xhp6 xhn6 vdd vbsyn gsyn
X_ihm_29_6 a_xp29 a_xn29 wp_ih_29_6 wn_ih_29_6 mhp6 mhn6 vdd vbsyn gsyn
X_ihx_29_6 a_xp29 a_xn29 wp_ih_29_6 wn_ih_29_6 xhp6 xhn6 vdd vbsyn gsyn
X_ihm_30_6 a_xp30 a_xn30 wp_ih_30_6 wn_ih_30_6 mhp6 mhn6 vdd vbsyn gsyn
X_ihx_30_6 a_xp30 a_xn30 wp_ih_30_6 wn_ih_30_6 xhp6 xhn6 vdd vbsyn gsyn
X_ihm_31_6 a_xp31 a_xn31 wp_ih_31_6 wn_ih_31_6 mhp6 mhn6 vdd vbsyn gsyn
X_ihx_31_6 a_xp31 a_xn31 wp_ih_31_6 wn_ih_31_6 xhp6 xhn6 vdd vbsyn gsyn
X_ihm_32_6 a_xp32 a_xn32 wp_ih_32_6 wn_ih_32_6 mhp6 mhn6 vdd vbsyn gsyn
X_ihx_32_6 a_xp32 a_xn32 wp_ih_32_6 wn_ih_32_6 xhp6 xhn6 vdd vbsyn gsyn
X_ihm_33_6 a_xp33 a_xn33 wp_ih_33_6 wn_ih_33_6 mhp6 mhn6 vdd vbsyn gsyn
X_ihx_33_6 a_xp33 a_xn33 wp_ih_33_6 wn_ih_33_6 xhp6 xhn6 vdd vbsyn gsyn
X_ihm_34_6 a_xp34 a_xn34 wp_ih_34_6 wn_ih_34_6 mhp6 mhn6 vdd vbsyn gsyn
X_ihx_34_6 a_xp34 a_xn34 wp_ih_34_6 wn_ih_34_6 xhp6 xhn6 vdd vbsyn gsyn
X_ihm_35_6 a_xp35 a_xn35 wp_ih_35_6 wn_ih_35_6 mhp6 mhn6 vdd vbsyn gsyn
X_ihx_35_6 a_xp35 a_xn35 wp_ih_35_6 wn_ih_35_6 xhp6 xhn6 vdd vbsyn gsyn
X_ihm_36_6 a_xp36 a_xn36 wp_ih_36_6 wn_ih_36_6 mhp6 mhn6 vdd vbsyn gsyn
X_ihx_36_6 a_xp36 a_xn36 wp_ih_36_6 wn_ih_36_6 xhp6 xhn6 vdd vbsyn gsyn
X_ihm_37_6 a_xp37 a_xn37 wp_ih_37_6 wn_ih_37_6 mhp6 mhn6 vdd vbsyn gsyn
X_ihx_37_6 a_xp37 a_xn37 wp_ih_37_6 wn_ih_37_6 xhp6 xhn6 vdd vbsyn gsyn
X_ihm_38_6 a_xp38 a_xn38 wp_ih_38_6 wn_ih_38_6 mhp6 mhn6 vdd vbsyn gsyn
X_ihx_38_6 a_xp38 a_xn38 wp_ih_38_6 wn_ih_38_6 xhp6 xhn6 vdd vbsyn gsyn
X_ihm_39_6 a_xp39 a_xn39 wp_ih_39_6 wn_ih_39_6 mhp6 mhn6 vdd vbsyn gsyn
X_ihx_39_6 a_xp39 a_xn39 wp_ih_39_6 wn_ih_39_6 xhp6 xhn6 vdd vbsyn gsyn
X_ihm_40_6 a_xp40 a_xn40 wp_ih_40_6 wn_ih_40_6 mhp6 mhn6 vdd vbsyn gsyn
X_ihx_40_6 a_xp40 a_xn40 wp_ih_40_6 wn_ih_40_6 xhp6 xhn6 vdd vbsyn gsyn
X_ihm_41_6 a_xp41 a_xn41 wp_ih_41_6 wn_ih_41_6 mhp6 mhn6 vdd vbsyn gsyn
X_ihx_41_6 a_xp41 a_xn41 wp_ih_41_6 wn_ih_41_6 xhp6 xhn6 vdd vbsyn gsyn
X_ihm_42_6 a_xp42 a_xn42 wp_ih_42_6 wn_ih_42_6 mhp6 mhn6 vdd vbsyn gsyn
X_ihx_42_6 a_xp42 a_xn42 wp_ih_42_6 wn_ih_42_6 xhp6 xhn6 vdd vbsyn gsyn
X_ihm_43_6 a_xp43 a_xn43 wp_ih_43_6 wn_ih_43_6 mhp6 mhn6 vdd vbsyn gsyn
X_ihx_43_6 a_xp43 a_xn43 wp_ih_43_6 wn_ih_43_6 xhp6 xhn6 vdd vbsyn gsyn
X_ihm_44_6 a_xp44 a_xn44 wp_ih_44_6 wn_ih_44_6 mhp6 mhn6 vdd vbsyn gsyn
X_ihx_44_6 a_xp44 a_xn44 wp_ih_44_6 wn_ih_44_6 xhp6 xhn6 vdd vbsyn gsyn
X_ihm_45_6 a_xp45 a_xn45 wp_ih_45_6 wn_ih_45_6 mhp6 mhn6 vdd vbsyn gsyn
X_ihx_45_6 a_xp45 a_xn45 wp_ih_45_6 wn_ih_45_6 xhp6 xhn6 vdd vbsyn gsyn
X_ihm_46_6 a_xp46 a_xn46 wp_ih_46_6 wn_ih_46_6 mhp6 mhn6 vdd vbsyn gsyn
X_ihx_46_6 a_xp46 a_xn46 wp_ih_46_6 wn_ih_46_6 xhp6 xhn6 vdd vbsyn gsyn
X_ihm_47_6 a_xp47 a_xn47 wp_ih_47_6 wn_ih_47_6 mhp6 mhn6 vdd vbsyn gsyn
X_ihx_47_6 a_xp47 a_xn47 wp_ih_47_6 wn_ih_47_6 xhp6 xhn6 vdd vbsyn gsyn
X_ihm_48_6 a_xp48 a_xn48 wp_ih_48_6 wn_ih_48_6 mhp6 mhn6 vdd vbsyn gsyn
X_ihx_48_6 a_xp48 a_xn48 wp_ih_48_6 wn_ih_48_6 xhp6 xhn6 vdd vbsyn gsyn
X_ihm_49_6 a_xp49 a_xn49 wp_ih_49_6 wn_ih_49_6 mhp6 mhn6 vdd vbsyn gsyn
X_ihx_49_6 a_xp49 a_xn49 wp_ih_49_6 wn_ih_49_6 xhp6 xhn6 vdd vbsyn gsyn
X_ihm_50_6 a_xp50 a_xn50 wp_ih_50_6 wn_ih_50_6 mhp6 mhn6 vdd vbsyn gsyn
X_ihx_50_6 a_xp50 a_xn50 wp_ih_50_6 wn_ih_50_6 xhp6 xhn6 vdd vbsyn gsyn
X_ihm_51_6 a_xp51 a_xn51 wp_ih_51_6 wn_ih_51_6 mhp6 mhn6 vdd vbsyn gsyn
X_ihx_51_6 a_xp51 a_xn51 wp_ih_51_6 wn_ih_51_6 xhp6 xhn6 vdd vbsyn gsyn
X_ihm_52_6 a_xp52 a_xn52 wp_ih_52_6 wn_ih_52_6 mhp6 mhn6 vdd vbsyn gsyn
X_ihx_52_6 a_xp52 a_xn52 wp_ih_52_6 wn_ih_52_6 xhp6 xhn6 vdd vbsyn gsyn
X_ihm_53_6 a_xp53 a_xn53 wp_ih_53_6 wn_ih_53_6 mhp6 mhn6 vdd vbsyn gsyn
X_ihx_53_6 a_xp53 a_xn53 wp_ih_53_6 wn_ih_53_6 xhp6 xhn6 vdd vbsyn gsyn
X_ihm_54_6 a_xp54 a_xn54 wp_ih_54_6 wn_ih_54_6 mhp6 mhn6 vdd vbsyn gsyn
X_ihx_54_6 a_xp54 a_xn54 wp_ih_54_6 wn_ih_54_6 xhp6 xhn6 vdd vbsyn gsyn
X_ihm_55_6 a_xp55 a_xn55 wp_ih_55_6 wn_ih_55_6 mhp6 mhn6 vdd vbsyn gsyn
X_ihx_55_6 a_xp55 a_xn55 wp_ih_55_6 wn_ih_55_6 xhp6 xhn6 vdd vbsyn gsyn
X_ihm_56_6 a_xp56 a_xn56 wp_ih_56_6 wn_ih_56_6 mhp6 mhn6 vdd vbsyn gsyn
X_ihx_56_6 a_xp56 a_xn56 wp_ih_56_6 wn_ih_56_6 xhp6 xhn6 vdd vbsyn gsyn
X_ihm_57_6 a_xp57 a_xn57 wp_ih_57_6 wn_ih_57_6 mhp6 mhn6 vdd vbsyn gsyn
X_ihx_57_6 a_xp57 a_xn57 wp_ih_57_6 wn_ih_57_6 xhp6 xhn6 vdd vbsyn gsyn
X_ihm_58_6 a_xp58 a_xn58 wp_ih_58_6 wn_ih_58_6 mhp6 mhn6 vdd vbsyn gsyn
X_ihx_58_6 a_xp58 a_xn58 wp_ih_58_6 wn_ih_58_6 xhp6 xhn6 vdd vbsyn gsyn
X_ihm_59_6 a_xp59 a_xn59 wp_ih_59_6 wn_ih_59_6 mhp6 mhn6 vdd vbsyn gsyn
X_ihx_59_6 a_xp59 a_xn59 wp_ih_59_6 wn_ih_59_6 xhp6 xhn6 vdd vbsyn gsyn
X_ihm_60_6 a_xp60 a_xn60 wp_ih_60_6 wn_ih_60_6 mhp6 mhn6 vdd vbsyn gsyn
X_ihx_60_6 a_xp60 a_xn60 wp_ih_60_6 wn_ih_60_6 xhp6 xhn6 vdd vbsyn gsyn
X_ihm_61_6 a_xp61 a_xn61 wp_ih_61_6 wn_ih_61_6 mhp6 mhn6 vdd vbsyn gsyn
X_ihx_61_6 a_xp61 a_xn61 wp_ih_61_6 wn_ih_61_6 xhp6 xhn6 vdd vbsyn gsyn
X_ihm_62_6 a_xp62 a_xn62 wp_ih_62_6 wn_ih_62_6 mhp6 mhn6 vdd vbsyn gsyn
X_ihx_62_6 a_xp62 a_xn62 wp_ih_62_6 wn_ih_62_6 xhp6 xhn6 vdd vbsyn gsyn
X_ihm_63_6 a_xp63 a_xn63 wp_ih_63_6 wn_ih_63_6 mhp6 mhn6 vdd vbsyn gsyn
X_ihx_63_6 a_xp63 a_xn63 wp_ih_63_6 wn_ih_63_6 xhp6 xhn6 vdd vbsyn gsyn
X_bk_6_0 eop0 eon0 wp_ho_6_0 wn_ho_6_0 xhp6 xhn6 vdd vbbk gsyn
X_bk_6_1 eop1 eon1 wp_ho_6_1 wn_ho_6_1 xhp6 xhn6 vdd vbbk gsyn
X_bk_6_2 eop2 eon2 wp_ho_6_2 wn_ho_6_2 xhp6 xhn6 vdd vbbk gsyn
X_bk_6_3 eop3 eon3 wp_ho_6_3 wn_ho_6_3 xhp6 xhn6 vdd vbbk gsyn
X_bk_6_4 eop4 eon4 wp_ho_6_4 wn_ho_6_4 xhp6 xhn6 vdd vbbk gsyn
Xn6 xhp6 xhn6 ahp6 ahn6 vdd vbneu dneuron
Xeh6 xhp6 xhn6 mhp6 mhn6 ehp6 ehn6 vdd gm esub
Xcm_mh7 mhp7 mhn7 vdd cmld
Rnd_mh7 mhp7 mhn7 20k
Xcm_xh7 xhp7 xhn7 vdd cmld
Rnd_xh7 xhp7 xhn7 20k
X_ihm_0_7 a_xp0 a_xn0 wp_ih_0_7 wn_ih_0_7 mhp7 mhn7 vdd vbsyn gsyn
X_ihx_0_7 a_xp0 a_xn0 wp_ih_0_7 wn_ih_0_7 xhp7 xhn7 vdd vbsyn gsyn
X_ihm_1_7 a_xp1 a_xn1 wp_ih_1_7 wn_ih_1_7 mhp7 mhn7 vdd vbsyn gsyn
X_ihx_1_7 a_xp1 a_xn1 wp_ih_1_7 wn_ih_1_7 xhp7 xhn7 vdd vbsyn gsyn
X_ihm_2_7 a_xp2 a_xn2 wp_ih_2_7 wn_ih_2_7 mhp7 mhn7 vdd vbsyn gsyn
X_ihx_2_7 a_xp2 a_xn2 wp_ih_2_7 wn_ih_2_7 xhp7 xhn7 vdd vbsyn gsyn
X_ihm_3_7 a_xp3 a_xn3 wp_ih_3_7 wn_ih_3_7 mhp7 mhn7 vdd vbsyn gsyn
X_ihx_3_7 a_xp3 a_xn3 wp_ih_3_7 wn_ih_3_7 xhp7 xhn7 vdd vbsyn gsyn
X_ihm_4_7 a_xp4 a_xn4 wp_ih_4_7 wn_ih_4_7 mhp7 mhn7 vdd vbsyn gsyn
X_ihx_4_7 a_xp4 a_xn4 wp_ih_4_7 wn_ih_4_7 xhp7 xhn7 vdd vbsyn gsyn
X_ihm_5_7 a_xp5 a_xn5 wp_ih_5_7 wn_ih_5_7 mhp7 mhn7 vdd vbsyn gsyn
X_ihx_5_7 a_xp5 a_xn5 wp_ih_5_7 wn_ih_5_7 xhp7 xhn7 vdd vbsyn gsyn
X_ihm_6_7 a_xp6 a_xn6 wp_ih_6_7 wn_ih_6_7 mhp7 mhn7 vdd vbsyn gsyn
X_ihx_6_7 a_xp6 a_xn6 wp_ih_6_7 wn_ih_6_7 xhp7 xhn7 vdd vbsyn gsyn
X_ihm_7_7 a_xp7 a_xn7 wp_ih_7_7 wn_ih_7_7 mhp7 mhn7 vdd vbsyn gsyn
X_ihx_7_7 a_xp7 a_xn7 wp_ih_7_7 wn_ih_7_7 xhp7 xhn7 vdd vbsyn gsyn
X_ihm_8_7 a_xp8 a_xn8 wp_ih_8_7 wn_ih_8_7 mhp7 mhn7 vdd vbsyn gsyn
X_ihx_8_7 a_xp8 a_xn8 wp_ih_8_7 wn_ih_8_7 xhp7 xhn7 vdd vbsyn gsyn
X_ihm_9_7 a_xp9 a_xn9 wp_ih_9_7 wn_ih_9_7 mhp7 mhn7 vdd vbsyn gsyn
X_ihx_9_7 a_xp9 a_xn9 wp_ih_9_7 wn_ih_9_7 xhp7 xhn7 vdd vbsyn gsyn
X_ihm_10_7 a_xp10 a_xn10 wp_ih_10_7 wn_ih_10_7 mhp7 mhn7 vdd vbsyn gsyn
X_ihx_10_7 a_xp10 a_xn10 wp_ih_10_7 wn_ih_10_7 xhp7 xhn7 vdd vbsyn gsyn
X_ihm_11_7 a_xp11 a_xn11 wp_ih_11_7 wn_ih_11_7 mhp7 mhn7 vdd vbsyn gsyn
X_ihx_11_7 a_xp11 a_xn11 wp_ih_11_7 wn_ih_11_7 xhp7 xhn7 vdd vbsyn gsyn
X_ihm_12_7 a_xp12 a_xn12 wp_ih_12_7 wn_ih_12_7 mhp7 mhn7 vdd vbsyn gsyn
X_ihx_12_7 a_xp12 a_xn12 wp_ih_12_7 wn_ih_12_7 xhp7 xhn7 vdd vbsyn gsyn
X_ihm_13_7 a_xp13 a_xn13 wp_ih_13_7 wn_ih_13_7 mhp7 mhn7 vdd vbsyn gsyn
X_ihx_13_7 a_xp13 a_xn13 wp_ih_13_7 wn_ih_13_7 xhp7 xhn7 vdd vbsyn gsyn
X_ihm_14_7 a_xp14 a_xn14 wp_ih_14_7 wn_ih_14_7 mhp7 mhn7 vdd vbsyn gsyn
X_ihx_14_7 a_xp14 a_xn14 wp_ih_14_7 wn_ih_14_7 xhp7 xhn7 vdd vbsyn gsyn
X_ihm_15_7 a_xp15 a_xn15 wp_ih_15_7 wn_ih_15_7 mhp7 mhn7 vdd vbsyn gsyn
X_ihx_15_7 a_xp15 a_xn15 wp_ih_15_7 wn_ih_15_7 xhp7 xhn7 vdd vbsyn gsyn
X_ihm_16_7 a_xp16 a_xn16 wp_ih_16_7 wn_ih_16_7 mhp7 mhn7 vdd vbsyn gsyn
X_ihx_16_7 a_xp16 a_xn16 wp_ih_16_7 wn_ih_16_7 xhp7 xhn7 vdd vbsyn gsyn
X_ihm_17_7 a_xp17 a_xn17 wp_ih_17_7 wn_ih_17_7 mhp7 mhn7 vdd vbsyn gsyn
X_ihx_17_7 a_xp17 a_xn17 wp_ih_17_7 wn_ih_17_7 xhp7 xhn7 vdd vbsyn gsyn
X_ihm_18_7 a_xp18 a_xn18 wp_ih_18_7 wn_ih_18_7 mhp7 mhn7 vdd vbsyn gsyn
X_ihx_18_7 a_xp18 a_xn18 wp_ih_18_7 wn_ih_18_7 xhp7 xhn7 vdd vbsyn gsyn
X_ihm_19_7 a_xp19 a_xn19 wp_ih_19_7 wn_ih_19_7 mhp7 mhn7 vdd vbsyn gsyn
X_ihx_19_7 a_xp19 a_xn19 wp_ih_19_7 wn_ih_19_7 xhp7 xhn7 vdd vbsyn gsyn
X_ihm_20_7 a_xp20 a_xn20 wp_ih_20_7 wn_ih_20_7 mhp7 mhn7 vdd vbsyn gsyn
X_ihx_20_7 a_xp20 a_xn20 wp_ih_20_7 wn_ih_20_7 xhp7 xhn7 vdd vbsyn gsyn
X_ihm_21_7 a_xp21 a_xn21 wp_ih_21_7 wn_ih_21_7 mhp7 mhn7 vdd vbsyn gsyn
X_ihx_21_7 a_xp21 a_xn21 wp_ih_21_7 wn_ih_21_7 xhp7 xhn7 vdd vbsyn gsyn
X_ihm_22_7 a_xp22 a_xn22 wp_ih_22_7 wn_ih_22_7 mhp7 mhn7 vdd vbsyn gsyn
X_ihx_22_7 a_xp22 a_xn22 wp_ih_22_7 wn_ih_22_7 xhp7 xhn7 vdd vbsyn gsyn
X_ihm_23_7 a_xp23 a_xn23 wp_ih_23_7 wn_ih_23_7 mhp7 mhn7 vdd vbsyn gsyn
X_ihx_23_7 a_xp23 a_xn23 wp_ih_23_7 wn_ih_23_7 xhp7 xhn7 vdd vbsyn gsyn
X_ihm_24_7 a_xp24 a_xn24 wp_ih_24_7 wn_ih_24_7 mhp7 mhn7 vdd vbsyn gsyn
X_ihx_24_7 a_xp24 a_xn24 wp_ih_24_7 wn_ih_24_7 xhp7 xhn7 vdd vbsyn gsyn
X_ihm_25_7 a_xp25 a_xn25 wp_ih_25_7 wn_ih_25_7 mhp7 mhn7 vdd vbsyn gsyn
X_ihx_25_7 a_xp25 a_xn25 wp_ih_25_7 wn_ih_25_7 xhp7 xhn7 vdd vbsyn gsyn
X_ihm_26_7 a_xp26 a_xn26 wp_ih_26_7 wn_ih_26_7 mhp7 mhn7 vdd vbsyn gsyn
X_ihx_26_7 a_xp26 a_xn26 wp_ih_26_7 wn_ih_26_7 xhp7 xhn7 vdd vbsyn gsyn
X_ihm_27_7 a_xp27 a_xn27 wp_ih_27_7 wn_ih_27_7 mhp7 mhn7 vdd vbsyn gsyn
X_ihx_27_7 a_xp27 a_xn27 wp_ih_27_7 wn_ih_27_7 xhp7 xhn7 vdd vbsyn gsyn
X_ihm_28_7 a_xp28 a_xn28 wp_ih_28_7 wn_ih_28_7 mhp7 mhn7 vdd vbsyn gsyn
X_ihx_28_7 a_xp28 a_xn28 wp_ih_28_7 wn_ih_28_7 xhp7 xhn7 vdd vbsyn gsyn
X_ihm_29_7 a_xp29 a_xn29 wp_ih_29_7 wn_ih_29_7 mhp7 mhn7 vdd vbsyn gsyn
X_ihx_29_7 a_xp29 a_xn29 wp_ih_29_7 wn_ih_29_7 xhp7 xhn7 vdd vbsyn gsyn
X_ihm_30_7 a_xp30 a_xn30 wp_ih_30_7 wn_ih_30_7 mhp7 mhn7 vdd vbsyn gsyn
X_ihx_30_7 a_xp30 a_xn30 wp_ih_30_7 wn_ih_30_7 xhp7 xhn7 vdd vbsyn gsyn
X_ihm_31_7 a_xp31 a_xn31 wp_ih_31_7 wn_ih_31_7 mhp7 mhn7 vdd vbsyn gsyn
X_ihx_31_7 a_xp31 a_xn31 wp_ih_31_7 wn_ih_31_7 xhp7 xhn7 vdd vbsyn gsyn
X_ihm_32_7 a_xp32 a_xn32 wp_ih_32_7 wn_ih_32_7 mhp7 mhn7 vdd vbsyn gsyn
X_ihx_32_7 a_xp32 a_xn32 wp_ih_32_7 wn_ih_32_7 xhp7 xhn7 vdd vbsyn gsyn
X_ihm_33_7 a_xp33 a_xn33 wp_ih_33_7 wn_ih_33_7 mhp7 mhn7 vdd vbsyn gsyn
X_ihx_33_7 a_xp33 a_xn33 wp_ih_33_7 wn_ih_33_7 xhp7 xhn7 vdd vbsyn gsyn
X_ihm_34_7 a_xp34 a_xn34 wp_ih_34_7 wn_ih_34_7 mhp7 mhn7 vdd vbsyn gsyn
X_ihx_34_7 a_xp34 a_xn34 wp_ih_34_7 wn_ih_34_7 xhp7 xhn7 vdd vbsyn gsyn
X_ihm_35_7 a_xp35 a_xn35 wp_ih_35_7 wn_ih_35_7 mhp7 mhn7 vdd vbsyn gsyn
X_ihx_35_7 a_xp35 a_xn35 wp_ih_35_7 wn_ih_35_7 xhp7 xhn7 vdd vbsyn gsyn
X_ihm_36_7 a_xp36 a_xn36 wp_ih_36_7 wn_ih_36_7 mhp7 mhn7 vdd vbsyn gsyn
X_ihx_36_7 a_xp36 a_xn36 wp_ih_36_7 wn_ih_36_7 xhp7 xhn7 vdd vbsyn gsyn
X_ihm_37_7 a_xp37 a_xn37 wp_ih_37_7 wn_ih_37_7 mhp7 mhn7 vdd vbsyn gsyn
X_ihx_37_7 a_xp37 a_xn37 wp_ih_37_7 wn_ih_37_7 xhp7 xhn7 vdd vbsyn gsyn
X_ihm_38_7 a_xp38 a_xn38 wp_ih_38_7 wn_ih_38_7 mhp7 mhn7 vdd vbsyn gsyn
X_ihx_38_7 a_xp38 a_xn38 wp_ih_38_7 wn_ih_38_7 xhp7 xhn7 vdd vbsyn gsyn
X_ihm_39_7 a_xp39 a_xn39 wp_ih_39_7 wn_ih_39_7 mhp7 mhn7 vdd vbsyn gsyn
X_ihx_39_7 a_xp39 a_xn39 wp_ih_39_7 wn_ih_39_7 xhp7 xhn7 vdd vbsyn gsyn
X_ihm_40_7 a_xp40 a_xn40 wp_ih_40_7 wn_ih_40_7 mhp7 mhn7 vdd vbsyn gsyn
X_ihx_40_7 a_xp40 a_xn40 wp_ih_40_7 wn_ih_40_7 xhp7 xhn7 vdd vbsyn gsyn
X_ihm_41_7 a_xp41 a_xn41 wp_ih_41_7 wn_ih_41_7 mhp7 mhn7 vdd vbsyn gsyn
X_ihx_41_7 a_xp41 a_xn41 wp_ih_41_7 wn_ih_41_7 xhp7 xhn7 vdd vbsyn gsyn
X_ihm_42_7 a_xp42 a_xn42 wp_ih_42_7 wn_ih_42_7 mhp7 mhn7 vdd vbsyn gsyn
X_ihx_42_7 a_xp42 a_xn42 wp_ih_42_7 wn_ih_42_7 xhp7 xhn7 vdd vbsyn gsyn
X_ihm_43_7 a_xp43 a_xn43 wp_ih_43_7 wn_ih_43_7 mhp7 mhn7 vdd vbsyn gsyn
X_ihx_43_7 a_xp43 a_xn43 wp_ih_43_7 wn_ih_43_7 xhp7 xhn7 vdd vbsyn gsyn
X_ihm_44_7 a_xp44 a_xn44 wp_ih_44_7 wn_ih_44_7 mhp7 mhn7 vdd vbsyn gsyn
X_ihx_44_7 a_xp44 a_xn44 wp_ih_44_7 wn_ih_44_7 xhp7 xhn7 vdd vbsyn gsyn
X_ihm_45_7 a_xp45 a_xn45 wp_ih_45_7 wn_ih_45_7 mhp7 mhn7 vdd vbsyn gsyn
X_ihx_45_7 a_xp45 a_xn45 wp_ih_45_7 wn_ih_45_7 xhp7 xhn7 vdd vbsyn gsyn
X_ihm_46_7 a_xp46 a_xn46 wp_ih_46_7 wn_ih_46_7 mhp7 mhn7 vdd vbsyn gsyn
X_ihx_46_7 a_xp46 a_xn46 wp_ih_46_7 wn_ih_46_7 xhp7 xhn7 vdd vbsyn gsyn
X_ihm_47_7 a_xp47 a_xn47 wp_ih_47_7 wn_ih_47_7 mhp7 mhn7 vdd vbsyn gsyn
X_ihx_47_7 a_xp47 a_xn47 wp_ih_47_7 wn_ih_47_7 xhp7 xhn7 vdd vbsyn gsyn
X_ihm_48_7 a_xp48 a_xn48 wp_ih_48_7 wn_ih_48_7 mhp7 mhn7 vdd vbsyn gsyn
X_ihx_48_7 a_xp48 a_xn48 wp_ih_48_7 wn_ih_48_7 xhp7 xhn7 vdd vbsyn gsyn
X_ihm_49_7 a_xp49 a_xn49 wp_ih_49_7 wn_ih_49_7 mhp7 mhn7 vdd vbsyn gsyn
X_ihx_49_7 a_xp49 a_xn49 wp_ih_49_7 wn_ih_49_7 xhp7 xhn7 vdd vbsyn gsyn
X_ihm_50_7 a_xp50 a_xn50 wp_ih_50_7 wn_ih_50_7 mhp7 mhn7 vdd vbsyn gsyn
X_ihx_50_7 a_xp50 a_xn50 wp_ih_50_7 wn_ih_50_7 xhp7 xhn7 vdd vbsyn gsyn
X_ihm_51_7 a_xp51 a_xn51 wp_ih_51_7 wn_ih_51_7 mhp7 mhn7 vdd vbsyn gsyn
X_ihx_51_7 a_xp51 a_xn51 wp_ih_51_7 wn_ih_51_7 xhp7 xhn7 vdd vbsyn gsyn
X_ihm_52_7 a_xp52 a_xn52 wp_ih_52_7 wn_ih_52_7 mhp7 mhn7 vdd vbsyn gsyn
X_ihx_52_7 a_xp52 a_xn52 wp_ih_52_7 wn_ih_52_7 xhp7 xhn7 vdd vbsyn gsyn
X_ihm_53_7 a_xp53 a_xn53 wp_ih_53_7 wn_ih_53_7 mhp7 mhn7 vdd vbsyn gsyn
X_ihx_53_7 a_xp53 a_xn53 wp_ih_53_7 wn_ih_53_7 xhp7 xhn7 vdd vbsyn gsyn
X_ihm_54_7 a_xp54 a_xn54 wp_ih_54_7 wn_ih_54_7 mhp7 mhn7 vdd vbsyn gsyn
X_ihx_54_7 a_xp54 a_xn54 wp_ih_54_7 wn_ih_54_7 xhp7 xhn7 vdd vbsyn gsyn
X_ihm_55_7 a_xp55 a_xn55 wp_ih_55_7 wn_ih_55_7 mhp7 mhn7 vdd vbsyn gsyn
X_ihx_55_7 a_xp55 a_xn55 wp_ih_55_7 wn_ih_55_7 xhp7 xhn7 vdd vbsyn gsyn
X_ihm_56_7 a_xp56 a_xn56 wp_ih_56_7 wn_ih_56_7 mhp7 mhn7 vdd vbsyn gsyn
X_ihx_56_7 a_xp56 a_xn56 wp_ih_56_7 wn_ih_56_7 xhp7 xhn7 vdd vbsyn gsyn
X_ihm_57_7 a_xp57 a_xn57 wp_ih_57_7 wn_ih_57_7 mhp7 mhn7 vdd vbsyn gsyn
X_ihx_57_7 a_xp57 a_xn57 wp_ih_57_7 wn_ih_57_7 xhp7 xhn7 vdd vbsyn gsyn
X_ihm_58_7 a_xp58 a_xn58 wp_ih_58_7 wn_ih_58_7 mhp7 mhn7 vdd vbsyn gsyn
X_ihx_58_7 a_xp58 a_xn58 wp_ih_58_7 wn_ih_58_7 xhp7 xhn7 vdd vbsyn gsyn
X_ihm_59_7 a_xp59 a_xn59 wp_ih_59_7 wn_ih_59_7 mhp7 mhn7 vdd vbsyn gsyn
X_ihx_59_7 a_xp59 a_xn59 wp_ih_59_7 wn_ih_59_7 xhp7 xhn7 vdd vbsyn gsyn
X_ihm_60_7 a_xp60 a_xn60 wp_ih_60_7 wn_ih_60_7 mhp7 mhn7 vdd vbsyn gsyn
X_ihx_60_7 a_xp60 a_xn60 wp_ih_60_7 wn_ih_60_7 xhp7 xhn7 vdd vbsyn gsyn
X_ihm_61_7 a_xp61 a_xn61 wp_ih_61_7 wn_ih_61_7 mhp7 mhn7 vdd vbsyn gsyn
X_ihx_61_7 a_xp61 a_xn61 wp_ih_61_7 wn_ih_61_7 xhp7 xhn7 vdd vbsyn gsyn
X_ihm_62_7 a_xp62 a_xn62 wp_ih_62_7 wn_ih_62_7 mhp7 mhn7 vdd vbsyn gsyn
X_ihx_62_7 a_xp62 a_xn62 wp_ih_62_7 wn_ih_62_7 xhp7 xhn7 vdd vbsyn gsyn
X_ihm_63_7 a_xp63 a_xn63 wp_ih_63_7 wn_ih_63_7 mhp7 mhn7 vdd vbsyn gsyn
X_ihx_63_7 a_xp63 a_xn63 wp_ih_63_7 wn_ih_63_7 xhp7 xhn7 vdd vbsyn gsyn
X_bk_7_0 eop0 eon0 wp_ho_7_0 wn_ho_7_0 xhp7 xhn7 vdd vbbk gsyn
X_bk_7_1 eop1 eon1 wp_ho_7_1 wn_ho_7_1 xhp7 xhn7 vdd vbbk gsyn
X_bk_7_2 eop2 eon2 wp_ho_7_2 wn_ho_7_2 xhp7 xhn7 vdd vbbk gsyn
X_bk_7_3 eop3 eon3 wp_ho_7_3 wn_ho_7_3 xhp7 xhn7 vdd vbbk gsyn
X_bk_7_4 eop4 eon4 wp_ho_7_4 wn_ho_7_4 xhp7 xhn7 vdd vbbk gsyn
Xn7 xhp7 xhn7 ahp7 ahn7 vdd vbneu dneuron
Xeh7 xhp7 xhn7 mhp7 mhn7 ehp7 ehn7 vdd gm esub
Xcm_mh8 mhp8 mhn8 vdd cmld
Rnd_mh8 mhp8 mhn8 20k
Xcm_xh8 xhp8 xhn8 vdd cmld
Rnd_xh8 xhp8 xhn8 20k
X_ihm_0_8 a_xp0 a_xn0 wp_ih_0_8 wn_ih_0_8 mhp8 mhn8 vdd vbsyn gsyn
X_ihx_0_8 a_xp0 a_xn0 wp_ih_0_8 wn_ih_0_8 xhp8 xhn8 vdd vbsyn gsyn
X_ihm_1_8 a_xp1 a_xn1 wp_ih_1_8 wn_ih_1_8 mhp8 mhn8 vdd vbsyn gsyn
X_ihx_1_8 a_xp1 a_xn1 wp_ih_1_8 wn_ih_1_8 xhp8 xhn8 vdd vbsyn gsyn
X_ihm_2_8 a_xp2 a_xn2 wp_ih_2_8 wn_ih_2_8 mhp8 mhn8 vdd vbsyn gsyn
X_ihx_2_8 a_xp2 a_xn2 wp_ih_2_8 wn_ih_2_8 xhp8 xhn8 vdd vbsyn gsyn
X_ihm_3_8 a_xp3 a_xn3 wp_ih_3_8 wn_ih_3_8 mhp8 mhn8 vdd vbsyn gsyn
X_ihx_3_8 a_xp3 a_xn3 wp_ih_3_8 wn_ih_3_8 xhp8 xhn8 vdd vbsyn gsyn
X_ihm_4_8 a_xp4 a_xn4 wp_ih_4_8 wn_ih_4_8 mhp8 mhn8 vdd vbsyn gsyn
X_ihx_4_8 a_xp4 a_xn4 wp_ih_4_8 wn_ih_4_8 xhp8 xhn8 vdd vbsyn gsyn
X_ihm_5_8 a_xp5 a_xn5 wp_ih_5_8 wn_ih_5_8 mhp8 mhn8 vdd vbsyn gsyn
X_ihx_5_8 a_xp5 a_xn5 wp_ih_5_8 wn_ih_5_8 xhp8 xhn8 vdd vbsyn gsyn
X_ihm_6_8 a_xp6 a_xn6 wp_ih_6_8 wn_ih_6_8 mhp8 mhn8 vdd vbsyn gsyn
X_ihx_6_8 a_xp6 a_xn6 wp_ih_6_8 wn_ih_6_8 xhp8 xhn8 vdd vbsyn gsyn
X_ihm_7_8 a_xp7 a_xn7 wp_ih_7_8 wn_ih_7_8 mhp8 mhn8 vdd vbsyn gsyn
X_ihx_7_8 a_xp7 a_xn7 wp_ih_7_8 wn_ih_7_8 xhp8 xhn8 vdd vbsyn gsyn
X_ihm_8_8 a_xp8 a_xn8 wp_ih_8_8 wn_ih_8_8 mhp8 mhn8 vdd vbsyn gsyn
X_ihx_8_8 a_xp8 a_xn8 wp_ih_8_8 wn_ih_8_8 xhp8 xhn8 vdd vbsyn gsyn
X_ihm_9_8 a_xp9 a_xn9 wp_ih_9_8 wn_ih_9_8 mhp8 mhn8 vdd vbsyn gsyn
X_ihx_9_8 a_xp9 a_xn9 wp_ih_9_8 wn_ih_9_8 xhp8 xhn8 vdd vbsyn gsyn
X_ihm_10_8 a_xp10 a_xn10 wp_ih_10_8 wn_ih_10_8 mhp8 mhn8 vdd vbsyn gsyn
X_ihx_10_8 a_xp10 a_xn10 wp_ih_10_8 wn_ih_10_8 xhp8 xhn8 vdd vbsyn gsyn
X_ihm_11_8 a_xp11 a_xn11 wp_ih_11_8 wn_ih_11_8 mhp8 mhn8 vdd vbsyn gsyn
X_ihx_11_8 a_xp11 a_xn11 wp_ih_11_8 wn_ih_11_8 xhp8 xhn8 vdd vbsyn gsyn
X_ihm_12_8 a_xp12 a_xn12 wp_ih_12_8 wn_ih_12_8 mhp8 mhn8 vdd vbsyn gsyn
X_ihx_12_8 a_xp12 a_xn12 wp_ih_12_8 wn_ih_12_8 xhp8 xhn8 vdd vbsyn gsyn
X_ihm_13_8 a_xp13 a_xn13 wp_ih_13_8 wn_ih_13_8 mhp8 mhn8 vdd vbsyn gsyn
X_ihx_13_8 a_xp13 a_xn13 wp_ih_13_8 wn_ih_13_8 xhp8 xhn8 vdd vbsyn gsyn
X_ihm_14_8 a_xp14 a_xn14 wp_ih_14_8 wn_ih_14_8 mhp8 mhn8 vdd vbsyn gsyn
X_ihx_14_8 a_xp14 a_xn14 wp_ih_14_8 wn_ih_14_8 xhp8 xhn8 vdd vbsyn gsyn
X_ihm_15_8 a_xp15 a_xn15 wp_ih_15_8 wn_ih_15_8 mhp8 mhn8 vdd vbsyn gsyn
X_ihx_15_8 a_xp15 a_xn15 wp_ih_15_8 wn_ih_15_8 xhp8 xhn8 vdd vbsyn gsyn
X_ihm_16_8 a_xp16 a_xn16 wp_ih_16_8 wn_ih_16_8 mhp8 mhn8 vdd vbsyn gsyn
X_ihx_16_8 a_xp16 a_xn16 wp_ih_16_8 wn_ih_16_8 xhp8 xhn8 vdd vbsyn gsyn
X_ihm_17_8 a_xp17 a_xn17 wp_ih_17_8 wn_ih_17_8 mhp8 mhn8 vdd vbsyn gsyn
X_ihx_17_8 a_xp17 a_xn17 wp_ih_17_8 wn_ih_17_8 xhp8 xhn8 vdd vbsyn gsyn
X_ihm_18_8 a_xp18 a_xn18 wp_ih_18_8 wn_ih_18_8 mhp8 mhn8 vdd vbsyn gsyn
X_ihx_18_8 a_xp18 a_xn18 wp_ih_18_8 wn_ih_18_8 xhp8 xhn8 vdd vbsyn gsyn
X_ihm_19_8 a_xp19 a_xn19 wp_ih_19_8 wn_ih_19_8 mhp8 mhn8 vdd vbsyn gsyn
X_ihx_19_8 a_xp19 a_xn19 wp_ih_19_8 wn_ih_19_8 xhp8 xhn8 vdd vbsyn gsyn
X_ihm_20_8 a_xp20 a_xn20 wp_ih_20_8 wn_ih_20_8 mhp8 mhn8 vdd vbsyn gsyn
X_ihx_20_8 a_xp20 a_xn20 wp_ih_20_8 wn_ih_20_8 xhp8 xhn8 vdd vbsyn gsyn
X_ihm_21_8 a_xp21 a_xn21 wp_ih_21_8 wn_ih_21_8 mhp8 mhn8 vdd vbsyn gsyn
X_ihx_21_8 a_xp21 a_xn21 wp_ih_21_8 wn_ih_21_8 xhp8 xhn8 vdd vbsyn gsyn
X_ihm_22_8 a_xp22 a_xn22 wp_ih_22_8 wn_ih_22_8 mhp8 mhn8 vdd vbsyn gsyn
X_ihx_22_8 a_xp22 a_xn22 wp_ih_22_8 wn_ih_22_8 xhp8 xhn8 vdd vbsyn gsyn
X_ihm_23_8 a_xp23 a_xn23 wp_ih_23_8 wn_ih_23_8 mhp8 mhn8 vdd vbsyn gsyn
X_ihx_23_8 a_xp23 a_xn23 wp_ih_23_8 wn_ih_23_8 xhp8 xhn8 vdd vbsyn gsyn
X_ihm_24_8 a_xp24 a_xn24 wp_ih_24_8 wn_ih_24_8 mhp8 mhn8 vdd vbsyn gsyn
X_ihx_24_8 a_xp24 a_xn24 wp_ih_24_8 wn_ih_24_8 xhp8 xhn8 vdd vbsyn gsyn
X_ihm_25_8 a_xp25 a_xn25 wp_ih_25_8 wn_ih_25_8 mhp8 mhn8 vdd vbsyn gsyn
X_ihx_25_8 a_xp25 a_xn25 wp_ih_25_8 wn_ih_25_8 xhp8 xhn8 vdd vbsyn gsyn
X_ihm_26_8 a_xp26 a_xn26 wp_ih_26_8 wn_ih_26_8 mhp8 mhn8 vdd vbsyn gsyn
X_ihx_26_8 a_xp26 a_xn26 wp_ih_26_8 wn_ih_26_8 xhp8 xhn8 vdd vbsyn gsyn
X_ihm_27_8 a_xp27 a_xn27 wp_ih_27_8 wn_ih_27_8 mhp8 mhn8 vdd vbsyn gsyn
X_ihx_27_8 a_xp27 a_xn27 wp_ih_27_8 wn_ih_27_8 xhp8 xhn8 vdd vbsyn gsyn
X_ihm_28_8 a_xp28 a_xn28 wp_ih_28_8 wn_ih_28_8 mhp8 mhn8 vdd vbsyn gsyn
X_ihx_28_8 a_xp28 a_xn28 wp_ih_28_8 wn_ih_28_8 xhp8 xhn8 vdd vbsyn gsyn
X_ihm_29_8 a_xp29 a_xn29 wp_ih_29_8 wn_ih_29_8 mhp8 mhn8 vdd vbsyn gsyn
X_ihx_29_8 a_xp29 a_xn29 wp_ih_29_8 wn_ih_29_8 xhp8 xhn8 vdd vbsyn gsyn
X_ihm_30_8 a_xp30 a_xn30 wp_ih_30_8 wn_ih_30_8 mhp8 mhn8 vdd vbsyn gsyn
X_ihx_30_8 a_xp30 a_xn30 wp_ih_30_8 wn_ih_30_8 xhp8 xhn8 vdd vbsyn gsyn
X_ihm_31_8 a_xp31 a_xn31 wp_ih_31_8 wn_ih_31_8 mhp8 mhn8 vdd vbsyn gsyn
X_ihx_31_8 a_xp31 a_xn31 wp_ih_31_8 wn_ih_31_8 xhp8 xhn8 vdd vbsyn gsyn
X_ihm_32_8 a_xp32 a_xn32 wp_ih_32_8 wn_ih_32_8 mhp8 mhn8 vdd vbsyn gsyn
X_ihx_32_8 a_xp32 a_xn32 wp_ih_32_8 wn_ih_32_8 xhp8 xhn8 vdd vbsyn gsyn
X_ihm_33_8 a_xp33 a_xn33 wp_ih_33_8 wn_ih_33_8 mhp8 mhn8 vdd vbsyn gsyn
X_ihx_33_8 a_xp33 a_xn33 wp_ih_33_8 wn_ih_33_8 xhp8 xhn8 vdd vbsyn gsyn
X_ihm_34_8 a_xp34 a_xn34 wp_ih_34_8 wn_ih_34_8 mhp8 mhn8 vdd vbsyn gsyn
X_ihx_34_8 a_xp34 a_xn34 wp_ih_34_8 wn_ih_34_8 xhp8 xhn8 vdd vbsyn gsyn
X_ihm_35_8 a_xp35 a_xn35 wp_ih_35_8 wn_ih_35_8 mhp8 mhn8 vdd vbsyn gsyn
X_ihx_35_8 a_xp35 a_xn35 wp_ih_35_8 wn_ih_35_8 xhp8 xhn8 vdd vbsyn gsyn
X_ihm_36_8 a_xp36 a_xn36 wp_ih_36_8 wn_ih_36_8 mhp8 mhn8 vdd vbsyn gsyn
X_ihx_36_8 a_xp36 a_xn36 wp_ih_36_8 wn_ih_36_8 xhp8 xhn8 vdd vbsyn gsyn
X_ihm_37_8 a_xp37 a_xn37 wp_ih_37_8 wn_ih_37_8 mhp8 mhn8 vdd vbsyn gsyn
X_ihx_37_8 a_xp37 a_xn37 wp_ih_37_8 wn_ih_37_8 xhp8 xhn8 vdd vbsyn gsyn
X_ihm_38_8 a_xp38 a_xn38 wp_ih_38_8 wn_ih_38_8 mhp8 mhn8 vdd vbsyn gsyn
X_ihx_38_8 a_xp38 a_xn38 wp_ih_38_8 wn_ih_38_8 xhp8 xhn8 vdd vbsyn gsyn
X_ihm_39_8 a_xp39 a_xn39 wp_ih_39_8 wn_ih_39_8 mhp8 mhn8 vdd vbsyn gsyn
X_ihx_39_8 a_xp39 a_xn39 wp_ih_39_8 wn_ih_39_8 xhp8 xhn8 vdd vbsyn gsyn
X_ihm_40_8 a_xp40 a_xn40 wp_ih_40_8 wn_ih_40_8 mhp8 mhn8 vdd vbsyn gsyn
X_ihx_40_8 a_xp40 a_xn40 wp_ih_40_8 wn_ih_40_8 xhp8 xhn8 vdd vbsyn gsyn
X_ihm_41_8 a_xp41 a_xn41 wp_ih_41_8 wn_ih_41_8 mhp8 mhn8 vdd vbsyn gsyn
X_ihx_41_8 a_xp41 a_xn41 wp_ih_41_8 wn_ih_41_8 xhp8 xhn8 vdd vbsyn gsyn
X_ihm_42_8 a_xp42 a_xn42 wp_ih_42_8 wn_ih_42_8 mhp8 mhn8 vdd vbsyn gsyn
X_ihx_42_8 a_xp42 a_xn42 wp_ih_42_8 wn_ih_42_8 xhp8 xhn8 vdd vbsyn gsyn
X_ihm_43_8 a_xp43 a_xn43 wp_ih_43_8 wn_ih_43_8 mhp8 mhn8 vdd vbsyn gsyn
X_ihx_43_8 a_xp43 a_xn43 wp_ih_43_8 wn_ih_43_8 xhp8 xhn8 vdd vbsyn gsyn
X_ihm_44_8 a_xp44 a_xn44 wp_ih_44_8 wn_ih_44_8 mhp8 mhn8 vdd vbsyn gsyn
X_ihx_44_8 a_xp44 a_xn44 wp_ih_44_8 wn_ih_44_8 xhp8 xhn8 vdd vbsyn gsyn
X_ihm_45_8 a_xp45 a_xn45 wp_ih_45_8 wn_ih_45_8 mhp8 mhn8 vdd vbsyn gsyn
X_ihx_45_8 a_xp45 a_xn45 wp_ih_45_8 wn_ih_45_8 xhp8 xhn8 vdd vbsyn gsyn
X_ihm_46_8 a_xp46 a_xn46 wp_ih_46_8 wn_ih_46_8 mhp8 mhn8 vdd vbsyn gsyn
X_ihx_46_8 a_xp46 a_xn46 wp_ih_46_8 wn_ih_46_8 xhp8 xhn8 vdd vbsyn gsyn
X_ihm_47_8 a_xp47 a_xn47 wp_ih_47_8 wn_ih_47_8 mhp8 mhn8 vdd vbsyn gsyn
X_ihx_47_8 a_xp47 a_xn47 wp_ih_47_8 wn_ih_47_8 xhp8 xhn8 vdd vbsyn gsyn
X_ihm_48_8 a_xp48 a_xn48 wp_ih_48_8 wn_ih_48_8 mhp8 mhn8 vdd vbsyn gsyn
X_ihx_48_8 a_xp48 a_xn48 wp_ih_48_8 wn_ih_48_8 xhp8 xhn8 vdd vbsyn gsyn
X_ihm_49_8 a_xp49 a_xn49 wp_ih_49_8 wn_ih_49_8 mhp8 mhn8 vdd vbsyn gsyn
X_ihx_49_8 a_xp49 a_xn49 wp_ih_49_8 wn_ih_49_8 xhp8 xhn8 vdd vbsyn gsyn
X_ihm_50_8 a_xp50 a_xn50 wp_ih_50_8 wn_ih_50_8 mhp8 mhn8 vdd vbsyn gsyn
X_ihx_50_8 a_xp50 a_xn50 wp_ih_50_8 wn_ih_50_8 xhp8 xhn8 vdd vbsyn gsyn
X_ihm_51_8 a_xp51 a_xn51 wp_ih_51_8 wn_ih_51_8 mhp8 mhn8 vdd vbsyn gsyn
X_ihx_51_8 a_xp51 a_xn51 wp_ih_51_8 wn_ih_51_8 xhp8 xhn8 vdd vbsyn gsyn
X_ihm_52_8 a_xp52 a_xn52 wp_ih_52_8 wn_ih_52_8 mhp8 mhn8 vdd vbsyn gsyn
X_ihx_52_8 a_xp52 a_xn52 wp_ih_52_8 wn_ih_52_8 xhp8 xhn8 vdd vbsyn gsyn
X_ihm_53_8 a_xp53 a_xn53 wp_ih_53_8 wn_ih_53_8 mhp8 mhn8 vdd vbsyn gsyn
X_ihx_53_8 a_xp53 a_xn53 wp_ih_53_8 wn_ih_53_8 xhp8 xhn8 vdd vbsyn gsyn
X_ihm_54_8 a_xp54 a_xn54 wp_ih_54_8 wn_ih_54_8 mhp8 mhn8 vdd vbsyn gsyn
X_ihx_54_8 a_xp54 a_xn54 wp_ih_54_8 wn_ih_54_8 xhp8 xhn8 vdd vbsyn gsyn
X_ihm_55_8 a_xp55 a_xn55 wp_ih_55_8 wn_ih_55_8 mhp8 mhn8 vdd vbsyn gsyn
X_ihx_55_8 a_xp55 a_xn55 wp_ih_55_8 wn_ih_55_8 xhp8 xhn8 vdd vbsyn gsyn
X_ihm_56_8 a_xp56 a_xn56 wp_ih_56_8 wn_ih_56_8 mhp8 mhn8 vdd vbsyn gsyn
X_ihx_56_8 a_xp56 a_xn56 wp_ih_56_8 wn_ih_56_8 xhp8 xhn8 vdd vbsyn gsyn
X_ihm_57_8 a_xp57 a_xn57 wp_ih_57_8 wn_ih_57_8 mhp8 mhn8 vdd vbsyn gsyn
X_ihx_57_8 a_xp57 a_xn57 wp_ih_57_8 wn_ih_57_8 xhp8 xhn8 vdd vbsyn gsyn
X_ihm_58_8 a_xp58 a_xn58 wp_ih_58_8 wn_ih_58_8 mhp8 mhn8 vdd vbsyn gsyn
X_ihx_58_8 a_xp58 a_xn58 wp_ih_58_8 wn_ih_58_8 xhp8 xhn8 vdd vbsyn gsyn
X_ihm_59_8 a_xp59 a_xn59 wp_ih_59_8 wn_ih_59_8 mhp8 mhn8 vdd vbsyn gsyn
X_ihx_59_8 a_xp59 a_xn59 wp_ih_59_8 wn_ih_59_8 xhp8 xhn8 vdd vbsyn gsyn
X_ihm_60_8 a_xp60 a_xn60 wp_ih_60_8 wn_ih_60_8 mhp8 mhn8 vdd vbsyn gsyn
X_ihx_60_8 a_xp60 a_xn60 wp_ih_60_8 wn_ih_60_8 xhp8 xhn8 vdd vbsyn gsyn
X_ihm_61_8 a_xp61 a_xn61 wp_ih_61_8 wn_ih_61_8 mhp8 mhn8 vdd vbsyn gsyn
X_ihx_61_8 a_xp61 a_xn61 wp_ih_61_8 wn_ih_61_8 xhp8 xhn8 vdd vbsyn gsyn
X_ihm_62_8 a_xp62 a_xn62 wp_ih_62_8 wn_ih_62_8 mhp8 mhn8 vdd vbsyn gsyn
X_ihx_62_8 a_xp62 a_xn62 wp_ih_62_8 wn_ih_62_8 xhp8 xhn8 vdd vbsyn gsyn
X_ihm_63_8 a_xp63 a_xn63 wp_ih_63_8 wn_ih_63_8 mhp8 mhn8 vdd vbsyn gsyn
X_ihx_63_8 a_xp63 a_xn63 wp_ih_63_8 wn_ih_63_8 xhp8 xhn8 vdd vbsyn gsyn
X_bk_8_0 eop0 eon0 wp_ho_8_0 wn_ho_8_0 xhp8 xhn8 vdd vbbk gsyn
X_bk_8_1 eop1 eon1 wp_ho_8_1 wn_ho_8_1 xhp8 xhn8 vdd vbbk gsyn
X_bk_8_2 eop2 eon2 wp_ho_8_2 wn_ho_8_2 xhp8 xhn8 vdd vbbk gsyn
X_bk_8_3 eop3 eon3 wp_ho_8_3 wn_ho_8_3 xhp8 xhn8 vdd vbbk gsyn
X_bk_8_4 eop4 eon4 wp_ho_8_4 wn_ho_8_4 xhp8 xhn8 vdd vbbk gsyn
Xn8 xhp8 xhn8 ahp8 ahn8 vdd vbneu dneuron
Xeh8 xhp8 xhn8 mhp8 mhn8 ehp8 ehn8 vdd gm esub
Xcm_mh9 mhp9 mhn9 vdd cmld
Rnd_mh9 mhp9 mhn9 20k
Xcm_xh9 xhp9 xhn9 vdd cmld
Rnd_xh9 xhp9 xhn9 20k
X_ihm_0_9 a_xp0 a_xn0 wp_ih_0_9 wn_ih_0_9 mhp9 mhn9 vdd vbsyn gsyn
X_ihx_0_9 a_xp0 a_xn0 wp_ih_0_9 wn_ih_0_9 xhp9 xhn9 vdd vbsyn gsyn
X_ihm_1_9 a_xp1 a_xn1 wp_ih_1_9 wn_ih_1_9 mhp9 mhn9 vdd vbsyn gsyn
X_ihx_1_9 a_xp1 a_xn1 wp_ih_1_9 wn_ih_1_9 xhp9 xhn9 vdd vbsyn gsyn
X_ihm_2_9 a_xp2 a_xn2 wp_ih_2_9 wn_ih_2_9 mhp9 mhn9 vdd vbsyn gsyn
X_ihx_2_9 a_xp2 a_xn2 wp_ih_2_9 wn_ih_2_9 xhp9 xhn9 vdd vbsyn gsyn
X_ihm_3_9 a_xp3 a_xn3 wp_ih_3_9 wn_ih_3_9 mhp9 mhn9 vdd vbsyn gsyn
X_ihx_3_9 a_xp3 a_xn3 wp_ih_3_9 wn_ih_3_9 xhp9 xhn9 vdd vbsyn gsyn
X_ihm_4_9 a_xp4 a_xn4 wp_ih_4_9 wn_ih_4_9 mhp9 mhn9 vdd vbsyn gsyn
X_ihx_4_9 a_xp4 a_xn4 wp_ih_4_9 wn_ih_4_9 xhp9 xhn9 vdd vbsyn gsyn
X_ihm_5_9 a_xp5 a_xn5 wp_ih_5_9 wn_ih_5_9 mhp9 mhn9 vdd vbsyn gsyn
X_ihx_5_9 a_xp5 a_xn5 wp_ih_5_9 wn_ih_5_9 xhp9 xhn9 vdd vbsyn gsyn
X_ihm_6_9 a_xp6 a_xn6 wp_ih_6_9 wn_ih_6_9 mhp9 mhn9 vdd vbsyn gsyn
X_ihx_6_9 a_xp6 a_xn6 wp_ih_6_9 wn_ih_6_9 xhp9 xhn9 vdd vbsyn gsyn
X_ihm_7_9 a_xp7 a_xn7 wp_ih_7_9 wn_ih_7_9 mhp9 mhn9 vdd vbsyn gsyn
X_ihx_7_9 a_xp7 a_xn7 wp_ih_7_9 wn_ih_7_9 xhp9 xhn9 vdd vbsyn gsyn
X_ihm_8_9 a_xp8 a_xn8 wp_ih_8_9 wn_ih_8_9 mhp9 mhn9 vdd vbsyn gsyn
X_ihx_8_9 a_xp8 a_xn8 wp_ih_8_9 wn_ih_8_9 xhp9 xhn9 vdd vbsyn gsyn
X_ihm_9_9 a_xp9 a_xn9 wp_ih_9_9 wn_ih_9_9 mhp9 mhn9 vdd vbsyn gsyn
X_ihx_9_9 a_xp9 a_xn9 wp_ih_9_9 wn_ih_9_9 xhp9 xhn9 vdd vbsyn gsyn
X_ihm_10_9 a_xp10 a_xn10 wp_ih_10_9 wn_ih_10_9 mhp9 mhn9 vdd vbsyn gsyn
X_ihx_10_9 a_xp10 a_xn10 wp_ih_10_9 wn_ih_10_9 xhp9 xhn9 vdd vbsyn gsyn
X_ihm_11_9 a_xp11 a_xn11 wp_ih_11_9 wn_ih_11_9 mhp9 mhn9 vdd vbsyn gsyn
X_ihx_11_9 a_xp11 a_xn11 wp_ih_11_9 wn_ih_11_9 xhp9 xhn9 vdd vbsyn gsyn
X_ihm_12_9 a_xp12 a_xn12 wp_ih_12_9 wn_ih_12_9 mhp9 mhn9 vdd vbsyn gsyn
X_ihx_12_9 a_xp12 a_xn12 wp_ih_12_9 wn_ih_12_9 xhp9 xhn9 vdd vbsyn gsyn
X_ihm_13_9 a_xp13 a_xn13 wp_ih_13_9 wn_ih_13_9 mhp9 mhn9 vdd vbsyn gsyn
X_ihx_13_9 a_xp13 a_xn13 wp_ih_13_9 wn_ih_13_9 xhp9 xhn9 vdd vbsyn gsyn
X_ihm_14_9 a_xp14 a_xn14 wp_ih_14_9 wn_ih_14_9 mhp9 mhn9 vdd vbsyn gsyn
X_ihx_14_9 a_xp14 a_xn14 wp_ih_14_9 wn_ih_14_9 xhp9 xhn9 vdd vbsyn gsyn
X_ihm_15_9 a_xp15 a_xn15 wp_ih_15_9 wn_ih_15_9 mhp9 mhn9 vdd vbsyn gsyn
X_ihx_15_9 a_xp15 a_xn15 wp_ih_15_9 wn_ih_15_9 xhp9 xhn9 vdd vbsyn gsyn
X_ihm_16_9 a_xp16 a_xn16 wp_ih_16_9 wn_ih_16_9 mhp9 mhn9 vdd vbsyn gsyn
X_ihx_16_9 a_xp16 a_xn16 wp_ih_16_9 wn_ih_16_9 xhp9 xhn9 vdd vbsyn gsyn
X_ihm_17_9 a_xp17 a_xn17 wp_ih_17_9 wn_ih_17_9 mhp9 mhn9 vdd vbsyn gsyn
X_ihx_17_9 a_xp17 a_xn17 wp_ih_17_9 wn_ih_17_9 xhp9 xhn9 vdd vbsyn gsyn
X_ihm_18_9 a_xp18 a_xn18 wp_ih_18_9 wn_ih_18_9 mhp9 mhn9 vdd vbsyn gsyn
X_ihx_18_9 a_xp18 a_xn18 wp_ih_18_9 wn_ih_18_9 xhp9 xhn9 vdd vbsyn gsyn
X_ihm_19_9 a_xp19 a_xn19 wp_ih_19_9 wn_ih_19_9 mhp9 mhn9 vdd vbsyn gsyn
X_ihx_19_9 a_xp19 a_xn19 wp_ih_19_9 wn_ih_19_9 xhp9 xhn9 vdd vbsyn gsyn
X_ihm_20_9 a_xp20 a_xn20 wp_ih_20_9 wn_ih_20_9 mhp9 mhn9 vdd vbsyn gsyn
X_ihx_20_9 a_xp20 a_xn20 wp_ih_20_9 wn_ih_20_9 xhp9 xhn9 vdd vbsyn gsyn
X_ihm_21_9 a_xp21 a_xn21 wp_ih_21_9 wn_ih_21_9 mhp9 mhn9 vdd vbsyn gsyn
X_ihx_21_9 a_xp21 a_xn21 wp_ih_21_9 wn_ih_21_9 xhp9 xhn9 vdd vbsyn gsyn
X_ihm_22_9 a_xp22 a_xn22 wp_ih_22_9 wn_ih_22_9 mhp9 mhn9 vdd vbsyn gsyn
X_ihx_22_9 a_xp22 a_xn22 wp_ih_22_9 wn_ih_22_9 xhp9 xhn9 vdd vbsyn gsyn
X_ihm_23_9 a_xp23 a_xn23 wp_ih_23_9 wn_ih_23_9 mhp9 mhn9 vdd vbsyn gsyn
X_ihx_23_9 a_xp23 a_xn23 wp_ih_23_9 wn_ih_23_9 xhp9 xhn9 vdd vbsyn gsyn
X_ihm_24_9 a_xp24 a_xn24 wp_ih_24_9 wn_ih_24_9 mhp9 mhn9 vdd vbsyn gsyn
X_ihx_24_9 a_xp24 a_xn24 wp_ih_24_9 wn_ih_24_9 xhp9 xhn9 vdd vbsyn gsyn
X_ihm_25_9 a_xp25 a_xn25 wp_ih_25_9 wn_ih_25_9 mhp9 mhn9 vdd vbsyn gsyn
X_ihx_25_9 a_xp25 a_xn25 wp_ih_25_9 wn_ih_25_9 xhp9 xhn9 vdd vbsyn gsyn
X_ihm_26_9 a_xp26 a_xn26 wp_ih_26_9 wn_ih_26_9 mhp9 mhn9 vdd vbsyn gsyn
X_ihx_26_9 a_xp26 a_xn26 wp_ih_26_9 wn_ih_26_9 xhp9 xhn9 vdd vbsyn gsyn
X_ihm_27_9 a_xp27 a_xn27 wp_ih_27_9 wn_ih_27_9 mhp9 mhn9 vdd vbsyn gsyn
X_ihx_27_9 a_xp27 a_xn27 wp_ih_27_9 wn_ih_27_9 xhp9 xhn9 vdd vbsyn gsyn
X_ihm_28_9 a_xp28 a_xn28 wp_ih_28_9 wn_ih_28_9 mhp9 mhn9 vdd vbsyn gsyn
X_ihx_28_9 a_xp28 a_xn28 wp_ih_28_9 wn_ih_28_9 xhp9 xhn9 vdd vbsyn gsyn
X_ihm_29_9 a_xp29 a_xn29 wp_ih_29_9 wn_ih_29_9 mhp9 mhn9 vdd vbsyn gsyn
X_ihx_29_9 a_xp29 a_xn29 wp_ih_29_9 wn_ih_29_9 xhp9 xhn9 vdd vbsyn gsyn
X_ihm_30_9 a_xp30 a_xn30 wp_ih_30_9 wn_ih_30_9 mhp9 mhn9 vdd vbsyn gsyn
X_ihx_30_9 a_xp30 a_xn30 wp_ih_30_9 wn_ih_30_9 xhp9 xhn9 vdd vbsyn gsyn
X_ihm_31_9 a_xp31 a_xn31 wp_ih_31_9 wn_ih_31_9 mhp9 mhn9 vdd vbsyn gsyn
X_ihx_31_9 a_xp31 a_xn31 wp_ih_31_9 wn_ih_31_9 xhp9 xhn9 vdd vbsyn gsyn
X_ihm_32_9 a_xp32 a_xn32 wp_ih_32_9 wn_ih_32_9 mhp9 mhn9 vdd vbsyn gsyn
X_ihx_32_9 a_xp32 a_xn32 wp_ih_32_9 wn_ih_32_9 xhp9 xhn9 vdd vbsyn gsyn
X_ihm_33_9 a_xp33 a_xn33 wp_ih_33_9 wn_ih_33_9 mhp9 mhn9 vdd vbsyn gsyn
X_ihx_33_9 a_xp33 a_xn33 wp_ih_33_9 wn_ih_33_9 xhp9 xhn9 vdd vbsyn gsyn
X_ihm_34_9 a_xp34 a_xn34 wp_ih_34_9 wn_ih_34_9 mhp9 mhn9 vdd vbsyn gsyn
X_ihx_34_9 a_xp34 a_xn34 wp_ih_34_9 wn_ih_34_9 xhp9 xhn9 vdd vbsyn gsyn
X_ihm_35_9 a_xp35 a_xn35 wp_ih_35_9 wn_ih_35_9 mhp9 mhn9 vdd vbsyn gsyn
X_ihx_35_9 a_xp35 a_xn35 wp_ih_35_9 wn_ih_35_9 xhp9 xhn9 vdd vbsyn gsyn
X_ihm_36_9 a_xp36 a_xn36 wp_ih_36_9 wn_ih_36_9 mhp9 mhn9 vdd vbsyn gsyn
X_ihx_36_9 a_xp36 a_xn36 wp_ih_36_9 wn_ih_36_9 xhp9 xhn9 vdd vbsyn gsyn
X_ihm_37_9 a_xp37 a_xn37 wp_ih_37_9 wn_ih_37_9 mhp9 mhn9 vdd vbsyn gsyn
X_ihx_37_9 a_xp37 a_xn37 wp_ih_37_9 wn_ih_37_9 xhp9 xhn9 vdd vbsyn gsyn
X_ihm_38_9 a_xp38 a_xn38 wp_ih_38_9 wn_ih_38_9 mhp9 mhn9 vdd vbsyn gsyn
X_ihx_38_9 a_xp38 a_xn38 wp_ih_38_9 wn_ih_38_9 xhp9 xhn9 vdd vbsyn gsyn
X_ihm_39_9 a_xp39 a_xn39 wp_ih_39_9 wn_ih_39_9 mhp9 mhn9 vdd vbsyn gsyn
X_ihx_39_9 a_xp39 a_xn39 wp_ih_39_9 wn_ih_39_9 xhp9 xhn9 vdd vbsyn gsyn
X_ihm_40_9 a_xp40 a_xn40 wp_ih_40_9 wn_ih_40_9 mhp9 mhn9 vdd vbsyn gsyn
X_ihx_40_9 a_xp40 a_xn40 wp_ih_40_9 wn_ih_40_9 xhp9 xhn9 vdd vbsyn gsyn
X_ihm_41_9 a_xp41 a_xn41 wp_ih_41_9 wn_ih_41_9 mhp9 mhn9 vdd vbsyn gsyn
X_ihx_41_9 a_xp41 a_xn41 wp_ih_41_9 wn_ih_41_9 xhp9 xhn9 vdd vbsyn gsyn
X_ihm_42_9 a_xp42 a_xn42 wp_ih_42_9 wn_ih_42_9 mhp9 mhn9 vdd vbsyn gsyn
X_ihx_42_9 a_xp42 a_xn42 wp_ih_42_9 wn_ih_42_9 xhp9 xhn9 vdd vbsyn gsyn
X_ihm_43_9 a_xp43 a_xn43 wp_ih_43_9 wn_ih_43_9 mhp9 mhn9 vdd vbsyn gsyn
X_ihx_43_9 a_xp43 a_xn43 wp_ih_43_9 wn_ih_43_9 xhp9 xhn9 vdd vbsyn gsyn
X_ihm_44_9 a_xp44 a_xn44 wp_ih_44_9 wn_ih_44_9 mhp9 mhn9 vdd vbsyn gsyn
X_ihx_44_9 a_xp44 a_xn44 wp_ih_44_9 wn_ih_44_9 xhp9 xhn9 vdd vbsyn gsyn
X_ihm_45_9 a_xp45 a_xn45 wp_ih_45_9 wn_ih_45_9 mhp9 mhn9 vdd vbsyn gsyn
X_ihx_45_9 a_xp45 a_xn45 wp_ih_45_9 wn_ih_45_9 xhp9 xhn9 vdd vbsyn gsyn
X_ihm_46_9 a_xp46 a_xn46 wp_ih_46_9 wn_ih_46_9 mhp9 mhn9 vdd vbsyn gsyn
X_ihx_46_9 a_xp46 a_xn46 wp_ih_46_9 wn_ih_46_9 xhp9 xhn9 vdd vbsyn gsyn
X_ihm_47_9 a_xp47 a_xn47 wp_ih_47_9 wn_ih_47_9 mhp9 mhn9 vdd vbsyn gsyn
X_ihx_47_9 a_xp47 a_xn47 wp_ih_47_9 wn_ih_47_9 xhp9 xhn9 vdd vbsyn gsyn
X_ihm_48_9 a_xp48 a_xn48 wp_ih_48_9 wn_ih_48_9 mhp9 mhn9 vdd vbsyn gsyn
X_ihx_48_9 a_xp48 a_xn48 wp_ih_48_9 wn_ih_48_9 xhp9 xhn9 vdd vbsyn gsyn
X_ihm_49_9 a_xp49 a_xn49 wp_ih_49_9 wn_ih_49_9 mhp9 mhn9 vdd vbsyn gsyn
X_ihx_49_9 a_xp49 a_xn49 wp_ih_49_9 wn_ih_49_9 xhp9 xhn9 vdd vbsyn gsyn
X_ihm_50_9 a_xp50 a_xn50 wp_ih_50_9 wn_ih_50_9 mhp9 mhn9 vdd vbsyn gsyn
X_ihx_50_9 a_xp50 a_xn50 wp_ih_50_9 wn_ih_50_9 xhp9 xhn9 vdd vbsyn gsyn
X_ihm_51_9 a_xp51 a_xn51 wp_ih_51_9 wn_ih_51_9 mhp9 mhn9 vdd vbsyn gsyn
X_ihx_51_9 a_xp51 a_xn51 wp_ih_51_9 wn_ih_51_9 xhp9 xhn9 vdd vbsyn gsyn
X_ihm_52_9 a_xp52 a_xn52 wp_ih_52_9 wn_ih_52_9 mhp9 mhn9 vdd vbsyn gsyn
X_ihx_52_9 a_xp52 a_xn52 wp_ih_52_9 wn_ih_52_9 xhp9 xhn9 vdd vbsyn gsyn
X_ihm_53_9 a_xp53 a_xn53 wp_ih_53_9 wn_ih_53_9 mhp9 mhn9 vdd vbsyn gsyn
X_ihx_53_9 a_xp53 a_xn53 wp_ih_53_9 wn_ih_53_9 xhp9 xhn9 vdd vbsyn gsyn
X_ihm_54_9 a_xp54 a_xn54 wp_ih_54_9 wn_ih_54_9 mhp9 mhn9 vdd vbsyn gsyn
X_ihx_54_9 a_xp54 a_xn54 wp_ih_54_9 wn_ih_54_9 xhp9 xhn9 vdd vbsyn gsyn
X_ihm_55_9 a_xp55 a_xn55 wp_ih_55_9 wn_ih_55_9 mhp9 mhn9 vdd vbsyn gsyn
X_ihx_55_9 a_xp55 a_xn55 wp_ih_55_9 wn_ih_55_9 xhp9 xhn9 vdd vbsyn gsyn
X_ihm_56_9 a_xp56 a_xn56 wp_ih_56_9 wn_ih_56_9 mhp9 mhn9 vdd vbsyn gsyn
X_ihx_56_9 a_xp56 a_xn56 wp_ih_56_9 wn_ih_56_9 xhp9 xhn9 vdd vbsyn gsyn
X_ihm_57_9 a_xp57 a_xn57 wp_ih_57_9 wn_ih_57_9 mhp9 mhn9 vdd vbsyn gsyn
X_ihx_57_9 a_xp57 a_xn57 wp_ih_57_9 wn_ih_57_9 xhp9 xhn9 vdd vbsyn gsyn
X_ihm_58_9 a_xp58 a_xn58 wp_ih_58_9 wn_ih_58_9 mhp9 mhn9 vdd vbsyn gsyn
X_ihx_58_9 a_xp58 a_xn58 wp_ih_58_9 wn_ih_58_9 xhp9 xhn9 vdd vbsyn gsyn
X_ihm_59_9 a_xp59 a_xn59 wp_ih_59_9 wn_ih_59_9 mhp9 mhn9 vdd vbsyn gsyn
X_ihx_59_9 a_xp59 a_xn59 wp_ih_59_9 wn_ih_59_9 xhp9 xhn9 vdd vbsyn gsyn
X_ihm_60_9 a_xp60 a_xn60 wp_ih_60_9 wn_ih_60_9 mhp9 mhn9 vdd vbsyn gsyn
X_ihx_60_9 a_xp60 a_xn60 wp_ih_60_9 wn_ih_60_9 xhp9 xhn9 vdd vbsyn gsyn
X_ihm_61_9 a_xp61 a_xn61 wp_ih_61_9 wn_ih_61_9 mhp9 mhn9 vdd vbsyn gsyn
X_ihx_61_9 a_xp61 a_xn61 wp_ih_61_9 wn_ih_61_9 xhp9 xhn9 vdd vbsyn gsyn
X_ihm_62_9 a_xp62 a_xn62 wp_ih_62_9 wn_ih_62_9 mhp9 mhn9 vdd vbsyn gsyn
X_ihx_62_9 a_xp62 a_xn62 wp_ih_62_9 wn_ih_62_9 xhp9 xhn9 vdd vbsyn gsyn
X_ihm_63_9 a_xp63 a_xn63 wp_ih_63_9 wn_ih_63_9 mhp9 mhn9 vdd vbsyn gsyn
X_ihx_63_9 a_xp63 a_xn63 wp_ih_63_9 wn_ih_63_9 xhp9 xhn9 vdd vbsyn gsyn
X_bk_9_0 eop0 eon0 wp_ho_9_0 wn_ho_9_0 xhp9 xhn9 vdd vbbk gsyn
X_bk_9_1 eop1 eon1 wp_ho_9_1 wn_ho_9_1 xhp9 xhn9 vdd vbbk gsyn
X_bk_9_2 eop2 eon2 wp_ho_9_2 wn_ho_9_2 xhp9 xhn9 vdd vbbk gsyn
X_bk_9_3 eop3 eon3 wp_ho_9_3 wn_ho_9_3 xhp9 xhn9 vdd vbbk gsyn
X_bk_9_4 eop4 eon4 wp_ho_9_4 wn_ho_9_4 xhp9 xhn9 vdd vbbk gsyn
Xn9 xhp9 xhn9 ahp9 ahn9 vdd vbneu dneuron
Xeh9 xhp9 xhn9 mhp9 mhn9 ehp9 ehn9 vdd gm esub
Xcm_mh10 mhp10 mhn10 vdd cmld
Rnd_mh10 mhp10 mhn10 20k
Xcm_xh10 xhp10 xhn10 vdd cmld
Rnd_xh10 xhp10 xhn10 20k
X_ihm_0_10 a_xp0 a_xn0 wp_ih_0_10 wn_ih_0_10 mhp10 mhn10 vdd vbsyn gsyn
X_ihx_0_10 a_xp0 a_xn0 wp_ih_0_10 wn_ih_0_10 xhp10 xhn10 vdd vbsyn gsyn
X_ihm_1_10 a_xp1 a_xn1 wp_ih_1_10 wn_ih_1_10 mhp10 mhn10 vdd vbsyn gsyn
X_ihx_1_10 a_xp1 a_xn1 wp_ih_1_10 wn_ih_1_10 xhp10 xhn10 vdd vbsyn gsyn
X_ihm_2_10 a_xp2 a_xn2 wp_ih_2_10 wn_ih_2_10 mhp10 mhn10 vdd vbsyn gsyn
X_ihx_2_10 a_xp2 a_xn2 wp_ih_2_10 wn_ih_2_10 xhp10 xhn10 vdd vbsyn gsyn
X_ihm_3_10 a_xp3 a_xn3 wp_ih_3_10 wn_ih_3_10 mhp10 mhn10 vdd vbsyn gsyn
X_ihx_3_10 a_xp3 a_xn3 wp_ih_3_10 wn_ih_3_10 xhp10 xhn10 vdd vbsyn gsyn
X_ihm_4_10 a_xp4 a_xn4 wp_ih_4_10 wn_ih_4_10 mhp10 mhn10 vdd vbsyn gsyn
X_ihx_4_10 a_xp4 a_xn4 wp_ih_4_10 wn_ih_4_10 xhp10 xhn10 vdd vbsyn gsyn
X_ihm_5_10 a_xp5 a_xn5 wp_ih_5_10 wn_ih_5_10 mhp10 mhn10 vdd vbsyn gsyn
X_ihx_5_10 a_xp5 a_xn5 wp_ih_5_10 wn_ih_5_10 xhp10 xhn10 vdd vbsyn gsyn
X_ihm_6_10 a_xp6 a_xn6 wp_ih_6_10 wn_ih_6_10 mhp10 mhn10 vdd vbsyn gsyn
X_ihx_6_10 a_xp6 a_xn6 wp_ih_6_10 wn_ih_6_10 xhp10 xhn10 vdd vbsyn gsyn
X_ihm_7_10 a_xp7 a_xn7 wp_ih_7_10 wn_ih_7_10 mhp10 mhn10 vdd vbsyn gsyn
X_ihx_7_10 a_xp7 a_xn7 wp_ih_7_10 wn_ih_7_10 xhp10 xhn10 vdd vbsyn gsyn
X_ihm_8_10 a_xp8 a_xn8 wp_ih_8_10 wn_ih_8_10 mhp10 mhn10 vdd vbsyn gsyn
X_ihx_8_10 a_xp8 a_xn8 wp_ih_8_10 wn_ih_8_10 xhp10 xhn10 vdd vbsyn gsyn
X_ihm_9_10 a_xp9 a_xn9 wp_ih_9_10 wn_ih_9_10 mhp10 mhn10 vdd vbsyn gsyn
X_ihx_9_10 a_xp9 a_xn9 wp_ih_9_10 wn_ih_9_10 xhp10 xhn10 vdd vbsyn gsyn
X_ihm_10_10 a_xp10 a_xn10 wp_ih_10_10 wn_ih_10_10 mhp10 mhn10 vdd vbsyn gsyn
X_ihx_10_10 a_xp10 a_xn10 wp_ih_10_10 wn_ih_10_10 xhp10 xhn10 vdd vbsyn gsyn
X_ihm_11_10 a_xp11 a_xn11 wp_ih_11_10 wn_ih_11_10 mhp10 mhn10 vdd vbsyn gsyn
X_ihx_11_10 a_xp11 a_xn11 wp_ih_11_10 wn_ih_11_10 xhp10 xhn10 vdd vbsyn gsyn
X_ihm_12_10 a_xp12 a_xn12 wp_ih_12_10 wn_ih_12_10 mhp10 mhn10 vdd vbsyn gsyn
X_ihx_12_10 a_xp12 a_xn12 wp_ih_12_10 wn_ih_12_10 xhp10 xhn10 vdd vbsyn gsyn
X_ihm_13_10 a_xp13 a_xn13 wp_ih_13_10 wn_ih_13_10 mhp10 mhn10 vdd vbsyn gsyn
X_ihx_13_10 a_xp13 a_xn13 wp_ih_13_10 wn_ih_13_10 xhp10 xhn10 vdd vbsyn gsyn
X_ihm_14_10 a_xp14 a_xn14 wp_ih_14_10 wn_ih_14_10 mhp10 mhn10 vdd vbsyn gsyn
X_ihx_14_10 a_xp14 a_xn14 wp_ih_14_10 wn_ih_14_10 xhp10 xhn10 vdd vbsyn gsyn
X_ihm_15_10 a_xp15 a_xn15 wp_ih_15_10 wn_ih_15_10 mhp10 mhn10 vdd vbsyn gsyn
X_ihx_15_10 a_xp15 a_xn15 wp_ih_15_10 wn_ih_15_10 xhp10 xhn10 vdd vbsyn gsyn
X_ihm_16_10 a_xp16 a_xn16 wp_ih_16_10 wn_ih_16_10 mhp10 mhn10 vdd vbsyn gsyn
X_ihx_16_10 a_xp16 a_xn16 wp_ih_16_10 wn_ih_16_10 xhp10 xhn10 vdd vbsyn gsyn
X_ihm_17_10 a_xp17 a_xn17 wp_ih_17_10 wn_ih_17_10 mhp10 mhn10 vdd vbsyn gsyn
X_ihx_17_10 a_xp17 a_xn17 wp_ih_17_10 wn_ih_17_10 xhp10 xhn10 vdd vbsyn gsyn
X_ihm_18_10 a_xp18 a_xn18 wp_ih_18_10 wn_ih_18_10 mhp10 mhn10 vdd vbsyn gsyn
X_ihx_18_10 a_xp18 a_xn18 wp_ih_18_10 wn_ih_18_10 xhp10 xhn10 vdd vbsyn gsyn
X_ihm_19_10 a_xp19 a_xn19 wp_ih_19_10 wn_ih_19_10 mhp10 mhn10 vdd vbsyn gsyn
X_ihx_19_10 a_xp19 a_xn19 wp_ih_19_10 wn_ih_19_10 xhp10 xhn10 vdd vbsyn gsyn
X_ihm_20_10 a_xp20 a_xn20 wp_ih_20_10 wn_ih_20_10 mhp10 mhn10 vdd vbsyn gsyn
X_ihx_20_10 a_xp20 a_xn20 wp_ih_20_10 wn_ih_20_10 xhp10 xhn10 vdd vbsyn gsyn
X_ihm_21_10 a_xp21 a_xn21 wp_ih_21_10 wn_ih_21_10 mhp10 mhn10 vdd vbsyn gsyn
X_ihx_21_10 a_xp21 a_xn21 wp_ih_21_10 wn_ih_21_10 xhp10 xhn10 vdd vbsyn gsyn
X_ihm_22_10 a_xp22 a_xn22 wp_ih_22_10 wn_ih_22_10 mhp10 mhn10 vdd vbsyn gsyn
X_ihx_22_10 a_xp22 a_xn22 wp_ih_22_10 wn_ih_22_10 xhp10 xhn10 vdd vbsyn gsyn
X_ihm_23_10 a_xp23 a_xn23 wp_ih_23_10 wn_ih_23_10 mhp10 mhn10 vdd vbsyn gsyn
X_ihx_23_10 a_xp23 a_xn23 wp_ih_23_10 wn_ih_23_10 xhp10 xhn10 vdd vbsyn gsyn
X_ihm_24_10 a_xp24 a_xn24 wp_ih_24_10 wn_ih_24_10 mhp10 mhn10 vdd vbsyn gsyn
X_ihx_24_10 a_xp24 a_xn24 wp_ih_24_10 wn_ih_24_10 xhp10 xhn10 vdd vbsyn gsyn
X_ihm_25_10 a_xp25 a_xn25 wp_ih_25_10 wn_ih_25_10 mhp10 mhn10 vdd vbsyn gsyn
X_ihx_25_10 a_xp25 a_xn25 wp_ih_25_10 wn_ih_25_10 xhp10 xhn10 vdd vbsyn gsyn
X_ihm_26_10 a_xp26 a_xn26 wp_ih_26_10 wn_ih_26_10 mhp10 mhn10 vdd vbsyn gsyn
X_ihx_26_10 a_xp26 a_xn26 wp_ih_26_10 wn_ih_26_10 xhp10 xhn10 vdd vbsyn gsyn
X_ihm_27_10 a_xp27 a_xn27 wp_ih_27_10 wn_ih_27_10 mhp10 mhn10 vdd vbsyn gsyn
X_ihx_27_10 a_xp27 a_xn27 wp_ih_27_10 wn_ih_27_10 xhp10 xhn10 vdd vbsyn gsyn
X_ihm_28_10 a_xp28 a_xn28 wp_ih_28_10 wn_ih_28_10 mhp10 mhn10 vdd vbsyn gsyn
X_ihx_28_10 a_xp28 a_xn28 wp_ih_28_10 wn_ih_28_10 xhp10 xhn10 vdd vbsyn gsyn
X_ihm_29_10 a_xp29 a_xn29 wp_ih_29_10 wn_ih_29_10 mhp10 mhn10 vdd vbsyn gsyn
X_ihx_29_10 a_xp29 a_xn29 wp_ih_29_10 wn_ih_29_10 xhp10 xhn10 vdd vbsyn gsyn
X_ihm_30_10 a_xp30 a_xn30 wp_ih_30_10 wn_ih_30_10 mhp10 mhn10 vdd vbsyn gsyn
X_ihx_30_10 a_xp30 a_xn30 wp_ih_30_10 wn_ih_30_10 xhp10 xhn10 vdd vbsyn gsyn
X_ihm_31_10 a_xp31 a_xn31 wp_ih_31_10 wn_ih_31_10 mhp10 mhn10 vdd vbsyn gsyn
X_ihx_31_10 a_xp31 a_xn31 wp_ih_31_10 wn_ih_31_10 xhp10 xhn10 vdd vbsyn gsyn
X_ihm_32_10 a_xp32 a_xn32 wp_ih_32_10 wn_ih_32_10 mhp10 mhn10 vdd vbsyn gsyn
X_ihx_32_10 a_xp32 a_xn32 wp_ih_32_10 wn_ih_32_10 xhp10 xhn10 vdd vbsyn gsyn
X_ihm_33_10 a_xp33 a_xn33 wp_ih_33_10 wn_ih_33_10 mhp10 mhn10 vdd vbsyn gsyn
X_ihx_33_10 a_xp33 a_xn33 wp_ih_33_10 wn_ih_33_10 xhp10 xhn10 vdd vbsyn gsyn
X_ihm_34_10 a_xp34 a_xn34 wp_ih_34_10 wn_ih_34_10 mhp10 mhn10 vdd vbsyn gsyn
X_ihx_34_10 a_xp34 a_xn34 wp_ih_34_10 wn_ih_34_10 xhp10 xhn10 vdd vbsyn gsyn
X_ihm_35_10 a_xp35 a_xn35 wp_ih_35_10 wn_ih_35_10 mhp10 mhn10 vdd vbsyn gsyn
X_ihx_35_10 a_xp35 a_xn35 wp_ih_35_10 wn_ih_35_10 xhp10 xhn10 vdd vbsyn gsyn
X_ihm_36_10 a_xp36 a_xn36 wp_ih_36_10 wn_ih_36_10 mhp10 mhn10 vdd vbsyn gsyn
X_ihx_36_10 a_xp36 a_xn36 wp_ih_36_10 wn_ih_36_10 xhp10 xhn10 vdd vbsyn gsyn
X_ihm_37_10 a_xp37 a_xn37 wp_ih_37_10 wn_ih_37_10 mhp10 mhn10 vdd vbsyn gsyn
X_ihx_37_10 a_xp37 a_xn37 wp_ih_37_10 wn_ih_37_10 xhp10 xhn10 vdd vbsyn gsyn
X_ihm_38_10 a_xp38 a_xn38 wp_ih_38_10 wn_ih_38_10 mhp10 mhn10 vdd vbsyn gsyn
X_ihx_38_10 a_xp38 a_xn38 wp_ih_38_10 wn_ih_38_10 xhp10 xhn10 vdd vbsyn gsyn
X_ihm_39_10 a_xp39 a_xn39 wp_ih_39_10 wn_ih_39_10 mhp10 mhn10 vdd vbsyn gsyn
X_ihx_39_10 a_xp39 a_xn39 wp_ih_39_10 wn_ih_39_10 xhp10 xhn10 vdd vbsyn gsyn
X_ihm_40_10 a_xp40 a_xn40 wp_ih_40_10 wn_ih_40_10 mhp10 mhn10 vdd vbsyn gsyn
X_ihx_40_10 a_xp40 a_xn40 wp_ih_40_10 wn_ih_40_10 xhp10 xhn10 vdd vbsyn gsyn
X_ihm_41_10 a_xp41 a_xn41 wp_ih_41_10 wn_ih_41_10 mhp10 mhn10 vdd vbsyn gsyn
X_ihx_41_10 a_xp41 a_xn41 wp_ih_41_10 wn_ih_41_10 xhp10 xhn10 vdd vbsyn gsyn
X_ihm_42_10 a_xp42 a_xn42 wp_ih_42_10 wn_ih_42_10 mhp10 mhn10 vdd vbsyn gsyn
X_ihx_42_10 a_xp42 a_xn42 wp_ih_42_10 wn_ih_42_10 xhp10 xhn10 vdd vbsyn gsyn
X_ihm_43_10 a_xp43 a_xn43 wp_ih_43_10 wn_ih_43_10 mhp10 mhn10 vdd vbsyn gsyn
X_ihx_43_10 a_xp43 a_xn43 wp_ih_43_10 wn_ih_43_10 xhp10 xhn10 vdd vbsyn gsyn
X_ihm_44_10 a_xp44 a_xn44 wp_ih_44_10 wn_ih_44_10 mhp10 mhn10 vdd vbsyn gsyn
X_ihx_44_10 a_xp44 a_xn44 wp_ih_44_10 wn_ih_44_10 xhp10 xhn10 vdd vbsyn gsyn
X_ihm_45_10 a_xp45 a_xn45 wp_ih_45_10 wn_ih_45_10 mhp10 mhn10 vdd vbsyn gsyn
X_ihx_45_10 a_xp45 a_xn45 wp_ih_45_10 wn_ih_45_10 xhp10 xhn10 vdd vbsyn gsyn
X_ihm_46_10 a_xp46 a_xn46 wp_ih_46_10 wn_ih_46_10 mhp10 mhn10 vdd vbsyn gsyn
X_ihx_46_10 a_xp46 a_xn46 wp_ih_46_10 wn_ih_46_10 xhp10 xhn10 vdd vbsyn gsyn
X_ihm_47_10 a_xp47 a_xn47 wp_ih_47_10 wn_ih_47_10 mhp10 mhn10 vdd vbsyn gsyn
X_ihx_47_10 a_xp47 a_xn47 wp_ih_47_10 wn_ih_47_10 xhp10 xhn10 vdd vbsyn gsyn
X_ihm_48_10 a_xp48 a_xn48 wp_ih_48_10 wn_ih_48_10 mhp10 mhn10 vdd vbsyn gsyn
X_ihx_48_10 a_xp48 a_xn48 wp_ih_48_10 wn_ih_48_10 xhp10 xhn10 vdd vbsyn gsyn
X_ihm_49_10 a_xp49 a_xn49 wp_ih_49_10 wn_ih_49_10 mhp10 mhn10 vdd vbsyn gsyn
X_ihx_49_10 a_xp49 a_xn49 wp_ih_49_10 wn_ih_49_10 xhp10 xhn10 vdd vbsyn gsyn
X_ihm_50_10 a_xp50 a_xn50 wp_ih_50_10 wn_ih_50_10 mhp10 mhn10 vdd vbsyn gsyn
X_ihx_50_10 a_xp50 a_xn50 wp_ih_50_10 wn_ih_50_10 xhp10 xhn10 vdd vbsyn gsyn
X_ihm_51_10 a_xp51 a_xn51 wp_ih_51_10 wn_ih_51_10 mhp10 mhn10 vdd vbsyn gsyn
X_ihx_51_10 a_xp51 a_xn51 wp_ih_51_10 wn_ih_51_10 xhp10 xhn10 vdd vbsyn gsyn
X_ihm_52_10 a_xp52 a_xn52 wp_ih_52_10 wn_ih_52_10 mhp10 mhn10 vdd vbsyn gsyn
X_ihx_52_10 a_xp52 a_xn52 wp_ih_52_10 wn_ih_52_10 xhp10 xhn10 vdd vbsyn gsyn
X_ihm_53_10 a_xp53 a_xn53 wp_ih_53_10 wn_ih_53_10 mhp10 mhn10 vdd vbsyn gsyn
X_ihx_53_10 a_xp53 a_xn53 wp_ih_53_10 wn_ih_53_10 xhp10 xhn10 vdd vbsyn gsyn
X_ihm_54_10 a_xp54 a_xn54 wp_ih_54_10 wn_ih_54_10 mhp10 mhn10 vdd vbsyn gsyn
X_ihx_54_10 a_xp54 a_xn54 wp_ih_54_10 wn_ih_54_10 xhp10 xhn10 vdd vbsyn gsyn
X_ihm_55_10 a_xp55 a_xn55 wp_ih_55_10 wn_ih_55_10 mhp10 mhn10 vdd vbsyn gsyn
X_ihx_55_10 a_xp55 a_xn55 wp_ih_55_10 wn_ih_55_10 xhp10 xhn10 vdd vbsyn gsyn
X_ihm_56_10 a_xp56 a_xn56 wp_ih_56_10 wn_ih_56_10 mhp10 mhn10 vdd vbsyn gsyn
X_ihx_56_10 a_xp56 a_xn56 wp_ih_56_10 wn_ih_56_10 xhp10 xhn10 vdd vbsyn gsyn
X_ihm_57_10 a_xp57 a_xn57 wp_ih_57_10 wn_ih_57_10 mhp10 mhn10 vdd vbsyn gsyn
X_ihx_57_10 a_xp57 a_xn57 wp_ih_57_10 wn_ih_57_10 xhp10 xhn10 vdd vbsyn gsyn
X_ihm_58_10 a_xp58 a_xn58 wp_ih_58_10 wn_ih_58_10 mhp10 mhn10 vdd vbsyn gsyn
X_ihx_58_10 a_xp58 a_xn58 wp_ih_58_10 wn_ih_58_10 xhp10 xhn10 vdd vbsyn gsyn
X_ihm_59_10 a_xp59 a_xn59 wp_ih_59_10 wn_ih_59_10 mhp10 mhn10 vdd vbsyn gsyn
X_ihx_59_10 a_xp59 a_xn59 wp_ih_59_10 wn_ih_59_10 xhp10 xhn10 vdd vbsyn gsyn
X_ihm_60_10 a_xp60 a_xn60 wp_ih_60_10 wn_ih_60_10 mhp10 mhn10 vdd vbsyn gsyn
X_ihx_60_10 a_xp60 a_xn60 wp_ih_60_10 wn_ih_60_10 xhp10 xhn10 vdd vbsyn gsyn
X_ihm_61_10 a_xp61 a_xn61 wp_ih_61_10 wn_ih_61_10 mhp10 mhn10 vdd vbsyn gsyn
X_ihx_61_10 a_xp61 a_xn61 wp_ih_61_10 wn_ih_61_10 xhp10 xhn10 vdd vbsyn gsyn
X_ihm_62_10 a_xp62 a_xn62 wp_ih_62_10 wn_ih_62_10 mhp10 mhn10 vdd vbsyn gsyn
X_ihx_62_10 a_xp62 a_xn62 wp_ih_62_10 wn_ih_62_10 xhp10 xhn10 vdd vbsyn gsyn
X_ihm_63_10 a_xp63 a_xn63 wp_ih_63_10 wn_ih_63_10 mhp10 mhn10 vdd vbsyn gsyn
X_ihx_63_10 a_xp63 a_xn63 wp_ih_63_10 wn_ih_63_10 xhp10 xhn10 vdd vbsyn gsyn
X_bk_10_0 eop0 eon0 wp_ho_10_0 wn_ho_10_0 xhp10 xhn10 vdd vbbk gsyn
X_bk_10_1 eop1 eon1 wp_ho_10_1 wn_ho_10_1 xhp10 xhn10 vdd vbbk gsyn
X_bk_10_2 eop2 eon2 wp_ho_10_2 wn_ho_10_2 xhp10 xhn10 vdd vbbk gsyn
X_bk_10_3 eop3 eon3 wp_ho_10_3 wn_ho_10_3 xhp10 xhn10 vdd vbbk gsyn
X_bk_10_4 eop4 eon4 wp_ho_10_4 wn_ho_10_4 xhp10 xhn10 vdd vbbk gsyn
Xn10 xhp10 xhn10 ahp10 ahn10 vdd vbneu dneuron
Xeh10 xhp10 xhn10 mhp10 mhn10 ehp10 ehn10 vdd gm esub
Xcm_mh11 mhp11 mhn11 vdd cmld
Rnd_mh11 mhp11 mhn11 20k
Xcm_xh11 xhp11 xhn11 vdd cmld
Rnd_xh11 xhp11 xhn11 20k
X_ihm_0_11 a_xp0 a_xn0 wp_ih_0_11 wn_ih_0_11 mhp11 mhn11 vdd vbsyn gsyn
X_ihx_0_11 a_xp0 a_xn0 wp_ih_0_11 wn_ih_0_11 xhp11 xhn11 vdd vbsyn gsyn
X_ihm_1_11 a_xp1 a_xn1 wp_ih_1_11 wn_ih_1_11 mhp11 mhn11 vdd vbsyn gsyn
X_ihx_1_11 a_xp1 a_xn1 wp_ih_1_11 wn_ih_1_11 xhp11 xhn11 vdd vbsyn gsyn
X_ihm_2_11 a_xp2 a_xn2 wp_ih_2_11 wn_ih_2_11 mhp11 mhn11 vdd vbsyn gsyn
X_ihx_2_11 a_xp2 a_xn2 wp_ih_2_11 wn_ih_2_11 xhp11 xhn11 vdd vbsyn gsyn
X_ihm_3_11 a_xp3 a_xn3 wp_ih_3_11 wn_ih_3_11 mhp11 mhn11 vdd vbsyn gsyn
X_ihx_3_11 a_xp3 a_xn3 wp_ih_3_11 wn_ih_3_11 xhp11 xhn11 vdd vbsyn gsyn
X_ihm_4_11 a_xp4 a_xn4 wp_ih_4_11 wn_ih_4_11 mhp11 mhn11 vdd vbsyn gsyn
X_ihx_4_11 a_xp4 a_xn4 wp_ih_4_11 wn_ih_4_11 xhp11 xhn11 vdd vbsyn gsyn
X_ihm_5_11 a_xp5 a_xn5 wp_ih_5_11 wn_ih_5_11 mhp11 mhn11 vdd vbsyn gsyn
X_ihx_5_11 a_xp5 a_xn5 wp_ih_5_11 wn_ih_5_11 xhp11 xhn11 vdd vbsyn gsyn
X_ihm_6_11 a_xp6 a_xn6 wp_ih_6_11 wn_ih_6_11 mhp11 mhn11 vdd vbsyn gsyn
X_ihx_6_11 a_xp6 a_xn6 wp_ih_6_11 wn_ih_6_11 xhp11 xhn11 vdd vbsyn gsyn
X_ihm_7_11 a_xp7 a_xn7 wp_ih_7_11 wn_ih_7_11 mhp11 mhn11 vdd vbsyn gsyn
X_ihx_7_11 a_xp7 a_xn7 wp_ih_7_11 wn_ih_7_11 xhp11 xhn11 vdd vbsyn gsyn
X_ihm_8_11 a_xp8 a_xn8 wp_ih_8_11 wn_ih_8_11 mhp11 mhn11 vdd vbsyn gsyn
X_ihx_8_11 a_xp8 a_xn8 wp_ih_8_11 wn_ih_8_11 xhp11 xhn11 vdd vbsyn gsyn
X_ihm_9_11 a_xp9 a_xn9 wp_ih_9_11 wn_ih_9_11 mhp11 mhn11 vdd vbsyn gsyn
X_ihx_9_11 a_xp9 a_xn9 wp_ih_9_11 wn_ih_9_11 xhp11 xhn11 vdd vbsyn gsyn
X_ihm_10_11 a_xp10 a_xn10 wp_ih_10_11 wn_ih_10_11 mhp11 mhn11 vdd vbsyn gsyn
X_ihx_10_11 a_xp10 a_xn10 wp_ih_10_11 wn_ih_10_11 xhp11 xhn11 vdd vbsyn gsyn
X_ihm_11_11 a_xp11 a_xn11 wp_ih_11_11 wn_ih_11_11 mhp11 mhn11 vdd vbsyn gsyn
X_ihx_11_11 a_xp11 a_xn11 wp_ih_11_11 wn_ih_11_11 xhp11 xhn11 vdd vbsyn gsyn
X_ihm_12_11 a_xp12 a_xn12 wp_ih_12_11 wn_ih_12_11 mhp11 mhn11 vdd vbsyn gsyn
X_ihx_12_11 a_xp12 a_xn12 wp_ih_12_11 wn_ih_12_11 xhp11 xhn11 vdd vbsyn gsyn
X_ihm_13_11 a_xp13 a_xn13 wp_ih_13_11 wn_ih_13_11 mhp11 mhn11 vdd vbsyn gsyn
X_ihx_13_11 a_xp13 a_xn13 wp_ih_13_11 wn_ih_13_11 xhp11 xhn11 vdd vbsyn gsyn
X_ihm_14_11 a_xp14 a_xn14 wp_ih_14_11 wn_ih_14_11 mhp11 mhn11 vdd vbsyn gsyn
X_ihx_14_11 a_xp14 a_xn14 wp_ih_14_11 wn_ih_14_11 xhp11 xhn11 vdd vbsyn gsyn
X_ihm_15_11 a_xp15 a_xn15 wp_ih_15_11 wn_ih_15_11 mhp11 mhn11 vdd vbsyn gsyn
X_ihx_15_11 a_xp15 a_xn15 wp_ih_15_11 wn_ih_15_11 xhp11 xhn11 vdd vbsyn gsyn
X_ihm_16_11 a_xp16 a_xn16 wp_ih_16_11 wn_ih_16_11 mhp11 mhn11 vdd vbsyn gsyn
X_ihx_16_11 a_xp16 a_xn16 wp_ih_16_11 wn_ih_16_11 xhp11 xhn11 vdd vbsyn gsyn
X_ihm_17_11 a_xp17 a_xn17 wp_ih_17_11 wn_ih_17_11 mhp11 mhn11 vdd vbsyn gsyn
X_ihx_17_11 a_xp17 a_xn17 wp_ih_17_11 wn_ih_17_11 xhp11 xhn11 vdd vbsyn gsyn
X_ihm_18_11 a_xp18 a_xn18 wp_ih_18_11 wn_ih_18_11 mhp11 mhn11 vdd vbsyn gsyn
X_ihx_18_11 a_xp18 a_xn18 wp_ih_18_11 wn_ih_18_11 xhp11 xhn11 vdd vbsyn gsyn
X_ihm_19_11 a_xp19 a_xn19 wp_ih_19_11 wn_ih_19_11 mhp11 mhn11 vdd vbsyn gsyn
X_ihx_19_11 a_xp19 a_xn19 wp_ih_19_11 wn_ih_19_11 xhp11 xhn11 vdd vbsyn gsyn
X_ihm_20_11 a_xp20 a_xn20 wp_ih_20_11 wn_ih_20_11 mhp11 mhn11 vdd vbsyn gsyn
X_ihx_20_11 a_xp20 a_xn20 wp_ih_20_11 wn_ih_20_11 xhp11 xhn11 vdd vbsyn gsyn
X_ihm_21_11 a_xp21 a_xn21 wp_ih_21_11 wn_ih_21_11 mhp11 mhn11 vdd vbsyn gsyn
X_ihx_21_11 a_xp21 a_xn21 wp_ih_21_11 wn_ih_21_11 xhp11 xhn11 vdd vbsyn gsyn
X_ihm_22_11 a_xp22 a_xn22 wp_ih_22_11 wn_ih_22_11 mhp11 mhn11 vdd vbsyn gsyn
X_ihx_22_11 a_xp22 a_xn22 wp_ih_22_11 wn_ih_22_11 xhp11 xhn11 vdd vbsyn gsyn
X_ihm_23_11 a_xp23 a_xn23 wp_ih_23_11 wn_ih_23_11 mhp11 mhn11 vdd vbsyn gsyn
X_ihx_23_11 a_xp23 a_xn23 wp_ih_23_11 wn_ih_23_11 xhp11 xhn11 vdd vbsyn gsyn
X_ihm_24_11 a_xp24 a_xn24 wp_ih_24_11 wn_ih_24_11 mhp11 mhn11 vdd vbsyn gsyn
X_ihx_24_11 a_xp24 a_xn24 wp_ih_24_11 wn_ih_24_11 xhp11 xhn11 vdd vbsyn gsyn
X_ihm_25_11 a_xp25 a_xn25 wp_ih_25_11 wn_ih_25_11 mhp11 mhn11 vdd vbsyn gsyn
X_ihx_25_11 a_xp25 a_xn25 wp_ih_25_11 wn_ih_25_11 xhp11 xhn11 vdd vbsyn gsyn
X_ihm_26_11 a_xp26 a_xn26 wp_ih_26_11 wn_ih_26_11 mhp11 mhn11 vdd vbsyn gsyn
X_ihx_26_11 a_xp26 a_xn26 wp_ih_26_11 wn_ih_26_11 xhp11 xhn11 vdd vbsyn gsyn
X_ihm_27_11 a_xp27 a_xn27 wp_ih_27_11 wn_ih_27_11 mhp11 mhn11 vdd vbsyn gsyn
X_ihx_27_11 a_xp27 a_xn27 wp_ih_27_11 wn_ih_27_11 xhp11 xhn11 vdd vbsyn gsyn
X_ihm_28_11 a_xp28 a_xn28 wp_ih_28_11 wn_ih_28_11 mhp11 mhn11 vdd vbsyn gsyn
X_ihx_28_11 a_xp28 a_xn28 wp_ih_28_11 wn_ih_28_11 xhp11 xhn11 vdd vbsyn gsyn
X_ihm_29_11 a_xp29 a_xn29 wp_ih_29_11 wn_ih_29_11 mhp11 mhn11 vdd vbsyn gsyn
X_ihx_29_11 a_xp29 a_xn29 wp_ih_29_11 wn_ih_29_11 xhp11 xhn11 vdd vbsyn gsyn
X_ihm_30_11 a_xp30 a_xn30 wp_ih_30_11 wn_ih_30_11 mhp11 mhn11 vdd vbsyn gsyn
X_ihx_30_11 a_xp30 a_xn30 wp_ih_30_11 wn_ih_30_11 xhp11 xhn11 vdd vbsyn gsyn
X_ihm_31_11 a_xp31 a_xn31 wp_ih_31_11 wn_ih_31_11 mhp11 mhn11 vdd vbsyn gsyn
X_ihx_31_11 a_xp31 a_xn31 wp_ih_31_11 wn_ih_31_11 xhp11 xhn11 vdd vbsyn gsyn
X_ihm_32_11 a_xp32 a_xn32 wp_ih_32_11 wn_ih_32_11 mhp11 mhn11 vdd vbsyn gsyn
X_ihx_32_11 a_xp32 a_xn32 wp_ih_32_11 wn_ih_32_11 xhp11 xhn11 vdd vbsyn gsyn
X_ihm_33_11 a_xp33 a_xn33 wp_ih_33_11 wn_ih_33_11 mhp11 mhn11 vdd vbsyn gsyn
X_ihx_33_11 a_xp33 a_xn33 wp_ih_33_11 wn_ih_33_11 xhp11 xhn11 vdd vbsyn gsyn
X_ihm_34_11 a_xp34 a_xn34 wp_ih_34_11 wn_ih_34_11 mhp11 mhn11 vdd vbsyn gsyn
X_ihx_34_11 a_xp34 a_xn34 wp_ih_34_11 wn_ih_34_11 xhp11 xhn11 vdd vbsyn gsyn
X_ihm_35_11 a_xp35 a_xn35 wp_ih_35_11 wn_ih_35_11 mhp11 mhn11 vdd vbsyn gsyn
X_ihx_35_11 a_xp35 a_xn35 wp_ih_35_11 wn_ih_35_11 xhp11 xhn11 vdd vbsyn gsyn
X_ihm_36_11 a_xp36 a_xn36 wp_ih_36_11 wn_ih_36_11 mhp11 mhn11 vdd vbsyn gsyn
X_ihx_36_11 a_xp36 a_xn36 wp_ih_36_11 wn_ih_36_11 xhp11 xhn11 vdd vbsyn gsyn
X_ihm_37_11 a_xp37 a_xn37 wp_ih_37_11 wn_ih_37_11 mhp11 mhn11 vdd vbsyn gsyn
X_ihx_37_11 a_xp37 a_xn37 wp_ih_37_11 wn_ih_37_11 xhp11 xhn11 vdd vbsyn gsyn
X_ihm_38_11 a_xp38 a_xn38 wp_ih_38_11 wn_ih_38_11 mhp11 mhn11 vdd vbsyn gsyn
X_ihx_38_11 a_xp38 a_xn38 wp_ih_38_11 wn_ih_38_11 xhp11 xhn11 vdd vbsyn gsyn
X_ihm_39_11 a_xp39 a_xn39 wp_ih_39_11 wn_ih_39_11 mhp11 mhn11 vdd vbsyn gsyn
X_ihx_39_11 a_xp39 a_xn39 wp_ih_39_11 wn_ih_39_11 xhp11 xhn11 vdd vbsyn gsyn
X_ihm_40_11 a_xp40 a_xn40 wp_ih_40_11 wn_ih_40_11 mhp11 mhn11 vdd vbsyn gsyn
X_ihx_40_11 a_xp40 a_xn40 wp_ih_40_11 wn_ih_40_11 xhp11 xhn11 vdd vbsyn gsyn
X_ihm_41_11 a_xp41 a_xn41 wp_ih_41_11 wn_ih_41_11 mhp11 mhn11 vdd vbsyn gsyn
X_ihx_41_11 a_xp41 a_xn41 wp_ih_41_11 wn_ih_41_11 xhp11 xhn11 vdd vbsyn gsyn
X_ihm_42_11 a_xp42 a_xn42 wp_ih_42_11 wn_ih_42_11 mhp11 mhn11 vdd vbsyn gsyn
X_ihx_42_11 a_xp42 a_xn42 wp_ih_42_11 wn_ih_42_11 xhp11 xhn11 vdd vbsyn gsyn
X_ihm_43_11 a_xp43 a_xn43 wp_ih_43_11 wn_ih_43_11 mhp11 mhn11 vdd vbsyn gsyn
X_ihx_43_11 a_xp43 a_xn43 wp_ih_43_11 wn_ih_43_11 xhp11 xhn11 vdd vbsyn gsyn
X_ihm_44_11 a_xp44 a_xn44 wp_ih_44_11 wn_ih_44_11 mhp11 mhn11 vdd vbsyn gsyn
X_ihx_44_11 a_xp44 a_xn44 wp_ih_44_11 wn_ih_44_11 xhp11 xhn11 vdd vbsyn gsyn
X_ihm_45_11 a_xp45 a_xn45 wp_ih_45_11 wn_ih_45_11 mhp11 mhn11 vdd vbsyn gsyn
X_ihx_45_11 a_xp45 a_xn45 wp_ih_45_11 wn_ih_45_11 xhp11 xhn11 vdd vbsyn gsyn
X_ihm_46_11 a_xp46 a_xn46 wp_ih_46_11 wn_ih_46_11 mhp11 mhn11 vdd vbsyn gsyn
X_ihx_46_11 a_xp46 a_xn46 wp_ih_46_11 wn_ih_46_11 xhp11 xhn11 vdd vbsyn gsyn
X_ihm_47_11 a_xp47 a_xn47 wp_ih_47_11 wn_ih_47_11 mhp11 mhn11 vdd vbsyn gsyn
X_ihx_47_11 a_xp47 a_xn47 wp_ih_47_11 wn_ih_47_11 xhp11 xhn11 vdd vbsyn gsyn
X_ihm_48_11 a_xp48 a_xn48 wp_ih_48_11 wn_ih_48_11 mhp11 mhn11 vdd vbsyn gsyn
X_ihx_48_11 a_xp48 a_xn48 wp_ih_48_11 wn_ih_48_11 xhp11 xhn11 vdd vbsyn gsyn
X_ihm_49_11 a_xp49 a_xn49 wp_ih_49_11 wn_ih_49_11 mhp11 mhn11 vdd vbsyn gsyn
X_ihx_49_11 a_xp49 a_xn49 wp_ih_49_11 wn_ih_49_11 xhp11 xhn11 vdd vbsyn gsyn
X_ihm_50_11 a_xp50 a_xn50 wp_ih_50_11 wn_ih_50_11 mhp11 mhn11 vdd vbsyn gsyn
X_ihx_50_11 a_xp50 a_xn50 wp_ih_50_11 wn_ih_50_11 xhp11 xhn11 vdd vbsyn gsyn
X_ihm_51_11 a_xp51 a_xn51 wp_ih_51_11 wn_ih_51_11 mhp11 mhn11 vdd vbsyn gsyn
X_ihx_51_11 a_xp51 a_xn51 wp_ih_51_11 wn_ih_51_11 xhp11 xhn11 vdd vbsyn gsyn
X_ihm_52_11 a_xp52 a_xn52 wp_ih_52_11 wn_ih_52_11 mhp11 mhn11 vdd vbsyn gsyn
X_ihx_52_11 a_xp52 a_xn52 wp_ih_52_11 wn_ih_52_11 xhp11 xhn11 vdd vbsyn gsyn
X_ihm_53_11 a_xp53 a_xn53 wp_ih_53_11 wn_ih_53_11 mhp11 mhn11 vdd vbsyn gsyn
X_ihx_53_11 a_xp53 a_xn53 wp_ih_53_11 wn_ih_53_11 xhp11 xhn11 vdd vbsyn gsyn
X_ihm_54_11 a_xp54 a_xn54 wp_ih_54_11 wn_ih_54_11 mhp11 mhn11 vdd vbsyn gsyn
X_ihx_54_11 a_xp54 a_xn54 wp_ih_54_11 wn_ih_54_11 xhp11 xhn11 vdd vbsyn gsyn
X_ihm_55_11 a_xp55 a_xn55 wp_ih_55_11 wn_ih_55_11 mhp11 mhn11 vdd vbsyn gsyn
X_ihx_55_11 a_xp55 a_xn55 wp_ih_55_11 wn_ih_55_11 xhp11 xhn11 vdd vbsyn gsyn
X_ihm_56_11 a_xp56 a_xn56 wp_ih_56_11 wn_ih_56_11 mhp11 mhn11 vdd vbsyn gsyn
X_ihx_56_11 a_xp56 a_xn56 wp_ih_56_11 wn_ih_56_11 xhp11 xhn11 vdd vbsyn gsyn
X_ihm_57_11 a_xp57 a_xn57 wp_ih_57_11 wn_ih_57_11 mhp11 mhn11 vdd vbsyn gsyn
X_ihx_57_11 a_xp57 a_xn57 wp_ih_57_11 wn_ih_57_11 xhp11 xhn11 vdd vbsyn gsyn
X_ihm_58_11 a_xp58 a_xn58 wp_ih_58_11 wn_ih_58_11 mhp11 mhn11 vdd vbsyn gsyn
X_ihx_58_11 a_xp58 a_xn58 wp_ih_58_11 wn_ih_58_11 xhp11 xhn11 vdd vbsyn gsyn
X_ihm_59_11 a_xp59 a_xn59 wp_ih_59_11 wn_ih_59_11 mhp11 mhn11 vdd vbsyn gsyn
X_ihx_59_11 a_xp59 a_xn59 wp_ih_59_11 wn_ih_59_11 xhp11 xhn11 vdd vbsyn gsyn
X_ihm_60_11 a_xp60 a_xn60 wp_ih_60_11 wn_ih_60_11 mhp11 mhn11 vdd vbsyn gsyn
X_ihx_60_11 a_xp60 a_xn60 wp_ih_60_11 wn_ih_60_11 xhp11 xhn11 vdd vbsyn gsyn
X_ihm_61_11 a_xp61 a_xn61 wp_ih_61_11 wn_ih_61_11 mhp11 mhn11 vdd vbsyn gsyn
X_ihx_61_11 a_xp61 a_xn61 wp_ih_61_11 wn_ih_61_11 xhp11 xhn11 vdd vbsyn gsyn
X_ihm_62_11 a_xp62 a_xn62 wp_ih_62_11 wn_ih_62_11 mhp11 mhn11 vdd vbsyn gsyn
X_ihx_62_11 a_xp62 a_xn62 wp_ih_62_11 wn_ih_62_11 xhp11 xhn11 vdd vbsyn gsyn
X_ihm_63_11 a_xp63 a_xn63 wp_ih_63_11 wn_ih_63_11 mhp11 mhn11 vdd vbsyn gsyn
X_ihx_63_11 a_xp63 a_xn63 wp_ih_63_11 wn_ih_63_11 xhp11 xhn11 vdd vbsyn gsyn
X_bk_11_0 eop0 eon0 wp_ho_11_0 wn_ho_11_0 xhp11 xhn11 vdd vbbk gsyn
X_bk_11_1 eop1 eon1 wp_ho_11_1 wn_ho_11_1 xhp11 xhn11 vdd vbbk gsyn
X_bk_11_2 eop2 eon2 wp_ho_11_2 wn_ho_11_2 xhp11 xhn11 vdd vbbk gsyn
X_bk_11_3 eop3 eon3 wp_ho_11_3 wn_ho_11_3 xhp11 xhn11 vdd vbbk gsyn
X_bk_11_4 eop4 eon4 wp_ho_11_4 wn_ho_11_4 xhp11 xhn11 vdd vbbk gsyn
Xn11 xhp11 xhn11 ahp11 ahn11 vdd vbneu dneuron
Xeh11 xhp11 xhn11 mhp11 mhn11 ehp11 ehn11 vdd gm esub
Xcm_mh12 mhp12 mhn12 vdd cmld
Rnd_mh12 mhp12 mhn12 20k
Xcm_xh12 xhp12 xhn12 vdd cmld
Rnd_xh12 xhp12 xhn12 20k
X_ihm_0_12 a_xp0 a_xn0 wp_ih_0_12 wn_ih_0_12 mhp12 mhn12 vdd vbsyn gsyn
X_ihx_0_12 a_xp0 a_xn0 wp_ih_0_12 wn_ih_0_12 xhp12 xhn12 vdd vbsyn gsyn
X_ihm_1_12 a_xp1 a_xn1 wp_ih_1_12 wn_ih_1_12 mhp12 mhn12 vdd vbsyn gsyn
X_ihx_1_12 a_xp1 a_xn1 wp_ih_1_12 wn_ih_1_12 xhp12 xhn12 vdd vbsyn gsyn
X_ihm_2_12 a_xp2 a_xn2 wp_ih_2_12 wn_ih_2_12 mhp12 mhn12 vdd vbsyn gsyn
X_ihx_2_12 a_xp2 a_xn2 wp_ih_2_12 wn_ih_2_12 xhp12 xhn12 vdd vbsyn gsyn
X_ihm_3_12 a_xp3 a_xn3 wp_ih_3_12 wn_ih_3_12 mhp12 mhn12 vdd vbsyn gsyn
X_ihx_3_12 a_xp3 a_xn3 wp_ih_3_12 wn_ih_3_12 xhp12 xhn12 vdd vbsyn gsyn
X_ihm_4_12 a_xp4 a_xn4 wp_ih_4_12 wn_ih_4_12 mhp12 mhn12 vdd vbsyn gsyn
X_ihx_4_12 a_xp4 a_xn4 wp_ih_4_12 wn_ih_4_12 xhp12 xhn12 vdd vbsyn gsyn
X_ihm_5_12 a_xp5 a_xn5 wp_ih_5_12 wn_ih_5_12 mhp12 mhn12 vdd vbsyn gsyn
X_ihx_5_12 a_xp5 a_xn5 wp_ih_5_12 wn_ih_5_12 xhp12 xhn12 vdd vbsyn gsyn
X_ihm_6_12 a_xp6 a_xn6 wp_ih_6_12 wn_ih_6_12 mhp12 mhn12 vdd vbsyn gsyn
X_ihx_6_12 a_xp6 a_xn6 wp_ih_6_12 wn_ih_6_12 xhp12 xhn12 vdd vbsyn gsyn
X_ihm_7_12 a_xp7 a_xn7 wp_ih_7_12 wn_ih_7_12 mhp12 mhn12 vdd vbsyn gsyn
X_ihx_7_12 a_xp7 a_xn7 wp_ih_7_12 wn_ih_7_12 xhp12 xhn12 vdd vbsyn gsyn
X_ihm_8_12 a_xp8 a_xn8 wp_ih_8_12 wn_ih_8_12 mhp12 mhn12 vdd vbsyn gsyn
X_ihx_8_12 a_xp8 a_xn8 wp_ih_8_12 wn_ih_8_12 xhp12 xhn12 vdd vbsyn gsyn
X_ihm_9_12 a_xp9 a_xn9 wp_ih_9_12 wn_ih_9_12 mhp12 mhn12 vdd vbsyn gsyn
X_ihx_9_12 a_xp9 a_xn9 wp_ih_9_12 wn_ih_9_12 xhp12 xhn12 vdd vbsyn gsyn
X_ihm_10_12 a_xp10 a_xn10 wp_ih_10_12 wn_ih_10_12 mhp12 mhn12 vdd vbsyn gsyn
X_ihx_10_12 a_xp10 a_xn10 wp_ih_10_12 wn_ih_10_12 xhp12 xhn12 vdd vbsyn gsyn
X_ihm_11_12 a_xp11 a_xn11 wp_ih_11_12 wn_ih_11_12 mhp12 mhn12 vdd vbsyn gsyn
X_ihx_11_12 a_xp11 a_xn11 wp_ih_11_12 wn_ih_11_12 xhp12 xhn12 vdd vbsyn gsyn
X_ihm_12_12 a_xp12 a_xn12 wp_ih_12_12 wn_ih_12_12 mhp12 mhn12 vdd vbsyn gsyn
X_ihx_12_12 a_xp12 a_xn12 wp_ih_12_12 wn_ih_12_12 xhp12 xhn12 vdd vbsyn gsyn
X_ihm_13_12 a_xp13 a_xn13 wp_ih_13_12 wn_ih_13_12 mhp12 mhn12 vdd vbsyn gsyn
X_ihx_13_12 a_xp13 a_xn13 wp_ih_13_12 wn_ih_13_12 xhp12 xhn12 vdd vbsyn gsyn
X_ihm_14_12 a_xp14 a_xn14 wp_ih_14_12 wn_ih_14_12 mhp12 mhn12 vdd vbsyn gsyn
X_ihx_14_12 a_xp14 a_xn14 wp_ih_14_12 wn_ih_14_12 xhp12 xhn12 vdd vbsyn gsyn
X_ihm_15_12 a_xp15 a_xn15 wp_ih_15_12 wn_ih_15_12 mhp12 mhn12 vdd vbsyn gsyn
X_ihx_15_12 a_xp15 a_xn15 wp_ih_15_12 wn_ih_15_12 xhp12 xhn12 vdd vbsyn gsyn
X_ihm_16_12 a_xp16 a_xn16 wp_ih_16_12 wn_ih_16_12 mhp12 mhn12 vdd vbsyn gsyn
X_ihx_16_12 a_xp16 a_xn16 wp_ih_16_12 wn_ih_16_12 xhp12 xhn12 vdd vbsyn gsyn
X_ihm_17_12 a_xp17 a_xn17 wp_ih_17_12 wn_ih_17_12 mhp12 mhn12 vdd vbsyn gsyn
X_ihx_17_12 a_xp17 a_xn17 wp_ih_17_12 wn_ih_17_12 xhp12 xhn12 vdd vbsyn gsyn
X_ihm_18_12 a_xp18 a_xn18 wp_ih_18_12 wn_ih_18_12 mhp12 mhn12 vdd vbsyn gsyn
X_ihx_18_12 a_xp18 a_xn18 wp_ih_18_12 wn_ih_18_12 xhp12 xhn12 vdd vbsyn gsyn
X_ihm_19_12 a_xp19 a_xn19 wp_ih_19_12 wn_ih_19_12 mhp12 mhn12 vdd vbsyn gsyn
X_ihx_19_12 a_xp19 a_xn19 wp_ih_19_12 wn_ih_19_12 xhp12 xhn12 vdd vbsyn gsyn
X_ihm_20_12 a_xp20 a_xn20 wp_ih_20_12 wn_ih_20_12 mhp12 mhn12 vdd vbsyn gsyn
X_ihx_20_12 a_xp20 a_xn20 wp_ih_20_12 wn_ih_20_12 xhp12 xhn12 vdd vbsyn gsyn
X_ihm_21_12 a_xp21 a_xn21 wp_ih_21_12 wn_ih_21_12 mhp12 mhn12 vdd vbsyn gsyn
X_ihx_21_12 a_xp21 a_xn21 wp_ih_21_12 wn_ih_21_12 xhp12 xhn12 vdd vbsyn gsyn
X_ihm_22_12 a_xp22 a_xn22 wp_ih_22_12 wn_ih_22_12 mhp12 mhn12 vdd vbsyn gsyn
X_ihx_22_12 a_xp22 a_xn22 wp_ih_22_12 wn_ih_22_12 xhp12 xhn12 vdd vbsyn gsyn
X_ihm_23_12 a_xp23 a_xn23 wp_ih_23_12 wn_ih_23_12 mhp12 mhn12 vdd vbsyn gsyn
X_ihx_23_12 a_xp23 a_xn23 wp_ih_23_12 wn_ih_23_12 xhp12 xhn12 vdd vbsyn gsyn
X_ihm_24_12 a_xp24 a_xn24 wp_ih_24_12 wn_ih_24_12 mhp12 mhn12 vdd vbsyn gsyn
X_ihx_24_12 a_xp24 a_xn24 wp_ih_24_12 wn_ih_24_12 xhp12 xhn12 vdd vbsyn gsyn
X_ihm_25_12 a_xp25 a_xn25 wp_ih_25_12 wn_ih_25_12 mhp12 mhn12 vdd vbsyn gsyn
X_ihx_25_12 a_xp25 a_xn25 wp_ih_25_12 wn_ih_25_12 xhp12 xhn12 vdd vbsyn gsyn
X_ihm_26_12 a_xp26 a_xn26 wp_ih_26_12 wn_ih_26_12 mhp12 mhn12 vdd vbsyn gsyn
X_ihx_26_12 a_xp26 a_xn26 wp_ih_26_12 wn_ih_26_12 xhp12 xhn12 vdd vbsyn gsyn
X_ihm_27_12 a_xp27 a_xn27 wp_ih_27_12 wn_ih_27_12 mhp12 mhn12 vdd vbsyn gsyn
X_ihx_27_12 a_xp27 a_xn27 wp_ih_27_12 wn_ih_27_12 xhp12 xhn12 vdd vbsyn gsyn
X_ihm_28_12 a_xp28 a_xn28 wp_ih_28_12 wn_ih_28_12 mhp12 mhn12 vdd vbsyn gsyn
X_ihx_28_12 a_xp28 a_xn28 wp_ih_28_12 wn_ih_28_12 xhp12 xhn12 vdd vbsyn gsyn
X_ihm_29_12 a_xp29 a_xn29 wp_ih_29_12 wn_ih_29_12 mhp12 mhn12 vdd vbsyn gsyn
X_ihx_29_12 a_xp29 a_xn29 wp_ih_29_12 wn_ih_29_12 xhp12 xhn12 vdd vbsyn gsyn
X_ihm_30_12 a_xp30 a_xn30 wp_ih_30_12 wn_ih_30_12 mhp12 mhn12 vdd vbsyn gsyn
X_ihx_30_12 a_xp30 a_xn30 wp_ih_30_12 wn_ih_30_12 xhp12 xhn12 vdd vbsyn gsyn
X_ihm_31_12 a_xp31 a_xn31 wp_ih_31_12 wn_ih_31_12 mhp12 mhn12 vdd vbsyn gsyn
X_ihx_31_12 a_xp31 a_xn31 wp_ih_31_12 wn_ih_31_12 xhp12 xhn12 vdd vbsyn gsyn
X_ihm_32_12 a_xp32 a_xn32 wp_ih_32_12 wn_ih_32_12 mhp12 mhn12 vdd vbsyn gsyn
X_ihx_32_12 a_xp32 a_xn32 wp_ih_32_12 wn_ih_32_12 xhp12 xhn12 vdd vbsyn gsyn
X_ihm_33_12 a_xp33 a_xn33 wp_ih_33_12 wn_ih_33_12 mhp12 mhn12 vdd vbsyn gsyn
X_ihx_33_12 a_xp33 a_xn33 wp_ih_33_12 wn_ih_33_12 xhp12 xhn12 vdd vbsyn gsyn
X_ihm_34_12 a_xp34 a_xn34 wp_ih_34_12 wn_ih_34_12 mhp12 mhn12 vdd vbsyn gsyn
X_ihx_34_12 a_xp34 a_xn34 wp_ih_34_12 wn_ih_34_12 xhp12 xhn12 vdd vbsyn gsyn
X_ihm_35_12 a_xp35 a_xn35 wp_ih_35_12 wn_ih_35_12 mhp12 mhn12 vdd vbsyn gsyn
X_ihx_35_12 a_xp35 a_xn35 wp_ih_35_12 wn_ih_35_12 xhp12 xhn12 vdd vbsyn gsyn
X_ihm_36_12 a_xp36 a_xn36 wp_ih_36_12 wn_ih_36_12 mhp12 mhn12 vdd vbsyn gsyn
X_ihx_36_12 a_xp36 a_xn36 wp_ih_36_12 wn_ih_36_12 xhp12 xhn12 vdd vbsyn gsyn
X_ihm_37_12 a_xp37 a_xn37 wp_ih_37_12 wn_ih_37_12 mhp12 mhn12 vdd vbsyn gsyn
X_ihx_37_12 a_xp37 a_xn37 wp_ih_37_12 wn_ih_37_12 xhp12 xhn12 vdd vbsyn gsyn
X_ihm_38_12 a_xp38 a_xn38 wp_ih_38_12 wn_ih_38_12 mhp12 mhn12 vdd vbsyn gsyn
X_ihx_38_12 a_xp38 a_xn38 wp_ih_38_12 wn_ih_38_12 xhp12 xhn12 vdd vbsyn gsyn
X_ihm_39_12 a_xp39 a_xn39 wp_ih_39_12 wn_ih_39_12 mhp12 mhn12 vdd vbsyn gsyn
X_ihx_39_12 a_xp39 a_xn39 wp_ih_39_12 wn_ih_39_12 xhp12 xhn12 vdd vbsyn gsyn
X_ihm_40_12 a_xp40 a_xn40 wp_ih_40_12 wn_ih_40_12 mhp12 mhn12 vdd vbsyn gsyn
X_ihx_40_12 a_xp40 a_xn40 wp_ih_40_12 wn_ih_40_12 xhp12 xhn12 vdd vbsyn gsyn
X_ihm_41_12 a_xp41 a_xn41 wp_ih_41_12 wn_ih_41_12 mhp12 mhn12 vdd vbsyn gsyn
X_ihx_41_12 a_xp41 a_xn41 wp_ih_41_12 wn_ih_41_12 xhp12 xhn12 vdd vbsyn gsyn
X_ihm_42_12 a_xp42 a_xn42 wp_ih_42_12 wn_ih_42_12 mhp12 mhn12 vdd vbsyn gsyn
X_ihx_42_12 a_xp42 a_xn42 wp_ih_42_12 wn_ih_42_12 xhp12 xhn12 vdd vbsyn gsyn
X_ihm_43_12 a_xp43 a_xn43 wp_ih_43_12 wn_ih_43_12 mhp12 mhn12 vdd vbsyn gsyn
X_ihx_43_12 a_xp43 a_xn43 wp_ih_43_12 wn_ih_43_12 xhp12 xhn12 vdd vbsyn gsyn
X_ihm_44_12 a_xp44 a_xn44 wp_ih_44_12 wn_ih_44_12 mhp12 mhn12 vdd vbsyn gsyn
X_ihx_44_12 a_xp44 a_xn44 wp_ih_44_12 wn_ih_44_12 xhp12 xhn12 vdd vbsyn gsyn
X_ihm_45_12 a_xp45 a_xn45 wp_ih_45_12 wn_ih_45_12 mhp12 mhn12 vdd vbsyn gsyn
X_ihx_45_12 a_xp45 a_xn45 wp_ih_45_12 wn_ih_45_12 xhp12 xhn12 vdd vbsyn gsyn
X_ihm_46_12 a_xp46 a_xn46 wp_ih_46_12 wn_ih_46_12 mhp12 mhn12 vdd vbsyn gsyn
X_ihx_46_12 a_xp46 a_xn46 wp_ih_46_12 wn_ih_46_12 xhp12 xhn12 vdd vbsyn gsyn
X_ihm_47_12 a_xp47 a_xn47 wp_ih_47_12 wn_ih_47_12 mhp12 mhn12 vdd vbsyn gsyn
X_ihx_47_12 a_xp47 a_xn47 wp_ih_47_12 wn_ih_47_12 xhp12 xhn12 vdd vbsyn gsyn
X_ihm_48_12 a_xp48 a_xn48 wp_ih_48_12 wn_ih_48_12 mhp12 mhn12 vdd vbsyn gsyn
X_ihx_48_12 a_xp48 a_xn48 wp_ih_48_12 wn_ih_48_12 xhp12 xhn12 vdd vbsyn gsyn
X_ihm_49_12 a_xp49 a_xn49 wp_ih_49_12 wn_ih_49_12 mhp12 mhn12 vdd vbsyn gsyn
X_ihx_49_12 a_xp49 a_xn49 wp_ih_49_12 wn_ih_49_12 xhp12 xhn12 vdd vbsyn gsyn
X_ihm_50_12 a_xp50 a_xn50 wp_ih_50_12 wn_ih_50_12 mhp12 mhn12 vdd vbsyn gsyn
X_ihx_50_12 a_xp50 a_xn50 wp_ih_50_12 wn_ih_50_12 xhp12 xhn12 vdd vbsyn gsyn
X_ihm_51_12 a_xp51 a_xn51 wp_ih_51_12 wn_ih_51_12 mhp12 mhn12 vdd vbsyn gsyn
X_ihx_51_12 a_xp51 a_xn51 wp_ih_51_12 wn_ih_51_12 xhp12 xhn12 vdd vbsyn gsyn
X_ihm_52_12 a_xp52 a_xn52 wp_ih_52_12 wn_ih_52_12 mhp12 mhn12 vdd vbsyn gsyn
X_ihx_52_12 a_xp52 a_xn52 wp_ih_52_12 wn_ih_52_12 xhp12 xhn12 vdd vbsyn gsyn
X_ihm_53_12 a_xp53 a_xn53 wp_ih_53_12 wn_ih_53_12 mhp12 mhn12 vdd vbsyn gsyn
X_ihx_53_12 a_xp53 a_xn53 wp_ih_53_12 wn_ih_53_12 xhp12 xhn12 vdd vbsyn gsyn
X_ihm_54_12 a_xp54 a_xn54 wp_ih_54_12 wn_ih_54_12 mhp12 mhn12 vdd vbsyn gsyn
X_ihx_54_12 a_xp54 a_xn54 wp_ih_54_12 wn_ih_54_12 xhp12 xhn12 vdd vbsyn gsyn
X_ihm_55_12 a_xp55 a_xn55 wp_ih_55_12 wn_ih_55_12 mhp12 mhn12 vdd vbsyn gsyn
X_ihx_55_12 a_xp55 a_xn55 wp_ih_55_12 wn_ih_55_12 xhp12 xhn12 vdd vbsyn gsyn
X_ihm_56_12 a_xp56 a_xn56 wp_ih_56_12 wn_ih_56_12 mhp12 mhn12 vdd vbsyn gsyn
X_ihx_56_12 a_xp56 a_xn56 wp_ih_56_12 wn_ih_56_12 xhp12 xhn12 vdd vbsyn gsyn
X_ihm_57_12 a_xp57 a_xn57 wp_ih_57_12 wn_ih_57_12 mhp12 mhn12 vdd vbsyn gsyn
X_ihx_57_12 a_xp57 a_xn57 wp_ih_57_12 wn_ih_57_12 xhp12 xhn12 vdd vbsyn gsyn
X_ihm_58_12 a_xp58 a_xn58 wp_ih_58_12 wn_ih_58_12 mhp12 mhn12 vdd vbsyn gsyn
X_ihx_58_12 a_xp58 a_xn58 wp_ih_58_12 wn_ih_58_12 xhp12 xhn12 vdd vbsyn gsyn
X_ihm_59_12 a_xp59 a_xn59 wp_ih_59_12 wn_ih_59_12 mhp12 mhn12 vdd vbsyn gsyn
X_ihx_59_12 a_xp59 a_xn59 wp_ih_59_12 wn_ih_59_12 xhp12 xhn12 vdd vbsyn gsyn
X_ihm_60_12 a_xp60 a_xn60 wp_ih_60_12 wn_ih_60_12 mhp12 mhn12 vdd vbsyn gsyn
X_ihx_60_12 a_xp60 a_xn60 wp_ih_60_12 wn_ih_60_12 xhp12 xhn12 vdd vbsyn gsyn
X_ihm_61_12 a_xp61 a_xn61 wp_ih_61_12 wn_ih_61_12 mhp12 mhn12 vdd vbsyn gsyn
X_ihx_61_12 a_xp61 a_xn61 wp_ih_61_12 wn_ih_61_12 xhp12 xhn12 vdd vbsyn gsyn
X_ihm_62_12 a_xp62 a_xn62 wp_ih_62_12 wn_ih_62_12 mhp12 mhn12 vdd vbsyn gsyn
X_ihx_62_12 a_xp62 a_xn62 wp_ih_62_12 wn_ih_62_12 xhp12 xhn12 vdd vbsyn gsyn
X_ihm_63_12 a_xp63 a_xn63 wp_ih_63_12 wn_ih_63_12 mhp12 mhn12 vdd vbsyn gsyn
X_ihx_63_12 a_xp63 a_xn63 wp_ih_63_12 wn_ih_63_12 xhp12 xhn12 vdd vbsyn gsyn
X_bk_12_0 eop0 eon0 wp_ho_12_0 wn_ho_12_0 xhp12 xhn12 vdd vbbk gsyn
X_bk_12_1 eop1 eon1 wp_ho_12_1 wn_ho_12_1 xhp12 xhn12 vdd vbbk gsyn
X_bk_12_2 eop2 eon2 wp_ho_12_2 wn_ho_12_2 xhp12 xhn12 vdd vbbk gsyn
X_bk_12_3 eop3 eon3 wp_ho_12_3 wn_ho_12_3 xhp12 xhn12 vdd vbbk gsyn
X_bk_12_4 eop4 eon4 wp_ho_12_4 wn_ho_12_4 xhp12 xhn12 vdd vbbk gsyn
Xn12 xhp12 xhn12 ahp12 ahn12 vdd vbneu dneuron
Xeh12 xhp12 xhn12 mhp12 mhn12 ehp12 ehn12 vdd gm esub
Xcm_mh13 mhp13 mhn13 vdd cmld
Rnd_mh13 mhp13 mhn13 20k
Xcm_xh13 xhp13 xhn13 vdd cmld
Rnd_xh13 xhp13 xhn13 20k
X_ihm_0_13 a_xp0 a_xn0 wp_ih_0_13 wn_ih_0_13 mhp13 mhn13 vdd vbsyn gsyn
X_ihx_0_13 a_xp0 a_xn0 wp_ih_0_13 wn_ih_0_13 xhp13 xhn13 vdd vbsyn gsyn
X_ihm_1_13 a_xp1 a_xn1 wp_ih_1_13 wn_ih_1_13 mhp13 mhn13 vdd vbsyn gsyn
X_ihx_1_13 a_xp1 a_xn1 wp_ih_1_13 wn_ih_1_13 xhp13 xhn13 vdd vbsyn gsyn
X_ihm_2_13 a_xp2 a_xn2 wp_ih_2_13 wn_ih_2_13 mhp13 mhn13 vdd vbsyn gsyn
X_ihx_2_13 a_xp2 a_xn2 wp_ih_2_13 wn_ih_2_13 xhp13 xhn13 vdd vbsyn gsyn
X_ihm_3_13 a_xp3 a_xn3 wp_ih_3_13 wn_ih_3_13 mhp13 mhn13 vdd vbsyn gsyn
X_ihx_3_13 a_xp3 a_xn3 wp_ih_3_13 wn_ih_3_13 xhp13 xhn13 vdd vbsyn gsyn
X_ihm_4_13 a_xp4 a_xn4 wp_ih_4_13 wn_ih_4_13 mhp13 mhn13 vdd vbsyn gsyn
X_ihx_4_13 a_xp4 a_xn4 wp_ih_4_13 wn_ih_4_13 xhp13 xhn13 vdd vbsyn gsyn
X_ihm_5_13 a_xp5 a_xn5 wp_ih_5_13 wn_ih_5_13 mhp13 mhn13 vdd vbsyn gsyn
X_ihx_5_13 a_xp5 a_xn5 wp_ih_5_13 wn_ih_5_13 xhp13 xhn13 vdd vbsyn gsyn
X_ihm_6_13 a_xp6 a_xn6 wp_ih_6_13 wn_ih_6_13 mhp13 mhn13 vdd vbsyn gsyn
X_ihx_6_13 a_xp6 a_xn6 wp_ih_6_13 wn_ih_6_13 xhp13 xhn13 vdd vbsyn gsyn
X_ihm_7_13 a_xp7 a_xn7 wp_ih_7_13 wn_ih_7_13 mhp13 mhn13 vdd vbsyn gsyn
X_ihx_7_13 a_xp7 a_xn7 wp_ih_7_13 wn_ih_7_13 xhp13 xhn13 vdd vbsyn gsyn
X_ihm_8_13 a_xp8 a_xn8 wp_ih_8_13 wn_ih_8_13 mhp13 mhn13 vdd vbsyn gsyn
X_ihx_8_13 a_xp8 a_xn8 wp_ih_8_13 wn_ih_8_13 xhp13 xhn13 vdd vbsyn gsyn
X_ihm_9_13 a_xp9 a_xn9 wp_ih_9_13 wn_ih_9_13 mhp13 mhn13 vdd vbsyn gsyn
X_ihx_9_13 a_xp9 a_xn9 wp_ih_9_13 wn_ih_9_13 xhp13 xhn13 vdd vbsyn gsyn
X_ihm_10_13 a_xp10 a_xn10 wp_ih_10_13 wn_ih_10_13 mhp13 mhn13 vdd vbsyn gsyn
X_ihx_10_13 a_xp10 a_xn10 wp_ih_10_13 wn_ih_10_13 xhp13 xhn13 vdd vbsyn gsyn
X_ihm_11_13 a_xp11 a_xn11 wp_ih_11_13 wn_ih_11_13 mhp13 mhn13 vdd vbsyn gsyn
X_ihx_11_13 a_xp11 a_xn11 wp_ih_11_13 wn_ih_11_13 xhp13 xhn13 vdd vbsyn gsyn
X_ihm_12_13 a_xp12 a_xn12 wp_ih_12_13 wn_ih_12_13 mhp13 mhn13 vdd vbsyn gsyn
X_ihx_12_13 a_xp12 a_xn12 wp_ih_12_13 wn_ih_12_13 xhp13 xhn13 vdd vbsyn gsyn
X_ihm_13_13 a_xp13 a_xn13 wp_ih_13_13 wn_ih_13_13 mhp13 mhn13 vdd vbsyn gsyn
X_ihx_13_13 a_xp13 a_xn13 wp_ih_13_13 wn_ih_13_13 xhp13 xhn13 vdd vbsyn gsyn
X_ihm_14_13 a_xp14 a_xn14 wp_ih_14_13 wn_ih_14_13 mhp13 mhn13 vdd vbsyn gsyn
X_ihx_14_13 a_xp14 a_xn14 wp_ih_14_13 wn_ih_14_13 xhp13 xhn13 vdd vbsyn gsyn
X_ihm_15_13 a_xp15 a_xn15 wp_ih_15_13 wn_ih_15_13 mhp13 mhn13 vdd vbsyn gsyn
X_ihx_15_13 a_xp15 a_xn15 wp_ih_15_13 wn_ih_15_13 xhp13 xhn13 vdd vbsyn gsyn
X_ihm_16_13 a_xp16 a_xn16 wp_ih_16_13 wn_ih_16_13 mhp13 mhn13 vdd vbsyn gsyn
X_ihx_16_13 a_xp16 a_xn16 wp_ih_16_13 wn_ih_16_13 xhp13 xhn13 vdd vbsyn gsyn
X_ihm_17_13 a_xp17 a_xn17 wp_ih_17_13 wn_ih_17_13 mhp13 mhn13 vdd vbsyn gsyn
X_ihx_17_13 a_xp17 a_xn17 wp_ih_17_13 wn_ih_17_13 xhp13 xhn13 vdd vbsyn gsyn
X_ihm_18_13 a_xp18 a_xn18 wp_ih_18_13 wn_ih_18_13 mhp13 mhn13 vdd vbsyn gsyn
X_ihx_18_13 a_xp18 a_xn18 wp_ih_18_13 wn_ih_18_13 xhp13 xhn13 vdd vbsyn gsyn
X_ihm_19_13 a_xp19 a_xn19 wp_ih_19_13 wn_ih_19_13 mhp13 mhn13 vdd vbsyn gsyn
X_ihx_19_13 a_xp19 a_xn19 wp_ih_19_13 wn_ih_19_13 xhp13 xhn13 vdd vbsyn gsyn
X_ihm_20_13 a_xp20 a_xn20 wp_ih_20_13 wn_ih_20_13 mhp13 mhn13 vdd vbsyn gsyn
X_ihx_20_13 a_xp20 a_xn20 wp_ih_20_13 wn_ih_20_13 xhp13 xhn13 vdd vbsyn gsyn
X_ihm_21_13 a_xp21 a_xn21 wp_ih_21_13 wn_ih_21_13 mhp13 mhn13 vdd vbsyn gsyn
X_ihx_21_13 a_xp21 a_xn21 wp_ih_21_13 wn_ih_21_13 xhp13 xhn13 vdd vbsyn gsyn
X_ihm_22_13 a_xp22 a_xn22 wp_ih_22_13 wn_ih_22_13 mhp13 mhn13 vdd vbsyn gsyn
X_ihx_22_13 a_xp22 a_xn22 wp_ih_22_13 wn_ih_22_13 xhp13 xhn13 vdd vbsyn gsyn
X_ihm_23_13 a_xp23 a_xn23 wp_ih_23_13 wn_ih_23_13 mhp13 mhn13 vdd vbsyn gsyn
X_ihx_23_13 a_xp23 a_xn23 wp_ih_23_13 wn_ih_23_13 xhp13 xhn13 vdd vbsyn gsyn
X_ihm_24_13 a_xp24 a_xn24 wp_ih_24_13 wn_ih_24_13 mhp13 mhn13 vdd vbsyn gsyn
X_ihx_24_13 a_xp24 a_xn24 wp_ih_24_13 wn_ih_24_13 xhp13 xhn13 vdd vbsyn gsyn
X_ihm_25_13 a_xp25 a_xn25 wp_ih_25_13 wn_ih_25_13 mhp13 mhn13 vdd vbsyn gsyn
X_ihx_25_13 a_xp25 a_xn25 wp_ih_25_13 wn_ih_25_13 xhp13 xhn13 vdd vbsyn gsyn
X_ihm_26_13 a_xp26 a_xn26 wp_ih_26_13 wn_ih_26_13 mhp13 mhn13 vdd vbsyn gsyn
X_ihx_26_13 a_xp26 a_xn26 wp_ih_26_13 wn_ih_26_13 xhp13 xhn13 vdd vbsyn gsyn
X_ihm_27_13 a_xp27 a_xn27 wp_ih_27_13 wn_ih_27_13 mhp13 mhn13 vdd vbsyn gsyn
X_ihx_27_13 a_xp27 a_xn27 wp_ih_27_13 wn_ih_27_13 xhp13 xhn13 vdd vbsyn gsyn
X_ihm_28_13 a_xp28 a_xn28 wp_ih_28_13 wn_ih_28_13 mhp13 mhn13 vdd vbsyn gsyn
X_ihx_28_13 a_xp28 a_xn28 wp_ih_28_13 wn_ih_28_13 xhp13 xhn13 vdd vbsyn gsyn
X_ihm_29_13 a_xp29 a_xn29 wp_ih_29_13 wn_ih_29_13 mhp13 mhn13 vdd vbsyn gsyn
X_ihx_29_13 a_xp29 a_xn29 wp_ih_29_13 wn_ih_29_13 xhp13 xhn13 vdd vbsyn gsyn
X_ihm_30_13 a_xp30 a_xn30 wp_ih_30_13 wn_ih_30_13 mhp13 mhn13 vdd vbsyn gsyn
X_ihx_30_13 a_xp30 a_xn30 wp_ih_30_13 wn_ih_30_13 xhp13 xhn13 vdd vbsyn gsyn
X_ihm_31_13 a_xp31 a_xn31 wp_ih_31_13 wn_ih_31_13 mhp13 mhn13 vdd vbsyn gsyn
X_ihx_31_13 a_xp31 a_xn31 wp_ih_31_13 wn_ih_31_13 xhp13 xhn13 vdd vbsyn gsyn
X_ihm_32_13 a_xp32 a_xn32 wp_ih_32_13 wn_ih_32_13 mhp13 mhn13 vdd vbsyn gsyn
X_ihx_32_13 a_xp32 a_xn32 wp_ih_32_13 wn_ih_32_13 xhp13 xhn13 vdd vbsyn gsyn
X_ihm_33_13 a_xp33 a_xn33 wp_ih_33_13 wn_ih_33_13 mhp13 mhn13 vdd vbsyn gsyn
X_ihx_33_13 a_xp33 a_xn33 wp_ih_33_13 wn_ih_33_13 xhp13 xhn13 vdd vbsyn gsyn
X_ihm_34_13 a_xp34 a_xn34 wp_ih_34_13 wn_ih_34_13 mhp13 mhn13 vdd vbsyn gsyn
X_ihx_34_13 a_xp34 a_xn34 wp_ih_34_13 wn_ih_34_13 xhp13 xhn13 vdd vbsyn gsyn
X_ihm_35_13 a_xp35 a_xn35 wp_ih_35_13 wn_ih_35_13 mhp13 mhn13 vdd vbsyn gsyn
X_ihx_35_13 a_xp35 a_xn35 wp_ih_35_13 wn_ih_35_13 xhp13 xhn13 vdd vbsyn gsyn
X_ihm_36_13 a_xp36 a_xn36 wp_ih_36_13 wn_ih_36_13 mhp13 mhn13 vdd vbsyn gsyn
X_ihx_36_13 a_xp36 a_xn36 wp_ih_36_13 wn_ih_36_13 xhp13 xhn13 vdd vbsyn gsyn
X_ihm_37_13 a_xp37 a_xn37 wp_ih_37_13 wn_ih_37_13 mhp13 mhn13 vdd vbsyn gsyn
X_ihx_37_13 a_xp37 a_xn37 wp_ih_37_13 wn_ih_37_13 xhp13 xhn13 vdd vbsyn gsyn
X_ihm_38_13 a_xp38 a_xn38 wp_ih_38_13 wn_ih_38_13 mhp13 mhn13 vdd vbsyn gsyn
X_ihx_38_13 a_xp38 a_xn38 wp_ih_38_13 wn_ih_38_13 xhp13 xhn13 vdd vbsyn gsyn
X_ihm_39_13 a_xp39 a_xn39 wp_ih_39_13 wn_ih_39_13 mhp13 mhn13 vdd vbsyn gsyn
X_ihx_39_13 a_xp39 a_xn39 wp_ih_39_13 wn_ih_39_13 xhp13 xhn13 vdd vbsyn gsyn
X_ihm_40_13 a_xp40 a_xn40 wp_ih_40_13 wn_ih_40_13 mhp13 mhn13 vdd vbsyn gsyn
X_ihx_40_13 a_xp40 a_xn40 wp_ih_40_13 wn_ih_40_13 xhp13 xhn13 vdd vbsyn gsyn
X_ihm_41_13 a_xp41 a_xn41 wp_ih_41_13 wn_ih_41_13 mhp13 mhn13 vdd vbsyn gsyn
X_ihx_41_13 a_xp41 a_xn41 wp_ih_41_13 wn_ih_41_13 xhp13 xhn13 vdd vbsyn gsyn
X_ihm_42_13 a_xp42 a_xn42 wp_ih_42_13 wn_ih_42_13 mhp13 mhn13 vdd vbsyn gsyn
X_ihx_42_13 a_xp42 a_xn42 wp_ih_42_13 wn_ih_42_13 xhp13 xhn13 vdd vbsyn gsyn
X_ihm_43_13 a_xp43 a_xn43 wp_ih_43_13 wn_ih_43_13 mhp13 mhn13 vdd vbsyn gsyn
X_ihx_43_13 a_xp43 a_xn43 wp_ih_43_13 wn_ih_43_13 xhp13 xhn13 vdd vbsyn gsyn
X_ihm_44_13 a_xp44 a_xn44 wp_ih_44_13 wn_ih_44_13 mhp13 mhn13 vdd vbsyn gsyn
X_ihx_44_13 a_xp44 a_xn44 wp_ih_44_13 wn_ih_44_13 xhp13 xhn13 vdd vbsyn gsyn
X_ihm_45_13 a_xp45 a_xn45 wp_ih_45_13 wn_ih_45_13 mhp13 mhn13 vdd vbsyn gsyn
X_ihx_45_13 a_xp45 a_xn45 wp_ih_45_13 wn_ih_45_13 xhp13 xhn13 vdd vbsyn gsyn
X_ihm_46_13 a_xp46 a_xn46 wp_ih_46_13 wn_ih_46_13 mhp13 mhn13 vdd vbsyn gsyn
X_ihx_46_13 a_xp46 a_xn46 wp_ih_46_13 wn_ih_46_13 xhp13 xhn13 vdd vbsyn gsyn
X_ihm_47_13 a_xp47 a_xn47 wp_ih_47_13 wn_ih_47_13 mhp13 mhn13 vdd vbsyn gsyn
X_ihx_47_13 a_xp47 a_xn47 wp_ih_47_13 wn_ih_47_13 xhp13 xhn13 vdd vbsyn gsyn
X_ihm_48_13 a_xp48 a_xn48 wp_ih_48_13 wn_ih_48_13 mhp13 mhn13 vdd vbsyn gsyn
X_ihx_48_13 a_xp48 a_xn48 wp_ih_48_13 wn_ih_48_13 xhp13 xhn13 vdd vbsyn gsyn
X_ihm_49_13 a_xp49 a_xn49 wp_ih_49_13 wn_ih_49_13 mhp13 mhn13 vdd vbsyn gsyn
X_ihx_49_13 a_xp49 a_xn49 wp_ih_49_13 wn_ih_49_13 xhp13 xhn13 vdd vbsyn gsyn
X_ihm_50_13 a_xp50 a_xn50 wp_ih_50_13 wn_ih_50_13 mhp13 mhn13 vdd vbsyn gsyn
X_ihx_50_13 a_xp50 a_xn50 wp_ih_50_13 wn_ih_50_13 xhp13 xhn13 vdd vbsyn gsyn
X_ihm_51_13 a_xp51 a_xn51 wp_ih_51_13 wn_ih_51_13 mhp13 mhn13 vdd vbsyn gsyn
X_ihx_51_13 a_xp51 a_xn51 wp_ih_51_13 wn_ih_51_13 xhp13 xhn13 vdd vbsyn gsyn
X_ihm_52_13 a_xp52 a_xn52 wp_ih_52_13 wn_ih_52_13 mhp13 mhn13 vdd vbsyn gsyn
X_ihx_52_13 a_xp52 a_xn52 wp_ih_52_13 wn_ih_52_13 xhp13 xhn13 vdd vbsyn gsyn
X_ihm_53_13 a_xp53 a_xn53 wp_ih_53_13 wn_ih_53_13 mhp13 mhn13 vdd vbsyn gsyn
X_ihx_53_13 a_xp53 a_xn53 wp_ih_53_13 wn_ih_53_13 xhp13 xhn13 vdd vbsyn gsyn
X_ihm_54_13 a_xp54 a_xn54 wp_ih_54_13 wn_ih_54_13 mhp13 mhn13 vdd vbsyn gsyn
X_ihx_54_13 a_xp54 a_xn54 wp_ih_54_13 wn_ih_54_13 xhp13 xhn13 vdd vbsyn gsyn
X_ihm_55_13 a_xp55 a_xn55 wp_ih_55_13 wn_ih_55_13 mhp13 mhn13 vdd vbsyn gsyn
X_ihx_55_13 a_xp55 a_xn55 wp_ih_55_13 wn_ih_55_13 xhp13 xhn13 vdd vbsyn gsyn
X_ihm_56_13 a_xp56 a_xn56 wp_ih_56_13 wn_ih_56_13 mhp13 mhn13 vdd vbsyn gsyn
X_ihx_56_13 a_xp56 a_xn56 wp_ih_56_13 wn_ih_56_13 xhp13 xhn13 vdd vbsyn gsyn
X_ihm_57_13 a_xp57 a_xn57 wp_ih_57_13 wn_ih_57_13 mhp13 mhn13 vdd vbsyn gsyn
X_ihx_57_13 a_xp57 a_xn57 wp_ih_57_13 wn_ih_57_13 xhp13 xhn13 vdd vbsyn gsyn
X_ihm_58_13 a_xp58 a_xn58 wp_ih_58_13 wn_ih_58_13 mhp13 mhn13 vdd vbsyn gsyn
X_ihx_58_13 a_xp58 a_xn58 wp_ih_58_13 wn_ih_58_13 xhp13 xhn13 vdd vbsyn gsyn
X_ihm_59_13 a_xp59 a_xn59 wp_ih_59_13 wn_ih_59_13 mhp13 mhn13 vdd vbsyn gsyn
X_ihx_59_13 a_xp59 a_xn59 wp_ih_59_13 wn_ih_59_13 xhp13 xhn13 vdd vbsyn gsyn
X_ihm_60_13 a_xp60 a_xn60 wp_ih_60_13 wn_ih_60_13 mhp13 mhn13 vdd vbsyn gsyn
X_ihx_60_13 a_xp60 a_xn60 wp_ih_60_13 wn_ih_60_13 xhp13 xhn13 vdd vbsyn gsyn
X_ihm_61_13 a_xp61 a_xn61 wp_ih_61_13 wn_ih_61_13 mhp13 mhn13 vdd vbsyn gsyn
X_ihx_61_13 a_xp61 a_xn61 wp_ih_61_13 wn_ih_61_13 xhp13 xhn13 vdd vbsyn gsyn
X_ihm_62_13 a_xp62 a_xn62 wp_ih_62_13 wn_ih_62_13 mhp13 mhn13 vdd vbsyn gsyn
X_ihx_62_13 a_xp62 a_xn62 wp_ih_62_13 wn_ih_62_13 xhp13 xhn13 vdd vbsyn gsyn
X_ihm_63_13 a_xp63 a_xn63 wp_ih_63_13 wn_ih_63_13 mhp13 mhn13 vdd vbsyn gsyn
X_ihx_63_13 a_xp63 a_xn63 wp_ih_63_13 wn_ih_63_13 xhp13 xhn13 vdd vbsyn gsyn
X_bk_13_0 eop0 eon0 wp_ho_13_0 wn_ho_13_0 xhp13 xhn13 vdd vbbk gsyn
X_bk_13_1 eop1 eon1 wp_ho_13_1 wn_ho_13_1 xhp13 xhn13 vdd vbbk gsyn
X_bk_13_2 eop2 eon2 wp_ho_13_2 wn_ho_13_2 xhp13 xhn13 vdd vbbk gsyn
X_bk_13_3 eop3 eon3 wp_ho_13_3 wn_ho_13_3 xhp13 xhn13 vdd vbbk gsyn
X_bk_13_4 eop4 eon4 wp_ho_13_4 wn_ho_13_4 xhp13 xhn13 vdd vbbk gsyn
Xn13 xhp13 xhn13 ahp13 ahn13 vdd vbneu dneuron
Xeh13 xhp13 xhn13 mhp13 mhn13 ehp13 ehn13 vdd gm esub
Xcm_mh14 mhp14 mhn14 vdd cmld
Rnd_mh14 mhp14 mhn14 20k
Xcm_xh14 xhp14 xhn14 vdd cmld
Rnd_xh14 xhp14 xhn14 20k
X_ihm_0_14 a_xp0 a_xn0 wp_ih_0_14 wn_ih_0_14 mhp14 mhn14 vdd vbsyn gsyn
X_ihx_0_14 a_xp0 a_xn0 wp_ih_0_14 wn_ih_0_14 xhp14 xhn14 vdd vbsyn gsyn
X_ihm_1_14 a_xp1 a_xn1 wp_ih_1_14 wn_ih_1_14 mhp14 mhn14 vdd vbsyn gsyn
X_ihx_1_14 a_xp1 a_xn1 wp_ih_1_14 wn_ih_1_14 xhp14 xhn14 vdd vbsyn gsyn
X_ihm_2_14 a_xp2 a_xn2 wp_ih_2_14 wn_ih_2_14 mhp14 mhn14 vdd vbsyn gsyn
X_ihx_2_14 a_xp2 a_xn2 wp_ih_2_14 wn_ih_2_14 xhp14 xhn14 vdd vbsyn gsyn
X_ihm_3_14 a_xp3 a_xn3 wp_ih_3_14 wn_ih_3_14 mhp14 mhn14 vdd vbsyn gsyn
X_ihx_3_14 a_xp3 a_xn3 wp_ih_3_14 wn_ih_3_14 xhp14 xhn14 vdd vbsyn gsyn
X_ihm_4_14 a_xp4 a_xn4 wp_ih_4_14 wn_ih_4_14 mhp14 mhn14 vdd vbsyn gsyn
X_ihx_4_14 a_xp4 a_xn4 wp_ih_4_14 wn_ih_4_14 xhp14 xhn14 vdd vbsyn gsyn
X_ihm_5_14 a_xp5 a_xn5 wp_ih_5_14 wn_ih_5_14 mhp14 mhn14 vdd vbsyn gsyn
X_ihx_5_14 a_xp5 a_xn5 wp_ih_5_14 wn_ih_5_14 xhp14 xhn14 vdd vbsyn gsyn
X_ihm_6_14 a_xp6 a_xn6 wp_ih_6_14 wn_ih_6_14 mhp14 mhn14 vdd vbsyn gsyn
X_ihx_6_14 a_xp6 a_xn6 wp_ih_6_14 wn_ih_6_14 xhp14 xhn14 vdd vbsyn gsyn
X_ihm_7_14 a_xp7 a_xn7 wp_ih_7_14 wn_ih_7_14 mhp14 mhn14 vdd vbsyn gsyn
X_ihx_7_14 a_xp7 a_xn7 wp_ih_7_14 wn_ih_7_14 xhp14 xhn14 vdd vbsyn gsyn
X_ihm_8_14 a_xp8 a_xn8 wp_ih_8_14 wn_ih_8_14 mhp14 mhn14 vdd vbsyn gsyn
X_ihx_8_14 a_xp8 a_xn8 wp_ih_8_14 wn_ih_8_14 xhp14 xhn14 vdd vbsyn gsyn
X_ihm_9_14 a_xp9 a_xn9 wp_ih_9_14 wn_ih_9_14 mhp14 mhn14 vdd vbsyn gsyn
X_ihx_9_14 a_xp9 a_xn9 wp_ih_9_14 wn_ih_9_14 xhp14 xhn14 vdd vbsyn gsyn
X_ihm_10_14 a_xp10 a_xn10 wp_ih_10_14 wn_ih_10_14 mhp14 mhn14 vdd vbsyn gsyn
X_ihx_10_14 a_xp10 a_xn10 wp_ih_10_14 wn_ih_10_14 xhp14 xhn14 vdd vbsyn gsyn
X_ihm_11_14 a_xp11 a_xn11 wp_ih_11_14 wn_ih_11_14 mhp14 mhn14 vdd vbsyn gsyn
X_ihx_11_14 a_xp11 a_xn11 wp_ih_11_14 wn_ih_11_14 xhp14 xhn14 vdd vbsyn gsyn
X_ihm_12_14 a_xp12 a_xn12 wp_ih_12_14 wn_ih_12_14 mhp14 mhn14 vdd vbsyn gsyn
X_ihx_12_14 a_xp12 a_xn12 wp_ih_12_14 wn_ih_12_14 xhp14 xhn14 vdd vbsyn gsyn
X_ihm_13_14 a_xp13 a_xn13 wp_ih_13_14 wn_ih_13_14 mhp14 mhn14 vdd vbsyn gsyn
X_ihx_13_14 a_xp13 a_xn13 wp_ih_13_14 wn_ih_13_14 xhp14 xhn14 vdd vbsyn gsyn
X_ihm_14_14 a_xp14 a_xn14 wp_ih_14_14 wn_ih_14_14 mhp14 mhn14 vdd vbsyn gsyn
X_ihx_14_14 a_xp14 a_xn14 wp_ih_14_14 wn_ih_14_14 xhp14 xhn14 vdd vbsyn gsyn
X_ihm_15_14 a_xp15 a_xn15 wp_ih_15_14 wn_ih_15_14 mhp14 mhn14 vdd vbsyn gsyn
X_ihx_15_14 a_xp15 a_xn15 wp_ih_15_14 wn_ih_15_14 xhp14 xhn14 vdd vbsyn gsyn
X_ihm_16_14 a_xp16 a_xn16 wp_ih_16_14 wn_ih_16_14 mhp14 mhn14 vdd vbsyn gsyn
X_ihx_16_14 a_xp16 a_xn16 wp_ih_16_14 wn_ih_16_14 xhp14 xhn14 vdd vbsyn gsyn
X_ihm_17_14 a_xp17 a_xn17 wp_ih_17_14 wn_ih_17_14 mhp14 mhn14 vdd vbsyn gsyn
X_ihx_17_14 a_xp17 a_xn17 wp_ih_17_14 wn_ih_17_14 xhp14 xhn14 vdd vbsyn gsyn
X_ihm_18_14 a_xp18 a_xn18 wp_ih_18_14 wn_ih_18_14 mhp14 mhn14 vdd vbsyn gsyn
X_ihx_18_14 a_xp18 a_xn18 wp_ih_18_14 wn_ih_18_14 xhp14 xhn14 vdd vbsyn gsyn
X_ihm_19_14 a_xp19 a_xn19 wp_ih_19_14 wn_ih_19_14 mhp14 mhn14 vdd vbsyn gsyn
X_ihx_19_14 a_xp19 a_xn19 wp_ih_19_14 wn_ih_19_14 xhp14 xhn14 vdd vbsyn gsyn
X_ihm_20_14 a_xp20 a_xn20 wp_ih_20_14 wn_ih_20_14 mhp14 mhn14 vdd vbsyn gsyn
X_ihx_20_14 a_xp20 a_xn20 wp_ih_20_14 wn_ih_20_14 xhp14 xhn14 vdd vbsyn gsyn
X_ihm_21_14 a_xp21 a_xn21 wp_ih_21_14 wn_ih_21_14 mhp14 mhn14 vdd vbsyn gsyn
X_ihx_21_14 a_xp21 a_xn21 wp_ih_21_14 wn_ih_21_14 xhp14 xhn14 vdd vbsyn gsyn
X_ihm_22_14 a_xp22 a_xn22 wp_ih_22_14 wn_ih_22_14 mhp14 mhn14 vdd vbsyn gsyn
X_ihx_22_14 a_xp22 a_xn22 wp_ih_22_14 wn_ih_22_14 xhp14 xhn14 vdd vbsyn gsyn
X_ihm_23_14 a_xp23 a_xn23 wp_ih_23_14 wn_ih_23_14 mhp14 mhn14 vdd vbsyn gsyn
X_ihx_23_14 a_xp23 a_xn23 wp_ih_23_14 wn_ih_23_14 xhp14 xhn14 vdd vbsyn gsyn
X_ihm_24_14 a_xp24 a_xn24 wp_ih_24_14 wn_ih_24_14 mhp14 mhn14 vdd vbsyn gsyn
X_ihx_24_14 a_xp24 a_xn24 wp_ih_24_14 wn_ih_24_14 xhp14 xhn14 vdd vbsyn gsyn
X_ihm_25_14 a_xp25 a_xn25 wp_ih_25_14 wn_ih_25_14 mhp14 mhn14 vdd vbsyn gsyn
X_ihx_25_14 a_xp25 a_xn25 wp_ih_25_14 wn_ih_25_14 xhp14 xhn14 vdd vbsyn gsyn
X_ihm_26_14 a_xp26 a_xn26 wp_ih_26_14 wn_ih_26_14 mhp14 mhn14 vdd vbsyn gsyn
X_ihx_26_14 a_xp26 a_xn26 wp_ih_26_14 wn_ih_26_14 xhp14 xhn14 vdd vbsyn gsyn
X_ihm_27_14 a_xp27 a_xn27 wp_ih_27_14 wn_ih_27_14 mhp14 mhn14 vdd vbsyn gsyn
X_ihx_27_14 a_xp27 a_xn27 wp_ih_27_14 wn_ih_27_14 xhp14 xhn14 vdd vbsyn gsyn
X_ihm_28_14 a_xp28 a_xn28 wp_ih_28_14 wn_ih_28_14 mhp14 mhn14 vdd vbsyn gsyn
X_ihx_28_14 a_xp28 a_xn28 wp_ih_28_14 wn_ih_28_14 xhp14 xhn14 vdd vbsyn gsyn
X_ihm_29_14 a_xp29 a_xn29 wp_ih_29_14 wn_ih_29_14 mhp14 mhn14 vdd vbsyn gsyn
X_ihx_29_14 a_xp29 a_xn29 wp_ih_29_14 wn_ih_29_14 xhp14 xhn14 vdd vbsyn gsyn
X_ihm_30_14 a_xp30 a_xn30 wp_ih_30_14 wn_ih_30_14 mhp14 mhn14 vdd vbsyn gsyn
X_ihx_30_14 a_xp30 a_xn30 wp_ih_30_14 wn_ih_30_14 xhp14 xhn14 vdd vbsyn gsyn
X_ihm_31_14 a_xp31 a_xn31 wp_ih_31_14 wn_ih_31_14 mhp14 mhn14 vdd vbsyn gsyn
X_ihx_31_14 a_xp31 a_xn31 wp_ih_31_14 wn_ih_31_14 xhp14 xhn14 vdd vbsyn gsyn
X_ihm_32_14 a_xp32 a_xn32 wp_ih_32_14 wn_ih_32_14 mhp14 mhn14 vdd vbsyn gsyn
X_ihx_32_14 a_xp32 a_xn32 wp_ih_32_14 wn_ih_32_14 xhp14 xhn14 vdd vbsyn gsyn
X_ihm_33_14 a_xp33 a_xn33 wp_ih_33_14 wn_ih_33_14 mhp14 mhn14 vdd vbsyn gsyn
X_ihx_33_14 a_xp33 a_xn33 wp_ih_33_14 wn_ih_33_14 xhp14 xhn14 vdd vbsyn gsyn
X_ihm_34_14 a_xp34 a_xn34 wp_ih_34_14 wn_ih_34_14 mhp14 mhn14 vdd vbsyn gsyn
X_ihx_34_14 a_xp34 a_xn34 wp_ih_34_14 wn_ih_34_14 xhp14 xhn14 vdd vbsyn gsyn
X_ihm_35_14 a_xp35 a_xn35 wp_ih_35_14 wn_ih_35_14 mhp14 mhn14 vdd vbsyn gsyn
X_ihx_35_14 a_xp35 a_xn35 wp_ih_35_14 wn_ih_35_14 xhp14 xhn14 vdd vbsyn gsyn
X_ihm_36_14 a_xp36 a_xn36 wp_ih_36_14 wn_ih_36_14 mhp14 mhn14 vdd vbsyn gsyn
X_ihx_36_14 a_xp36 a_xn36 wp_ih_36_14 wn_ih_36_14 xhp14 xhn14 vdd vbsyn gsyn
X_ihm_37_14 a_xp37 a_xn37 wp_ih_37_14 wn_ih_37_14 mhp14 mhn14 vdd vbsyn gsyn
X_ihx_37_14 a_xp37 a_xn37 wp_ih_37_14 wn_ih_37_14 xhp14 xhn14 vdd vbsyn gsyn
X_ihm_38_14 a_xp38 a_xn38 wp_ih_38_14 wn_ih_38_14 mhp14 mhn14 vdd vbsyn gsyn
X_ihx_38_14 a_xp38 a_xn38 wp_ih_38_14 wn_ih_38_14 xhp14 xhn14 vdd vbsyn gsyn
X_ihm_39_14 a_xp39 a_xn39 wp_ih_39_14 wn_ih_39_14 mhp14 mhn14 vdd vbsyn gsyn
X_ihx_39_14 a_xp39 a_xn39 wp_ih_39_14 wn_ih_39_14 xhp14 xhn14 vdd vbsyn gsyn
X_ihm_40_14 a_xp40 a_xn40 wp_ih_40_14 wn_ih_40_14 mhp14 mhn14 vdd vbsyn gsyn
X_ihx_40_14 a_xp40 a_xn40 wp_ih_40_14 wn_ih_40_14 xhp14 xhn14 vdd vbsyn gsyn
X_ihm_41_14 a_xp41 a_xn41 wp_ih_41_14 wn_ih_41_14 mhp14 mhn14 vdd vbsyn gsyn
X_ihx_41_14 a_xp41 a_xn41 wp_ih_41_14 wn_ih_41_14 xhp14 xhn14 vdd vbsyn gsyn
X_ihm_42_14 a_xp42 a_xn42 wp_ih_42_14 wn_ih_42_14 mhp14 mhn14 vdd vbsyn gsyn
X_ihx_42_14 a_xp42 a_xn42 wp_ih_42_14 wn_ih_42_14 xhp14 xhn14 vdd vbsyn gsyn
X_ihm_43_14 a_xp43 a_xn43 wp_ih_43_14 wn_ih_43_14 mhp14 mhn14 vdd vbsyn gsyn
X_ihx_43_14 a_xp43 a_xn43 wp_ih_43_14 wn_ih_43_14 xhp14 xhn14 vdd vbsyn gsyn
X_ihm_44_14 a_xp44 a_xn44 wp_ih_44_14 wn_ih_44_14 mhp14 mhn14 vdd vbsyn gsyn
X_ihx_44_14 a_xp44 a_xn44 wp_ih_44_14 wn_ih_44_14 xhp14 xhn14 vdd vbsyn gsyn
X_ihm_45_14 a_xp45 a_xn45 wp_ih_45_14 wn_ih_45_14 mhp14 mhn14 vdd vbsyn gsyn
X_ihx_45_14 a_xp45 a_xn45 wp_ih_45_14 wn_ih_45_14 xhp14 xhn14 vdd vbsyn gsyn
X_ihm_46_14 a_xp46 a_xn46 wp_ih_46_14 wn_ih_46_14 mhp14 mhn14 vdd vbsyn gsyn
X_ihx_46_14 a_xp46 a_xn46 wp_ih_46_14 wn_ih_46_14 xhp14 xhn14 vdd vbsyn gsyn
X_ihm_47_14 a_xp47 a_xn47 wp_ih_47_14 wn_ih_47_14 mhp14 mhn14 vdd vbsyn gsyn
X_ihx_47_14 a_xp47 a_xn47 wp_ih_47_14 wn_ih_47_14 xhp14 xhn14 vdd vbsyn gsyn
X_ihm_48_14 a_xp48 a_xn48 wp_ih_48_14 wn_ih_48_14 mhp14 mhn14 vdd vbsyn gsyn
X_ihx_48_14 a_xp48 a_xn48 wp_ih_48_14 wn_ih_48_14 xhp14 xhn14 vdd vbsyn gsyn
X_ihm_49_14 a_xp49 a_xn49 wp_ih_49_14 wn_ih_49_14 mhp14 mhn14 vdd vbsyn gsyn
X_ihx_49_14 a_xp49 a_xn49 wp_ih_49_14 wn_ih_49_14 xhp14 xhn14 vdd vbsyn gsyn
X_ihm_50_14 a_xp50 a_xn50 wp_ih_50_14 wn_ih_50_14 mhp14 mhn14 vdd vbsyn gsyn
X_ihx_50_14 a_xp50 a_xn50 wp_ih_50_14 wn_ih_50_14 xhp14 xhn14 vdd vbsyn gsyn
X_ihm_51_14 a_xp51 a_xn51 wp_ih_51_14 wn_ih_51_14 mhp14 mhn14 vdd vbsyn gsyn
X_ihx_51_14 a_xp51 a_xn51 wp_ih_51_14 wn_ih_51_14 xhp14 xhn14 vdd vbsyn gsyn
X_ihm_52_14 a_xp52 a_xn52 wp_ih_52_14 wn_ih_52_14 mhp14 mhn14 vdd vbsyn gsyn
X_ihx_52_14 a_xp52 a_xn52 wp_ih_52_14 wn_ih_52_14 xhp14 xhn14 vdd vbsyn gsyn
X_ihm_53_14 a_xp53 a_xn53 wp_ih_53_14 wn_ih_53_14 mhp14 mhn14 vdd vbsyn gsyn
X_ihx_53_14 a_xp53 a_xn53 wp_ih_53_14 wn_ih_53_14 xhp14 xhn14 vdd vbsyn gsyn
X_ihm_54_14 a_xp54 a_xn54 wp_ih_54_14 wn_ih_54_14 mhp14 mhn14 vdd vbsyn gsyn
X_ihx_54_14 a_xp54 a_xn54 wp_ih_54_14 wn_ih_54_14 xhp14 xhn14 vdd vbsyn gsyn
X_ihm_55_14 a_xp55 a_xn55 wp_ih_55_14 wn_ih_55_14 mhp14 mhn14 vdd vbsyn gsyn
X_ihx_55_14 a_xp55 a_xn55 wp_ih_55_14 wn_ih_55_14 xhp14 xhn14 vdd vbsyn gsyn
X_ihm_56_14 a_xp56 a_xn56 wp_ih_56_14 wn_ih_56_14 mhp14 mhn14 vdd vbsyn gsyn
X_ihx_56_14 a_xp56 a_xn56 wp_ih_56_14 wn_ih_56_14 xhp14 xhn14 vdd vbsyn gsyn
X_ihm_57_14 a_xp57 a_xn57 wp_ih_57_14 wn_ih_57_14 mhp14 mhn14 vdd vbsyn gsyn
X_ihx_57_14 a_xp57 a_xn57 wp_ih_57_14 wn_ih_57_14 xhp14 xhn14 vdd vbsyn gsyn
X_ihm_58_14 a_xp58 a_xn58 wp_ih_58_14 wn_ih_58_14 mhp14 mhn14 vdd vbsyn gsyn
X_ihx_58_14 a_xp58 a_xn58 wp_ih_58_14 wn_ih_58_14 xhp14 xhn14 vdd vbsyn gsyn
X_ihm_59_14 a_xp59 a_xn59 wp_ih_59_14 wn_ih_59_14 mhp14 mhn14 vdd vbsyn gsyn
X_ihx_59_14 a_xp59 a_xn59 wp_ih_59_14 wn_ih_59_14 xhp14 xhn14 vdd vbsyn gsyn
X_ihm_60_14 a_xp60 a_xn60 wp_ih_60_14 wn_ih_60_14 mhp14 mhn14 vdd vbsyn gsyn
X_ihx_60_14 a_xp60 a_xn60 wp_ih_60_14 wn_ih_60_14 xhp14 xhn14 vdd vbsyn gsyn
X_ihm_61_14 a_xp61 a_xn61 wp_ih_61_14 wn_ih_61_14 mhp14 mhn14 vdd vbsyn gsyn
X_ihx_61_14 a_xp61 a_xn61 wp_ih_61_14 wn_ih_61_14 xhp14 xhn14 vdd vbsyn gsyn
X_ihm_62_14 a_xp62 a_xn62 wp_ih_62_14 wn_ih_62_14 mhp14 mhn14 vdd vbsyn gsyn
X_ihx_62_14 a_xp62 a_xn62 wp_ih_62_14 wn_ih_62_14 xhp14 xhn14 vdd vbsyn gsyn
X_ihm_63_14 a_xp63 a_xn63 wp_ih_63_14 wn_ih_63_14 mhp14 mhn14 vdd vbsyn gsyn
X_ihx_63_14 a_xp63 a_xn63 wp_ih_63_14 wn_ih_63_14 xhp14 xhn14 vdd vbsyn gsyn
X_bk_14_0 eop0 eon0 wp_ho_14_0 wn_ho_14_0 xhp14 xhn14 vdd vbbk gsyn
X_bk_14_1 eop1 eon1 wp_ho_14_1 wn_ho_14_1 xhp14 xhn14 vdd vbbk gsyn
X_bk_14_2 eop2 eon2 wp_ho_14_2 wn_ho_14_2 xhp14 xhn14 vdd vbbk gsyn
X_bk_14_3 eop3 eon3 wp_ho_14_3 wn_ho_14_3 xhp14 xhn14 vdd vbbk gsyn
X_bk_14_4 eop4 eon4 wp_ho_14_4 wn_ho_14_4 xhp14 xhn14 vdd vbbk gsyn
Xn14 xhp14 xhn14 ahp14 ahn14 vdd vbneu dneuron
Xeh14 xhp14 xhn14 mhp14 mhn14 ehp14 ehn14 vdd gm esub
Xcm_mh15 mhp15 mhn15 vdd cmld
Rnd_mh15 mhp15 mhn15 20k
Xcm_xh15 xhp15 xhn15 vdd cmld
Rnd_xh15 xhp15 xhn15 20k
X_ihm_0_15 a_xp0 a_xn0 wp_ih_0_15 wn_ih_0_15 mhp15 mhn15 vdd vbsyn gsyn
X_ihx_0_15 a_xp0 a_xn0 wp_ih_0_15 wn_ih_0_15 xhp15 xhn15 vdd vbsyn gsyn
X_ihm_1_15 a_xp1 a_xn1 wp_ih_1_15 wn_ih_1_15 mhp15 mhn15 vdd vbsyn gsyn
X_ihx_1_15 a_xp1 a_xn1 wp_ih_1_15 wn_ih_1_15 xhp15 xhn15 vdd vbsyn gsyn
X_ihm_2_15 a_xp2 a_xn2 wp_ih_2_15 wn_ih_2_15 mhp15 mhn15 vdd vbsyn gsyn
X_ihx_2_15 a_xp2 a_xn2 wp_ih_2_15 wn_ih_2_15 xhp15 xhn15 vdd vbsyn gsyn
X_ihm_3_15 a_xp3 a_xn3 wp_ih_3_15 wn_ih_3_15 mhp15 mhn15 vdd vbsyn gsyn
X_ihx_3_15 a_xp3 a_xn3 wp_ih_3_15 wn_ih_3_15 xhp15 xhn15 vdd vbsyn gsyn
X_ihm_4_15 a_xp4 a_xn4 wp_ih_4_15 wn_ih_4_15 mhp15 mhn15 vdd vbsyn gsyn
X_ihx_4_15 a_xp4 a_xn4 wp_ih_4_15 wn_ih_4_15 xhp15 xhn15 vdd vbsyn gsyn
X_ihm_5_15 a_xp5 a_xn5 wp_ih_5_15 wn_ih_5_15 mhp15 mhn15 vdd vbsyn gsyn
X_ihx_5_15 a_xp5 a_xn5 wp_ih_5_15 wn_ih_5_15 xhp15 xhn15 vdd vbsyn gsyn
X_ihm_6_15 a_xp6 a_xn6 wp_ih_6_15 wn_ih_6_15 mhp15 mhn15 vdd vbsyn gsyn
X_ihx_6_15 a_xp6 a_xn6 wp_ih_6_15 wn_ih_6_15 xhp15 xhn15 vdd vbsyn gsyn
X_ihm_7_15 a_xp7 a_xn7 wp_ih_7_15 wn_ih_7_15 mhp15 mhn15 vdd vbsyn gsyn
X_ihx_7_15 a_xp7 a_xn7 wp_ih_7_15 wn_ih_7_15 xhp15 xhn15 vdd vbsyn gsyn
X_ihm_8_15 a_xp8 a_xn8 wp_ih_8_15 wn_ih_8_15 mhp15 mhn15 vdd vbsyn gsyn
X_ihx_8_15 a_xp8 a_xn8 wp_ih_8_15 wn_ih_8_15 xhp15 xhn15 vdd vbsyn gsyn
X_ihm_9_15 a_xp9 a_xn9 wp_ih_9_15 wn_ih_9_15 mhp15 mhn15 vdd vbsyn gsyn
X_ihx_9_15 a_xp9 a_xn9 wp_ih_9_15 wn_ih_9_15 xhp15 xhn15 vdd vbsyn gsyn
X_ihm_10_15 a_xp10 a_xn10 wp_ih_10_15 wn_ih_10_15 mhp15 mhn15 vdd vbsyn gsyn
X_ihx_10_15 a_xp10 a_xn10 wp_ih_10_15 wn_ih_10_15 xhp15 xhn15 vdd vbsyn gsyn
X_ihm_11_15 a_xp11 a_xn11 wp_ih_11_15 wn_ih_11_15 mhp15 mhn15 vdd vbsyn gsyn
X_ihx_11_15 a_xp11 a_xn11 wp_ih_11_15 wn_ih_11_15 xhp15 xhn15 vdd vbsyn gsyn
X_ihm_12_15 a_xp12 a_xn12 wp_ih_12_15 wn_ih_12_15 mhp15 mhn15 vdd vbsyn gsyn
X_ihx_12_15 a_xp12 a_xn12 wp_ih_12_15 wn_ih_12_15 xhp15 xhn15 vdd vbsyn gsyn
X_ihm_13_15 a_xp13 a_xn13 wp_ih_13_15 wn_ih_13_15 mhp15 mhn15 vdd vbsyn gsyn
X_ihx_13_15 a_xp13 a_xn13 wp_ih_13_15 wn_ih_13_15 xhp15 xhn15 vdd vbsyn gsyn
X_ihm_14_15 a_xp14 a_xn14 wp_ih_14_15 wn_ih_14_15 mhp15 mhn15 vdd vbsyn gsyn
X_ihx_14_15 a_xp14 a_xn14 wp_ih_14_15 wn_ih_14_15 xhp15 xhn15 vdd vbsyn gsyn
X_ihm_15_15 a_xp15 a_xn15 wp_ih_15_15 wn_ih_15_15 mhp15 mhn15 vdd vbsyn gsyn
X_ihx_15_15 a_xp15 a_xn15 wp_ih_15_15 wn_ih_15_15 xhp15 xhn15 vdd vbsyn gsyn
X_ihm_16_15 a_xp16 a_xn16 wp_ih_16_15 wn_ih_16_15 mhp15 mhn15 vdd vbsyn gsyn
X_ihx_16_15 a_xp16 a_xn16 wp_ih_16_15 wn_ih_16_15 xhp15 xhn15 vdd vbsyn gsyn
X_ihm_17_15 a_xp17 a_xn17 wp_ih_17_15 wn_ih_17_15 mhp15 mhn15 vdd vbsyn gsyn
X_ihx_17_15 a_xp17 a_xn17 wp_ih_17_15 wn_ih_17_15 xhp15 xhn15 vdd vbsyn gsyn
X_ihm_18_15 a_xp18 a_xn18 wp_ih_18_15 wn_ih_18_15 mhp15 mhn15 vdd vbsyn gsyn
X_ihx_18_15 a_xp18 a_xn18 wp_ih_18_15 wn_ih_18_15 xhp15 xhn15 vdd vbsyn gsyn
X_ihm_19_15 a_xp19 a_xn19 wp_ih_19_15 wn_ih_19_15 mhp15 mhn15 vdd vbsyn gsyn
X_ihx_19_15 a_xp19 a_xn19 wp_ih_19_15 wn_ih_19_15 xhp15 xhn15 vdd vbsyn gsyn
X_ihm_20_15 a_xp20 a_xn20 wp_ih_20_15 wn_ih_20_15 mhp15 mhn15 vdd vbsyn gsyn
X_ihx_20_15 a_xp20 a_xn20 wp_ih_20_15 wn_ih_20_15 xhp15 xhn15 vdd vbsyn gsyn
X_ihm_21_15 a_xp21 a_xn21 wp_ih_21_15 wn_ih_21_15 mhp15 mhn15 vdd vbsyn gsyn
X_ihx_21_15 a_xp21 a_xn21 wp_ih_21_15 wn_ih_21_15 xhp15 xhn15 vdd vbsyn gsyn
X_ihm_22_15 a_xp22 a_xn22 wp_ih_22_15 wn_ih_22_15 mhp15 mhn15 vdd vbsyn gsyn
X_ihx_22_15 a_xp22 a_xn22 wp_ih_22_15 wn_ih_22_15 xhp15 xhn15 vdd vbsyn gsyn
X_ihm_23_15 a_xp23 a_xn23 wp_ih_23_15 wn_ih_23_15 mhp15 mhn15 vdd vbsyn gsyn
X_ihx_23_15 a_xp23 a_xn23 wp_ih_23_15 wn_ih_23_15 xhp15 xhn15 vdd vbsyn gsyn
X_ihm_24_15 a_xp24 a_xn24 wp_ih_24_15 wn_ih_24_15 mhp15 mhn15 vdd vbsyn gsyn
X_ihx_24_15 a_xp24 a_xn24 wp_ih_24_15 wn_ih_24_15 xhp15 xhn15 vdd vbsyn gsyn
X_ihm_25_15 a_xp25 a_xn25 wp_ih_25_15 wn_ih_25_15 mhp15 mhn15 vdd vbsyn gsyn
X_ihx_25_15 a_xp25 a_xn25 wp_ih_25_15 wn_ih_25_15 xhp15 xhn15 vdd vbsyn gsyn
X_ihm_26_15 a_xp26 a_xn26 wp_ih_26_15 wn_ih_26_15 mhp15 mhn15 vdd vbsyn gsyn
X_ihx_26_15 a_xp26 a_xn26 wp_ih_26_15 wn_ih_26_15 xhp15 xhn15 vdd vbsyn gsyn
X_ihm_27_15 a_xp27 a_xn27 wp_ih_27_15 wn_ih_27_15 mhp15 mhn15 vdd vbsyn gsyn
X_ihx_27_15 a_xp27 a_xn27 wp_ih_27_15 wn_ih_27_15 xhp15 xhn15 vdd vbsyn gsyn
X_ihm_28_15 a_xp28 a_xn28 wp_ih_28_15 wn_ih_28_15 mhp15 mhn15 vdd vbsyn gsyn
X_ihx_28_15 a_xp28 a_xn28 wp_ih_28_15 wn_ih_28_15 xhp15 xhn15 vdd vbsyn gsyn
X_ihm_29_15 a_xp29 a_xn29 wp_ih_29_15 wn_ih_29_15 mhp15 mhn15 vdd vbsyn gsyn
X_ihx_29_15 a_xp29 a_xn29 wp_ih_29_15 wn_ih_29_15 xhp15 xhn15 vdd vbsyn gsyn
X_ihm_30_15 a_xp30 a_xn30 wp_ih_30_15 wn_ih_30_15 mhp15 mhn15 vdd vbsyn gsyn
X_ihx_30_15 a_xp30 a_xn30 wp_ih_30_15 wn_ih_30_15 xhp15 xhn15 vdd vbsyn gsyn
X_ihm_31_15 a_xp31 a_xn31 wp_ih_31_15 wn_ih_31_15 mhp15 mhn15 vdd vbsyn gsyn
X_ihx_31_15 a_xp31 a_xn31 wp_ih_31_15 wn_ih_31_15 xhp15 xhn15 vdd vbsyn gsyn
X_ihm_32_15 a_xp32 a_xn32 wp_ih_32_15 wn_ih_32_15 mhp15 mhn15 vdd vbsyn gsyn
X_ihx_32_15 a_xp32 a_xn32 wp_ih_32_15 wn_ih_32_15 xhp15 xhn15 vdd vbsyn gsyn
X_ihm_33_15 a_xp33 a_xn33 wp_ih_33_15 wn_ih_33_15 mhp15 mhn15 vdd vbsyn gsyn
X_ihx_33_15 a_xp33 a_xn33 wp_ih_33_15 wn_ih_33_15 xhp15 xhn15 vdd vbsyn gsyn
X_ihm_34_15 a_xp34 a_xn34 wp_ih_34_15 wn_ih_34_15 mhp15 mhn15 vdd vbsyn gsyn
X_ihx_34_15 a_xp34 a_xn34 wp_ih_34_15 wn_ih_34_15 xhp15 xhn15 vdd vbsyn gsyn
X_ihm_35_15 a_xp35 a_xn35 wp_ih_35_15 wn_ih_35_15 mhp15 mhn15 vdd vbsyn gsyn
X_ihx_35_15 a_xp35 a_xn35 wp_ih_35_15 wn_ih_35_15 xhp15 xhn15 vdd vbsyn gsyn
X_ihm_36_15 a_xp36 a_xn36 wp_ih_36_15 wn_ih_36_15 mhp15 mhn15 vdd vbsyn gsyn
X_ihx_36_15 a_xp36 a_xn36 wp_ih_36_15 wn_ih_36_15 xhp15 xhn15 vdd vbsyn gsyn
X_ihm_37_15 a_xp37 a_xn37 wp_ih_37_15 wn_ih_37_15 mhp15 mhn15 vdd vbsyn gsyn
X_ihx_37_15 a_xp37 a_xn37 wp_ih_37_15 wn_ih_37_15 xhp15 xhn15 vdd vbsyn gsyn
X_ihm_38_15 a_xp38 a_xn38 wp_ih_38_15 wn_ih_38_15 mhp15 mhn15 vdd vbsyn gsyn
X_ihx_38_15 a_xp38 a_xn38 wp_ih_38_15 wn_ih_38_15 xhp15 xhn15 vdd vbsyn gsyn
X_ihm_39_15 a_xp39 a_xn39 wp_ih_39_15 wn_ih_39_15 mhp15 mhn15 vdd vbsyn gsyn
X_ihx_39_15 a_xp39 a_xn39 wp_ih_39_15 wn_ih_39_15 xhp15 xhn15 vdd vbsyn gsyn
X_ihm_40_15 a_xp40 a_xn40 wp_ih_40_15 wn_ih_40_15 mhp15 mhn15 vdd vbsyn gsyn
X_ihx_40_15 a_xp40 a_xn40 wp_ih_40_15 wn_ih_40_15 xhp15 xhn15 vdd vbsyn gsyn
X_ihm_41_15 a_xp41 a_xn41 wp_ih_41_15 wn_ih_41_15 mhp15 mhn15 vdd vbsyn gsyn
X_ihx_41_15 a_xp41 a_xn41 wp_ih_41_15 wn_ih_41_15 xhp15 xhn15 vdd vbsyn gsyn
X_ihm_42_15 a_xp42 a_xn42 wp_ih_42_15 wn_ih_42_15 mhp15 mhn15 vdd vbsyn gsyn
X_ihx_42_15 a_xp42 a_xn42 wp_ih_42_15 wn_ih_42_15 xhp15 xhn15 vdd vbsyn gsyn
X_ihm_43_15 a_xp43 a_xn43 wp_ih_43_15 wn_ih_43_15 mhp15 mhn15 vdd vbsyn gsyn
X_ihx_43_15 a_xp43 a_xn43 wp_ih_43_15 wn_ih_43_15 xhp15 xhn15 vdd vbsyn gsyn
X_ihm_44_15 a_xp44 a_xn44 wp_ih_44_15 wn_ih_44_15 mhp15 mhn15 vdd vbsyn gsyn
X_ihx_44_15 a_xp44 a_xn44 wp_ih_44_15 wn_ih_44_15 xhp15 xhn15 vdd vbsyn gsyn
X_ihm_45_15 a_xp45 a_xn45 wp_ih_45_15 wn_ih_45_15 mhp15 mhn15 vdd vbsyn gsyn
X_ihx_45_15 a_xp45 a_xn45 wp_ih_45_15 wn_ih_45_15 xhp15 xhn15 vdd vbsyn gsyn
X_ihm_46_15 a_xp46 a_xn46 wp_ih_46_15 wn_ih_46_15 mhp15 mhn15 vdd vbsyn gsyn
X_ihx_46_15 a_xp46 a_xn46 wp_ih_46_15 wn_ih_46_15 xhp15 xhn15 vdd vbsyn gsyn
X_ihm_47_15 a_xp47 a_xn47 wp_ih_47_15 wn_ih_47_15 mhp15 mhn15 vdd vbsyn gsyn
X_ihx_47_15 a_xp47 a_xn47 wp_ih_47_15 wn_ih_47_15 xhp15 xhn15 vdd vbsyn gsyn
X_ihm_48_15 a_xp48 a_xn48 wp_ih_48_15 wn_ih_48_15 mhp15 mhn15 vdd vbsyn gsyn
X_ihx_48_15 a_xp48 a_xn48 wp_ih_48_15 wn_ih_48_15 xhp15 xhn15 vdd vbsyn gsyn
X_ihm_49_15 a_xp49 a_xn49 wp_ih_49_15 wn_ih_49_15 mhp15 mhn15 vdd vbsyn gsyn
X_ihx_49_15 a_xp49 a_xn49 wp_ih_49_15 wn_ih_49_15 xhp15 xhn15 vdd vbsyn gsyn
X_ihm_50_15 a_xp50 a_xn50 wp_ih_50_15 wn_ih_50_15 mhp15 mhn15 vdd vbsyn gsyn
X_ihx_50_15 a_xp50 a_xn50 wp_ih_50_15 wn_ih_50_15 xhp15 xhn15 vdd vbsyn gsyn
X_ihm_51_15 a_xp51 a_xn51 wp_ih_51_15 wn_ih_51_15 mhp15 mhn15 vdd vbsyn gsyn
X_ihx_51_15 a_xp51 a_xn51 wp_ih_51_15 wn_ih_51_15 xhp15 xhn15 vdd vbsyn gsyn
X_ihm_52_15 a_xp52 a_xn52 wp_ih_52_15 wn_ih_52_15 mhp15 mhn15 vdd vbsyn gsyn
X_ihx_52_15 a_xp52 a_xn52 wp_ih_52_15 wn_ih_52_15 xhp15 xhn15 vdd vbsyn gsyn
X_ihm_53_15 a_xp53 a_xn53 wp_ih_53_15 wn_ih_53_15 mhp15 mhn15 vdd vbsyn gsyn
X_ihx_53_15 a_xp53 a_xn53 wp_ih_53_15 wn_ih_53_15 xhp15 xhn15 vdd vbsyn gsyn
X_ihm_54_15 a_xp54 a_xn54 wp_ih_54_15 wn_ih_54_15 mhp15 mhn15 vdd vbsyn gsyn
X_ihx_54_15 a_xp54 a_xn54 wp_ih_54_15 wn_ih_54_15 xhp15 xhn15 vdd vbsyn gsyn
X_ihm_55_15 a_xp55 a_xn55 wp_ih_55_15 wn_ih_55_15 mhp15 mhn15 vdd vbsyn gsyn
X_ihx_55_15 a_xp55 a_xn55 wp_ih_55_15 wn_ih_55_15 xhp15 xhn15 vdd vbsyn gsyn
X_ihm_56_15 a_xp56 a_xn56 wp_ih_56_15 wn_ih_56_15 mhp15 mhn15 vdd vbsyn gsyn
X_ihx_56_15 a_xp56 a_xn56 wp_ih_56_15 wn_ih_56_15 xhp15 xhn15 vdd vbsyn gsyn
X_ihm_57_15 a_xp57 a_xn57 wp_ih_57_15 wn_ih_57_15 mhp15 mhn15 vdd vbsyn gsyn
X_ihx_57_15 a_xp57 a_xn57 wp_ih_57_15 wn_ih_57_15 xhp15 xhn15 vdd vbsyn gsyn
X_ihm_58_15 a_xp58 a_xn58 wp_ih_58_15 wn_ih_58_15 mhp15 mhn15 vdd vbsyn gsyn
X_ihx_58_15 a_xp58 a_xn58 wp_ih_58_15 wn_ih_58_15 xhp15 xhn15 vdd vbsyn gsyn
X_ihm_59_15 a_xp59 a_xn59 wp_ih_59_15 wn_ih_59_15 mhp15 mhn15 vdd vbsyn gsyn
X_ihx_59_15 a_xp59 a_xn59 wp_ih_59_15 wn_ih_59_15 xhp15 xhn15 vdd vbsyn gsyn
X_ihm_60_15 a_xp60 a_xn60 wp_ih_60_15 wn_ih_60_15 mhp15 mhn15 vdd vbsyn gsyn
X_ihx_60_15 a_xp60 a_xn60 wp_ih_60_15 wn_ih_60_15 xhp15 xhn15 vdd vbsyn gsyn
X_ihm_61_15 a_xp61 a_xn61 wp_ih_61_15 wn_ih_61_15 mhp15 mhn15 vdd vbsyn gsyn
X_ihx_61_15 a_xp61 a_xn61 wp_ih_61_15 wn_ih_61_15 xhp15 xhn15 vdd vbsyn gsyn
X_ihm_62_15 a_xp62 a_xn62 wp_ih_62_15 wn_ih_62_15 mhp15 mhn15 vdd vbsyn gsyn
X_ihx_62_15 a_xp62 a_xn62 wp_ih_62_15 wn_ih_62_15 xhp15 xhn15 vdd vbsyn gsyn
X_ihm_63_15 a_xp63 a_xn63 wp_ih_63_15 wn_ih_63_15 mhp15 mhn15 vdd vbsyn gsyn
X_ihx_63_15 a_xp63 a_xn63 wp_ih_63_15 wn_ih_63_15 xhp15 xhn15 vdd vbsyn gsyn
X_bk_15_0 eop0 eon0 wp_ho_15_0 wn_ho_15_0 xhp15 xhn15 vdd vbbk gsyn
X_bk_15_1 eop1 eon1 wp_ho_15_1 wn_ho_15_1 xhp15 xhn15 vdd vbbk gsyn
X_bk_15_2 eop2 eon2 wp_ho_15_2 wn_ho_15_2 xhp15 xhn15 vdd vbbk gsyn
X_bk_15_3 eop3 eon3 wp_ho_15_3 wn_ho_15_3 xhp15 xhn15 vdd vbbk gsyn
X_bk_15_4 eop4 eon4 wp_ho_15_4 wn_ho_15_4 xhp15 xhn15 vdd vbbk gsyn
Xn15 xhp15 xhn15 ahp15 ahn15 vdd vbneu dneuron
Xeh15 xhp15 xhn15 mhp15 mhn15 ehp15 ehn15 vdd gm esub
Xcm_mh16 mhp16 mhn16 vdd cmld
Rnd_mh16 mhp16 mhn16 20k
Xcm_xh16 xhp16 xhn16 vdd cmld
Rnd_xh16 xhp16 xhn16 20k
X_ihm_0_16 a_xp0 a_xn0 wp_ih_0_16 wn_ih_0_16 mhp16 mhn16 vdd vbsyn gsyn
X_ihx_0_16 a_xp0 a_xn0 wp_ih_0_16 wn_ih_0_16 xhp16 xhn16 vdd vbsyn gsyn
X_ihm_1_16 a_xp1 a_xn1 wp_ih_1_16 wn_ih_1_16 mhp16 mhn16 vdd vbsyn gsyn
X_ihx_1_16 a_xp1 a_xn1 wp_ih_1_16 wn_ih_1_16 xhp16 xhn16 vdd vbsyn gsyn
X_ihm_2_16 a_xp2 a_xn2 wp_ih_2_16 wn_ih_2_16 mhp16 mhn16 vdd vbsyn gsyn
X_ihx_2_16 a_xp2 a_xn2 wp_ih_2_16 wn_ih_2_16 xhp16 xhn16 vdd vbsyn gsyn
X_ihm_3_16 a_xp3 a_xn3 wp_ih_3_16 wn_ih_3_16 mhp16 mhn16 vdd vbsyn gsyn
X_ihx_3_16 a_xp3 a_xn3 wp_ih_3_16 wn_ih_3_16 xhp16 xhn16 vdd vbsyn gsyn
X_ihm_4_16 a_xp4 a_xn4 wp_ih_4_16 wn_ih_4_16 mhp16 mhn16 vdd vbsyn gsyn
X_ihx_4_16 a_xp4 a_xn4 wp_ih_4_16 wn_ih_4_16 xhp16 xhn16 vdd vbsyn gsyn
X_ihm_5_16 a_xp5 a_xn5 wp_ih_5_16 wn_ih_5_16 mhp16 mhn16 vdd vbsyn gsyn
X_ihx_5_16 a_xp5 a_xn5 wp_ih_5_16 wn_ih_5_16 xhp16 xhn16 vdd vbsyn gsyn
X_ihm_6_16 a_xp6 a_xn6 wp_ih_6_16 wn_ih_6_16 mhp16 mhn16 vdd vbsyn gsyn
X_ihx_6_16 a_xp6 a_xn6 wp_ih_6_16 wn_ih_6_16 xhp16 xhn16 vdd vbsyn gsyn
X_ihm_7_16 a_xp7 a_xn7 wp_ih_7_16 wn_ih_7_16 mhp16 mhn16 vdd vbsyn gsyn
X_ihx_7_16 a_xp7 a_xn7 wp_ih_7_16 wn_ih_7_16 xhp16 xhn16 vdd vbsyn gsyn
X_ihm_8_16 a_xp8 a_xn8 wp_ih_8_16 wn_ih_8_16 mhp16 mhn16 vdd vbsyn gsyn
X_ihx_8_16 a_xp8 a_xn8 wp_ih_8_16 wn_ih_8_16 xhp16 xhn16 vdd vbsyn gsyn
X_ihm_9_16 a_xp9 a_xn9 wp_ih_9_16 wn_ih_9_16 mhp16 mhn16 vdd vbsyn gsyn
X_ihx_9_16 a_xp9 a_xn9 wp_ih_9_16 wn_ih_9_16 xhp16 xhn16 vdd vbsyn gsyn
X_ihm_10_16 a_xp10 a_xn10 wp_ih_10_16 wn_ih_10_16 mhp16 mhn16 vdd vbsyn gsyn
X_ihx_10_16 a_xp10 a_xn10 wp_ih_10_16 wn_ih_10_16 xhp16 xhn16 vdd vbsyn gsyn
X_ihm_11_16 a_xp11 a_xn11 wp_ih_11_16 wn_ih_11_16 mhp16 mhn16 vdd vbsyn gsyn
X_ihx_11_16 a_xp11 a_xn11 wp_ih_11_16 wn_ih_11_16 xhp16 xhn16 vdd vbsyn gsyn
X_ihm_12_16 a_xp12 a_xn12 wp_ih_12_16 wn_ih_12_16 mhp16 mhn16 vdd vbsyn gsyn
X_ihx_12_16 a_xp12 a_xn12 wp_ih_12_16 wn_ih_12_16 xhp16 xhn16 vdd vbsyn gsyn
X_ihm_13_16 a_xp13 a_xn13 wp_ih_13_16 wn_ih_13_16 mhp16 mhn16 vdd vbsyn gsyn
X_ihx_13_16 a_xp13 a_xn13 wp_ih_13_16 wn_ih_13_16 xhp16 xhn16 vdd vbsyn gsyn
X_ihm_14_16 a_xp14 a_xn14 wp_ih_14_16 wn_ih_14_16 mhp16 mhn16 vdd vbsyn gsyn
X_ihx_14_16 a_xp14 a_xn14 wp_ih_14_16 wn_ih_14_16 xhp16 xhn16 vdd vbsyn gsyn
X_ihm_15_16 a_xp15 a_xn15 wp_ih_15_16 wn_ih_15_16 mhp16 mhn16 vdd vbsyn gsyn
X_ihx_15_16 a_xp15 a_xn15 wp_ih_15_16 wn_ih_15_16 xhp16 xhn16 vdd vbsyn gsyn
X_ihm_16_16 a_xp16 a_xn16 wp_ih_16_16 wn_ih_16_16 mhp16 mhn16 vdd vbsyn gsyn
X_ihx_16_16 a_xp16 a_xn16 wp_ih_16_16 wn_ih_16_16 xhp16 xhn16 vdd vbsyn gsyn
X_ihm_17_16 a_xp17 a_xn17 wp_ih_17_16 wn_ih_17_16 mhp16 mhn16 vdd vbsyn gsyn
X_ihx_17_16 a_xp17 a_xn17 wp_ih_17_16 wn_ih_17_16 xhp16 xhn16 vdd vbsyn gsyn
X_ihm_18_16 a_xp18 a_xn18 wp_ih_18_16 wn_ih_18_16 mhp16 mhn16 vdd vbsyn gsyn
X_ihx_18_16 a_xp18 a_xn18 wp_ih_18_16 wn_ih_18_16 xhp16 xhn16 vdd vbsyn gsyn
X_ihm_19_16 a_xp19 a_xn19 wp_ih_19_16 wn_ih_19_16 mhp16 mhn16 vdd vbsyn gsyn
X_ihx_19_16 a_xp19 a_xn19 wp_ih_19_16 wn_ih_19_16 xhp16 xhn16 vdd vbsyn gsyn
X_ihm_20_16 a_xp20 a_xn20 wp_ih_20_16 wn_ih_20_16 mhp16 mhn16 vdd vbsyn gsyn
X_ihx_20_16 a_xp20 a_xn20 wp_ih_20_16 wn_ih_20_16 xhp16 xhn16 vdd vbsyn gsyn
X_ihm_21_16 a_xp21 a_xn21 wp_ih_21_16 wn_ih_21_16 mhp16 mhn16 vdd vbsyn gsyn
X_ihx_21_16 a_xp21 a_xn21 wp_ih_21_16 wn_ih_21_16 xhp16 xhn16 vdd vbsyn gsyn
X_ihm_22_16 a_xp22 a_xn22 wp_ih_22_16 wn_ih_22_16 mhp16 mhn16 vdd vbsyn gsyn
X_ihx_22_16 a_xp22 a_xn22 wp_ih_22_16 wn_ih_22_16 xhp16 xhn16 vdd vbsyn gsyn
X_ihm_23_16 a_xp23 a_xn23 wp_ih_23_16 wn_ih_23_16 mhp16 mhn16 vdd vbsyn gsyn
X_ihx_23_16 a_xp23 a_xn23 wp_ih_23_16 wn_ih_23_16 xhp16 xhn16 vdd vbsyn gsyn
X_ihm_24_16 a_xp24 a_xn24 wp_ih_24_16 wn_ih_24_16 mhp16 mhn16 vdd vbsyn gsyn
X_ihx_24_16 a_xp24 a_xn24 wp_ih_24_16 wn_ih_24_16 xhp16 xhn16 vdd vbsyn gsyn
X_ihm_25_16 a_xp25 a_xn25 wp_ih_25_16 wn_ih_25_16 mhp16 mhn16 vdd vbsyn gsyn
X_ihx_25_16 a_xp25 a_xn25 wp_ih_25_16 wn_ih_25_16 xhp16 xhn16 vdd vbsyn gsyn
X_ihm_26_16 a_xp26 a_xn26 wp_ih_26_16 wn_ih_26_16 mhp16 mhn16 vdd vbsyn gsyn
X_ihx_26_16 a_xp26 a_xn26 wp_ih_26_16 wn_ih_26_16 xhp16 xhn16 vdd vbsyn gsyn
X_ihm_27_16 a_xp27 a_xn27 wp_ih_27_16 wn_ih_27_16 mhp16 mhn16 vdd vbsyn gsyn
X_ihx_27_16 a_xp27 a_xn27 wp_ih_27_16 wn_ih_27_16 xhp16 xhn16 vdd vbsyn gsyn
X_ihm_28_16 a_xp28 a_xn28 wp_ih_28_16 wn_ih_28_16 mhp16 mhn16 vdd vbsyn gsyn
X_ihx_28_16 a_xp28 a_xn28 wp_ih_28_16 wn_ih_28_16 xhp16 xhn16 vdd vbsyn gsyn
X_ihm_29_16 a_xp29 a_xn29 wp_ih_29_16 wn_ih_29_16 mhp16 mhn16 vdd vbsyn gsyn
X_ihx_29_16 a_xp29 a_xn29 wp_ih_29_16 wn_ih_29_16 xhp16 xhn16 vdd vbsyn gsyn
X_ihm_30_16 a_xp30 a_xn30 wp_ih_30_16 wn_ih_30_16 mhp16 mhn16 vdd vbsyn gsyn
X_ihx_30_16 a_xp30 a_xn30 wp_ih_30_16 wn_ih_30_16 xhp16 xhn16 vdd vbsyn gsyn
X_ihm_31_16 a_xp31 a_xn31 wp_ih_31_16 wn_ih_31_16 mhp16 mhn16 vdd vbsyn gsyn
X_ihx_31_16 a_xp31 a_xn31 wp_ih_31_16 wn_ih_31_16 xhp16 xhn16 vdd vbsyn gsyn
X_ihm_32_16 a_xp32 a_xn32 wp_ih_32_16 wn_ih_32_16 mhp16 mhn16 vdd vbsyn gsyn
X_ihx_32_16 a_xp32 a_xn32 wp_ih_32_16 wn_ih_32_16 xhp16 xhn16 vdd vbsyn gsyn
X_ihm_33_16 a_xp33 a_xn33 wp_ih_33_16 wn_ih_33_16 mhp16 mhn16 vdd vbsyn gsyn
X_ihx_33_16 a_xp33 a_xn33 wp_ih_33_16 wn_ih_33_16 xhp16 xhn16 vdd vbsyn gsyn
X_ihm_34_16 a_xp34 a_xn34 wp_ih_34_16 wn_ih_34_16 mhp16 mhn16 vdd vbsyn gsyn
X_ihx_34_16 a_xp34 a_xn34 wp_ih_34_16 wn_ih_34_16 xhp16 xhn16 vdd vbsyn gsyn
X_ihm_35_16 a_xp35 a_xn35 wp_ih_35_16 wn_ih_35_16 mhp16 mhn16 vdd vbsyn gsyn
X_ihx_35_16 a_xp35 a_xn35 wp_ih_35_16 wn_ih_35_16 xhp16 xhn16 vdd vbsyn gsyn
X_ihm_36_16 a_xp36 a_xn36 wp_ih_36_16 wn_ih_36_16 mhp16 mhn16 vdd vbsyn gsyn
X_ihx_36_16 a_xp36 a_xn36 wp_ih_36_16 wn_ih_36_16 xhp16 xhn16 vdd vbsyn gsyn
X_ihm_37_16 a_xp37 a_xn37 wp_ih_37_16 wn_ih_37_16 mhp16 mhn16 vdd vbsyn gsyn
X_ihx_37_16 a_xp37 a_xn37 wp_ih_37_16 wn_ih_37_16 xhp16 xhn16 vdd vbsyn gsyn
X_ihm_38_16 a_xp38 a_xn38 wp_ih_38_16 wn_ih_38_16 mhp16 mhn16 vdd vbsyn gsyn
X_ihx_38_16 a_xp38 a_xn38 wp_ih_38_16 wn_ih_38_16 xhp16 xhn16 vdd vbsyn gsyn
X_ihm_39_16 a_xp39 a_xn39 wp_ih_39_16 wn_ih_39_16 mhp16 mhn16 vdd vbsyn gsyn
X_ihx_39_16 a_xp39 a_xn39 wp_ih_39_16 wn_ih_39_16 xhp16 xhn16 vdd vbsyn gsyn
X_ihm_40_16 a_xp40 a_xn40 wp_ih_40_16 wn_ih_40_16 mhp16 mhn16 vdd vbsyn gsyn
X_ihx_40_16 a_xp40 a_xn40 wp_ih_40_16 wn_ih_40_16 xhp16 xhn16 vdd vbsyn gsyn
X_ihm_41_16 a_xp41 a_xn41 wp_ih_41_16 wn_ih_41_16 mhp16 mhn16 vdd vbsyn gsyn
X_ihx_41_16 a_xp41 a_xn41 wp_ih_41_16 wn_ih_41_16 xhp16 xhn16 vdd vbsyn gsyn
X_ihm_42_16 a_xp42 a_xn42 wp_ih_42_16 wn_ih_42_16 mhp16 mhn16 vdd vbsyn gsyn
X_ihx_42_16 a_xp42 a_xn42 wp_ih_42_16 wn_ih_42_16 xhp16 xhn16 vdd vbsyn gsyn
X_ihm_43_16 a_xp43 a_xn43 wp_ih_43_16 wn_ih_43_16 mhp16 mhn16 vdd vbsyn gsyn
X_ihx_43_16 a_xp43 a_xn43 wp_ih_43_16 wn_ih_43_16 xhp16 xhn16 vdd vbsyn gsyn
X_ihm_44_16 a_xp44 a_xn44 wp_ih_44_16 wn_ih_44_16 mhp16 mhn16 vdd vbsyn gsyn
X_ihx_44_16 a_xp44 a_xn44 wp_ih_44_16 wn_ih_44_16 xhp16 xhn16 vdd vbsyn gsyn
X_ihm_45_16 a_xp45 a_xn45 wp_ih_45_16 wn_ih_45_16 mhp16 mhn16 vdd vbsyn gsyn
X_ihx_45_16 a_xp45 a_xn45 wp_ih_45_16 wn_ih_45_16 xhp16 xhn16 vdd vbsyn gsyn
X_ihm_46_16 a_xp46 a_xn46 wp_ih_46_16 wn_ih_46_16 mhp16 mhn16 vdd vbsyn gsyn
X_ihx_46_16 a_xp46 a_xn46 wp_ih_46_16 wn_ih_46_16 xhp16 xhn16 vdd vbsyn gsyn
X_ihm_47_16 a_xp47 a_xn47 wp_ih_47_16 wn_ih_47_16 mhp16 mhn16 vdd vbsyn gsyn
X_ihx_47_16 a_xp47 a_xn47 wp_ih_47_16 wn_ih_47_16 xhp16 xhn16 vdd vbsyn gsyn
X_ihm_48_16 a_xp48 a_xn48 wp_ih_48_16 wn_ih_48_16 mhp16 mhn16 vdd vbsyn gsyn
X_ihx_48_16 a_xp48 a_xn48 wp_ih_48_16 wn_ih_48_16 xhp16 xhn16 vdd vbsyn gsyn
X_ihm_49_16 a_xp49 a_xn49 wp_ih_49_16 wn_ih_49_16 mhp16 mhn16 vdd vbsyn gsyn
X_ihx_49_16 a_xp49 a_xn49 wp_ih_49_16 wn_ih_49_16 xhp16 xhn16 vdd vbsyn gsyn
X_ihm_50_16 a_xp50 a_xn50 wp_ih_50_16 wn_ih_50_16 mhp16 mhn16 vdd vbsyn gsyn
X_ihx_50_16 a_xp50 a_xn50 wp_ih_50_16 wn_ih_50_16 xhp16 xhn16 vdd vbsyn gsyn
X_ihm_51_16 a_xp51 a_xn51 wp_ih_51_16 wn_ih_51_16 mhp16 mhn16 vdd vbsyn gsyn
X_ihx_51_16 a_xp51 a_xn51 wp_ih_51_16 wn_ih_51_16 xhp16 xhn16 vdd vbsyn gsyn
X_ihm_52_16 a_xp52 a_xn52 wp_ih_52_16 wn_ih_52_16 mhp16 mhn16 vdd vbsyn gsyn
X_ihx_52_16 a_xp52 a_xn52 wp_ih_52_16 wn_ih_52_16 xhp16 xhn16 vdd vbsyn gsyn
X_ihm_53_16 a_xp53 a_xn53 wp_ih_53_16 wn_ih_53_16 mhp16 mhn16 vdd vbsyn gsyn
X_ihx_53_16 a_xp53 a_xn53 wp_ih_53_16 wn_ih_53_16 xhp16 xhn16 vdd vbsyn gsyn
X_ihm_54_16 a_xp54 a_xn54 wp_ih_54_16 wn_ih_54_16 mhp16 mhn16 vdd vbsyn gsyn
X_ihx_54_16 a_xp54 a_xn54 wp_ih_54_16 wn_ih_54_16 xhp16 xhn16 vdd vbsyn gsyn
X_ihm_55_16 a_xp55 a_xn55 wp_ih_55_16 wn_ih_55_16 mhp16 mhn16 vdd vbsyn gsyn
X_ihx_55_16 a_xp55 a_xn55 wp_ih_55_16 wn_ih_55_16 xhp16 xhn16 vdd vbsyn gsyn
X_ihm_56_16 a_xp56 a_xn56 wp_ih_56_16 wn_ih_56_16 mhp16 mhn16 vdd vbsyn gsyn
X_ihx_56_16 a_xp56 a_xn56 wp_ih_56_16 wn_ih_56_16 xhp16 xhn16 vdd vbsyn gsyn
X_ihm_57_16 a_xp57 a_xn57 wp_ih_57_16 wn_ih_57_16 mhp16 mhn16 vdd vbsyn gsyn
X_ihx_57_16 a_xp57 a_xn57 wp_ih_57_16 wn_ih_57_16 xhp16 xhn16 vdd vbsyn gsyn
X_ihm_58_16 a_xp58 a_xn58 wp_ih_58_16 wn_ih_58_16 mhp16 mhn16 vdd vbsyn gsyn
X_ihx_58_16 a_xp58 a_xn58 wp_ih_58_16 wn_ih_58_16 xhp16 xhn16 vdd vbsyn gsyn
X_ihm_59_16 a_xp59 a_xn59 wp_ih_59_16 wn_ih_59_16 mhp16 mhn16 vdd vbsyn gsyn
X_ihx_59_16 a_xp59 a_xn59 wp_ih_59_16 wn_ih_59_16 xhp16 xhn16 vdd vbsyn gsyn
X_ihm_60_16 a_xp60 a_xn60 wp_ih_60_16 wn_ih_60_16 mhp16 mhn16 vdd vbsyn gsyn
X_ihx_60_16 a_xp60 a_xn60 wp_ih_60_16 wn_ih_60_16 xhp16 xhn16 vdd vbsyn gsyn
X_ihm_61_16 a_xp61 a_xn61 wp_ih_61_16 wn_ih_61_16 mhp16 mhn16 vdd vbsyn gsyn
X_ihx_61_16 a_xp61 a_xn61 wp_ih_61_16 wn_ih_61_16 xhp16 xhn16 vdd vbsyn gsyn
X_ihm_62_16 a_xp62 a_xn62 wp_ih_62_16 wn_ih_62_16 mhp16 mhn16 vdd vbsyn gsyn
X_ihx_62_16 a_xp62 a_xn62 wp_ih_62_16 wn_ih_62_16 xhp16 xhn16 vdd vbsyn gsyn
X_ihm_63_16 a_xp63 a_xn63 wp_ih_63_16 wn_ih_63_16 mhp16 mhn16 vdd vbsyn gsyn
X_ihx_63_16 a_xp63 a_xn63 wp_ih_63_16 wn_ih_63_16 xhp16 xhn16 vdd vbsyn gsyn
X_bk_16_0 eop0 eon0 wp_ho_16_0 wn_ho_16_0 xhp16 xhn16 vdd vbbk gsyn
X_bk_16_1 eop1 eon1 wp_ho_16_1 wn_ho_16_1 xhp16 xhn16 vdd vbbk gsyn
X_bk_16_2 eop2 eon2 wp_ho_16_2 wn_ho_16_2 xhp16 xhn16 vdd vbbk gsyn
X_bk_16_3 eop3 eon3 wp_ho_16_3 wn_ho_16_3 xhp16 xhn16 vdd vbbk gsyn
X_bk_16_4 eop4 eon4 wp_ho_16_4 wn_ho_16_4 xhp16 xhn16 vdd vbbk gsyn
Xn16 xhp16 xhn16 ahp16 ahn16 vdd vbneu dneuron
Xeh16 xhp16 xhn16 mhp16 mhn16 ehp16 ehn16 vdd gm esub
Xcm_mh17 mhp17 mhn17 vdd cmld
Rnd_mh17 mhp17 mhn17 20k
Xcm_xh17 xhp17 xhn17 vdd cmld
Rnd_xh17 xhp17 xhn17 20k
X_ihm_0_17 a_xp0 a_xn0 wp_ih_0_17 wn_ih_0_17 mhp17 mhn17 vdd vbsyn gsyn
X_ihx_0_17 a_xp0 a_xn0 wp_ih_0_17 wn_ih_0_17 xhp17 xhn17 vdd vbsyn gsyn
X_ihm_1_17 a_xp1 a_xn1 wp_ih_1_17 wn_ih_1_17 mhp17 mhn17 vdd vbsyn gsyn
X_ihx_1_17 a_xp1 a_xn1 wp_ih_1_17 wn_ih_1_17 xhp17 xhn17 vdd vbsyn gsyn
X_ihm_2_17 a_xp2 a_xn2 wp_ih_2_17 wn_ih_2_17 mhp17 mhn17 vdd vbsyn gsyn
X_ihx_2_17 a_xp2 a_xn2 wp_ih_2_17 wn_ih_2_17 xhp17 xhn17 vdd vbsyn gsyn
X_ihm_3_17 a_xp3 a_xn3 wp_ih_3_17 wn_ih_3_17 mhp17 mhn17 vdd vbsyn gsyn
X_ihx_3_17 a_xp3 a_xn3 wp_ih_3_17 wn_ih_3_17 xhp17 xhn17 vdd vbsyn gsyn
X_ihm_4_17 a_xp4 a_xn4 wp_ih_4_17 wn_ih_4_17 mhp17 mhn17 vdd vbsyn gsyn
X_ihx_4_17 a_xp4 a_xn4 wp_ih_4_17 wn_ih_4_17 xhp17 xhn17 vdd vbsyn gsyn
X_ihm_5_17 a_xp5 a_xn5 wp_ih_5_17 wn_ih_5_17 mhp17 mhn17 vdd vbsyn gsyn
X_ihx_5_17 a_xp5 a_xn5 wp_ih_5_17 wn_ih_5_17 xhp17 xhn17 vdd vbsyn gsyn
X_ihm_6_17 a_xp6 a_xn6 wp_ih_6_17 wn_ih_6_17 mhp17 mhn17 vdd vbsyn gsyn
X_ihx_6_17 a_xp6 a_xn6 wp_ih_6_17 wn_ih_6_17 xhp17 xhn17 vdd vbsyn gsyn
X_ihm_7_17 a_xp7 a_xn7 wp_ih_7_17 wn_ih_7_17 mhp17 mhn17 vdd vbsyn gsyn
X_ihx_7_17 a_xp7 a_xn7 wp_ih_7_17 wn_ih_7_17 xhp17 xhn17 vdd vbsyn gsyn
X_ihm_8_17 a_xp8 a_xn8 wp_ih_8_17 wn_ih_8_17 mhp17 mhn17 vdd vbsyn gsyn
X_ihx_8_17 a_xp8 a_xn8 wp_ih_8_17 wn_ih_8_17 xhp17 xhn17 vdd vbsyn gsyn
X_ihm_9_17 a_xp9 a_xn9 wp_ih_9_17 wn_ih_9_17 mhp17 mhn17 vdd vbsyn gsyn
X_ihx_9_17 a_xp9 a_xn9 wp_ih_9_17 wn_ih_9_17 xhp17 xhn17 vdd vbsyn gsyn
X_ihm_10_17 a_xp10 a_xn10 wp_ih_10_17 wn_ih_10_17 mhp17 mhn17 vdd vbsyn gsyn
X_ihx_10_17 a_xp10 a_xn10 wp_ih_10_17 wn_ih_10_17 xhp17 xhn17 vdd vbsyn gsyn
X_ihm_11_17 a_xp11 a_xn11 wp_ih_11_17 wn_ih_11_17 mhp17 mhn17 vdd vbsyn gsyn
X_ihx_11_17 a_xp11 a_xn11 wp_ih_11_17 wn_ih_11_17 xhp17 xhn17 vdd vbsyn gsyn
X_ihm_12_17 a_xp12 a_xn12 wp_ih_12_17 wn_ih_12_17 mhp17 mhn17 vdd vbsyn gsyn
X_ihx_12_17 a_xp12 a_xn12 wp_ih_12_17 wn_ih_12_17 xhp17 xhn17 vdd vbsyn gsyn
X_ihm_13_17 a_xp13 a_xn13 wp_ih_13_17 wn_ih_13_17 mhp17 mhn17 vdd vbsyn gsyn
X_ihx_13_17 a_xp13 a_xn13 wp_ih_13_17 wn_ih_13_17 xhp17 xhn17 vdd vbsyn gsyn
X_ihm_14_17 a_xp14 a_xn14 wp_ih_14_17 wn_ih_14_17 mhp17 mhn17 vdd vbsyn gsyn
X_ihx_14_17 a_xp14 a_xn14 wp_ih_14_17 wn_ih_14_17 xhp17 xhn17 vdd vbsyn gsyn
X_ihm_15_17 a_xp15 a_xn15 wp_ih_15_17 wn_ih_15_17 mhp17 mhn17 vdd vbsyn gsyn
X_ihx_15_17 a_xp15 a_xn15 wp_ih_15_17 wn_ih_15_17 xhp17 xhn17 vdd vbsyn gsyn
X_ihm_16_17 a_xp16 a_xn16 wp_ih_16_17 wn_ih_16_17 mhp17 mhn17 vdd vbsyn gsyn
X_ihx_16_17 a_xp16 a_xn16 wp_ih_16_17 wn_ih_16_17 xhp17 xhn17 vdd vbsyn gsyn
X_ihm_17_17 a_xp17 a_xn17 wp_ih_17_17 wn_ih_17_17 mhp17 mhn17 vdd vbsyn gsyn
X_ihx_17_17 a_xp17 a_xn17 wp_ih_17_17 wn_ih_17_17 xhp17 xhn17 vdd vbsyn gsyn
X_ihm_18_17 a_xp18 a_xn18 wp_ih_18_17 wn_ih_18_17 mhp17 mhn17 vdd vbsyn gsyn
X_ihx_18_17 a_xp18 a_xn18 wp_ih_18_17 wn_ih_18_17 xhp17 xhn17 vdd vbsyn gsyn
X_ihm_19_17 a_xp19 a_xn19 wp_ih_19_17 wn_ih_19_17 mhp17 mhn17 vdd vbsyn gsyn
X_ihx_19_17 a_xp19 a_xn19 wp_ih_19_17 wn_ih_19_17 xhp17 xhn17 vdd vbsyn gsyn
X_ihm_20_17 a_xp20 a_xn20 wp_ih_20_17 wn_ih_20_17 mhp17 mhn17 vdd vbsyn gsyn
X_ihx_20_17 a_xp20 a_xn20 wp_ih_20_17 wn_ih_20_17 xhp17 xhn17 vdd vbsyn gsyn
X_ihm_21_17 a_xp21 a_xn21 wp_ih_21_17 wn_ih_21_17 mhp17 mhn17 vdd vbsyn gsyn
X_ihx_21_17 a_xp21 a_xn21 wp_ih_21_17 wn_ih_21_17 xhp17 xhn17 vdd vbsyn gsyn
X_ihm_22_17 a_xp22 a_xn22 wp_ih_22_17 wn_ih_22_17 mhp17 mhn17 vdd vbsyn gsyn
X_ihx_22_17 a_xp22 a_xn22 wp_ih_22_17 wn_ih_22_17 xhp17 xhn17 vdd vbsyn gsyn
X_ihm_23_17 a_xp23 a_xn23 wp_ih_23_17 wn_ih_23_17 mhp17 mhn17 vdd vbsyn gsyn
X_ihx_23_17 a_xp23 a_xn23 wp_ih_23_17 wn_ih_23_17 xhp17 xhn17 vdd vbsyn gsyn
X_ihm_24_17 a_xp24 a_xn24 wp_ih_24_17 wn_ih_24_17 mhp17 mhn17 vdd vbsyn gsyn
X_ihx_24_17 a_xp24 a_xn24 wp_ih_24_17 wn_ih_24_17 xhp17 xhn17 vdd vbsyn gsyn
X_ihm_25_17 a_xp25 a_xn25 wp_ih_25_17 wn_ih_25_17 mhp17 mhn17 vdd vbsyn gsyn
X_ihx_25_17 a_xp25 a_xn25 wp_ih_25_17 wn_ih_25_17 xhp17 xhn17 vdd vbsyn gsyn
X_ihm_26_17 a_xp26 a_xn26 wp_ih_26_17 wn_ih_26_17 mhp17 mhn17 vdd vbsyn gsyn
X_ihx_26_17 a_xp26 a_xn26 wp_ih_26_17 wn_ih_26_17 xhp17 xhn17 vdd vbsyn gsyn
X_ihm_27_17 a_xp27 a_xn27 wp_ih_27_17 wn_ih_27_17 mhp17 mhn17 vdd vbsyn gsyn
X_ihx_27_17 a_xp27 a_xn27 wp_ih_27_17 wn_ih_27_17 xhp17 xhn17 vdd vbsyn gsyn
X_ihm_28_17 a_xp28 a_xn28 wp_ih_28_17 wn_ih_28_17 mhp17 mhn17 vdd vbsyn gsyn
X_ihx_28_17 a_xp28 a_xn28 wp_ih_28_17 wn_ih_28_17 xhp17 xhn17 vdd vbsyn gsyn
X_ihm_29_17 a_xp29 a_xn29 wp_ih_29_17 wn_ih_29_17 mhp17 mhn17 vdd vbsyn gsyn
X_ihx_29_17 a_xp29 a_xn29 wp_ih_29_17 wn_ih_29_17 xhp17 xhn17 vdd vbsyn gsyn
X_ihm_30_17 a_xp30 a_xn30 wp_ih_30_17 wn_ih_30_17 mhp17 mhn17 vdd vbsyn gsyn
X_ihx_30_17 a_xp30 a_xn30 wp_ih_30_17 wn_ih_30_17 xhp17 xhn17 vdd vbsyn gsyn
X_ihm_31_17 a_xp31 a_xn31 wp_ih_31_17 wn_ih_31_17 mhp17 mhn17 vdd vbsyn gsyn
X_ihx_31_17 a_xp31 a_xn31 wp_ih_31_17 wn_ih_31_17 xhp17 xhn17 vdd vbsyn gsyn
X_ihm_32_17 a_xp32 a_xn32 wp_ih_32_17 wn_ih_32_17 mhp17 mhn17 vdd vbsyn gsyn
X_ihx_32_17 a_xp32 a_xn32 wp_ih_32_17 wn_ih_32_17 xhp17 xhn17 vdd vbsyn gsyn
X_ihm_33_17 a_xp33 a_xn33 wp_ih_33_17 wn_ih_33_17 mhp17 mhn17 vdd vbsyn gsyn
X_ihx_33_17 a_xp33 a_xn33 wp_ih_33_17 wn_ih_33_17 xhp17 xhn17 vdd vbsyn gsyn
X_ihm_34_17 a_xp34 a_xn34 wp_ih_34_17 wn_ih_34_17 mhp17 mhn17 vdd vbsyn gsyn
X_ihx_34_17 a_xp34 a_xn34 wp_ih_34_17 wn_ih_34_17 xhp17 xhn17 vdd vbsyn gsyn
X_ihm_35_17 a_xp35 a_xn35 wp_ih_35_17 wn_ih_35_17 mhp17 mhn17 vdd vbsyn gsyn
X_ihx_35_17 a_xp35 a_xn35 wp_ih_35_17 wn_ih_35_17 xhp17 xhn17 vdd vbsyn gsyn
X_ihm_36_17 a_xp36 a_xn36 wp_ih_36_17 wn_ih_36_17 mhp17 mhn17 vdd vbsyn gsyn
X_ihx_36_17 a_xp36 a_xn36 wp_ih_36_17 wn_ih_36_17 xhp17 xhn17 vdd vbsyn gsyn
X_ihm_37_17 a_xp37 a_xn37 wp_ih_37_17 wn_ih_37_17 mhp17 mhn17 vdd vbsyn gsyn
X_ihx_37_17 a_xp37 a_xn37 wp_ih_37_17 wn_ih_37_17 xhp17 xhn17 vdd vbsyn gsyn
X_ihm_38_17 a_xp38 a_xn38 wp_ih_38_17 wn_ih_38_17 mhp17 mhn17 vdd vbsyn gsyn
X_ihx_38_17 a_xp38 a_xn38 wp_ih_38_17 wn_ih_38_17 xhp17 xhn17 vdd vbsyn gsyn
X_ihm_39_17 a_xp39 a_xn39 wp_ih_39_17 wn_ih_39_17 mhp17 mhn17 vdd vbsyn gsyn
X_ihx_39_17 a_xp39 a_xn39 wp_ih_39_17 wn_ih_39_17 xhp17 xhn17 vdd vbsyn gsyn
X_ihm_40_17 a_xp40 a_xn40 wp_ih_40_17 wn_ih_40_17 mhp17 mhn17 vdd vbsyn gsyn
X_ihx_40_17 a_xp40 a_xn40 wp_ih_40_17 wn_ih_40_17 xhp17 xhn17 vdd vbsyn gsyn
X_ihm_41_17 a_xp41 a_xn41 wp_ih_41_17 wn_ih_41_17 mhp17 mhn17 vdd vbsyn gsyn
X_ihx_41_17 a_xp41 a_xn41 wp_ih_41_17 wn_ih_41_17 xhp17 xhn17 vdd vbsyn gsyn
X_ihm_42_17 a_xp42 a_xn42 wp_ih_42_17 wn_ih_42_17 mhp17 mhn17 vdd vbsyn gsyn
X_ihx_42_17 a_xp42 a_xn42 wp_ih_42_17 wn_ih_42_17 xhp17 xhn17 vdd vbsyn gsyn
X_ihm_43_17 a_xp43 a_xn43 wp_ih_43_17 wn_ih_43_17 mhp17 mhn17 vdd vbsyn gsyn
X_ihx_43_17 a_xp43 a_xn43 wp_ih_43_17 wn_ih_43_17 xhp17 xhn17 vdd vbsyn gsyn
X_ihm_44_17 a_xp44 a_xn44 wp_ih_44_17 wn_ih_44_17 mhp17 mhn17 vdd vbsyn gsyn
X_ihx_44_17 a_xp44 a_xn44 wp_ih_44_17 wn_ih_44_17 xhp17 xhn17 vdd vbsyn gsyn
X_ihm_45_17 a_xp45 a_xn45 wp_ih_45_17 wn_ih_45_17 mhp17 mhn17 vdd vbsyn gsyn
X_ihx_45_17 a_xp45 a_xn45 wp_ih_45_17 wn_ih_45_17 xhp17 xhn17 vdd vbsyn gsyn
X_ihm_46_17 a_xp46 a_xn46 wp_ih_46_17 wn_ih_46_17 mhp17 mhn17 vdd vbsyn gsyn
X_ihx_46_17 a_xp46 a_xn46 wp_ih_46_17 wn_ih_46_17 xhp17 xhn17 vdd vbsyn gsyn
X_ihm_47_17 a_xp47 a_xn47 wp_ih_47_17 wn_ih_47_17 mhp17 mhn17 vdd vbsyn gsyn
X_ihx_47_17 a_xp47 a_xn47 wp_ih_47_17 wn_ih_47_17 xhp17 xhn17 vdd vbsyn gsyn
X_ihm_48_17 a_xp48 a_xn48 wp_ih_48_17 wn_ih_48_17 mhp17 mhn17 vdd vbsyn gsyn
X_ihx_48_17 a_xp48 a_xn48 wp_ih_48_17 wn_ih_48_17 xhp17 xhn17 vdd vbsyn gsyn
X_ihm_49_17 a_xp49 a_xn49 wp_ih_49_17 wn_ih_49_17 mhp17 mhn17 vdd vbsyn gsyn
X_ihx_49_17 a_xp49 a_xn49 wp_ih_49_17 wn_ih_49_17 xhp17 xhn17 vdd vbsyn gsyn
X_ihm_50_17 a_xp50 a_xn50 wp_ih_50_17 wn_ih_50_17 mhp17 mhn17 vdd vbsyn gsyn
X_ihx_50_17 a_xp50 a_xn50 wp_ih_50_17 wn_ih_50_17 xhp17 xhn17 vdd vbsyn gsyn
X_ihm_51_17 a_xp51 a_xn51 wp_ih_51_17 wn_ih_51_17 mhp17 mhn17 vdd vbsyn gsyn
X_ihx_51_17 a_xp51 a_xn51 wp_ih_51_17 wn_ih_51_17 xhp17 xhn17 vdd vbsyn gsyn
X_ihm_52_17 a_xp52 a_xn52 wp_ih_52_17 wn_ih_52_17 mhp17 mhn17 vdd vbsyn gsyn
X_ihx_52_17 a_xp52 a_xn52 wp_ih_52_17 wn_ih_52_17 xhp17 xhn17 vdd vbsyn gsyn
X_ihm_53_17 a_xp53 a_xn53 wp_ih_53_17 wn_ih_53_17 mhp17 mhn17 vdd vbsyn gsyn
X_ihx_53_17 a_xp53 a_xn53 wp_ih_53_17 wn_ih_53_17 xhp17 xhn17 vdd vbsyn gsyn
X_ihm_54_17 a_xp54 a_xn54 wp_ih_54_17 wn_ih_54_17 mhp17 mhn17 vdd vbsyn gsyn
X_ihx_54_17 a_xp54 a_xn54 wp_ih_54_17 wn_ih_54_17 xhp17 xhn17 vdd vbsyn gsyn
X_ihm_55_17 a_xp55 a_xn55 wp_ih_55_17 wn_ih_55_17 mhp17 mhn17 vdd vbsyn gsyn
X_ihx_55_17 a_xp55 a_xn55 wp_ih_55_17 wn_ih_55_17 xhp17 xhn17 vdd vbsyn gsyn
X_ihm_56_17 a_xp56 a_xn56 wp_ih_56_17 wn_ih_56_17 mhp17 mhn17 vdd vbsyn gsyn
X_ihx_56_17 a_xp56 a_xn56 wp_ih_56_17 wn_ih_56_17 xhp17 xhn17 vdd vbsyn gsyn
X_ihm_57_17 a_xp57 a_xn57 wp_ih_57_17 wn_ih_57_17 mhp17 mhn17 vdd vbsyn gsyn
X_ihx_57_17 a_xp57 a_xn57 wp_ih_57_17 wn_ih_57_17 xhp17 xhn17 vdd vbsyn gsyn
X_ihm_58_17 a_xp58 a_xn58 wp_ih_58_17 wn_ih_58_17 mhp17 mhn17 vdd vbsyn gsyn
X_ihx_58_17 a_xp58 a_xn58 wp_ih_58_17 wn_ih_58_17 xhp17 xhn17 vdd vbsyn gsyn
X_ihm_59_17 a_xp59 a_xn59 wp_ih_59_17 wn_ih_59_17 mhp17 mhn17 vdd vbsyn gsyn
X_ihx_59_17 a_xp59 a_xn59 wp_ih_59_17 wn_ih_59_17 xhp17 xhn17 vdd vbsyn gsyn
X_ihm_60_17 a_xp60 a_xn60 wp_ih_60_17 wn_ih_60_17 mhp17 mhn17 vdd vbsyn gsyn
X_ihx_60_17 a_xp60 a_xn60 wp_ih_60_17 wn_ih_60_17 xhp17 xhn17 vdd vbsyn gsyn
X_ihm_61_17 a_xp61 a_xn61 wp_ih_61_17 wn_ih_61_17 mhp17 mhn17 vdd vbsyn gsyn
X_ihx_61_17 a_xp61 a_xn61 wp_ih_61_17 wn_ih_61_17 xhp17 xhn17 vdd vbsyn gsyn
X_ihm_62_17 a_xp62 a_xn62 wp_ih_62_17 wn_ih_62_17 mhp17 mhn17 vdd vbsyn gsyn
X_ihx_62_17 a_xp62 a_xn62 wp_ih_62_17 wn_ih_62_17 xhp17 xhn17 vdd vbsyn gsyn
X_ihm_63_17 a_xp63 a_xn63 wp_ih_63_17 wn_ih_63_17 mhp17 mhn17 vdd vbsyn gsyn
X_ihx_63_17 a_xp63 a_xn63 wp_ih_63_17 wn_ih_63_17 xhp17 xhn17 vdd vbsyn gsyn
X_bk_17_0 eop0 eon0 wp_ho_17_0 wn_ho_17_0 xhp17 xhn17 vdd vbbk gsyn
X_bk_17_1 eop1 eon1 wp_ho_17_1 wn_ho_17_1 xhp17 xhn17 vdd vbbk gsyn
X_bk_17_2 eop2 eon2 wp_ho_17_2 wn_ho_17_2 xhp17 xhn17 vdd vbbk gsyn
X_bk_17_3 eop3 eon3 wp_ho_17_3 wn_ho_17_3 xhp17 xhn17 vdd vbbk gsyn
X_bk_17_4 eop4 eon4 wp_ho_17_4 wn_ho_17_4 xhp17 xhn17 vdd vbbk gsyn
Xn17 xhp17 xhn17 ahp17 ahn17 vdd vbneu dneuron
Xeh17 xhp17 xhn17 mhp17 mhn17 ehp17 ehn17 vdd gm esub
Xcm_mh18 mhp18 mhn18 vdd cmld
Rnd_mh18 mhp18 mhn18 20k
Xcm_xh18 xhp18 xhn18 vdd cmld
Rnd_xh18 xhp18 xhn18 20k
X_ihm_0_18 a_xp0 a_xn0 wp_ih_0_18 wn_ih_0_18 mhp18 mhn18 vdd vbsyn gsyn
X_ihx_0_18 a_xp0 a_xn0 wp_ih_0_18 wn_ih_0_18 xhp18 xhn18 vdd vbsyn gsyn
X_ihm_1_18 a_xp1 a_xn1 wp_ih_1_18 wn_ih_1_18 mhp18 mhn18 vdd vbsyn gsyn
X_ihx_1_18 a_xp1 a_xn1 wp_ih_1_18 wn_ih_1_18 xhp18 xhn18 vdd vbsyn gsyn
X_ihm_2_18 a_xp2 a_xn2 wp_ih_2_18 wn_ih_2_18 mhp18 mhn18 vdd vbsyn gsyn
X_ihx_2_18 a_xp2 a_xn2 wp_ih_2_18 wn_ih_2_18 xhp18 xhn18 vdd vbsyn gsyn
X_ihm_3_18 a_xp3 a_xn3 wp_ih_3_18 wn_ih_3_18 mhp18 mhn18 vdd vbsyn gsyn
X_ihx_3_18 a_xp3 a_xn3 wp_ih_3_18 wn_ih_3_18 xhp18 xhn18 vdd vbsyn gsyn
X_ihm_4_18 a_xp4 a_xn4 wp_ih_4_18 wn_ih_4_18 mhp18 mhn18 vdd vbsyn gsyn
X_ihx_4_18 a_xp4 a_xn4 wp_ih_4_18 wn_ih_4_18 xhp18 xhn18 vdd vbsyn gsyn
X_ihm_5_18 a_xp5 a_xn5 wp_ih_5_18 wn_ih_5_18 mhp18 mhn18 vdd vbsyn gsyn
X_ihx_5_18 a_xp5 a_xn5 wp_ih_5_18 wn_ih_5_18 xhp18 xhn18 vdd vbsyn gsyn
X_ihm_6_18 a_xp6 a_xn6 wp_ih_6_18 wn_ih_6_18 mhp18 mhn18 vdd vbsyn gsyn
X_ihx_6_18 a_xp6 a_xn6 wp_ih_6_18 wn_ih_6_18 xhp18 xhn18 vdd vbsyn gsyn
X_ihm_7_18 a_xp7 a_xn7 wp_ih_7_18 wn_ih_7_18 mhp18 mhn18 vdd vbsyn gsyn
X_ihx_7_18 a_xp7 a_xn7 wp_ih_7_18 wn_ih_7_18 xhp18 xhn18 vdd vbsyn gsyn
X_ihm_8_18 a_xp8 a_xn8 wp_ih_8_18 wn_ih_8_18 mhp18 mhn18 vdd vbsyn gsyn
X_ihx_8_18 a_xp8 a_xn8 wp_ih_8_18 wn_ih_8_18 xhp18 xhn18 vdd vbsyn gsyn
X_ihm_9_18 a_xp9 a_xn9 wp_ih_9_18 wn_ih_9_18 mhp18 mhn18 vdd vbsyn gsyn
X_ihx_9_18 a_xp9 a_xn9 wp_ih_9_18 wn_ih_9_18 xhp18 xhn18 vdd vbsyn gsyn
X_ihm_10_18 a_xp10 a_xn10 wp_ih_10_18 wn_ih_10_18 mhp18 mhn18 vdd vbsyn gsyn
X_ihx_10_18 a_xp10 a_xn10 wp_ih_10_18 wn_ih_10_18 xhp18 xhn18 vdd vbsyn gsyn
X_ihm_11_18 a_xp11 a_xn11 wp_ih_11_18 wn_ih_11_18 mhp18 mhn18 vdd vbsyn gsyn
X_ihx_11_18 a_xp11 a_xn11 wp_ih_11_18 wn_ih_11_18 xhp18 xhn18 vdd vbsyn gsyn
X_ihm_12_18 a_xp12 a_xn12 wp_ih_12_18 wn_ih_12_18 mhp18 mhn18 vdd vbsyn gsyn
X_ihx_12_18 a_xp12 a_xn12 wp_ih_12_18 wn_ih_12_18 xhp18 xhn18 vdd vbsyn gsyn
X_ihm_13_18 a_xp13 a_xn13 wp_ih_13_18 wn_ih_13_18 mhp18 mhn18 vdd vbsyn gsyn
X_ihx_13_18 a_xp13 a_xn13 wp_ih_13_18 wn_ih_13_18 xhp18 xhn18 vdd vbsyn gsyn
X_ihm_14_18 a_xp14 a_xn14 wp_ih_14_18 wn_ih_14_18 mhp18 mhn18 vdd vbsyn gsyn
X_ihx_14_18 a_xp14 a_xn14 wp_ih_14_18 wn_ih_14_18 xhp18 xhn18 vdd vbsyn gsyn
X_ihm_15_18 a_xp15 a_xn15 wp_ih_15_18 wn_ih_15_18 mhp18 mhn18 vdd vbsyn gsyn
X_ihx_15_18 a_xp15 a_xn15 wp_ih_15_18 wn_ih_15_18 xhp18 xhn18 vdd vbsyn gsyn
X_ihm_16_18 a_xp16 a_xn16 wp_ih_16_18 wn_ih_16_18 mhp18 mhn18 vdd vbsyn gsyn
X_ihx_16_18 a_xp16 a_xn16 wp_ih_16_18 wn_ih_16_18 xhp18 xhn18 vdd vbsyn gsyn
X_ihm_17_18 a_xp17 a_xn17 wp_ih_17_18 wn_ih_17_18 mhp18 mhn18 vdd vbsyn gsyn
X_ihx_17_18 a_xp17 a_xn17 wp_ih_17_18 wn_ih_17_18 xhp18 xhn18 vdd vbsyn gsyn
X_ihm_18_18 a_xp18 a_xn18 wp_ih_18_18 wn_ih_18_18 mhp18 mhn18 vdd vbsyn gsyn
X_ihx_18_18 a_xp18 a_xn18 wp_ih_18_18 wn_ih_18_18 xhp18 xhn18 vdd vbsyn gsyn
X_ihm_19_18 a_xp19 a_xn19 wp_ih_19_18 wn_ih_19_18 mhp18 mhn18 vdd vbsyn gsyn
X_ihx_19_18 a_xp19 a_xn19 wp_ih_19_18 wn_ih_19_18 xhp18 xhn18 vdd vbsyn gsyn
X_ihm_20_18 a_xp20 a_xn20 wp_ih_20_18 wn_ih_20_18 mhp18 mhn18 vdd vbsyn gsyn
X_ihx_20_18 a_xp20 a_xn20 wp_ih_20_18 wn_ih_20_18 xhp18 xhn18 vdd vbsyn gsyn
X_ihm_21_18 a_xp21 a_xn21 wp_ih_21_18 wn_ih_21_18 mhp18 mhn18 vdd vbsyn gsyn
X_ihx_21_18 a_xp21 a_xn21 wp_ih_21_18 wn_ih_21_18 xhp18 xhn18 vdd vbsyn gsyn
X_ihm_22_18 a_xp22 a_xn22 wp_ih_22_18 wn_ih_22_18 mhp18 mhn18 vdd vbsyn gsyn
X_ihx_22_18 a_xp22 a_xn22 wp_ih_22_18 wn_ih_22_18 xhp18 xhn18 vdd vbsyn gsyn
X_ihm_23_18 a_xp23 a_xn23 wp_ih_23_18 wn_ih_23_18 mhp18 mhn18 vdd vbsyn gsyn
X_ihx_23_18 a_xp23 a_xn23 wp_ih_23_18 wn_ih_23_18 xhp18 xhn18 vdd vbsyn gsyn
X_ihm_24_18 a_xp24 a_xn24 wp_ih_24_18 wn_ih_24_18 mhp18 mhn18 vdd vbsyn gsyn
X_ihx_24_18 a_xp24 a_xn24 wp_ih_24_18 wn_ih_24_18 xhp18 xhn18 vdd vbsyn gsyn
X_ihm_25_18 a_xp25 a_xn25 wp_ih_25_18 wn_ih_25_18 mhp18 mhn18 vdd vbsyn gsyn
X_ihx_25_18 a_xp25 a_xn25 wp_ih_25_18 wn_ih_25_18 xhp18 xhn18 vdd vbsyn gsyn
X_ihm_26_18 a_xp26 a_xn26 wp_ih_26_18 wn_ih_26_18 mhp18 mhn18 vdd vbsyn gsyn
X_ihx_26_18 a_xp26 a_xn26 wp_ih_26_18 wn_ih_26_18 xhp18 xhn18 vdd vbsyn gsyn
X_ihm_27_18 a_xp27 a_xn27 wp_ih_27_18 wn_ih_27_18 mhp18 mhn18 vdd vbsyn gsyn
X_ihx_27_18 a_xp27 a_xn27 wp_ih_27_18 wn_ih_27_18 xhp18 xhn18 vdd vbsyn gsyn
X_ihm_28_18 a_xp28 a_xn28 wp_ih_28_18 wn_ih_28_18 mhp18 mhn18 vdd vbsyn gsyn
X_ihx_28_18 a_xp28 a_xn28 wp_ih_28_18 wn_ih_28_18 xhp18 xhn18 vdd vbsyn gsyn
X_ihm_29_18 a_xp29 a_xn29 wp_ih_29_18 wn_ih_29_18 mhp18 mhn18 vdd vbsyn gsyn
X_ihx_29_18 a_xp29 a_xn29 wp_ih_29_18 wn_ih_29_18 xhp18 xhn18 vdd vbsyn gsyn
X_ihm_30_18 a_xp30 a_xn30 wp_ih_30_18 wn_ih_30_18 mhp18 mhn18 vdd vbsyn gsyn
X_ihx_30_18 a_xp30 a_xn30 wp_ih_30_18 wn_ih_30_18 xhp18 xhn18 vdd vbsyn gsyn
X_ihm_31_18 a_xp31 a_xn31 wp_ih_31_18 wn_ih_31_18 mhp18 mhn18 vdd vbsyn gsyn
X_ihx_31_18 a_xp31 a_xn31 wp_ih_31_18 wn_ih_31_18 xhp18 xhn18 vdd vbsyn gsyn
X_ihm_32_18 a_xp32 a_xn32 wp_ih_32_18 wn_ih_32_18 mhp18 mhn18 vdd vbsyn gsyn
X_ihx_32_18 a_xp32 a_xn32 wp_ih_32_18 wn_ih_32_18 xhp18 xhn18 vdd vbsyn gsyn
X_ihm_33_18 a_xp33 a_xn33 wp_ih_33_18 wn_ih_33_18 mhp18 mhn18 vdd vbsyn gsyn
X_ihx_33_18 a_xp33 a_xn33 wp_ih_33_18 wn_ih_33_18 xhp18 xhn18 vdd vbsyn gsyn
X_ihm_34_18 a_xp34 a_xn34 wp_ih_34_18 wn_ih_34_18 mhp18 mhn18 vdd vbsyn gsyn
X_ihx_34_18 a_xp34 a_xn34 wp_ih_34_18 wn_ih_34_18 xhp18 xhn18 vdd vbsyn gsyn
X_ihm_35_18 a_xp35 a_xn35 wp_ih_35_18 wn_ih_35_18 mhp18 mhn18 vdd vbsyn gsyn
X_ihx_35_18 a_xp35 a_xn35 wp_ih_35_18 wn_ih_35_18 xhp18 xhn18 vdd vbsyn gsyn
X_ihm_36_18 a_xp36 a_xn36 wp_ih_36_18 wn_ih_36_18 mhp18 mhn18 vdd vbsyn gsyn
X_ihx_36_18 a_xp36 a_xn36 wp_ih_36_18 wn_ih_36_18 xhp18 xhn18 vdd vbsyn gsyn
X_ihm_37_18 a_xp37 a_xn37 wp_ih_37_18 wn_ih_37_18 mhp18 mhn18 vdd vbsyn gsyn
X_ihx_37_18 a_xp37 a_xn37 wp_ih_37_18 wn_ih_37_18 xhp18 xhn18 vdd vbsyn gsyn
X_ihm_38_18 a_xp38 a_xn38 wp_ih_38_18 wn_ih_38_18 mhp18 mhn18 vdd vbsyn gsyn
X_ihx_38_18 a_xp38 a_xn38 wp_ih_38_18 wn_ih_38_18 xhp18 xhn18 vdd vbsyn gsyn
X_ihm_39_18 a_xp39 a_xn39 wp_ih_39_18 wn_ih_39_18 mhp18 mhn18 vdd vbsyn gsyn
X_ihx_39_18 a_xp39 a_xn39 wp_ih_39_18 wn_ih_39_18 xhp18 xhn18 vdd vbsyn gsyn
X_ihm_40_18 a_xp40 a_xn40 wp_ih_40_18 wn_ih_40_18 mhp18 mhn18 vdd vbsyn gsyn
X_ihx_40_18 a_xp40 a_xn40 wp_ih_40_18 wn_ih_40_18 xhp18 xhn18 vdd vbsyn gsyn
X_ihm_41_18 a_xp41 a_xn41 wp_ih_41_18 wn_ih_41_18 mhp18 mhn18 vdd vbsyn gsyn
X_ihx_41_18 a_xp41 a_xn41 wp_ih_41_18 wn_ih_41_18 xhp18 xhn18 vdd vbsyn gsyn
X_ihm_42_18 a_xp42 a_xn42 wp_ih_42_18 wn_ih_42_18 mhp18 mhn18 vdd vbsyn gsyn
X_ihx_42_18 a_xp42 a_xn42 wp_ih_42_18 wn_ih_42_18 xhp18 xhn18 vdd vbsyn gsyn
X_ihm_43_18 a_xp43 a_xn43 wp_ih_43_18 wn_ih_43_18 mhp18 mhn18 vdd vbsyn gsyn
X_ihx_43_18 a_xp43 a_xn43 wp_ih_43_18 wn_ih_43_18 xhp18 xhn18 vdd vbsyn gsyn
X_ihm_44_18 a_xp44 a_xn44 wp_ih_44_18 wn_ih_44_18 mhp18 mhn18 vdd vbsyn gsyn
X_ihx_44_18 a_xp44 a_xn44 wp_ih_44_18 wn_ih_44_18 xhp18 xhn18 vdd vbsyn gsyn
X_ihm_45_18 a_xp45 a_xn45 wp_ih_45_18 wn_ih_45_18 mhp18 mhn18 vdd vbsyn gsyn
X_ihx_45_18 a_xp45 a_xn45 wp_ih_45_18 wn_ih_45_18 xhp18 xhn18 vdd vbsyn gsyn
X_ihm_46_18 a_xp46 a_xn46 wp_ih_46_18 wn_ih_46_18 mhp18 mhn18 vdd vbsyn gsyn
X_ihx_46_18 a_xp46 a_xn46 wp_ih_46_18 wn_ih_46_18 xhp18 xhn18 vdd vbsyn gsyn
X_ihm_47_18 a_xp47 a_xn47 wp_ih_47_18 wn_ih_47_18 mhp18 mhn18 vdd vbsyn gsyn
X_ihx_47_18 a_xp47 a_xn47 wp_ih_47_18 wn_ih_47_18 xhp18 xhn18 vdd vbsyn gsyn
X_ihm_48_18 a_xp48 a_xn48 wp_ih_48_18 wn_ih_48_18 mhp18 mhn18 vdd vbsyn gsyn
X_ihx_48_18 a_xp48 a_xn48 wp_ih_48_18 wn_ih_48_18 xhp18 xhn18 vdd vbsyn gsyn
X_ihm_49_18 a_xp49 a_xn49 wp_ih_49_18 wn_ih_49_18 mhp18 mhn18 vdd vbsyn gsyn
X_ihx_49_18 a_xp49 a_xn49 wp_ih_49_18 wn_ih_49_18 xhp18 xhn18 vdd vbsyn gsyn
X_ihm_50_18 a_xp50 a_xn50 wp_ih_50_18 wn_ih_50_18 mhp18 mhn18 vdd vbsyn gsyn
X_ihx_50_18 a_xp50 a_xn50 wp_ih_50_18 wn_ih_50_18 xhp18 xhn18 vdd vbsyn gsyn
X_ihm_51_18 a_xp51 a_xn51 wp_ih_51_18 wn_ih_51_18 mhp18 mhn18 vdd vbsyn gsyn
X_ihx_51_18 a_xp51 a_xn51 wp_ih_51_18 wn_ih_51_18 xhp18 xhn18 vdd vbsyn gsyn
X_ihm_52_18 a_xp52 a_xn52 wp_ih_52_18 wn_ih_52_18 mhp18 mhn18 vdd vbsyn gsyn
X_ihx_52_18 a_xp52 a_xn52 wp_ih_52_18 wn_ih_52_18 xhp18 xhn18 vdd vbsyn gsyn
X_ihm_53_18 a_xp53 a_xn53 wp_ih_53_18 wn_ih_53_18 mhp18 mhn18 vdd vbsyn gsyn
X_ihx_53_18 a_xp53 a_xn53 wp_ih_53_18 wn_ih_53_18 xhp18 xhn18 vdd vbsyn gsyn
X_ihm_54_18 a_xp54 a_xn54 wp_ih_54_18 wn_ih_54_18 mhp18 mhn18 vdd vbsyn gsyn
X_ihx_54_18 a_xp54 a_xn54 wp_ih_54_18 wn_ih_54_18 xhp18 xhn18 vdd vbsyn gsyn
X_ihm_55_18 a_xp55 a_xn55 wp_ih_55_18 wn_ih_55_18 mhp18 mhn18 vdd vbsyn gsyn
X_ihx_55_18 a_xp55 a_xn55 wp_ih_55_18 wn_ih_55_18 xhp18 xhn18 vdd vbsyn gsyn
X_ihm_56_18 a_xp56 a_xn56 wp_ih_56_18 wn_ih_56_18 mhp18 mhn18 vdd vbsyn gsyn
X_ihx_56_18 a_xp56 a_xn56 wp_ih_56_18 wn_ih_56_18 xhp18 xhn18 vdd vbsyn gsyn
X_ihm_57_18 a_xp57 a_xn57 wp_ih_57_18 wn_ih_57_18 mhp18 mhn18 vdd vbsyn gsyn
X_ihx_57_18 a_xp57 a_xn57 wp_ih_57_18 wn_ih_57_18 xhp18 xhn18 vdd vbsyn gsyn
X_ihm_58_18 a_xp58 a_xn58 wp_ih_58_18 wn_ih_58_18 mhp18 mhn18 vdd vbsyn gsyn
X_ihx_58_18 a_xp58 a_xn58 wp_ih_58_18 wn_ih_58_18 xhp18 xhn18 vdd vbsyn gsyn
X_ihm_59_18 a_xp59 a_xn59 wp_ih_59_18 wn_ih_59_18 mhp18 mhn18 vdd vbsyn gsyn
X_ihx_59_18 a_xp59 a_xn59 wp_ih_59_18 wn_ih_59_18 xhp18 xhn18 vdd vbsyn gsyn
X_ihm_60_18 a_xp60 a_xn60 wp_ih_60_18 wn_ih_60_18 mhp18 mhn18 vdd vbsyn gsyn
X_ihx_60_18 a_xp60 a_xn60 wp_ih_60_18 wn_ih_60_18 xhp18 xhn18 vdd vbsyn gsyn
X_ihm_61_18 a_xp61 a_xn61 wp_ih_61_18 wn_ih_61_18 mhp18 mhn18 vdd vbsyn gsyn
X_ihx_61_18 a_xp61 a_xn61 wp_ih_61_18 wn_ih_61_18 xhp18 xhn18 vdd vbsyn gsyn
X_ihm_62_18 a_xp62 a_xn62 wp_ih_62_18 wn_ih_62_18 mhp18 mhn18 vdd vbsyn gsyn
X_ihx_62_18 a_xp62 a_xn62 wp_ih_62_18 wn_ih_62_18 xhp18 xhn18 vdd vbsyn gsyn
X_ihm_63_18 a_xp63 a_xn63 wp_ih_63_18 wn_ih_63_18 mhp18 mhn18 vdd vbsyn gsyn
X_ihx_63_18 a_xp63 a_xn63 wp_ih_63_18 wn_ih_63_18 xhp18 xhn18 vdd vbsyn gsyn
X_bk_18_0 eop0 eon0 wp_ho_18_0 wn_ho_18_0 xhp18 xhn18 vdd vbbk gsyn
X_bk_18_1 eop1 eon1 wp_ho_18_1 wn_ho_18_1 xhp18 xhn18 vdd vbbk gsyn
X_bk_18_2 eop2 eon2 wp_ho_18_2 wn_ho_18_2 xhp18 xhn18 vdd vbbk gsyn
X_bk_18_3 eop3 eon3 wp_ho_18_3 wn_ho_18_3 xhp18 xhn18 vdd vbbk gsyn
X_bk_18_4 eop4 eon4 wp_ho_18_4 wn_ho_18_4 xhp18 xhn18 vdd vbbk gsyn
Xn18 xhp18 xhn18 ahp18 ahn18 vdd vbneu dneuron
Xeh18 xhp18 xhn18 mhp18 mhn18 ehp18 ehn18 vdd gm esub
Xcm_mh19 mhp19 mhn19 vdd cmld
Rnd_mh19 mhp19 mhn19 20k
Xcm_xh19 xhp19 xhn19 vdd cmld
Rnd_xh19 xhp19 xhn19 20k
X_ihm_0_19 a_xp0 a_xn0 wp_ih_0_19 wn_ih_0_19 mhp19 mhn19 vdd vbsyn gsyn
X_ihx_0_19 a_xp0 a_xn0 wp_ih_0_19 wn_ih_0_19 xhp19 xhn19 vdd vbsyn gsyn
X_ihm_1_19 a_xp1 a_xn1 wp_ih_1_19 wn_ih_1_19 mhp19 mhn19 vdd vbsyn gsyn
X_ihx_1_19 a_xp1 a_xn1 wp_ih_1_19 wn_ih_1_19 xhp19 xhn19 vdd vbsyn gsyn
X_ihm_2_19 a_xp2 a_xn2 wp_ih_2_19 wn_ih_2_19 mhp19 mhn19 vdd vbsyn gsyn
X_ihx_2_19 a_xp2 a_xn2 wp_ih_2_19 wn_ih_2_19 xhp19 xhn19 vdd vbsyn gsyn
X_ihm_3_19 a_xp3 a_xn3 wp_ih_3_19 wn_ih_3_19 mhp19 mhn19 vdd vbsyn gsyn
X_ihx_3_19 a_xp3 a_xn3 wp_ih_3_19 wn_ih_3_19 xhp19 xhn19 vdd vbsyn gsyn
X_ihm_4_19 a_xp4 a_xn4 wp_ih_4_19 wn_ih_4_19 mhp19 mhn19 vdd vbsyn gsyn
X_ihx_4_19 a_xp4 a_xn4 wp_ih_4_19 wn_ih_4_19 xhp19 xhn19 vdd vbsyn gsyn
X_ihm_5_19 a_xp5 a_xn5 wp_ih_5_19 wn_ih_5_19 mhp19 mhn19 vdd vbsyn gsyn
X_ihx_5_19 a_xp5 a_xn5 wp_ih_5_19 wn_ih_5_19 xhp19 xhn19 vdd vbsyn gsyn
X_ihm_6_19 a_xp6 a_xn6 wp_ih_6_19 wn_ih_6_19 mhp19 mhn19 vdd vbsyn gsyn
X_ihx_6_19 a_xp6 a_xn6 wp_ih_6_19 wn_ih_6_19 xhp19 xhn19 vdd vbsyn gsyn
X_ihm_7_19 a_xp7 a_xn7 wp_ih_7_19 wn_ih_7_19 mhp19 mhn19 vdd vbsyn gsyn
X_ihx_7_19 a_xp7 a_xn7 wp_ih_7_19 wn_ih_7_19 xhp19 xhn19 vdd vbsyn gsyn
X_ihm_8_19 a_xp8 a_xn8 wp_ih_8_19 wn_ih_8_19 mhp19 mhn19 vdd vbsyn gsyn
X_ihx_8_19 a_xp8 a_xn8 wp_ih_8_19 wn_ih_8_19 xhp19 xhn19 vdd vbsyn gsyn
X_ihm_9_19 a_xp9 a_xn9 wp_ih_9_19 wn_ih_9_19 mhp19 mhn19 vdd vbsyn gsyn
X_ihx_9_19 a_xp9 a_xn9 wp_ih_9_19 wn_ih_9_19 xhp19 xhn19 vdd vbsyn gsyn
X_ihm_10_19 a_xp10 a_xn10 wp_ih_10_19 wn_ih_10_19 mhp19 mhn19 vdd vbsyn gsyn
X_ihx_10_19 a_xp10 a_xn10 wp_ih_10_19 wn_ih_10_19 xhp19 xhn19 vdd vbsyn gsyn
X_ihm_11_19 a_xp11 a_xn11 wp_ih_11_19 wn_ih_11_19 mhp19 mhn19 vdd vbsyn gsyn
X_ihx_11_19 a_xp11 a_xn11 wp_ih_11_19 wn_ih_11_19 xhp19 xhn19 vdd vbsyn gsyn
X_ihm_12_19 a_xp12 a_xn12 wp_ih_12_19 wn_ih_12_19 mhp19 mhn19 vdd vbsyn gsyn
X_ihx_12_19 a_xp12 a_xn12 wp_ih_12_19 wn_ih_12_19 xhp19 xhn19 vdd vbsyn gsyn
X_ihm_13_19 a_xp13 a_xn13 wp_ih_13_19 wn_ih_13_19 mhp19 mhn19 vdd vbsyn gsyn
X_ihx_13_19 a_xp13 a_xn13 wp_ih_13_19 wn_ih_13_19 xhp19 xhn19 vdd vbsyn gsyn
X_ihm_14_19 a_xp14 a_xn14 wp_ih_14_19 wn_ih_14_19 mhp19 mhn19 vdd vbsyn gsyn
X_ihx_14_19 a_xp14 a_xn14 wp_ih_14_19 wn_ih_14_19 xhp19 xhn19 vdd vbsyn gsyn
X_ihm_15_19 a_xp15 a_xn15 wp_ih_15_19 wn_ih_15_19 mhp19 mhn19 vdd vbsyn gsyn
X_ihx_15_19 a_xp15 a_xn15 wp_ih_15_19 wn_ih_15_19 xhp19 xhn19 vdd vbsyn gsyn
X_ihm_16_19 a_xp16 a_xn16 wp_ih_16_19 wn_ih_16_19 mhp19 mhn19 vdd vbsyn gsyn
X_ihx_16_19 a_xp16 a_xn16 wp_ih_16_19 wn_ih_16_19 xhp19 xhn19 vdd vbsyn gsyn
X_ihm_17_19 a_xp17 a_xn17 wp_ih_17_19 wn_ih_17_19 mhp19 mhn19 vdd vbsyn gsyn
X_ihx_17_19 a_xp17 a_xn17 wp_ih_17_19 wn_ih_17_19 xhp19 xhn19 vdd vbsyn gsyn
X_ihm_18_19 a_xp18 a_xn18 wp_ih_18_19 wn_ih_18_19 mhp19 mhn19 vdd vbsyn gsyn
X_ihx_18_19 a_xp18 a_xn18 wp_ih_18_19 wn_ih_18_19 xhp19 xhn19 vdd vbsyn gsyn
X_ihm_19_19 a_xp19 a_xn19 wp_ih_19_19 wn_ih_19_19 mhp19 mhn19 vdd vbsyn gsyn
X_ihx_19_19 a_xp19 a_xn19 wp_ih_19_19 wn_ih_19_19 xhp19 xhn19 vdd vbsyn gsyn
X_ihm_20_19 a_xp20 a_xn20 wp_ih_20_19 wn_ih_20_19 mhp19 mhn19 vdd vbsyn gsyn
X_ihx_20_19 a_xp20 a_xn20 wp_ih_20_19 wn_ih_20_19 xhp19 xhn19 vdd vbsyn gsyn
X_ihm_21_19 a_xp21 a_xn21 wp_ih_21_19 wn_ih_21_19 mhp19 mhn19 vdd vbsyn gsyn
X_ihx_21_19 a_xp21 a_xn21 wp_ih_21_19 wn_ih_21_19 xhp19 xhn19 vdd vbsyn gsyn
X_ihm_22_19 a_xp22 a_xn22 wp_ih_22_19 wn_ih_22_19 mhp19 mhn19 vdd vbsyn gsyn
X_ihx_22_19 a_xp22 a_xn22 wp_ih_22_19 wn_ih_22_19 xhp19 xhn19 vdd vbsyn gsyn
X_ihm_23_19 a_xp23 a_xn23 wp_ih_23_19 wn_ih_23_19 mhp19 mhn19 vdd vbsyn gsyn
X_ihx_23_19 a_xp23 a_xn23 wp_ih_23_19 wn_ih_23_19 xhp19 xhn19 vdd vbsyn gsyn
X_ihm_24_19 a_xp24 a_xn24 wp_ih_24_19 wn_ih_24_19 mhp19 mhn19 vdd vbsyn gsyn
X_ihx_24_19 a_xp24 a_xn24 wp_ih_24_19 wn_ih_24_19 xhp19 xhn19 vdd vbsyn gsyn
X_ihm_25_19 a_xp25 a_xn25 wp_ih_25_19 wn_ih_25_19 mhp19 mhn19 vdd vbsyn gsyn
X_ihx_25_19 a_xp25 a_xn25 wp_ih_25_19 wn_ih_25_19 xhp19 xhn19 vdd vbsyn gsyn
X_ihm_26_19 a_xp26 a_xn26 wp_ih_26_19 wn_ih_26_19 mhp19 mhn19 vdd vbsyn gsyn
X_ihx_26_19 a_xp26 a_xn26 wp_ih_26_19 wn_ih_26_19 xhp19 xhn19 vdd vbsyn gsyn
X_ihm_27_19 a_xp27 a_xn27 wp_ih_27_19 wn_ih_27_19 mhp19 mhn19 vdd vbsyn gsyn
X_ihx_27_19 a_xp27 a_xn27 wp_ih_27_19 wn_ih_27_19 xhp19 xhn19 vdd vbsyn gsyn
X_ihm_28_19 a_xp28 a_xn28 wp_ih_28_19 wn_ih_28_19 mhp19 mhn19 vdd vbsyn gsyn
X_ihx_28_19 a_xp28 a_xn28 wp_ih_28_19 wn_ih_28_19 xhp19 xhn19 vdd vbsyn gsyn
X_ihm_29_19 a_xp29 a_xn29 wp_ih_29_19 wn_ih_29_19 mhp19 mhn19 vdd vbsyn gsyn
X_ihx_29_19 a_xp29 a_xn29 wp_ih_29_19 wn_ih_29_19 xhp19 xhn19 vdd vbsyn gsyn
X_ihm_30_19 a_xp30 a_xn30 wp_ih_30_19 wn_ih_30_19 mhp19 mhn19 vdd vbsyn gsyn
X_ihx_30_19 a_xp30 a_xn30 wp_ih_30_19 wn_ih_30_19 xhp19 xhn19 vdd vbsyn gsyn
X_ihm_31_19 a_xp31 a_xn31 wp_ih_31_19 wn_ih_31_19 mhp19 mhn19 vdd vbsyn gsyn
X_ihx_31_19 a_xp31 a_xn31 wp_ih_31_19 wn_ih_31_19 xhp19 xhn19 vdd vbsyn gsyn
X_ihm_32_19 a_xp32 a_xn32 wp_ih_32_19 wn_ih_32_19 mhp19 mhn19 vdd vbsyn gsyn
X_ihx_32_19 a_xp32 a_xn32 wp_ih_32_19 wn_ih_32_19 xhp19 xhn19 vdd vbsyn gsyn
X_ihm_33_19 a_xp33 a_xn33 wp_ih_33_19 wn_ih_33_19 mhp19 mhn19 vdd vbsyn gsyn
X_ihx_33_19 a_xp33 a_xn33 wp_ih_33_19 wn_ih_33_19 xhp19 xhn19 vdd vbsyn gsyn
X_ihm_34_19 a_xp34 a_xn34 wp_ih_34_19 wn_ih_34_19 mhp19 mhn19 vdd vbsyn gsyn
X_ihx_34_19 a_xp34 a_xn34 wp_ih_34_19 wn_ih_34_19 xhp19 xhn19 vdd vbsyn gsyn
X_ihm_35_19 a_xp35 a_xn35 wp_ih_35_19 wn_ih_35_19 mhp19 mhn19 vdd vbsyn gsyn
X_ihx_35_19 a_xp35 a_xn35 wp_ih_35_19 wn_ih_35_19 xhp19 xhn19 vdd vbsyn gsyn
X_ihm_36_19 a_xp36 a_xn36 wp_ih_36_19 wn_ih_36_19 mhp19 mhn19 vdd vbsyn gsyn
X_ihx_36_19 a_xp36 a_xn36 wp_ih_36_19 wn_ih_36_19 xhp19 xhn19 vdd vbsyn gsyn
X_ihm_37_19 a_xp37 a_xn37 wp_ih_37_19 wn_ih_37_19 mhp19 mhn19 vdd vbsyn gsyn
X_ihx_37_19 a_xp37 a_xn37 wp_ih_37_19 wn_ih_37_19 xhp19 xhn19 vdd vbsyn gsyn
X_ihm_38_19 a_xp38 a_xn38 wp_ih_38_19 wn_ih_38_19 mhp19 mhn19 vdd vbsyn gsyn
X_ihx_38_19 a_xp38 a_xn38 wp_ih_38_19 wn_ih_38_19 xhp19 xhn19 vdd vbsyn gsyn
X_ihm_39_19 a_xp39 a_xn39 wp_ih_39_19 wn_ih_39_19 mhp19 mhn19 vdd vbsyn gsyn
X_ihx_39_19 a_xp39 a_xn39 wp_ih_39_19 wn_ih_39_19 xhp19 xhn19 vdd vbsyn gsyn
X_ihm_40_19 a_xp40 a_xn40 wp_ih_40_19 wn_ih_40_19 mhp19 mhn19 vdd vbsyn gsyn
X_ihx_40_19 a_xp40 a_xn40 wp_ih_40_19 wn_ih_40_19 xhp19 xhn19 vdd vbsyn gsyn
X_ihm_41_19 a_xp41 a_xn41 wp_ih_41_19 wn_ih_41_19 mhp19 mhn19 vdd vbsyn gsyn
X_ihx_41_19 a_xp41 a_xn41 wp_ih_41_19 wn_ih_41_19 xhp19 xhn19 vdd vbsyn gsyn
X_ihm_42_19 a_xp42 a_xn42 wp_ih_42_19 wn_ih_42_19 mhp19 mhn19 vdd vbsyn gsyn
X_ihx_42_19 a_xp42 a_xn42 wp_ih_42_19 wn_ih_42_19 xhp19 xhn19 vdd vbsyn gsyn
X_ihm_43_19 a_xp43 a_xn43 wp_ih_43_19 wn_ih_43_19 mhp19 mhn19 vdd vbsyn gsyn
X_ihx_43_19 a_xp43 a_xn43 wp_ih_43_19 wn_ih_43_19 xhp19 xhn19 vdd vbsyn gsyn
X_ihm_44_19 a_xp44 a_xn44 wp_ih_44_19 wn_ih_44_19 mhp19 mhn19 vdd vbsyn gsyn
X_ihx_44_19 a_xp44 a_xn44 wp_ih_44_19 wn_ih_44_19 xhp19 xhn19 vdd vbsyn gsyn
X_ihm_45_19 a_xp45 a_xn45 wp_ih_45_19 wn_ih_45_19 mhp19 mhn19 vdd vbsyn gsyn
X_ihx_45_19 a_xp45 a_xn45 wp_ih_45_19 wn_ih_45_19 xhp19 xhn19 vdd vbsyn gsyn
X_ihm_46_19 a_xp46 a_xn46 wp_ih_46_19 wn_ih_46_19 mhp19 mhn19 vdd vbsyn gsyn
X_ihx_46_19 a_xp46 a_xn46 wp_ih_46_19 wn_ih_46_19 xhp19 xhn19 vdd vbsyn gsyn
X_ihm_47_19 a_xp47 a_xn47 wp_ih_47_19 wn_ih_47_19 mhp19 mhn19 vdd vbsyn gsyn
X_ihx_47_19 a_xp47 a_xn47 wp_ih_47_19 wn_ih_47_19 xhp19 xhn19 vdd vbsyn gsyn
X_ihm_48_19 a_xp48 a_xn48 wp_ih_48_19 wn_ih_48_19 mhp19 mhn19 vdd vbsyn gsyn
X_ihx_48_19 a_xp48 a_xn48 wp_ih_48_19 wn_ih_48_19 xhp19 xhn19 vdd vbsyn gsyn
X_ihm_49_19 a_xp49 a_xn49 wp_ih_49_19 wn_ih_49_19 mhp19 mhn19 vdd vbsyn gsyn
X_ihx_49_19 a_xp49 a_xn49 wp_ih_49_19 wn_ih_49_19 xhp19 xhn19 vdd vbsyn gsyn
X_ihm_50_19 a_xp50 a_xn50 wp_ih_50_19 wn_ih_50_19 mhp19 mhn19 vdd vbsyn gsyn
X_ihx_50_19 a_xp50 a_xn50 wp_ih_50_19 wn_ih_50_19 xhp19 xhn19 vdd vbsyn gsyn
X_ihm_51_19 a_xp51 a_xn51 wp_ih_51_19 wn_ih_51_19 mhp19 mhn19 vdd vbsyn gsyn
X_ihx_51_19 a_xp51 a_xn51 wp_ih_51_19 wn_ih_51_19 xhp19 xhn19 vdd vbsyn gsyn
X_ihm_52_19 a_xp52 a_xn52 wp_ih_52_19 wn_ih_52_19 mhp19 mhn19 vdd vbsyn gsyn
X_ihx_52_19 a_xp52 a_xn52 wp_ih_52_19 wn_ih_52_19 xhp19 xhn19 vdd vbsyn gsyn
X_ihm_53_19 a_xp53 a_xn53 wp_ih_53_19 wn_ih_53_19 mhp19 mhn19 vdd vbsyn gsyn
X_ihx_53_19 a_xp53 a_xn53 wp_ih_53_19 wn_ih_53_19 xhp19 xhn19 vdd vbsyn gsyn
X_ihm_54_19 a_xp54 a_xn54 wp_ih_54_19 wn_ih_54_19 mhp19 mhn19 vdd vbsyn gsyn
X_ihx_54_19 a_xp54 a_xn54 wp_ih_54_19 wn_ih_54_19 xhp19 xhn19 vdd vbsyn gsyn
X_ihm_55_19 a_xp55 a_xn55 wp_ih_55_19 wn_ih_55_19 mhp19 mhn19 vdd vbsyn gsyn
X_ihx_55_19 a_xp55 a_xn55 wp_ih_55_19 wn_ih_55_19 xhp19 xhn19 vdd vbsyn gsyn
X_ihm_56_19 a_xp56 a_xn56 wp_ih_56_19 wn_ih_56_19 mhp19 mhn19 vdd vbsyn gsyn
X_ihx_56_19 a_xp56 a_xn56 wp_ih_56_19 wn_ih_56_19 xhp19 xhn19 vdd vbsyn gsyn
X_ihm_57_19 a_xp57 a_xn57 wp_ih_57_19 wn_ih_57_19 mhp19 mhn19 vdd vbsyn gsyn
X_ihx_57_19 a_xp57 a_xn57 wp_ih_57_19 wn_ih_57_19 xhp19 xhn19 vdd vbsyn gsyn
X_ihm_58_19 a_xp58 a_xn58 wp_ih_58_19 wn_ih_58_19 mhp19 mhn19 vdd vbsyn gsyn
X_ihx_58_19 a_xp58 a_xn58 wp_ih_58_19 wn_ih_58_19 xhp19 xhn19 vdd vbsyn gsyn
X_ihm_59_19 a_xp59 a_xn59 wp_ih_59_19 wn_ih_59_19 mhp19 mhn19 vdd vbsyn gsyn
X_ihx_59_19 a_xp59 a_xn59 wp_ih_59_19 wn_ih_59_19 xhp19 xhn19 vdd vbsyn gsyn
X_ihm_60_19 a_xp60 a_xn60 wp_ih_60_19 wn_ih_60_19 mhp19 mhn19 vdd vbsyn gsyn
X_ihx_60_19 a_xp60 a_xn60 wp_ih_60_19 wn_ih_60_19 xhp19 xhn19 vdd vbsyn gsyn
X_ihm_61_19 a_xp61 a_xn61 wp_ih_61_19 wn_ih_61_19 mhp19 mhn19 vdd vbsyn gsyn
X_ihx_61_19 a_xp61 a_xn61 wp_ih_61_19 wn_ih_61_19 xhp19 xhn19 vdd vbsyn gsyn
X_ihm_62_19 a_xp62 a_xn62 wp_ih_62_19 wn_ih_62_19 mhp19 mhn19 vdd vbsyn gsyn
X_ihx_62_19 a_xp62 a_xn62 wp_ih_62_19 wn_ih_62_19 xhp19 xhn19 vdd vbsyn gsyn
X_ihm_63_19 a_xp63 a_xn63 wp_ih_63_19 wn_ih_63_19 mhp19 mhn19 vdd vbsyn gsyn
X_ihx_63_19 a_xp63 a_xn63 wp_ih_63_19 wn_ih_63_19 xhp19 xhn19 vdd vbsyn gsyn
X_bk_19_0 eop0 eon0 wp_ho_19_0 wn_ho_19_0 xhp19 xhn19 vdd vbbk gsyn
X_bk_19_1 eop1 eon1 wp_ho_19_1 wn_ho_19_1 xhp19 xhn19 vdd vbbk gsyn
X_bk_19_2 eop2 eon2 wp_ho_19_2 wn_ho_19_2 xhp19 xhn19 vdd vbbk gsyn
X_bk_19_3 eop3 eon3 wp_ho_19_3 wn_ho_19_3 xhp19 xhn19 vdd vbbk gsyn
X_bk_19_4 eop4 eon4 wp_ho_19_4 wn_ho_19_4 xhp19 xhn19 vdd vbbk gsyn
Xn19 xhp19 xhn19 ahp19 ahn19 vdd vbneu dneuron
Xeh19 xhp19 xhn19 mhp19 mhn19 ehp19 ehn19 vdd gm esub
Xcm_mo0 mop0 mon0 vdd cmld
Rnd_mo0 mop0 mon0 20k
X_ho_0_0 ahp0 ahn0 wp_ho_0_0 wn_ho_0_0 mop0 mon0 vdd vbsyn gsyn
X_ho_1_0 ahp1 ahn1 wp_ho_1_0 wn_ho_1_0 mop0 mon0 vdd vbsyn gsyn
X_ho_2_0 ahp2 ahn2 wp_ho_2_0 wn_ho_2_0 mop0 mon0 vdd vbsyn gsyn
X_ho_3_0 ahp3 ahn3 wp_ho_3_0 wn_ho_3_0 mop0 mon0 vdd vbsyn gsyn
X_ho_4_0 ahp4 ahn4 wp_ho_4_0 wn_ho_4_0 mop0 mon0 vdd vbsyn gsyn
X_ho_5_0 ahp5 ahn5 wp_ho_5_0 wn_ho_5_0 mop0 mon0 vdd vbsyn gsyn
X_ho_6_0 ahp6 ahn6 wp_ho_6_0 wn_ho_6_0 mop0 mon0 vdd vbsyn gsyn
X_ho_7_0 ahp7 ahn7 wp_ho_7_0 wn_ho_7_0 mop0 mon0 vdd vbsyn gsyn
X_ho_8_0 ahp8 ahn8 wp_ho_8_0 wn_ho_8_0 mop0 mon0 vdd vbsyn gsyn
X_ho_9_0 ahp9 ahn9 wp_ho_9_0 wn_ho_9_0 mop0 mon0 vdd vbsyn gsyn
X_ho_10_0 ahp10 ahn10 wp_ho_10_0 wn_ho_10_0 mop0 mon0 vdd vbsyn gsyn
X_ho_11_0 ahp11 ahn11 wp_ho_11_0 wn_ho_11_0 mop0 mon0 vdd vbsyn gsyn
X_ho_12_0 ahp12 ahn12 wp_ho_12_0 wn_ho_12_0 mop0 mon0 vdd vbsyn gsyn
X_ho_13_0 ahp13 ahn13 wp_ho_13_0 wn_ho_13_0 mop0 mon0 vdd vbsyn gsyn
X_ho_14_0 ahp14 ahn14 wp_ho_14_0 wn_ho_14_0 mop0 mon0 vdd vbsyn gsyn
X_ho_15_0 ahp15 ahn15 wp_ho_15_0 wn_ho_15_0 mop0 mon0 vdd vbsyn gsyn
X_ho_16_0 ahp16 ahn16 wp_ho_16_0 wn_ho_16_0 mop0 mon0 vdd vbsyn gsyn
X_ho_17_0 ahp17 ahn17 wp_ho_17_0 wn_ho_17_0 mop0 mon0 vdd vbsyn gsyn
X_ho_18_0 ahp18 ahn18 wp_ho_18_0 wn_ho_18_0 mop0 mon0 vdd vbsyn gsyn
X_ho_19_0 ahp19 ahn19 wp_ho_19_0 wn_ho_19_0 mop0 mon0 vdd vbsyn gsyn
Veop0 eop0 0 0.5
Veon0 eon0 0 0.5
Xcm_mo1 mop1 mon1 vdd cmld
Rnd_mo1 mop1 mon1 20k
X_ho_0_1 ahp0 ahn0 wp_ho_0_1 wn_ho_0_1 mop1 mon1 vdd vbsyn gsyn
X_ho_1_1 ahp1 ahn1 wp_ho_1_1 wn_ho_1_1 mop1 mon1 vdd vbsyn gsyn
X_ho_2_1 ahp2 ahn2 wp_ho_2_1 wn_ho_2_1 mop1 mon1 vdd vbsyn gsyn
X_ho_3_1 ahp3 ahn3 wp_ho_3_1 wn_ho_3_1 mop1 mon1 vdd vbsyn gsyn
X_ho_4_1 ahp4 ahn4 wp_ho_4_1 wn_ho_4_1 mop1 mon1 vdd vbsyn gsyn
X_ho_5_1 ahp5 ahn5 wp_ho_5_1 wn_ho_5_1 mop1 mon1 vdd vbsyn gsyn
X_ho_6_1 ahp6 ahn6 wp_ho_6_1 wn_ho_6_1 mop1 mon1 vdd vbsyn gsyn
X_ho_7_1 ahp7 ahn7 wp_ho_7_1 wn_ho_7_1 mop1 mon1 vdd vbsyn gsyn
X_ho_8_1 ahp8 ahn8 wp_ho_8_1 wn_ho_8_1 mop1 mon1 vdd vbsyn gsyn
X_ho_9_1 ahp9 ahn9 wp_ho_9_1 wn_ho_9_1 mop1 mon1 vdd vbsyn gsyn
X_ho_10_1 ahp10 ahn10 wp_ho_10_1 wn_ho_10_1 mop1 mon1 vdd vbsyn gsyn
X_ho_11_1 ahp11 ahn11 wp_ho_11_1 wn_ho_11_1 mop1 mon1 vdd vbsyn gsyn
X_ho_12_1 ahp12 ahn12 wp_ho_12_1 wn_ho_12_1 mop1 mon1 vdd vbsyn gsyn
X_ho_13_1 ahp13 ahn13 wp_ho_13_1 wn_ho_13_1 mop1 mon1 vdd vbsyn gsyn
X_ho_14_1 ahp14 ahn14 wp_ho_14_1 wn_ho_14_1 mop1 mon1 vdd vbsyn gsyn
X_ho_15_1 ahp15 ahn15 wp_ho_15_1 wn_ho_15_1 mop1 mon1 vdd vbsyn gsyn
X_ho_16_1 ahp16 ahn16 wp_ho_16_1 wn_ho_16_1 mop1 mon1 vdd vbsyn gsyn
X_ho_17_1 ahp17 ahn17 wp_ho_17_1 wn_ho_17_1 mop1 mon1 vdd vbsyn gsyn
X_ho_18_1 ahp18 ahn18 wp_ho_18_1 wn_ho_18_1 mop1 mon1 vdd vbsyn gsyn
X_ho_19_1 ahp19 ahn19 wp_ho_19_1 wn_ho_19_1 mop1 mon1 vdd vbsyn gsyn
Veop1 eop1 0 0.5
Veon1 eon1 0 0.5
Xcm_mo2 mop2 mon2 vdd cmld
Rnd_mo2 mop2 mon2 20k
X_ho_0_2 ahp0 ahn0 wp_ho_0_2 wn_ho_0_2 mop2 mon2 vdd vbsyn gsyn
X_ho_1_2 ahp1 ahn1 wp_ho_1_2 wn_ho_1_2 mop2 mon2 vdd vbsyn gsyn
X_ho_2_2 ahp2 ahn2 wp_ho_2_2 wn_ho_2_2 mop2 mon2 vdd vbsyn gsyn
X_ho_3_2 ahp3 ahn3 wp_ho_3_2 wn_ho_3_2 mop2 mon2 vdd vbsyn gsyn
X_ho_4_2 ahp4 ahn4 wp_ho_4_2 wn_ho_4_2 mop2 mon2 vdd vbsyn gsyn
X_ho_5_2 ahp5 ahn5 wp_ho_5_2 wn_ho_5_2 mop2 mon2 vdd vbsyn gsyn
X_ho_6_2 ahp6 ahn6 wp_ho_6_2 wn_ho_6_2 mop2 mon2 vdd vbsyn gsyn
X_ho_7_2 ahp7 ahn7 wp_ho_7_2 wn_ho_7_2 mop2 mon2 vdd vbsyn gsyn
X_ho_8_2 ahp8 ahn8 wp_ho_8_2 wn_ho_8_2 mop2 mon2 vdd vbsyn gsyn
X_ho_9_2 ahp9 ahn9 wp_ho_9_2 wn_ho_9_2 mop2 mon2 vdd vbsyn gsyn
X_ho_10_2 ahp10 ahn10 wp_ho_10_2 wn_ho_10_2 mop2 mon2 vdd vbsyn gsyn
X_ho_11_2 ahp11 ahn11 wp_ho_11_2 wn_ho_11_2 mop2 mon2 vdd vbsyn gsyn
X_ho_12_2 ahp12 ahn12 wp_ho_12_2 wn_ho_12_2 mop2 mon2 vdd vbsyn gsyn
X_ho_13_2 ahp13 ahn13 wp_ho_13_2 wn_ho_13_2 mop2 mon2 vdd vbsyn gsyn
X_ho_14_2 ahp14 ahn14 wp_ho_14_2 wn_ho_14_2 mop2 mon2 vdd vbsyn gsyn
X_ho_15_2 ahp15 ahn15 wp_ho_15_2 wn_ho_15_2 mop2 mon2 vdd vbsyn gsyn
X_ho_16_2 ahp16 ahn16 wp_ho_16_2 wn_ho_16_2 mop2 mon2 vdd vbsyn gsyn
X_ho_17_2 ahp17 ahn17 wp_ho_17_2 wn_ho_17_2 mop2 mon2 vdd vbsyn gsyn
X_ho_18_2 ahp18 ahn18 wp_ho_18_2 wn_ho_18_2 mop2 mon2 vdd vbsyn gsyn
X_ho_19_2 ahp19 ahn19 wp_ho_19_2 wn_ho_19_2 mop2 mon2 vdd vbsyn gsyn
Veop2 eop2 0 0.5
Veon2 eon2 0 0.5
Xcm_mo3 mop3 mon3 vdd cmld
Rnd_mo3 mop3 mon3 20k
X_ho_0_3 ahp0 ahn0 wp_ho_0_3 wn_ho_0_3 mop3 mon3 vdd vbsyn gsyn
X_ho_1_3 ahp1 ahn1 wp_ho_1_3 wn_ho_1_3 mop3 mon3 vdd vbsyn gsyn
X_ho_2_3 ahp2 ahn2 wp_ho_2_3 wn_ho_2_3 mop3 mon3 vdd vbsyn gsyn
X_ho_3_3 ahp3 ahn3 wp_ho_3_3 wn_ho_3_3 mop3 mon3 vdd vbsyn gsyn
X_ho_4_3 ahp4 ahn4 wp_ho_4_3 wn_ho_4_3 mop3 mon3 vdd vbsyn gsyn
X_ho_5_3 ahp5 ahn5 wp_ho_5_3 wn_ho_5_3 mop3 mon3 vdd vbsyn gsyn
X_ho_6_3 ahp6 ahn6 wp_ho_6_3 wn_ho_6_3 mop3 mon3 vdd vbsyn gsyn
X_ho_7_3 ahp7 ahn7 wp_ho_7_3 wn_ho_7_3 mop3 mon3 vdd vbsyn gsyn
X_ho_8_3 ahp8 ahn8 wp_ho_8_3 wn_ho_8_3 mop3 mon3 vdd vbsyn gsyn
X_ho_9_3 ahp9 ahn9 wp_ho_9_3 wn_ho_9_3 mop3 mon3 vdd vbsyn gsyn
X_ho_10_3 ahp10 ahn10 wp_ho_10_3 wn_ho_10_3 mop3 mon3 vdd vbsyn gsyn
X_ho_11_3 ahp11 ahn11 wp_ho_11_3 wn_ho_11_3 mop3 mon3 vdd vbsyn gsyn
X_ho_12_3 ahp12 ahn12 wp_ho_12_3 wn_ho_12_3 mop3 mon3 vdd vbsyn gsyn
X_ho_13_3 ahp13 ahn13 wp_ho_13_3 wn_ho_13_3 mop3 mon3 vdd vbsyn gsyn
X_ho_14_3 ahp14 ahn14 wp_ho_14_3 wn_ho_14_3 mop3 mon3 vdd vbsyn gsyn
X_ho_15_3 ahp15 ahn15 wp_ho_15_3 wn_ho_15_3 mop3 mon3 vdd vbsyn gsyn
X_ho_16_3 ahp16 ahn16 wp_ho_16_3 wn_ho_16_3 mop3 mon3 vdd vbsyn gsyn
X_ho_17_3 ahp17 ahn17 wp_ho_17_3 wn_ho_17_3 mop3 mon3 vdd vbsyn gsyn
X_ho_18_3 ahp18 ahn18 wp_ho_18_3 wn_ho_18_3 mop3 mon3 vdd vbsyn gsyn
X_ho_19_3 ahp19 ahn19 wp_ho_19_3 wn_ho_19_3 mop3 mon3 vdd vbsyn gsyn
Veop3 eop3 0 0.5
Veon3 eon3 0 0.5
Xcm_mo4 mop4 mon4 vdd cmld
Rnd_mo4 mop4 mon4 20k
X_ho_0_4 ahp0 ahn0 wp_ho_0_4 wn_ho_0_4 mop4 mon4 vdd vbsyn gsyn
X_ho_1_4 ahp1 ahn1 wp_ho_1_4 wn_ho_1_4 mop4 mon4 vdd vbsyn gsyn
X_ho_2_4 ahp2 ahn2 wp_ho_2_4 wn_ho_2_4 mop4 mon4 vdd vbsyn gsyn
X_ho_3_4 ahp3 ahn3 wp_ho_3_4 wn_ho_3_4 mop4 mon4 vdd vbsyn gsyn
X_ho_4_4 ahp4 ahn4 wp_ho_4_4 wn_ho_4_4 mop4 mon4 vdd vbsyn gsyn
X_ho_5_4 ahp5 ahn5 wp_ho_5_4 wn_ho_5_4 mop4 mon4 vdd vbsyn gsyn
X_ho_6_4 ahp6 ahn6 wp_ho_6_4 wn_ho_6_4 mop4 mon4 vdd vbsyn gsyn
X_ho_7_4 ahp7 ahn7 wp_ho_7_4 wn_ho_7_4 mop4 mon4 vdd vbsyn gsyn
X_ho_8_4 ahp8 ahn8 wp_ho_8_4 wn_ho_8_4 mop4 mon4 vdd vbsyn gsyn
X_ho_9_4 ahp9 ahn9 wp_ho_9_4 wn_ho_9_4 mop4 mon4 vdd vbsyn gsyn
X_ho_10_4 ahp10 ahn10 wp_ho_10_4 wn_ho_10_4 mop4 mon4 vdd vbsyn gsyn
X_ho_11_4 ahp11 ahn11 wp_ho_11_4 wn_ho_11_4 mop4 mon4 vdd vbsyn gsyn
X_ho_12_4 ahp12 ahn12 wp_ho_12_4 wn_ho_12_4 mop4 mon4 vdd vbsyn gsyn
X_ho_13_4 ahp13 ahn13 wp_ho_13_4 wn_ho_13_4 mop4 mon4 vdd vbsyn gsyn
X_ho_14_4 ahp14 ahn14 wp_ho_14_4 wn_ho_14_4 mop4 mon4 vdd vbsyn gsyn
X_ho_15_4 ahp15 ahn15 wp_ho_15_4 wn_ho_15_4 mop4 mon4 vdd vbsyn gsyn
X_ho_16_4 ahp16 ahn16 wp_ho_16_4 wn_ho_16_4 mop4 mon4 vdd vbsyn gsyn
X_ho_17_4 ahp17 ahn17 wp_ho_17_4 wn_ho_17_4 mop4 mon4 vdd vbsyn gsyn
X_ho_18_4 ahp18 ahn18 wp_ho_18_4 wn_ho_18_4 mop4 mon4 vdd vbsyn gsyn
X_ho_19_4 ahp19 ahn19 wp_ho_19_4 wn_ho_19_4 mop4 mon4 vdd vbsyn gsyn
Veop4 eop4 0 0.5
Veon4 eon4 0 0.5
.options gmin=1e-12 reltol=1e-3 itl1=500 rshunt=1e9
.end
