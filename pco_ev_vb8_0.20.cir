pc orchestrated
.model NNR NMOS (LEVEL=1 VTO=0.2 KP=120u LAMBDA=0.02 GAMMA=0 PHI=0.7)
.model PNR PMOS (LEVEL=1 VTO=-0.2 KP=40u LAMBDA=0.02 GAMMA=0 PHI=0.7)
.subckt gsyn inp inn wp wn outp outn vdd vbn
Mtail nt vbn 0 0 NNR W=400u L=100u
M5 na wp nt 0 NNR W=200u L=100u
M6 nb wn nt 0 NNR W=200u L=100u
M1 outp inp na 0 NNR W=200u L=100u
M2 outn inn na 0 NNR W=200u L=100u
M3 outn inp nb 0 NNR W=200u L=100u
M4 outp inn nb 0 NNR W=200u L=100u
.ends
.subckt cmld p n vdd
Rcs1 p cmx 300k
Rcs2 n cmx 300k
MLp p cmx vdd vdd PNR W=4000u L=100u
MLn n cmx vdd vdd PNR W=4000u L=100u
.ends
.subckt dneuron up un ap an vdd vbn
M1 an up tn 0 NNR W=200u L=100u
M2 ap un tn 0 NNR W=200u L=100u
Mt tn vbn 0 0 NNR W=200u L=100u
Xcm ap an vdd cmld
.ends
.subckt esub xp xn mp mn ep en vdd vbn
Mt nt vbn 0 0 NNR W=400u L=100u
M1x ep xn nt 0 NNR W=200u L=100u
M2x en xp nt 0 NNR W=200u L=100u
M1m ep mp nt 0 NNR W=200u L=100u
M2m en mn nt 0 NNR W=200u L=100u
RLp vdd ep 50k
RLn vdd en 50k
.ends
Vdd vdd 0 1.0
Vbsyn vbsyn 0 0.45
Vbbk vbbk 0 0.20
Vbneu vbneu 0 0.35
Vgm gm 0 0.6
Vwcm wcm 0 0.5
Vref vref 0 0.5
Vbg vbg 0 0.35
Vxp0 a_xp0 0 0.5
Vxn0 a_xn0 0 0.5
Vxp1 a_xp1 0 0.5
Vxn1 a_xn1 0 0.5
Vxp2 a_xp2 0 0.5
Vxn2 a_xn2 0 0.5
Vxp3 a_xp3 0 0.5
Vxn3 a_xn3 0 0.5
Vxp4 a_xp4 0 0.5
Vxn4 a_xn4 0 0.5
Vxp5 a_xp5 0 0.5
Vxn5 a_xn5 0 0.5
Vxp6 a_xp6 0 0.5
Vxn6 a_xn6 0 0.5
Vxp7 a_xp7 0 0.5
Vxn7 a_xn7 0 0.5
Vxp8 a_xp8 0 0.5
Vxn8 a_xn8 0 0.5
Vxp9 a_xp9 0 0.5
Vxn9 a_xn9 0 0.5
Vxp10 a_xp10 0 0.5
Vxn10 a_xn10 0 0.5
Vxp11 a_xp11 0 0.5
Vxn11 a_xn11 0 0.5
Vxp12 a_xp12 0 0.5
Vxn12 a_xn12 0 0.5
Vxp13 a_xp13 0 0.5
Vxn13 a_xn13 0 0.5
Vxp14 a_xp14 0 0.5
Vxn14 a_xn14 0 0.5
Vxp15 a_xp15 0 0.5
Vxn15 a_xn15 0 0.5
Vxp16 a_xp16 0 0.5
Vxn16 a_xn16 0 0.5
Vxp17 a_xp17 0 0.5
Vxn17 a_xn17 0 0.5
Vxp18 a_xp18 0 0.5
Vxn18 a_xn18 0 0.5
Vxp19 a_xp19 0 0.5
Vxn19 a_xn19 0 0.5
Vxp20 a_xp20 0 0.5
Vxn20 a_xn20 0 0.5
Vxp21 a_xp21 0 0.5
Vxn21 a_xn21 0 0.5
Vxp22 a_xp22 0 0.5
Vxn22 a_xn22 0 0.5
Vxp23 a_xp23 0 0.5
Vxn23 a_xn23 0 0.5
Vxp24 a_xp24 0 0.5
Vxn24 a_xn24 0 0.5
Vxp25 a_xp25 0 0.5
Vxn25 a_xn25 0 0.5
Vxp26 a_xp26 0 0.5
Vxn26 a_xn26 0 0.5
Vxp27 a_xp27 0 0.5
Vxn27 a_xn27 0 0.5
Vxp28 a_xp28 0 0.5
Vxn28 a_xn28 0 0.5
Vxp29 a_xp29 0 0.5
Vxn29 a_xn29 0 0.5
Vxp30 a_xp30 0 0.5
Vxn30 a_xn30 0 0.5
Vxp31 a_xp31 0 0.5
Vxn31 a_xn31 0 0.5
Vxp32 a_xp32 0 0.5
Vxn32 a_xn32 0 0.5
Vxp33 a_xp33 0 0.5
Vxn33 a_xn33 0 0.5
Vxp34 a_xp34 0 0.5
Vxn34 a_xn34 0 0.5
Vxp35 a_xp35 0 0.5
Vxn35 a_xn35 0 0.5
Vxp36 a_xp36 0 0.5
Vxn36 a_xn36 0 0.5
Vxp37 a_xp37 0 0.5
Vxn37 a_xn37 0 0.5
Vxp38 a_xp38 0 0.5
Vxn38 a_xn38 0 0.5
Vxp39 a_xp39 0 0.5
Vxn39 a_xn39 0 0.5
Vxp40 a_xp40 0 0.5
Vxn40 a_xn40 0 0.5
Vxp41 a_xp41 0 0.5
Vxn41 a_xn41 0 0.5
Vxp42 a_xp42 0 0.5
Vxn42 a_xn42 0 0.5
Vxp43 a_xp43 0 0.5
Vxn43 a_xn43 0 0.5
Vxp44 a_xp44 0 0.5
Vxn44 a_xn44 0 0.5
Vxp45 a_xp45 0 0.5
Vxn45 a_xn45 0 0.5
Vxp46 a_xp46 0 0.5
Vxn46 a_xn46 0 0.5
Vxp47 a_xp47 0 0.5
Vxn47 a_xn47 0 0.5
Vxp48 a_xp48 0 0.5
Vxn48 a_xn48 0 0.5
Vxp49 a_xp49 0 0.5
Vxn49 a_xn49 0 0.5
Vxp50 a_xp50 0 0.5
Vxn50 a_xn50 0 0.5
Vxp51 a_xp51 0 0.5
Vxn51 a_xn51 0 0.5
Vxp52 a_xp52 0 0.5
Vxn52 a_xn52 0 0.5
Vxp53 a_xp53 0 0.5
Vxn53 a_xn53 0 0.5
Vxp54 a_xp54 0 0.5
Vxn54 a_xn54 0 0.5
Vxp55 a_xp55 0 0.5
Vxn55 a_xn55 0 0.5
Vxp56 a_xp56 0 0.5
Vxn56 a_xn56 0 0.5
Vxp57 a_xp57 0 0.5
Vxn57 a_xn57 0 0.5
Vxp58 a_xp58 0 0.5
Vxn58 a_xn58 0 0.5
Vxp59 a_xp59 0 0.5
Vxn59 a_xn59 0 0.5
Vxp60 a_xp60 0 0.5
Vxn60 a_xn60 0 0.5
Vxp61 a_xp61 0 0.5
Vxn61 a_xn61 0 0.5
Vxp62 a_xp62 0 0.5
Vxn62 a_xn62 0 0.5
Vxp63 a_xp63 0 0.5
Vxn63 a_xn63 0 0.5
Vwp_ih_0_0 wp_ih_0_0 0 0.5570783526649328
Vwn_ih_0_0 wn_ih_0_0 0 0.4429216473350672
Vwp_ih_1_0 wp_ih_1_0 0 0.6868493546805954
Vwn_ih_1_0 wn_ih_1_0 0 0.3131506453194047
Vwp_ih_2_0 wp_ih_2_0 0 0.7176296205588424
Vwn_ih_2_0 wn_ih_2_0 0 0.3
Vwp_ih_3_0 wp_ih_3_0 0 0.511610209242645
Vwn_ih_3_0 wn_ih_3_0 0 0.488389790757355
Vwp_ih_4_0 wp_ih_4_0 0 0.6072060348132962
Vwn_ih_4_0 wn_ih_4_0 0 0.39279396518670384
Vwp_ih_5_0 wp_ih_5_0 0 0.6089573492852869
Vwn_ih_5_0 wn_ih_5_0 0 0.3910426507147131
Vwp_ih_6_0 wp_ih_6_0 0 0.416928897935831
Vwn_ih_6_0 wn_ih_6_0 0 0.583071102064169
Vwp_ih_7_0 wp_ih_7_0 0 0.3
Vwn_ih_7_0 wn_ih_7_0 0 0.7037527796552725
Vwp_ih_8_0 wp_ih_8_0 0 0.5037064783225775
Vwn_ih_8_0 wn_ih_8_0 0 0.49629352167742247
Vwp_ih_9_0 wp_ih_9_0 0 0.3
Vwn_ih_9_0 wn_ih_9_0 0 0.7114641196688646
Vwp_ih_10_0 wp_ih_10_0 0 0.46160844644542076
Vwn_ih_10_0 wn_ih_10_0 0 0.5383915535545792
Vwp_ih_11_0 wp_ih_11_0 0 0.5729740504147243
Vwn_ih_11_0 wn_ih_11_0 0 0.4270259495852758
Vwp_ih_12_0 wp_ih_12_0 0 0.32959166142799967
Vwn_ih_12_0 wn_ih_12_0 0 0.6704083385720003
Vwp_ih_13_0 wp_ih_13_0 0 0.5038754460717965
Vwn_ih_13_0 wn_ih_13_0 0 0.4961245539282036
Vwp_ih_14_0 wp_ih_14_0 0 0.6488021738370878
Vwn_ih_14_0 wn_ih_14_0 0 0.3511978261629122
Vwp_ih_15_0 wp_ih_15_0 0 0.5433814968825157
Vwn_ih_15_0 wn_ih_15_0 0 0.45661850311748436
Vwp_ih_16_0 wp_ih_16_0 0 0.5626786040899615
Vwn_ih_16_0 wn_ih_16_0 0 0.43732139591003855
Vwp_ih_17_0 wp_ih_17_0 0 0.6088088496580094
Vwn_ih_17_0 wn_ih_17_0 0 0.3911911503419906
Vwp_ih_18_0 wp_ih_18_0 0 0.7079555686557416
Vwn_ih_18_0 wn_ih_18_0 0 0.3
Vwp_ih_19_0 wp_ih_19_0 0 0.5181707698067824
Vwn_ih_19_0 wn_ih_19_0 0 0.4818292301932176
Vwp_ih_20_0 wp_ih_20_0 0 0.647540103371975
Vwn_ih_20_0 wn_ih_20_0 0 0.352459896628025
Vwp_ih_21_0 wp_ih_21_0 0 0.49229969403950913
Vwn_ih_21_0 wn_ih_21_0 0 0.5077003059604909
Vwp_ih_22_0 wp_ih_22_0 0 0.4344597421479819
Vwn_ih_22_0 wn_ih_22_0 0 0.5655402578520181
Vwp_ih_23_0 wp_ih_23_0 0 0.5377785163541078
Vwn_ih_23_0 wn_ih_23_0 0 0.4622214836458922
Vwp_ih_24_0 wp_ih_24_0 0 0.4273024582409995
Vwn_ih_24_0 wn_ih_24_0 0 0.5726975417590006
Vwp_ih_25_0 wp_ih_25_0 0 0.4312244941080121
Vwn_ih_25_0 wn_ih_25_0 0 0.5687755058919879
Vwp_ih_26_0 wp_ih_26_0 0 0.4270711243469304
Vwn_ih_26_0 wn_ih_26_0 0 0.5729288756530696
Vwp_ih_27_0 wp_ih_27_0 0 0.3
Vwn_ih_27_0 wn_ih_27_0 0 0.77545090346398
Vwp_ih_28_0 wp_ih_28_0 0 0.5126599373192716
Vwn_ih_28_0 wn_ih_28_0 0 0.4873400626807284
Vwp_ih_29_0 wp_ih_29_0 0 0.3483397569685438
Vwn_ih_29_0 wn_ih_29_0 0 0.6516602430314562
Vwp_ih_30_0 wp_ih_30_0 0 0.4871277055198067
Vwn_ih_30_0 wn_ih_30_0 0 0.5128722944801933
Vwp_ih_31_0 wp_ih_31_0 0 0.6739962536581794
Vwn_ih_31_0 wn_ih_31_0 0 0.3260037463418206
Vwp_ih_32_0 wp_ih_32_0 0 0.4374799612271252
Vwn_ih_32_0 wn_ih_32_0 0 0.5625200387728748
Vwp_ih_33_0 wp_ih_33_0 0 0.43495890098630274
Vwn_ih_33_0 wn_ih_33_0 0 0.5650410990136973
Vwp_ih_34_0 wp_ih_34_0 0 0.6636691261402154
Vwn_ih_34_0 wn_ih_34_0 0 0.33633087385978455
Vwp_ih_35_0 wp_ih_35_0 0 0.5655566918557159
Vwn_ih_35_0 wn_ih_35_0 0 0.4344433081442841
Vwp_ih_36_0 wp_ih_36_0 0 0.6171832516823171
Vwn_ih_36_0 wn_ih_36_0 0 0.38281674831768286
Vwp_ih_37_0 wp_ih_37_0 0 0.4573650519215608
Vwn_ih_37_0 wn_ih_37_0 0 0.5426349480784391
Vwp_ih_38_0 wp_ih_38_0 0 0.5897699855445113
Vwn_ih_38_0 wn_ih_38_0 0 0.4102300144554887
Vwp_ih_39_0 wp_ih_39_0 0 0.4176597693011837
Vwn_ih_39_0 wn_ih_39_0 0 0.5823402306988162
Vwp_ih_40_0 wp_ih_40_0 0 0.41887979292537214
Vwn_ih_40_0 wn_ih_40_0 0 0.5811202070746279
Vwp_ih_41_0 wp_ih_41_0 0 0.571549313384608
Vwn_ih_41_0 wn_ih_41_0 0 0.42845068661539204
Vwp_ih_42_0 wp_ih_42_0 0 0.42819521944727307
Vwn_ih_42_0 wn_ih_42_0 0 0.5718047805527269
Vwp_ih_43_0 wp_ih_43_0 0 0.5920542251892744
Vwn_ih_43_0 wn_ih_43_0 0 0.4079457748107255
Vwp_ih_44_0 wp_ih_44_0 0 0.7870021442515158
Vwn_ih_44_0 wn_ih_44_0 0 0.3
Vwp_ih_45_0 wp_ih_45_0 0 0.3
Vwn_ih_45_0 wn_ih_45_0 0 0.7023383044336743
Vwp_ih_46_0 wp_ih_46_0 0 0.4097354748654506
Vwn_ih_46_0 wn_ih_46_0 0 0.5902645251345494
Vwp_ih_47_0 wp_ih_47_0 0 0.6344175418211209
Vwn_ih_47_0 wn_ih_47_0 0 0.36558245817887913
Vwp_ih_48_0 wp_ih_48_0 0 0.4825906196608132
Vwn_ih_48_0 wn_ih_48_0 0 0.5174093803391868
Vwp_ih_49_0 wp_ih_49_0 0 0.6393307819751086
Vwn_ih_49_0 wn_ih_49_0 0 0.3606692180248913
Vwp_ih_50_0 wp_ih_50_0 0 0.3787922872240511
Vwn_ih_50_0 wn_ih_50_0 0 0.6212077127759489
Vwp_ih_51_0 wp_ih_51_0 0 0.5397613013369564
Vwn_ih_51_0 wn_ih_51_0 0 0.46023869866304357
Vwp_ih_52_0 wp_ih_52_0 0 0.48193324186125863
Vwn_ih_52_0 wn_ih_52_0 0 0.5180667581387414
Vwp_ih_53_0 wp_ih_53_0 0 0.5168444867448011
Vwn_ih_53_0 wn_ih_53_0 0 0.4831555132551989
Vwp_ih_54_0 wp_ih_54_0 0 0.5397339222866436
Vwn_ih_54_0 wn_ih_54_0 0 0.4602660777133564
Vwp_ih_55_0 wp_ih_55_0 0 0.3535992364812852
Vwn_ih_55_0 wn_ih_55_0 0 0.6464007635187148
Vwp_ih_56_0 wp_ih_56_0 0 0.37110350175688467
Vwn_ih_56_0 wn_ih_56_0 0 0.6288964982431153
Vwp_ih_57_0 wp_ih_57_0 0 0.6679092808274507
Vwn_ih_57_0 wn_ih_57_0 0 0.3320907191725493
Vwp_ih_58_0 wp_ih_58_0 0 0.5351856453897147
Vwn_ih_58_0 wn_ih_58_0 0 0.4648143546102853
Vwp_ih_59_0 wp_ih_59_0 0 0.5127615599543153
Vwn_ih_59_0 wn_ih_59_0 0 0.48723844004568473
Vwp_ih_60_0 wp_ih_60_0 0 0.4947110332863736
Vwn_ih_60_0 wn_ih_60_0 0 0.5052889667136264
Vwp_ih_61_0 wp_ih_61_0 0 0.5427850998447341
Vwn_ih_61_0 wn_ih_61_0 0 0.45721490015526595
Vwp_ih_62_0 wp_ih_62_0 0 0.36128759127134646
Vwn_ih_62_0 wn_ih_62_0 0 0.6387124087286535
Vwp_ih_63_0 wp_ih_63_0 0 0.38011672017255205
Vwn_ih_63_0 wn_ih_63_0 0 0.619883279827448
Vwp_ho_0_0 wp_ho_0_0 0 0.42707253262278777
Vwn_ho_0_0 wn_ho_0_0 0 0.5729274673772122
Vwp_ho_0_1 wp_ho_0_1 0 0.5894280196646158
Vwn_ho_0_1 wn_ho_0_1 0 0.4105719803353842
Vwp_ho_0_2 wp_ho_0_2 0 0.49586418384611686
Vwn_ho_0_2 wn_ho_0_2 0 0.5041358161538831
Vwp_ho_0_3 wp_ho_0_3 0 0.38393881490630266
Vwn_ho_0_3 wn_ho_0_3 0 0.6160611850936973
Vwp_ho_0_4 wp_ho_0_4 0 0.7403038780927803
Vwn_ho_0_4 wn_ho_0_4 0 0.3
Vwp_ih_0_1 wp_ih_0_1 0 0.656540989664772
Vwn_ih_0_1 wn_ih_0_1 0 0.343459010335228
Vwp_ih_1_1 wp_ih_1_1 0 0.5181530266216596
Vwn_ih_1_1 wn_ih_1_1 0 0.4818469733783404
Vwp_ih_2_1 wp_ih_2_1 0 0.6020361048384841
Vwn_ih_2_1 wn_ih_2_1 0 0.3979638951615159
Vwp_ih_3_1 wp_ih_3_1 0 0.4273203191694472
Vwn_ih_3_1 wn_ih_3_1 0 0.5726796808305528
Vwp_ih_4_1 wp_ih_4_1 0 0.6652070456431166
Vwn_ih_4_1 wn_ih_4_1 0 0.3347929543568834
Vwp_ih_5_1 wp_ih_5_1 0 0.5414334086383423
Vwn_ih_5_1 wn_ih_5_1 0 0.4585665913616577
Vwp_ih_6_1 wp_ih_6_1 0 0.5577494983100103
Vwn_ih_6_1 wn_ih_6_1 0 0.4422505016899897
Vwp_ih_7_1 wp_ih_7_1 0 0.5658475205258937
Vwn_ih_7_1 wn_ih_7_1 0 0.43415247947410635
Vwp_ih_8_1 wp_ih_8_1 0 0.4043588912753444
Vwn_ih_8_1 wn_ih_8_1 0 0.5956411087246556
Vwp_ih_9_1 wp_ih_9_1 0 0.3
Vwn_ih_9_1 wn_ih_9_1 0 0.7238865036080072
Vwp_ih_10_1 wp_ih_10_1 0 0.3710236799497877
Vwn_ih_10_1 wn_ih_10_1 0 0.6289763200502123
Vwp_ih_11_1 wp_ih_11_1 0 0.6956627428863633
Vwn_ih_11_1 wn_ih_11_1 0 0.30433725711363663
Vwp_ih_12_1 wp_ih_12_1 0 0.6560820764384584
Vwn_ih_12_1 wn_ih_12_1 0 0.3439179235615416
Vwp_ih_13_1 wp_ih_13_1 0 0.4583694358426436
Vwn_ih_13_1 wn_ih_13_1 0 0.5416305641573564
Vwp_ih_14_1 wp_ih_14_1 0 0.4637988407556626
Vwn_ih_14_1 wn_ih_14_1 0 0.5362011592443374
Vwp_ih_15_1 wp_ih_15_1 0 0.6243927052683024
Vwn_ih_15_1 wn_ih_15_1 0 0.3756072947316976
Vwp_ih_16_1 wp_ih_16_1 0 0.4797908152695697
Vwn_ih_16_1 wn_ih_16_1 0 0.5202091847304303
Vwp_ih_17_1 wp_ih_17_1 0 0.3440888155843066
Vwn_ih_17_1 wn_ih_17_1 0 0.6559111844156934
Vwp_ih_18_1 wp_ih_18_1 0 0.6518651711115393
Vwn_ih_18_1 wn_ih_18_1 0 0.3481348288884607
Vwp_ih_19_1 wp_ih_19_1 0 0.5572614293496718
Vwn_ih_19_1 wn_ih_19_1 0 0.4427385706503282
Vwp_ih_20_1 wp_ih_20_1 0 0.3
Vwn_ih_20_1 wn_ih_20_1 0 0.8019607658004262
Vwp_ih_21_1 wp_ih_21_1 0 0.4624171873364147
Vwn_ih_21_1 wn_ih_21_1 0 0.5375828126635853
Vwp_ih_22_1 wp_ih_22_1 0 0.5172404243941208
Vwn_ih_22_1 wn_ih_22_1 0 0.4827595756058793
Vwp_ih_23_1 wp_ih_23_1 0 0.5577496192470546
Vwn_ih_23_1 wn_ih_23_1 0 0.4422503807529454
Vwp_ih_24_1 wp_ih_24_1 0 0.5182581427173962
Vwn_ih_24_1 wn_ih_24_1 0 0.48174185728260377
Vwp_ih_25_1 wp_ih_25_1 0 0.42371098433076504
Vwn_ih_25_1 wn_ih_25_1 0 0.576289015669235
Vwp_ih_26_1 wp_ih_26_1 0 0.48610891471640155
Vwn_ih_26_1 wn_ih_26_1 0 0.5138910852835985
Vwp_ih_27_1 wp_ih_27_1 0 0.5353760381532321
Vwn_ih_27_1 wn_ih_27_1 0 0.46462396184676796
Vwp_ih_28_1 wp_ih_28_1 0 0.467839509726318
Vwn_ih_28_1 wn_ih_28_1 0 0.5321604902736821
Vwp_ih_29_1 wp_ih_29_1 0 0.45537191363525514
Vwn_ih_29_1 wn_ih_29_1 0 0.5446280863647449
Vwp_ih_30_1 wp_ih_30_1 0 0.650250072639778
Vwn_ih_30_1 wn_ih_30_1 0 0.349749927360222
Vwp_ih_31_1 wp_ih_31_1 0 0.38640707776768973
Vwn_ih_31_1 wn_ih_31_1 0 0.6135929222323102
Vwp_ih_32_1 wp_ih_32_1 0 0.45806438346681055
Vwn_ih_32_1 wn_ih_32_1 0 0.5419356165331894
Vwp_ih_33_1 wp_ih_33_1 0 0.3
Vwn_ih_33_1 wn_ih_33_1 0 0.7437522815658908
Vwp_ih_34_1 wp_ih_34_1 0 0.5649163956141694
Vwn_ih_34_1 wn_ih_34_1 0 0.4350836043858306
Vwp_ih_35_1 wp_ih_35_1 0 0.5993917351816263
Vwn_ih_35_1 wn_ih_35_1 0 0.40060826481837375
Vwp_ih_36_1 wp_ih_36_1 0 0.5658184199115901
Vwn_ih_36_1 wn_ih_36_1 0 0.43418158008840985
Vwp_ih_37_1 wp_ih_37_1 0 0.6101206984953474
Vwn_ih_37_1 wn_ih_37_1 0 0.38987930150465255
Vwp_ih_38_1 wp_ih_38_1 0 0.5528848093716273
Vwn_ih_38_1 wn_ih_38_1 0 0.4471151906283727
Vwp_ih_39_1 wp_ih_39_1 0 0.5411018469144094
Vwn_ih_39_1 wn_ih_39_1 0 0.4588981530855905
Vwp_ih_40_1 wp_ih_40_1 0 0.5568736480385617
Vwn_ih_40_1 wn_ih_40_1 0 0.4431263519614384
Vwp_ih_41_1 wp_ih_41_1 0 0.4679229881656068
Vwn_ih_41_1 wn_ih_41_1 0 0.5320770118343933
Vwp_ih_42_1 wp_ih_42_1 0 0.6425993435115682
Vwn_ih_42_1 wn_ih_42_1 0 0.3574006564884318
Vwp_ih_43_1 wp_ih_43_1 0 0.4581713521983012
Vwn_ih_43_1 wn_ih_43_1 0 0.5418286478016988
Vwp_ih_44_1 wp_ih_44_1 0 0.32451776898137685
Vwn_ih_44_1 wn_ih_44_1 0 0.6754822310186231
Vwp_ih_45_1 wp_ih_45_1 0 0.6019740336342141
Vwn_ih_45_1 wn_ih_45_1 0 0.3980259663657859
Vwp_ih_46_1 wp_ih_46_1 0 0.7220843335941778
Vwn_ih_46_1 wn_ih_46_1 0 0.3
Vwp_ih_47_1 wp_ih_47_1 0 0.3847818656851243
Vwn_ih_47_1 wn_ih_47_1 0 0.6152181343148757
Vwp_ih_48_1 wp_ih_48_1 0 0.4878042644488572
Vwn_ih_48_1 wn_ih_48_1 0 0.5121957355511428
Vwp_ih_49_1 wp_ih_49_1 0 0.4177469587138367
Vwn_ih_49_1 wn_ih_49_1 0 0.5822530412861633
Vwp_ih_50_1 wp_ih_50_1 0 0.45433000998469797
Vwn_ih_50_1 wn_ih_50_1 0 0.545669990015302
Vwp_ih_51_1 wp_ih_51_1 0 0.505531156613559
Vwn_ih_51_1 wn_ih_51_1 0 0.49446884338644104
Vwp_ih_52_1 wp_ih_52_1 0 0.35098298566625974
Vwn_ih_52_1 wn_ih_52_1 0 0.6490170143337403
Vwp_ih_53_1 wp_ih_53_1 0 0.46668155944792555
Vwn_ih_53_1 wn_ih_53_1 0 0.5333184405520744
Vwp_ih_54_1 wp_ih_54_1 0 0.32408391363411354
Vwn_ih_54_1 wn_ih_54_1 0 0.6759160863658864
Vwp_ih_55_1 wp_ih_55_1 0 0.4318126834470226
Vwn_ih_55_1 wn_ih_55_1 0 0.5681873165529774
Vwp_ih_56_1 wp_ih_56_1 0 0.3576716415216215
Vwn_ih_56_1 wn_ih_56_1 0 0.6423283584783785
Vwp_ih_57_1 wp_ih_57_1 0 0.3729127160647827
Vwn_ih_57_1 wn_ih_57_1 0 0.6270872839352173
Vwp_ih_58_1 wp_ih_58_1 0 0.3
Vwn_ih_58_1 wn_ih_58_1 0 0.706389281678984
Vwp_ih_59_1 wp_ih_59_1 0 0.646322550647916
Vwn_ih_59_1 wn_ih_59_1 0 0.35367744935208395
Vwp_ih_60_1 wp_ih_60_1 0 0.5610870901687461
Vwn_ih_60_1 wn_ih_60_1 0 0.4389129098312538
Vwp_ih_61_1 wp_ih_61_1 0 0.3
Vwn_ih_61_1 wn_ih_61_1 0 0.7300956852147793
Vwp_ih_62_1 wp_ih_62_1 0 0.42838068871425494
Vwn_ih_62_1 wn_ih_62_1 0 0.5716193112857451
Vwp_ih_63_1 wp_ih_63_1 0 0.4195473680116311
Vwn_ih_63_1 wn_ih_63_1 0 0.5804526319883689
Vwp_ho_1_0 wp_ho_1_0 0 0.7420505489824798
Vwn_ho_1_0 wn_ho_1_0 0 0.3
Vwp_ho_1_1 wp_ho_1_1 0 0.4039080141368722
Vwn_ho_1_1 wn_ho_1_1 0 0.5960919858631277
Vwp_ho_1_2 wp_ho_1_2 0 0.35524861344244996
Vwn_ho_1_2 wn_ho_1_2 0 0.64475138655755
Vwp_ho_1_3 wp_ho_1_3 0 0.5473610507543393
Vwn_ho_1_3 wn_ho_1_3 0 0.45263894924566067
Vwp_ho_1_4 wp_ho_1_4 0 0.43195502474111325
Vwn_ho_1_4 wn_ho_1_4 0 0.5680449752588868
Vwp_ih_0_2 wp_ih_0_2 0 0.4170867046197684
Vwn_ih_0_2 wn_ih_0_2 0 0.5829132953802316
Vwp_ih_1_2 wp_ih_1_2 0 0.3263739784932219
Vwn_ih_1_2 wn_ih_1_2 0 0.6736260215067781
Vwp_ih_2_2 wp_ih_2_2 0 0.5905262865642146
Vwn_ih_2_2 wn_ih_2_2 0 0.40947371343578537
Vwp_ih_3_2 wp_ih_3_2 0 0.45249634573904013
Vwn_ih_3_2 wn_ih_3_2 0 0.5475036542609599
Vwp_ih_4_2 wp_ih_4_2 0 0.5561778691387417
Vwn_ih_4_2 wn_ih_4_2 0 0.4438221308612584
Vwp_ih_5_2 wp_ih_5_2 0 0.5632106918199713
Vwn_ih_5_2 wn_ih_5_2 0 0.4367893081800287
Vwp_ih_6_2 wp_ih_6_2 0 0.6650534374005064
Vwn_ih_6_2 wn_ih_6_2 0 0.33494656259949357
Vwp_ih_7_2 wp_ih_7_2 0 0.3
Vwn_ih_7_2 wn_ih_7_2 0 0.7177846733291773
Vwp_ih_8_2 wp_ih_8_2 0 0.7086322533709947
Vwn_ih_8_2 wn_ih_8_2 0 0.3
Vwp_ih_9_2 wp_ih_9_2 0 0.6522578328669476
Vwn_ih_9_2 wn_ih_9_2 0 0.3477421671330524
Vwp_ih_10_2 wp_ih_10_2 0 0.5687679190802608
Vwn_ih_10_2 wn_ih_10_2 0 0.4312320809197392
Vwp_ih_11_2 wp_ih_11_2 0 0.7860310675080939
Vwn_ih_11_2 wn_ih_11_2 0 0.3
Vwp_ih_12_2 wp_ih_12_2 0 0.5245974317512677
Vwn_ih_12_2 wn_ih_12_2 0 0.4754025682487322
Vwp_ih_13_2 wp_ih_13_2 0 0.5985774699284262
Vwn_ih_13_2 wn_ih_13_2 0 0.4014225300715738
Vwp_ih_14_2 wp_ih_14_2 0 0.41139032224784483
Vwn_ih_14_2 wn_ih_14_2 0 0.5886096777521551
Vwp_ih_15_2 wp_ih_15_2 0 0.6361228889542194
Vwn_ih_15_2 wn_ih_15_2 0 0.36387711104578063
Vwp_ih_16_2 wp_ih_16_2 0 0.5201391163666897
Vwn_ih_16_2 wn_ih_16_2 0 0.47986088363331025
Vwp_ih_17_2 wp_ih_17_2 0 0.44585598261727444
Vwn_ih_17_2 wn_ih_17_2 0 0.5541440173827256
Vwp_ih_18_2 wp_ih_18_2 0 0.7540327037979051
Vwn_ih_18_2 wn_ih_18_2 0 0.3
Vwp_ih_19_2 wp_ih_19_2 0 0.4634240402551002
Vwn_ih_19_2 wn_ih_19_2 0 0.5365759597448998
Vwp_ih_20_2 wp_ih_20_2 0 0.5010633593130221
Vwn_ih_20_2 wn_ih_20_2 0 0.4989366406869779
Vwp_ih_21_2 wp_ih_21_2 0 0.4763264051208646
Vwn_ih_21_2 wn_ih_21_2 0 0.5236735948791355
Vwp_ih_22_2 wp_ih_22_2 0 0.40931949041162224
Vwn_ih_22_2 wn_ih_22_2 0 0.5906805095883778
Vwp_ih_23_2 wp_ih_23_2 0 0.5637526880636514
Vwn_ih_23_2 wn_ih_23_2 0 0.4362473119363486
Vwp_ih_24_2 wp_ih_24_2 0 0.5886091524479278
Vwn_ih_24_2 wn_ih_24_2 0 0.4113908475520723
Vwp_ih_25_2 wp_ih_25_2 0 0.542524703328647
Vwn_ih_25_2 wn_ih_25_2 0 0.45747529667135295
Vwp_ih_26_2 wp_ih_26_2 0 0.3
Vwn_ih_26_2 wn_ih_26_2 0 0.7832693913733922
Vwp_ih_27_2 wp_ih_27_2 0 0.6209596404107702
Vwn_ih_27_2 wn_ih_27_2 0 0.37904035958922977
Vwp_ih_28_2 wp_ih_28_2 0 0.45797139802122877
Vwn_ih_28_2 wn_ih_28_2 0 0.5420286019787712
Vwp_ih_29_2 wp_ih_29_2 0 0.35404119057328326
Vwn_ih_29_2 wn_ih_29_2 0 0.6459588094267168
Vwp_ih_30_2 wp_ih_30_2 0 0.5723937150861169
Vwn_ih_30_2 wn_ih_30_2 0 0.42760628491388303
Vwp_ih_31_2 wp_ih_31_2 0 0.5675419304448636
Vwn_ih_31_2 wn_ih_31_2 0 0.43245806955513644
Vwp_ih_32_2 wp_ih_32_2 0 0.3748311557262396
Vwn_ih_32_2 wn_ih_32_2 0 0.6251688442737604
Vwp_ih_33_2 wp_ih_33_2 0 0.7966922814599078
Vwn_ih_33_2 wn_ih_33_2 0 0.3
Vwp_ih_34_2 wp_ih_34_2 0 0.35484481407492197
Vwn_ih_34_2 wn_ih_34_2 0 0.645155185925078
Vwp_ih_35_2 wp_ih_35_2 0 0.3
Vwn_ih_35_2 wn_ih_35_2 0 0.7079603245261347
Vwp_ih_36_2 wp_ih_36_2 0 0.361499428844202
Vwn_ih_36_2 wn_ih_36_2 0 0.6385005711557981
Vwp_ih_37_2 wp_ih_37_2 0 0.6704959811468076
Vwn_ih_37_2 wn_ih_37_2 0 0.32950401885319236
Vwp_ih_38_2 wp_ih_38_2 0 0.4788971929155781
Vwn_ih_38_2 wn_ih_38_2 0 0.5211028070844219
Vwp_ih_39_2 wp_ih_39_2 0 0.455353197458217
Vwn_ih_39_2 wn_ih_39_2 0 0.544646802541783
Vwp_ih_40_2 wp_ih_40_2 0 0.4925410734640007
Vwn_ih_40_2 wn_ih_40_2 0 0.5074589265359993
Vwp_ih_41_2 wp_ih_41_2 0 0.4284063310500434
Vwn_ih_41_2 wn_ih_41_2 0 0.5715936689499566
Vwp_ih_42_2 wp_ih_42_2 0 0.41716839040075154
Vwn_ih_42_2 wn_ih_42_2 0 0.5828316095992485
Vwp_ih_43_2 wp_ih_43_2 0 0.42305414074334735
Vwn_ih_43_2 wn_ih_43_2 0 0.5769458592566526
Vwp_ih_44_2 wp_ih_44_2 0 0.5849546628160907
Vwn_ih_44_2 wn_ih_44_2 0 0.41504533718390935
Vwp_ih_45_2 wp_ih_45_2 0 0.622454706280599
Vwn_ih_45_2 wn_ih_45_2 0 0.3775452937194011
Vwp_ih_46_2 wp_ih_46_2 0 0.37338889256206675
Vwn_ih_46_2 wn_ih_46_2 0 0.6266111074379332
Vwp_ih_47_2 wp_ih_47_2 0 0.5287073566086069
Vwn_ih_47_2 wn_ih_47_2 0 0.47129264339139304
Vwp_ih_48_2 wp_ih_48_2 0 0.5945848689498904
Vwn_ih_48_2 wn_ih_48_2 0 0.4054151310501097
Vwp_ih_49_2 wp_ih_49_2 0 0.3701897660592661
Vwn_ih_49_2 wn_ih_49_2 0 0.6298102339407339
Vwp_ih_50_2 wp_ih_50_2 0 0.4396920089579365
Vwn_ih_50_2 wn_ih_50_2 0 0.5603079910420635
Vwp_ih_51_2 wp_ih_51_2 0 0.37543230052270504
Vwn_ih_51_2 wn_ih_51_2 0 0.624567699477295
Vwp_ih_52_2 wp_ih_52_2 0 0.3450765748379316
Vwn_ih_52_2 wn_ih_52_2 0 0.6549234251620684
Vwp_ih_53_2 wp_ih_53_2 0 0.5122235442548002
Vwn_ih_53_2 wn_ih_53_2 0 0.4877764557451998
Vwp_ih_54_2 wp_ih_54_2 0 0.411664115440385
Vwn_ih_54_2 wn_ih_54_2 0 0.588335884559615
Vwp_ih_55_2 wp_ih_55_2 0 0.5757354906973456
Vwn_ih_55_2 wn_ih_55_2 0 0.42426450930265436
Vwp_ih_56_2 wp_ih_56_2 0 0.4964693692861636
Vwn_ih_56_2 wn_ih_56_2 0 0.5035306307138364
Vwp_ih_57_2 wp_ih_57_2 0 0.5495152826245994
Vwn_ih_57_2 wn_ih_57_2 0 0.4504847173754007
Vwp_ih_58_2 wp_ih_58_2 0 0.4649260504856154
Vwn_ih_58_2 wn_ih_58_2 0 0.5350739495143846
Vwp_ih_59_2 wp_ih_59_2 0 0.42380031408931723
Vwn_ih_59_2 wn_ih_59_2 0 0.5761996859106828
Vwp_ih_60_2 wp_ih_60_2 0 0.48911922378718625
Vwn_ih_60_2 wn_ih_60_2 0 0.5108807762128138
Vwp_ih_61_2 wp_ih_61_2 0 0.4994004643668085
Vwn_ih_61_2 wn_ih_61_2 0 0.5005995356331915
Vwp_ih_62_2 wp_ih_62_2 0 0.4152973406580056
Vwn_ih_62_2 wn_ih_62_2 0 0.5847026593419944
Vwp_ih_63_2 wp_ih_63_2 0 0.5511914546132198
Vwn_ih_63_2 wn_ih_63_2 0 0.44880854538678017
Vwp_ho_2_0 wp_ho_2_0 0 0.3373707813347524
Vwn_ho_2_0 wn_ho_2_0 0 0.6626292186652476
Vwp_ho_2_1 wp_ho_2_1 0 0.40685716323624704
Vwn_ho_2_1 wn_ho_2_1 0 0.593142836763753
Vwp_ho_2_2 wp_ho_2_2 0 0.3920104267270207
Vwn_ho_2_2 wn_ho_2_2 0 0.6079895732729793
Vwp_ho_2_3 wp_ho_2_3 0 0.6070792055693326
Vwn_ho_2_3 wn_ho_2_3 0 0.3929207944306674
Vwp_ho_2_4 wp_ho_2_4 0 0.6086329524370179
Vwn_ho_2_4 wn_ho_2_4 0 0.39136704756298213
Vwp_ih_0_3 wp_ih_0_3 0 0.5895913827171763
Vwn_ih_0_3 wn_ih_0_3 0 0.41040861728282374
Vwp_ih_1_3 wp_ih_1_3 0 0.5189699246397111
Vwn_ih_1_3 wn_ih_1_3 0 0.48103007536028886
Vwp_ih_2_3 wp_ih_2_3 0 0.7056189066201872
Vwn_ih_2_3 wn_ih_2_3 0 0.3
Vwp_ih_3_3 wp_ih_3_3 0 0.4241193188419141
Vwn_ih_3_3 wn_ih_3_3 0 0.5758806811580859
Vwp_ih_4_3 wp_ih_4_3 0 0.5624715701841324
Vwn_ih_4_3 wn_ih_4_3 0 0.4375284298158676
Vwp_ih_5_3 wp_ih_5_3 0 0.4509518239365127
Vwn_ih_5_3 wn_ih_5_3 0 0.5490481760634873
Vwp_ih_6_3 wp_ih_6_3 0 0.5281555404410311
Vwn_ih_6_3 wn_ih_6_3 0 0.47184445955896887
Vwp_ih_7_3 wp_ih_7_3 0 0.4004060792501498
Vwn_ih_7_3 wn_ih_7_3 0 0.5995939207498502
Vwp_ih_8_3 wp_ih_8_3 0 0.633814805283772
Vwn_ih_8_3 wn_ih_8_3 0 0.366185194716228
Vwp_ih_9_3 wp_ih_9_3 0 0.5211225086908708
Vwn_ih_9_3 wn_ih_9_3 0 0.47887749130912916
Vwp_ih_10_3 wp_ih_10_3 0 0.6430693399487801
Vwn_ih_10_3 wn_ih_10_3 0 0.35693066005121993
Vwp_ih_11_3 wp_ih_11_3 0 0.3480685307811491
Vwn_ih_11_3 wn_ih_11_3 0 0.6519314692188509
Vwp_ih_12_3 wp_ih_12_3 0 0.44077817489590704
Vwn_ih_12_3 wn_ih_12_3 0 0.5592218251040929
Vwp_ih_13_3 wp_ih_13_3 0 0.39289210396663143
Vwn_ih_13_3 wn_ih_13_3 0 0.6071078960333686
Vwp_ih_14_3 wp_ih_14_3 0 0.43616697616501987
Vwn_ih_14_3 wn_ih_14_3 0 0.5638330238349801
Vwp_ih_15_3 wp_ih_15_3 0 0.41688683633770107
Vwn_ih_15_3 wn_ih_15_3 0 0.5831131636622989
Vwp_ih_16_3 wp_ih_16_3 0 0.48553508788552485
Vwn_ih_16_3 wn_ih_16_3 0 0.5144649121144751
Vwp_ih_17_3 wp_ih_17_3 0 0.49793034275265885
Vwn_ih_17_3 wn_ih_17_3 0 0.5020696572473411
Vwp_ih_18_3 wp_ih_18_3 0 0.4950818162364125
Vwn_ih_18_3 wn_ih_18_3 0 0.5049181837635875
Vwp_ih_19_3 wp_ih_19_3 0 0.43333713517858075
Vwn_ih_19_3 wn_ih_19_3 0 0.5666628648214193
Vwp_ih_20_3 wp_ih_20_3 0 0.5224910213466402
Vwn_ih_20_3 wn_ih_20_3 0 0.4775089786533598
Vwp_ih_21_3 wp_ih_21_3 0 0.6050738594637082
Vwn_ih_21_3 wn_ih_21_3 0 0.3949261405362918
Vwp_ih_22_3 wp_ih_22_3 0 0.39172693208132925
Vwn_ih_22_3 wn_ih_22_3 0 0.6082730679186708
Vwp_ih_23_3 wp_ih_23_3 0 0.5001066350002306
Vwn_ih_23_3 wn_ih_23_3 0 0.4998933649997694
Vwp_ih_24_3 wp_ih_24_3 0 0.4911114932988942
Vwn_ih_24_3 wn_ih_24_3 0 0.5088885067011057
Vwp_ih_25_3 wp_ih_25_3 0 0.5562025561068515
Vwn_ih_25_3 wn_ih_25_3 0 0.4437974438931485
Vwp_ih_26_3 wp_ih_26_3 0 0.49233696982714825
Vwn_ih_26_3 wn_ih_26_3 0 0.5076630301728517
Vwp_ih_27_3 wp_ih_27_3 0 0.4981202235685993
Vwn_ih_27_3 wn_ih_27_3 0 0.5018797764314007
Vwp_ih_28_3 wp_ih_28_3 0 0.3810685061326242
Vwn_ih_28_3 wn_ih_28_3 0 0.6189314938673758
Vwp_ih_29_3 wp_ih_29_3 0 0.5026044606871569
Vwn_ih_29_3 wn_ih_29_3 0 0.497395539312843
Vwp_ih_30_3 wp_ih_30_3 0 0.3893738612841069
Vwn_ih_30_3 wn_ih_30_3 0 0.6106261387158931
Vwp_ih_31_3 wp_ih_31_3 0 0.5618845097796894
Vwn_ih_31_3 wn_ih_31_3 0 0.4381154902203106
Vwp_ih_32_3 wp_ih_32_3 0 0.4876137278856174
Vwn_ih_32_3 wn_ih_32_3 0 0.5123862721143826
Vwp_ih_33_3 wp_ih_33_3 0 0.5047830101137598
Vwn_ih_33_3 wn_ih_33_3 0 0.49521698988624024
Vwp_ih_34_3 wp_ih_34_3 0 0.39305715594916474
Vwn_ih_34_3 wn_ih_34_3 0 0.6069428440508352
Vwp_ih_35_3 wp_ih_35_3 0 0.5964509095930027
Vwn_ih_35_3 wn_ih_35_3 0 0.4035490904069973
Vwp_ih_36_3 wp_ih_36_3 0 0.5830776690718609
Vwn_ih_36_3 wn_ih_36_3 0 0.41692233092813913
Vwp_ih_37_3 wp_ih_37_3 0 0.6033828714859769
Vwn_ih_37_3 wn_ih_37_3 0 0.3966171285140231
Vwp_ih_38_3 wp_ih_38_3 0 0.7672863297095811
Vwn_ih_38_3 wn_ih_38_3 0 0.3
Vwp_ih_39_3 wp_ih_39_3 0 0.4936976741248312
Vwn_ih_39_3 wn_ih_39_3 0 0.5063023258751689
Vwp_ih_40_3 wp_ih_40_3 0 0.6444083402969368
Vwn_ih_40_3 wn_ih_40_3 0 0.35559165970306317
Vwp_ih_41_3 wp_ih_41_3 0 0.4851406632291294
Vwn_ih_41_3 wn_ih_41_3 0 0.5148593367708706
Vwp_ih_42_3 wp_ih_42_3 0 0.5472904755008358
Vwn_ih_42_3 wn_ih_42_3 0 0.45270952449916424
Vwp_ih_43_3 wp_ih_43_3 0 0.5438404913135523
Vwn_ih_43_3 wn_ih_43_3 0 0.4561595086864477
Vwp_ih_44_3 wp_ih_44_3 0 0.531751011603017
Vwn_ih_44_3 wn_ih_44_3 0 0.4682489883969831
Vwp_ih_45_3 wp_ih_45_3 0 0.5789907414224457
Vwn_ih_45_3 wn_ih_45_3 0 0.4210092585775543
Vwp_ih_46_3 wp_ih_46_3 0 0.46352763435929045
Vwn_ih_46_3 wn_ih_46_3 0 0.5364723656407095
Vwp_ih_47_3 wp_ih_47_3 0 0.5049118737897772
Vwn_ih_47_3 wn_ih_47_3 0 0.4950881262102228
Vwp_ih_48_3 wp_ih_48_3 0 0.5642371576810173
Vwn_ih_48_3 wn_ih_48_3 0 0.43576284231898266
Vwp_ih_49_3 wp_ih_49_3 0 0.7097424680046189
Vwn_ih_49_3 wn_ih_49_3 0 0.3
Vwp_ih_50_3 wp_ih_50_3 0 0.3989171997221106
Vwn_ih_50_3 wn_ih_50_3 0 0.6010828002778894
Vwp_ih_51_3 wp_ih_51_3 0 0.3
Vwn_ih_51_3 wn_ih_51_3 0 0.7167359144459495
Vwp_ih_52_3 wp_ih_52_3 0 0.4419097410622762
Vwn_ih_52_3 wn_ih_52_3 0 0.5580902589377238
Vwp_ih_53_3 wp_ih_53_3 0 0.5107914119576944
Vwn_ih_53_3 wn_ih_53_3 0 0.48920858804230566
Vwp_ih_54_3 wp_ih_54_3 0 0.5209972511844428
Vwn_ih_54_3 wn_ih_54_3 0 0.47900274881555716
Vwp_ih_55_3 wp_ih_55_3 0 0.5110661342944081
Vwn_ih_55_3 wn_ih_55_3 0 0.4889338657055919
Vwp_ih_56_3 wp_ih_56_3 0 0.641934814721454
Vwn_ih_56_3 wn_ih_56_3 0 0.358065185278546
Vwp_ih_57_3 wp_ih_57_3 0 0.6171259751340656
Vwn_ih_57_3 wn_ih_57_3 0 0.3828740248659344
Vwp_ih_58_3 wp_ih_58_3 0 0.4940878514058445
Vwn_ih_58_3 wn_ih_58_3 0 0.5059121485941556
Vwp_ih_59_3 wp_ih_59_3 0 0.44365434526973757
Vwn_ih_59_3 wn_ih_59_3 0 0.5563456547302624
Vwp_ih_60_3 wp_ih_60_3 0 0.4584789342340993
Vwn_ih_60_3 wn_ih_60_3 0 0.5415210657659008
Vwp_ih_61_3 wp_ih_61_3 0 0.4572435016420882
Vwn_ih_61_3 wn_ih_61_3 0 0.5427564983579117
Vwp_ih_62_3 wp_ih_62_3 0 0.4729280631406234
Vwn_ih_62_3 wn_ih_62_3 0 0.5270719368593766
Vwp_ih_63_3 wp_ih_63_3 0 0.3112819326148406
Vwn_ih_63_3 wn_ih_63_3 0 0.6887180673851594
Vwp_ho_3_0 wp_ho_3_0 0 0.6013939720804229
Vwn_ho_3_0 wn_ho_3_0 0 0.3986060279195771
Vwp_ho_3_1 wp_ho_3_1 0 0.3068823896676748
Vwn_ho_3_1 wn_ho_3_1 0 0.6931176103323252
Vwp_ho_3_2 wp_ho_3_2 0 0.4889820198207185
Vwn_ho_3_2 wn_ho_3_2 0 0.5110179801792816
Vwp_ho_3_3 wp_ho_3_3 0 0.4383931001064197
Vwn_ho_3_3 wn_ho_3_3 0 0.5616068998935803
Vwp_ho_3_4 wp_ho_3_4 0 0.5159035345823698
Vwn_ho_3_4 wn_ho_3_4 0 0.48409646541763024
Vwp_ih_0_4 wp_ih_0_4 0 0.44467511076288524
Vwn_ih_0_4 wn_ih_0_4 0 0.5553248892371148
Vwp_ih_1_4 wp_ih_1_4 0 0.44901439744448407
Vwn_ih_1_4 wn_ih_1_4 0 0.550985602555516
Vwp_ih_2_4 wp_ih_2_4 0 0.4773343537162448
Vwn_ih_2_4 wn_ih_2_4 0 0.5226656462837552
Vwp_ih_3_4 wp_ih_3_4 0 0.4694839985095852
Vwn_ih_3_4 wn_ih_3_4 0 0.5305160014904148
Vwp_ih_4_4 wp_ih_4_4 0 0.5806408569953044
Vwn_ih_4_4 wn_ih_4_4 0 0.41935914300469557
Vwp_ih_5_4 wp_ih_5_4 0 0.43616679728444097
Vwn_ih_5_4 wn_ih_5_4 0 0.563833202715559
Vwp_ih_6_4 wp_ih_6_4 0 0.44737067582829415
Vwn_ih_6_4 wn_ih_6_4 0 0.5526293241717058
Vwp_ih_7_4 wp_ih_7_4 0 0.5650326505601648
Vwn_ih_7_4 wn_ih_7_4 0 0.43496734943983517
Vwp_ih_8_4 wp_ih_8_4 0 0.47176221839069216
Vwn_ih_8_4 wn_ih_8_4 0 0.5282377816093079
Vwp_ih_9_4 wp_ih_9_4 0 0.5259745672214811
Vwn_ih_9_4 wn_ih_9_4 0 0.47402543277851894
Vwp_ih_10_4 wp_ih_10_4 0 0.5803202838027327
Vwn_ih_10_4 wn_ih_10_4 0 0.4196797161972673
Vwp_ih_11_4 wp_ih_11_4 0 0.5506363393733666
Vwn_ih_11_4 wn_ih_11_4 0 0.4493636606266334
Vwp_ih_12_4 wp_ih_12_4 0 0.530019493758118
Vwn_ih_12_4 wn_ih_12_4 0 0.4699805062418821
Vwp_ih_13_4 wp_ih_13_4 0 0.4764270130789016
Vwn_ih_13_4 wn_ih_13_4 0 0.5235729869210983
Vwp_ih_14_4 wp_ih_14_4 0 0.5818272923711849
Vwn_ih_14_4 wn_ih_14_4 0 0.41817270762881514
Vwp_ih_15_4 wp_ih_15_4 0 0.5210659929518
Vwn_ih_15_4 wn_ih_15_4 0 0.47893400704819994
Vwp_ih_16_4 wp_ih_16_4 0 0.4394176698725902
Vwn_ih_16_4 wn_ih_16_4 0 0.5605823301274098
Vwp_ih_17_4 wp_ih_17_4 0 0.4819028975601188
Vwn_ih_17_4 wn_ih_17_4 0 0.5180971024398813
Vwp_ih_18_4 wp_ih_18_4 0 0.3538244747212963
Vwn_ih_18_4 wn_ih_18_4 0 0.6461755252787037
Vwp_ih_19_4 wp_ih_19_4 0 0.3846132831023705
Vwn_ih_19_4 wn_ih_19_4 0 0.6153867168976295
Vwp_ih_20_4 wp_ih_20_4 0 0.3
Vwn_ih_20_4 wn_ih_20_4 0 0.725948964413424
Vwp_ih_21_4 wp_ih_21_4 0 0.4184082342071706
Vwn_ih_21_4 wn_ih_21_4 0 0.5815917657928295
Vwp_ih_22_4 wp_ih_22_4 0 0.6602654505957061
Vwn_ih_22_4 wn_ih_22_4 0 0.33973454940429393
Vwp_ih_23_4 wp_ih_23_4 0 0.43322133920080963
Vwn_ih_23_4 wn_ih_23_4 0 0.5667786607991904
Vwp_ih_24_4 wp_ih_24_4 0 0.5945048980523242
Vwn_ih_24_4 wn_ih_24_4 0 0.40549510194767585
Vwp_ih_25_4 wp_ih_25_4 0 0.4995860174932638
Vwn_ih_25_4 wn_ih_25_4 0 0.5004139825067362
Vwp_ih_26_4 wp_ih_26_4 0 0.41593414122901595
Vwn_ih_26_4 wn_ih_26_4 0 0.584065858770984
Vwp_ih_27_4 wp_ih_27_4 0 0.660593541815349
Vwn_ih_27_4 wn_ih_27_4 0 0.339406458184651
Vwp_ih_28_4 wp_ih_28_4 0 0.569864701828777
Vwn_ih_28_4 wn_ih_28_4 0 0.430135298171223
Vwp_ih_29_4 wp_ih_29_4 0 0.3
Vwn_ih_29_4 wn_ih_29_4 0 0.7102160678336134
Vwp_ih_30_4 wp_ih_30_4 0 0.6249682637824028
Vwn_ih_30_4 wn_ih_30_4 0 0.3750317362175972
Vwp_ih_31_4 wp_ih_31_4 0 0.37102502057320974
Vwn_ih_31_4 wn_ih_31_4 0 0.6289749794267903
Vwp_ih_32_4 wp_ih_32_4 0 0.47865032641008426
Vwn_ih_32_4 wn_ih_32_4 0 0.5213496735899158
Vwp_ih_33_4 wp_ih_33_4 0 0.5801736106020674
Vwn_ih_33_4 wn_ih_33_4 0 0.4198263893979326
Vwp_ih_34_4 wp_ih_34_4 0 0.46401762072809843
Vwn_ih_34_4 wn_ih_34_4 0 0.5359823792719016
Vwp_ih_35_4 wp_ih_35_4 0 0.6342732866740649
Vwn_ih_35_4 wn_ih_35_4 0 0.3657267133259351
Vwp_ih_36_4 wp_ih_36_4 0 0.5913516512615795
Vwn_ih_36_4 wn_ih_36_4 0 0.40864834873842054
Vwp_ih_37_4 wp_ih_37_4 0 0.31077492674156293
Vwn_ih_37_4 wn_ih_37_4 0 0.6892250732584371
Vwp_ih_38_4 wp_ih_38_4 0 0.44330790122794633
Vwn_ih_38_4 wn_ih_38_4 0 0.5566920987720537
Vwp_ih_39_4 wp_ih_39_4 0 0.5338488479865637
Vwn_ih_39_4 wn_ih_39_4 0 0.46615115201343627
Vwp_ih_40_4 wp_ih_40_4 0 0.43100015824819493
Vwn_ih_40_4 wn_ih_40_4 0 0.5689998417518051
Vwp_ih_41_4 wp_ih_41_4 0 0.4740468192582634
Vwn_ih_41_4 wn_ih_41_4 0 0.5259531807417366
Vwp_ih_42_4 wp_ih_42_4 0 0.5959741893666742
Vwn_ih_42_4 wn_ih_42_4 0 0.40402581063332577
Vwp_ih_43_4 wp_ih_43_4 0 0.5380137568020147
Vwn_ih_43_4 wn_ih_43_4 0 0.46198624319798537
Vwp_ih_44_4 wp_ih_44_4 0 0.3895257157814168
Vwn_ih_44_4 wn_ih_44_4 0 0.6104742842185832
Vwp_ih_45_4 wp_ih_45_4 0 0.5209527643224364
Vwn_ih_45_4 wn_ih_45_4 0 0.4790472356775636
Vwp_ih_46_4 wp_ih_46_4 0 0.42652764378681535
Vwn_ih_46_4 wn_ih_46_4 0 0.5734723562131847
Vwp_ih_47_4 wp_ih_47_4 0 0.3541769168925456
Vwn_ih_47_4 wn_ih_47_4 0 0.6458230831074544
Vwp_ih_48_4 wp_ih_48_4 0 0.3643932979997521
Vwn_ih_48_4 wn_ih_48_4 0 0.6356067020002478
Vwp_ih_49_4 wp_ih_49_4 0 0.5344346644521102
Vwn_ih_49_4 wn_ih_49_4 0 0.4655653355478898
Vwp_ih_50_4 wp_ih_50_4 0 0.49662635528077254
Vwn_ih_50_4 wn_ih_50_4 0 0.5033736447192274
Vwp_ih_51_4 wp_ih_51_4 0 0.5006518170270111
Vwn_ih_51_4 wn_ih_51_4 0 0.49934818297298894
Vwp_ih_52_4 wp_ih_52_4 0 0.36245491425531007
Vwn_ih_52_4 wn_ih_52_4 0 0.6375450857446899
Vwp_ih_53_4 wp_ih_53_4 0 0.4779284540014909
Vwn_ih_53_4 wn_ih_53_4 0 0.522071545998509
Vwp_ih_54_4 wp_ih_54_4 0 0.37553988707010905
Vwn_ih_54_4 wn_ih_54_4 0 0.624460112929891
Vwp_ih_55_4 wp_ih_55_4 0 0.38883273997200457
Vwn_ih_55_4 wn_ih_55_4 0 0.6111672600279955
Vwp_ih_56_4 wp_ih_56_4 0 0.48018478918514745
Vwn_ih_56_4 wn_ih_56_4 0 0.5198152108148526
Vwp_ih_57_4 wp_ih_57_4 0 0.3339931458415404
Vwn_ih_57_4 wn_ih_57_4 0 0.6660068541584596
Vwp_ih_58_4 wp_ih_58_4 0 0.5803120719640534
Vwn_ih_58_4 wn_ih_58_4 0 0.4196879280359466
Vwp_ih_59_4 wp_ih_59_4 0 0.7984259421527491
Vwn_ih_59_4 wn_ih_59_4 0 0.3
Vwp_ih_60_4 wp_ih_60_4 0 0.5550587898908885
Vwn_ih_60_4 wn_ih_60_4 0 0.4449412101091115
Vwp_ih_61_4 wp_ih_61_4 0 0.3748516233205393
Vwn_ih_61_4 wn_ih_61_4 0 0.6251483766794608
Vwp_ih_62_4 wp_ih_62_4 0 0.4674577383018218
Vwn_ih_62_4 wn_ih_62_4 0 0.5325422616981782
Vwp_ih_63_4 wp_ih_63_4 0 0.3133474467701315
Vwn_ih_63_4 wn_ih_63_4 0 0.6866525532298685
Vwp_ho_4_0 wp_ho_4_0 0 0.5133694166176016
Vwn_ho_4_0 wn_ho_4_0 0 0.4866305833823984
Vwp_ho_4_1 wp_ho_4_1 0 0.6119486272999175
Vwn_ho_4_1 wn_ho_4_1 0 0.3880513727000825
Vwp_ho_4_2 wp_ho_4_2 0 0.6274265141809625
Vwn_ho_4_2 wn_ho_4_2 0 0.3725734858190375
Vwp_ho_4_3 wp_ho_4_3 0 0.7373797908308646
Vwn_ho_4_3 wn_ho_4_3 0 0.3
Vwp_ho_4_4 wp_ho_4_4 0 0.5340663955582767
Vwn_ho_4_4 wn_ho_4_4 0 0.46593360444172327
Vwp_ih_0_5 wp_ih_0_5 0 0.4546860342449334
Vwn_ih_0_5 wn_ih_0_5 0 0.5453139657550665
Vwp_ih_1_5 wp_ih_1_5 0 0.5608776722683261
Vwn_ih_1_5 wn_ih_1_5 0 0.43912232773167387
Vwp_ih_2_5 wp_ih_2_5 0 0.5707261719422927
Vwn_ih_2_5 wn_ih_2_5 0 0.4292738280577073
Vwp_ih_3_5 wp_ih_3_5 0 0.3761908695369881
Vwn_ih_3_5 wn_ih_3_5 0 0.6238091304630119
Vwp_ih_4_5 wp_ih_4_5 0 0.535897478418395
Vwn_ih_4_5 wn_ih_4_5 0 0.46410252158160503
Vwp_ih_5_5 wp_ih_5_5 0 0.6387689630006536
Vwn_ih_5_5 wn_ih_5_5 0 0.36123103699934644
Vwp_ih_6_5 wp_ih_6_5 0 0.7106109902118917
Vwn_ih_6_5 wn_ih_6_5 0 0.3
Vwp_ih_7_5 wp_ih_7_5 0 0.41590461407615475
Vwn_ih_7_5 wn_ih_7_5 0 0.5840953859238452
Vwp_ih_8_5 wp_ih_8_5 0 0.396295998550486
Vwn_ih_8_5 wn_ih_8_5 0 0.603704001449514
Vwp_ih_9_5 wp_ih_9_5 0 0.5065299042944474
Vwn_ih_9_5 wn_ih_9_5 0 0.4934700957055525
Vwp_ih_10_5 wp_ih_10_5 0 0.3
Vwn_ih_10_5 wn_ih_10_5 0 0.8513708207082058
Vwp_ih_11_5 wp_ih_11_5 0 0.43627591986189374
Vwn_ih_11_5 wn_ih_11_5 0 0.5637240801381063
Vwp_ih_12_5 wp_ih_12_5 0 0.46748300368254575
Vwn_ih_12_5 wn_ih_12_5 0 0.5325169963174543
Vwp_ih_13_5 wp_ih_13_5 0 0.44487896149545353
Vwn_ih_13_5 wn_ih_13_5 0 0.5551210385045465
Vwp_ih_14_5 wp_ih_14_5 0 0.30993521262049734
Vwn_ih_14_5 wn_ih_14_5 0 0.6900647873795027
Vwp_ih_15_5 wp_ih_15_5 0 0.4705338670724417
Vwn_ih_15_5 wn_ih_15_5 0 0.5294661329275583
Vwp_ih_16_5 wp_ih_16_5 0 0.4068069655933182
Vwn_ih_16_5 wn_ih_16_5 0 0.5931930344066818
Vwp_ih_17_5 wp_ih_17_5 0 0.5908979670149748
Vwn_ih_17_5 wn_ih_17_5 0 0.4091020329850253
Vwp_ih_18_5 wp_ih_18_5 0 0.38978302190926845
Vwn_ih_18_5 wn_ih_18_5 0 0.6102169780907315
Vwp_ih_19_5 wp_ih_19_5 0 0.46611858442865106
Vwn_ih_19_5 wn_ih_19_5 0 0.5338814155713489
Vwp_ih_20_5 wp_ih_20_5 0 0.4720462489857916
Vwn_ih_20_5 wn_ih_20_5 0 0.5279537510142084
Vwp_ih_21_5 wp_ih_21_5 0 0.5681085705589424
Vwn_ih_21_5 wn_ih_21_5 0 0.43189142944105763
Vwp_ih_22_5 wp_ih_22_5 0 0.3
Vwn_ih_22_5 wn_ih_22_5 0 0.8055085520439293
Vwp_ih_23_5 wp_ih_23_5 0 0.45912500770447995
Vwn_ih_23_5 wn_ih_23_5 0 0.54087499229552
Vwp_ih_24_5 wp_ih_24_5 0 0.5911538179128412
Vwn_ih_24_5 wn_ih_24_5 0 0.40884618208715884
Vwp_ih_25_5 wp_ih_25_5 0 0.45659741153281186
Vwn_ih_25_5 wn_ih_25_5 0 0.5434025884671881
Vwp_ih_26_5 wp_ih_26_5 0 0.31676756403344697
Vwn_ih_26_5 wn_ih_26_5 0 0.683232435966553
Vwp_ih_27_5 wp_ih_27_5 0 0.5391917807100749
Vwn_ih_27_5 wn_ih_27_5 0 0.4608082192899251
Vwp_ih_28_5 wp_ih_28_5 0 0.5404024287492211
Vwn_ih_28_5 wn_ih_28_5 0 0.45959757125077894
Vwp_ih_29_5 wp_ih_29_5 0 0.4675412729651206
Vwn_ih_29_5 wn_ih_29_5 0 0.5324587270348794
Vwp_ih_30_5 wp_ih_30_5 0 0.36082451512499236
Vwn_ih_30_5 wn_ih_30_5 0 0.6391754848750076
Vwp_ih_31_5 wp_ih_31_5 0 0.41111898253675005
Vwn_ih_31_5 wn_ih_31_5 0 0.58888101746325
Vwp_ih_32_5 wp_ih_32_5 0 0.46234921892762876
Vwn_ih_32_5 wn_ih_32_5 0 0.5376507810723712
Vwp_ih_33_5 wp_ih_33_5 0 0.39493605730900566
Vwn_ih_33_5 wn_ih_33_5 0 0.6050639426909943
Vwp_ih_34_5 wp_ih_34_5 0 0.3
Vwn_ih_34_5 wn_ih_34_5 0 0.7304214018023538
Vwp_ih_35_5 wp_ih_35_5 0 0.4076855841282604
Vwn_ih_35_5 wn_ih_35_5 0 0.5923144158717396
Vwp_ih_36_5 wp_ih_36_5 0 0.4925907278633869
Vwn_ih_36_5 wn_ih_36_5 0 0.5074092721366131
Vwp_ih_37_5 wp_ih_37_5 0 0.43915279192501344
Vwn_ih_37_5 wn_ih_37_5 0 0.5608472080749866
Vwp_ih_38_5 wp_ih_38_5 0 0.49093125930339165
Vwn_ih_38_5 wn_ih_38_5 0 0.5090687406966083
Vwp_ih_39_5 wp_ih_39_5 0 0.5100389574755508
Vwn_ih_39_5 wn_ih_39_5 0 0.48996104252444916
Vwp_ih_40_5 wp_ih_40_5 0 0.6075890600437185
Vwn_ih_40_5 wn_ih_40_5 0 0.3924109399562815
Vwp_ih_41_5 wp_ih_41_5 0 0.7644588948141867
Vwn_ih_41_5 wn_ih_41_5 0 0.3
Vwp_ih_42_5 wp_ih_42_5 0 0.5878134608151687
Vwn_ih_42_5 wn_ih_42_5 0 0.4121865391848313
Vwp_ih_43_5 wp_ih_43_5 0 0.3314805744141406
Vwn_ih_43_5 wn_ih_43_5 0 0.6685194255858594
Vwp_ih_44_5 wp_ih_44_5 0 0.3
Vwn_ih_44_5 wn_ih_44_5 0 0.8188333936762762
Vwp_ih_45_5 wp_ih_45_5 0 0.4886645397596824
Vwn_ih_45_5 wn_ih_45_5 0 0.5113354602403176
Vwp_ih_46_5 wp_ih_46_5 0 0.5085666122309556
Vwn_ih_46_5 wn_ih_46_5 0 0.4914333877690444
Vwp_ih_47_5 wp_ih_47_5 0 0.3605752032998509
Vwn_ih_47_5 wn_ih_47_5 0 0.6394247967001492
Vwp_ih_48_5 wp_ih_48_5 0 0.5326438564642489
Vwn_ih_48_5 wn_ih_48_5 0 0.46735614353575106
Vwp_ih_49_5 wp_ih_49_5 0 0.40796724945574436
Vwn_ih_49_5 wn_ih_49_5 0 0.5920327505442556
Vwp_ih_50_5 wp_ih_50_5 0 0.5483203679337965
Vwn_ih_50_5 wn_ih_50_5 0 0.45167963206620354
Vwp_ih_51_5 wp_ih_51_5 0 0.46093781924338056
Vwn_ih_51_5 wn_ih_51_5 0 0.5390621807566194
Vwp_ih_52_5 wp_ih_52_5 0 0.5476955108869566
Vwn_ih_52_5 wn_ih_52_5 0 0.4523044891130434
Vwp_ih_53_5 wp_ih_53_5 0 0.3
Vwn_ih_53_5 wn_ih_53_5 0 0.7091834232926519
Vwp_ih_54_5 wp_ih_54_5 0 0.4473839749880841
Vwn_ih_54_5 wn_ih_54_5 0 0.552616025011916
Vwp_ih_55_5 wp_ih_55_5 0 0.48216847922329453
Vwn_ih_55_5 wn_ih_55_5 0 0.5178315207767055
Vwp_ih_56_5 wp_ih_56_5 0 0.32901503298800827
Vwn_ih_56_5 wn_ih_56_5 0 0.6709849670119917
Vwp_ih_57_5 wp_ih_57_5 0 0.7258805909872077
Vwn_ih_57_5 wn_ih_57_5 0 0.3
Vwp_ih_58_5 wp_ih_58_5 0 0.43510719054853714
Vwn_ih_58_5 wn_ih_58_5 0 0.5648928094514629
Vwp_ih_59_5 wp_ih_59_5 0 0.6667966074810051
Vwn_ih_59_5 wn_ih_59_5 0 0.3332033925189949
Vwp_ih_60_5 wp_ih_60_5 0 0.42027894906559465
Vwn_ih_60_5 wn_ih_60_5 0 0.5797210509344054
Vwp_ih_61_5 wp_ih_61_5 0 0.4724034613422796
Vwn_ih_61_5 wn_ih_61_5 0 0.5275965386577204
Vwp_ih_62_5 wp_ih_62_5 0 0.6420682294052024
Vwn_ih_62_5 wn_ih_62_5 0 0.35793177059479764
Vwp_ih_63_5 wp_ih_63_5 0 0.5364592214033351
Vwn_ih_63_5 wn_ih_63_5 0 0.46354077859666487
Vwp_ho_5_0 wp_ho_5_0 0 0.7305075708148382
Vwn_ho_5_0 wn_ho_5_0 0 0.3
Vwp_ho_5_1 wp_ho_5_1 0 0.5325354111319172
Vwn_ho_5_1 wn_ho_5_1 0 0.46746458886808284
Vwp_ho_5_2 wp_ho_5_2 0 0.746985681667875
Vwn_ho_5_2 wn_ho_5_2 0 0.3
Vwp_ho_5_3 wp_ho_5_3 0 0.4718104181663715
Vwn_ho_5_3 wn_ho_5_3 0 0.5281895818336285
Vwp_ho_5_4 wp_ho_5_4 0 0.6520845455856488
Vwn_ho_5_4 wn_ho_5_4 0 0.34791545441435123
Vwp_ih_0_6 wp_ih_0_6 0 0.5230465220347833
Vwn_ih_0_6 wn_ih_0_6 0 0.4769534779652167
Vwp_ih_1_6 wp_ih_1_6 0 0.5319132137811461
Vwn_ih_1_6 wn_ih_1_6 0 0.4680867862188539
Vwp_ih_2_6 wp_ih_2_6 0 0.33606105485109594
Vwn_ih_2_6 wn_ih_2_6 0 0.6639389451489041
Vwp_ih_3_6 wp_ih_3_6 0 0.4532535831634243
Vwn_ih_3_6 wn_ih_3_6 0 0.5467464168365758
Vwp_ih_4_6 wp_ih_4_6 0 0.3852265215341964
Vwn_ih_4_6 wn_ih_4_6 0 0.6147734784658037
Vwp_ih_5_6 wp_ih_5_6 0 0.5236896382777179
Vwn_ih_5_6 wn_ih_5_6 0 0.4763103617222822
Vwp_ih_6_6 wp_ih_6_6 0 0.43472022435157975
Vwn_ih_6_6 wn_ih_6_6 0 0.5652797756484202
Vwp_ih_7_6 wp_ih_7_6 0 0.49471290542003016
Vwn_ih_7_6 wn_ih_7_6 0 0.5052870945799698
Vwp_ih_8_6 wp_ih_8_6 0 0.49072489240868694
Vwn_ih_8_6 wn_ih_8_6 0 0.5092751075913131
Vwp_ih_9_6 wp_ih_9_6 0 0.4956355538113984
Vwn_ih_9_6 wn_ih_9_6 0 0.5043644461886015
Vwp_ih_10_6 wp_ih_10_6 0 0.49583034537061643
Vwn_ih_10_6 wn_ih_10_6 0 0.5041696546293836
Vwp_ih_11_6 wp_ih_11_6 0 0.4217146272339682
Vwn_ih_11_6 wn_ih_11_6 0 0.5782853727660318
Vwp_ih_12_6 wp_ih_12_6 0 0.3735196645332159
Vwn_ih_12_6 wn_ih_12_6 0 0.626480335466784
Vwp_ih_13_6 wp_ih_13_6 0 0.42027724287756496
Vwn_ih_13_6 wn_ih_13_6 0 0.579722757122435
Vwp_ih_14_6 wp_ih_14_6 0 0.6285846008772378
Vwn_ih_14_6 wn_ih_14_6 0 0.3714153991227622
Vwp_ih_15_6 wp_ih_15_6 0 0.5448994167757824
Vwn_ih_15_6 wn_ih_15_6 0 0.45510058322421765
Vwp_ih_16_6 wp_ih_16_6 0 0.5704346432710419
Vwn_ih_16_6 wn_ih_16_6 0 0.4295653567289581
Vwp_ih_17_6 wp_ih_17_6 0 0.6655961499565217
Vwn_ih_17_6 wn_ih_17_6 0 0.3344038500434783
Vwp_ih_18_6 wp_ih_18_6 0 0.3584682880192204
Vwn_ih_18_6 wn_ih_18_6 0 0.6415317119807795
Vwp_ih_19_6 wp_ih_19_6 0 0.5611942905778186
Vwn_ih_19_6 wn_ih_19_6 0 0.43880570942218144
Vwp_ih_20_6 wp_ih_20_6 0 0.37099110737567054
Vwn_ih_20_6 wn_ih_20_6 0 0.6290088926243295
Vwp_ih_21_6 wp_ih_21_6 0 0.4598800881359735
Vwn_ih_21_6 wn_ih_21_6 0 0.5401199118640265
Vwp_ih_22_6 wp_ih_22_6 0 0.5581087811324786
Vwn_ih_22_6 wn_ih_22_6 0 0.4418912188675213
Vwp_ih_23_6 wp_ih_23_6 0 0.6937214320563709
Vwn_ih_23_6 wn_ih_23_6 0 0.30627856794362907
Vwp_ih_24_6 wp_ih_24_6 0 0.40614020690297736
Vwn_ih_24_6 wn_ih_24_6 0 0.5938597930970226
Vwp_ih_25_6 wp_ih_25_6 0 0.48862444956873885
Vwn_ih_25_6 wn_ih_25_6 0 0.5113755504312611
Vwp_ih_26_6 wp_ih_26_6 0 0.63874841647459
Vwn_ih_26_6 wn_ih_26_6 0 0.3612515835254099
Vwp_ih_27_6 wp_ih_27_6 0 0.32122302567615535
Vwn_ih_27_6 wn_ih_27_6 0 0.6787769743238447
Vwp_ih_28_6 wp_ih_28_6 0 0.5434535497647873
Vwn_ih_28_6 wn_ih_28_6 0 0.4565464502352127
Vwp_ih_29_6 wp_ih_29_6 0 0.46300662195225384
Vwn_ih_29_6 wn_ih_29_6 0 0.5369933780477462
Vwp_ih_30_6 wp_ih_30_6 0 0.39419660342359325
Vwn_ih_30_6 wn_ih_30_6 0 0.6058033965764067
Vwp_ih_31_6 wp_ih_31_6 0 0.517595698768833
Vwn_ih_31_6 wn_ih_31_6 0 0.48240430123116695
Vwp_ih_32_6 wp_ih_32_6 0 0.5713911034216189
Vwn_ih_32_6 wn_ih_32_6 0 0.42860889657838114
Vwp_ih_33_6 wp_ih_33_6 0 0.3905480285208548
Vwn_ih_33_6 wn_ih_33_6 0 0.6094519714791452
Vwp_ih_34_6 wp_ih_34_6 0 0.5455987738216089
Vwn_ih_34_6 wn_ih_34_6 0 0.45440122617839107
Vwp_ih_35_6 wp_ih_35_6 0 0.5208043987544116
Vwn_ih_35_6 wn_ih_35_6 0 0.4791956012455883
Vwp_ih_36_6 wp_ih_36_6 0 0.3509824032796743
Vwn_ih_36_6 wn_ih_36_6 0 0.6490175967203258
Vwp_ih_37_6 wp_ih_37_6 0 0.6864095440328147
Vwn_ih_37_6 wn_ih_37_6 0 0.31359045596718527
Vwp_ih_38_6 wp_ih_38_6 0 0.6307883203784175
Vwn_ih_38_6 wn_ih_38_6 0 0.3692116796215826
Vwp_ih_39_6 wp_ih_39_6 0 0.39680879025330584
Vwn_ih_39_6 wn_ih_39_6 0 0.6031912097466942
Vwp_ih_40_6 wp_ih_40_6 0 0.4296042940722985
Vwn_ih_40_6 wn_ih_40_6 0 0.5703957059277015
Vwp_ih_41_6 wp_ih_41_6 0 0.5924936280497082
Vwn_ih_41_6 wn_ih_41_6 0 0.4075063719502918
Vwp_ih_42_6 wp_ih_42_6 0 0.4405461143140553
Vwn_ih_42_6 wn_ih_42_6 0 0.5594538856859447
Vwp_ih_43_6 wp_ih_43_6 0 0.3
Vwn_ih_43_6 wn_ih_43_6 0 0.7207662326267142
Vwp_ih_44_6 wp_ih_44_6 0 0.6258658534880872
Vwn_ih_44_6 wn_ih_44_6 0 0.3741341465119128
Vwp_ih_45_6 wp_ih_45_6 0 0.5010537707558927
Vwn_ih_45_6 wn_ih_45_6 0 0.49894622924410725
Vwp_ih_46_6 wp_ih_46_6 0 0.7288431429157901
Vwn_ih_46_6 wn_ih_46_6 0 0.3
Vwp_ih_47_6 wp_ih_47_6 0 0.5428960547802784
Vwn_ih_47_6 wn_ih_47_6 0 0.45710394521972164
Vwp_ih_48_6 wp_ih_48_6 0 0.5229190987259615
Vwn_ih_48_6 wn_ih_48_6 0 0.47708090127403846
Vwp_ih_49_6 wp_ih_49_6 0 0.8449400577672959
Vwn_ih_49_6 wn_ih_49_6 0 0.3
Vwp_ih_50_6 wp_ih_50_6 0 0.47937591848582817
Vwn_ih_50_6 wn_ih_50_6 0 0.5206240815141718
Vwp_ih_51_6 wp_ih_51_6 0 0.3857821082147745
Vwn_ih_51_6 wn_ih_51_6 0 0.6142178917852255
Vwp_ih_52_6 wp_ih_52_6 0 0.5275037575483098
Vwn_ih_52_6 wn_ih_52_6 0 0.47249624245169025
Vwp_ih_53_6 wp_ih_53_6 0 0.6362905883625279
Vwn_ih_53_6 wn_ih_53_6 0 0.36370941163747206
Vwp_ih_54_6 wp_ih_54_6 0 0.36018558269762857
Vwn_ih_54_6 wn_ih_54_6 0 0.6398144173023714
Vwp_ih_55_6 wp_ih_55_6 0 0.39100818688334527
Vwn_ih_55_6 wn_ih_55_6 0 0.6089918131166547
Vwp_ih_56_6 wp_ih_56_6 0 0.5539732518051715
Vwn_ih_56_6 wn_ih_56_6 0 0.44602674819482846
Vwp_ih_57_6 wp_ih_57_6 0 0.3
Vwn_ih_57_6 wn_ih_57_6 0 0.8836814470020353
Vwp_ih_58_6 wp_ih_58_6 0 0.36887856104212324
Vwn_ih_58_6 wn_ih_58_6 0 0.6311214389578768
Vwp_ih_59_6 wp_ih_59_6 0 0.5954580898930484
Vwn_ih_59_6 wn_ih_59_6 0 0.4045419101069517
Vwp_ih_60_6 wp_ih_60_6 0 0.4295912100616285
Vwn_ih_60_6 wn_ih_60_6 0 0.5704087899383715
Vwp_ih_61_6 wp_ih_61_6 0 0.30482202407707343
Vwn_ih_61_6 wn_ih_61_6 0 0.6951779759229266
Vwp_ih_62_6 wp_ih_62_6 0 0.7310679990115168
Vwn_ih_62_6 wn_ih_62_6 0 0.3
Vwp_ih_63_6 wp_ih_63_6 0 0.3307357811272078
Vwn_ih_63_6 wn_ih_63_6 0 0.6692642188727922
Vwp_ho_6_0 wp_ho_6_0 0 0.6573518505060842
Vwn_ho_6_0 wn_ho_6_0 0 0.34264814949391575
Vwp_ho_6_1 wp_ho_6_1 0 0.5593399676849988
Vwn_ho_6_1 wn_ho_6_1 0 0.4406600323150012
Vwp_ho_6_2 wp_ho_6_2 0 0.3697768204528967
Vwn_ho_6_2 wn_ho_6_2 0 0.6302231795471033
Vwp_ho_6_3 wp_ho_6_3 0 0.4239367762646491
Vwn_ho_6_3 wn_ho_6_3 0 0.5760632237353509
Vwp_ho_6_4 wp_ho_6_4 0 0.6022485833946851
Vwn_ho_6_4 wn_ho_6_4 0 0.3977514166053149
Vwp_ih_0_7 wp_ih_0_7 0 0.4371961343648113
Vwn_ih_0_7 wn_ih_0_7 0 0.5628038656351887
Vwp_ih_1_7 wp_ih_1_7 0 0.45527222008511653
Vwn_ih_1_7 wn_ih_1_7 0 0.5447277799148834
Vwp_ih_2_7 wp_ih_2_7 0 0.5099773272773241
Vwn_ih_2_7 wn_ih_2_7 0 0.49002267272267586
Vwp_ih_3_7 wp_ih_3_7 0 0.4556593757715262
Vwn_ih_3_7 wn_ih_3_7 0 0.5443406242284738
Vwp_ih_4_7 wp_ih_4_7 0 0.49028419057194683
Vwn_ih_4_7 wn_ih_4_7 0 0.5097158094280532
Vwp_ih_5_7 wp_ih_5_7 0 0.5068993494891092
Vwn_ih_5_7 wn_ih_5_7 0 0.4931006505108908
Vwp_ih_6_7 wp_ih_6_7 0 0.4895988285480293
Vwn_ih_6_7 wn_ih_6_7 0 0.5104011714519707
Vwp_ih_7_7 wp_ih_7_7 0 0.511192860883189
Vwn_ih_7_7 wn_ih_7_7 0 0.488807139116811
Vwp_ih_8_7 wp_ih_8_7 0 0.3
Vwn_ih_8_7 wn_ih_8_7 0 0.7854710825379632
Vwp_ih_9_7 wp_ih_9_7 0 0.5529277637321076
Vwn_ih_9_7 wn_ih_9_7 0 0.4470722362678924
Vwp_ih_10_7 wp_ih_10_7 0 0.3314651962422756
Vwn_ih_10_7 wn_ih_10_7 0 0.6685348037577243
Vwp_ih_11_7 wp_ih_11_7 0 0.3
Vwn_ih_11_7 wn_ih_11_7 0 0.7599974613474874
Vwp_ih_12_7 wp_ih_12_7 0 0.6657617487789448
Vwn_ih_12_7 wn_ih_12_7 0 0.3342382512210552
Vwp_ih_13_7 wp_ih_13_7 0 0.34573816649610734
Vwn_ih_13_7 wn_ih_13_7 0 0.6542618335038927
Vwp_ih_14_7 wp_ih_14_7 0 0.5215842927145051
Vwn_ih_14_7 wn_ih_14_7 0 0.47841570728549493
Vwp_ih_15_7 wp_ih_15_7 0 0.4072926215522146
Vwn_ih_15_7 wn_ih_15_7 0 0.5927073784477854
Vwp_ih_16_7 wp_ih_16_7 0 0.41858405409554633
Vwn_ih_16_7 wn_ih_16_7 0 0.5814159459044537
Vwp_ih_17_7 wp_ih_17_7 0 0.558038572229859
Vwn_ih_17_7 wn_ih_17_7 0 0.44196142777014097
Vwp_ih_18_7 wp_ih_18_7 0 0.37421300489701903
Vwn_ih_18_7 wn_ih_18_7 0 0.625786995102981
Vwp_ih_19_7 wp_ih_19_7 0 0.5447209130497979
Vwn_ih_19_7 wn_ih_19_7 0 0.45527908695020214
Vwp_ih_20_7 wp_ih_20_7 0 0.5456830971491611
Vwn_ih_20_7 wn_ih_20_7 0 0.4543169028508389
Vwp_ih_21_7 wp_ih_21_7 0 0.6397337496723376
Vwn_ih_21_7 wn_ih_21_7 0 0.36026625032766235
Vwp_ih_22_7 wp_ih_22_7 0 0.45965441354035386
Vwn_ih_22_7 wn_ih_22_7 0 0.5403455864596461
Vwp_ih_23_7 wp_ih_23_7 0 0.6255898704037053
Vwn_ih_23_7 wn_ih_23_7 0 0.3744101295962947
Vwp_ih_24_7 wp_ih_24_7 0 0.7064833648090478
Vwn_ih_24_7 wn_ih_24_7 0 0.3
Vwp_ih_25_7 wp_ih_25_7 0 0.6904018735304558
Vwn_ih_25_7 wn_ih_25_7 0 0.30959812646954415
Vwp_ih_26_7 wp_ih_26_7 0 0.5703292348149673
Vwn_ih_26_7 wn_ih_26_7 0 0.4296707651850326
Vwp_ih_27_7 wp_ih_27_7 0 0.5538999286314805
Vwn_ih_27_7 wn_ih_27_7 0 0.4461000713685195
Vwp_ih_28_7 wp_ih_28_7 0 0.8419345952871129
Vwn_ih_28_7 wn_ih_28_7 0 0.3
Vwp_ih_29_7 wp_ih_29_7 0 0.7678611150557068
Vwn_ih_29_7 wn_ih_29_7 0 0.3
Vwp_ih_30_7 wp_ih_30_7 0 0.4080059259069471
Vwn_ih_30_7 wn_ih_30_7 0 0.5919940740930529
Vwp_ih_31_7 wp_ih_31_7 0 0.6108330843533947
Vwn_ih_31_7 wn_ih_31_7 0 0.38916691564660527
Vwp_ih_32_7 wp_ih_32_7 0 0.5722351078476282
Vwn_ih_32_7 wn_ih_32_7 0 0.42776489215237185
Vwp_ih_33_7 wp_ih_33_7 0 0.5086720953797985
Vwn_ih_33_7 wn_ih_33_7 0 0.4913279046202015
Vwp_ih_34_7 wp_ih_34_7 0 0.5183974757746581
Vwn_ih_34_7 wn_ih_34_7 0 0.4816025242253419
Vwp_ih_35_7 wp_ih_35_7 0 0.5585342134954776
Vwn_ih_35_7 wn_ih_35_7 0 0.44146578650452234
Vwp_ih_36_7 wp_ih_36_7 0 0.6124830172795519
Vwn_ih_36_7 wn_ih_36_7 0 0.3875169827204481
Vwp_ih_37_7 wp_ih_37_7 0 0.5262523833981961
Vwn_ih_37_7 wn_ih_37_7 0 0.47374761660180387
Vwp_ih_38_7 wp_ih_38_7 0 0.5407752457471721
Vwn_ih_38_7 wn_ih_38_7 0 0.45922475425282794
Vwp_ih_39_7 wp_ih_39_7 0 0.6670568376971169
Vwn_ih_39_7 wn_ih_39_7 0 0.33294316230288307
Vwp_ih_40_7 wp_ih_40_7 0 0.5381264292112843
Vwn_ih_40_7 wn_ih_40_7 0 0.46187357078871577
Vwp_ih_41_7 wp_ih_41_7 0 0.5654026978055697
Vwn_ih_41_7 wn_ih_41_7 0 0.4345973021944302
Vwp_ih_42_7 wp_ih_42_7 0 0.6188276115895321
Vwn_ih_42_7 wn_ih_42_7 0 0.38117238841046786
Vwp_ih_43_7 wp_ih_43_7 0 0.6959914899270107
Vwn_ih_43_7 wn_ih_43_7 0 0.30400851007298935
Vwp_ih_44_7 wp_ih_44_7 0 0.6472449115040477
Vwn_ih_44_7 wn_ih_44_7 0 0.35275508849595233
Vwp_ih_45_7 wp_ih_45_7 0 0.5452657943392272
Vwn_ih_45_7 wn_ih_45_7 0 0.4547342056607729
Vwp_ih_46_7 wp_ih_46_7 0 0.5249378544771277
Vwn_ih_46_7 wn_ih_46_7 0 0.47506214552287235
Vwp_ih_47_7 wp_ih_47_7 0 0.35316757065783033
Vwn_ih_47_7 wn_ih_47_7 0 0.6468324293421697
Vwp_ih_48_7 wp_ih_48_7 0 0.5350475052924262
Vwn_ih_48_7 wn_ih_48_7 0 0.4649524947075738
Vwp_ih_49_7 wp_ih_49_7 0 0.37553962880650127
Vwn_ih_49_7 wn_ih_49_7 0 0.6244603711934987
Vwp_ih_50_7 wp_ih_50_7 0 0.37711526701810905
Vwn_ih_50_7 wn_ih_50_7 0 0.622884732981891
Vwp_ih_51_7 wp_ih_51_7 0 0.5780610712962861
Vwn_ih_51_7 wn_ih_51_7 0 0.42193892870371386
Vwp_ih_52_7 wp_ih_52_7 0 0.48793073797090947
Vwn_ih_52_7 wn_ih_52_7 0 0.5120692620290905
Vwp_ih_53_7 wp_ih_53_7 0 0.5566651395235243
Vwn_ih_53_7 wn_ih_53_7 0 0.4433348604764758
Vwp_ih_54_7 wp_ih_54_7 0 0.42476442591464014
Vwn_ih_54_7 wn_ih_54_7 0 0.5752355740853599
Vwp_ih_55_7 wp_ih_55_7 0 0.6441444808971395
Vwn_ih_55_7 wn_ih_55_7 0 0.35585551910286045
Vwp_ih_56_7 wp_ih_56_7 0 0.5172526616067481
Vwn_ih_56_7 wn_ih_56_7 0 0.48274733839325185
Vwp_ih_57_7 wp_ih_57_7 0 0.6425273992440342
Vwn_ih_57_7 wn_ih_57_7 0 0.35747260075596576
Vwp_ih_58_7 wp_ih_58_7 0 0.5808128588218191
Vwn_ih_58_7 wn_ih_58_7 0 0.4191871411781809
Vwp_ih_59_7 wp_ih_59_7 0 0.5198298846318394
Vwn_ih_59_7 wn_ih_59_7 0 0.48017011536816057
Vwp_ih_60_7 wp_ih_60_7 0 0.44257671066671345
Vwn_ih_60_7 wn_ih_60_7 0 0.5574232893332866
Vwp_ih_61_7 wp_ih_61_7 0 0.5037809093178637
Vwn_ih_61_7 wn_ih_61_7 0 0.4962190906821363
Vwp_ih_62_7 wp_ih_62_7 0 0.5993612582583945
Vwn_ih_62_7 wn_ih_62_7 0 0.4006387417416055
Vwp_ih_63_7 wp_ih_63_7 0 0.5837189280984751
Vwn_ih_63_7 wn_ih_63_7 0 0.41628107190152486
Vwp_ho_7_0 wp_ho_7_0 0 0.4894018368845584
Vwn_ho_7_0 wn_ho_7_0 0 0.5105981631154416
Vwp_ho_7_1 wp_ho_7_1 0 0.6742969924072109
Vwn_ho_7_1 wn_ho_7_1 0 0.3257030075927892
Vwp_ho_7_2 wp_ho_7_2 0 0.5207996499630179
Vwn_ho_7_2 wn_ho_7_2 0 0.4792003500369821
Vwp_ho_7_3 wp_ho_7_3 0 0.5355654846089518
Vwn_ho_7_3 wn_ho_7_3 0 0.4644345153910482
Vwp_ho_7_4 wp_ho_7_4 0 0.518518449891379
Vwn_ho_7_4 wn_ho_7_4 0 0.481481550108621
Vwp_ih_0_8 wp_ih_0_8 0 0.35652984169955093
Vwn_ih_0_8 wn_ih_0_8 0 0.6434701583004491
Vwp_ih_1_8 wp_ih_1_8 0 0.6230818463295135
Vwn_ih_1_8 wn_ih_1_8 0 0.37691815367048653
Vwp_ih_2_8 wp_ih_2_8 0 0.474331047022987
Vwn_ih_2_8 wn_ih_2_8 0 0.525668952977013
Vwp_ih_3_8 wp_ih_3_8 0 0.5978316465204653
Vwn_ih_3_8 wn_ih_3_8 0 0.4021683534795347
Vwp_ih_4_8 wp_ih_4_8 0 0.4163014086307326
Vwn_ih_4_8 wn_ih_4_8 0 0.5836985913692674
Vwp_ih_5_8 wp_ih_5_8 0 0.576542634518789
Vwn_ih_5_8 wn_ih_5_8 0 0.423457365481211
Vwp_ih_6_8 wp_ih_6_8 0 0.40440897406085574
Vwn_ih_6_8 wn_ih_6_8 0 0.5955910259391443
Vwp_ih_7_8 wp_ih_7_8 0 0.5155228197991082
Vwn_ih_7_8 wn_ih_7_8 0 0.4844771802008918
Vwp_ih_8_8 wp_ih_8_8 0 0.46423642319364206
Vwn_ih_8_8 wn_ih_8_8 0 0.535763576806358
Vwp_ih_9_8 wp_ih_9_8 0 0.46573129197687096
Vwn_ih_9_8 wn_ih_9_8 0 0.534268708023129
Vwp_ih_10_8 wp_ih_10_8 0 0.4320095307690912
Vwn_ih_10_8 wn_ih_10_8 0 0.5679904692309088
Vwp_ih_11_8 wp_ih_11_8 0 0.4815705084499389
Vwn_ih_11_8 wn_ih_11_8 0 0.5184294915500611
Vwp_ih_12_8 wp_ih_12_8 0 0.3
Vwn_ih_12_8 wn_ih_12_8 0 0.708876162820099
Vwp_ih_13_8 wp_ih_13_8 0 0.6051919632081703
Vwn_ih_13_8 wn_ih_13_8 0 0.3948080367918297
Vwp_ih_14_8 wp_ih_14_8 0 0.6154023904506065
Vwn_ih_14_8 wn_ih_14_8 0 0.3845976095493935
Vwp_ih_15_8 wp_ih_15_8 0 0.44686713525836214
Vwn_ih_15_8 wn_ih_15_8 0 0.5531328647416379
Vwp_ih_16_8 wp_ih_16_8 0 0.334429444891048
Vwn_ih_16_8 wn_ih_16_8 0 0.665570555108952
Vwp_ih_17_8 wp_ih_17_8 0 0.42239488762156685
Vwn_ih_17_8 wn_ih_17_8 0 0.5776051123784331
Vwp_ih_18_8 wp_ih_18_8 0 0.6137137195637451
Vwn_ih_18_8 wn_ih_18_8 0 0.3862862804362549
Vwp_ih_19_8 wp_ih_19_8 0 0.5750624928058129
Vwn_ih_19_8 wn_ih_19_8 0 0.4249375071941871
Vwp_ih_20_8 wp_ih_20_8 0 0.463957572689747
Vwn_ih_20_8 wn_ih_20_8 0 0.536042427310253
Vwp_ih_21_8 wp_ih_21_8 0 0.6076729736168701
Vwn_ih_21_8 wn_ih_21_8 0 0.39232702638312994
Vwp_ih_22_8 wp_ih_22_8 0 0.37502230924009766
Vwn_ih_22_8 wn_ih_22_8 0 0.6249776907599023
Vwp_ih_23_8 wp_ih_23_8 0 0.42648364026908103
Vwn_ih_23_8 wn_ih_23_8 0 0.573516359730919
Vwp_ih_24_8 wp_ih_24_8 0 0.5569528696020187
Vwn_ih_24_8 wn_ih_24_8 0 0.44304713039798127
Vwp_ih_25_8 wp_ih_25_8 0 0.488490400435465
Vwn_ih_25_8 wn_ih_25_8 0 0.511509599564535
Vwp_ih_26_8 wp_ih_26_8 0 0.42929291610137554
Vwn_ih_26_8 wn_ih_26_8 0 0.5707070838986245
Vwp_ih_27_8 wp_ih_27_8 0 0.3
Vwn_ih_27_8 wn_ih_27_8 0 0.8014553276613683
Vwp_ih_28_8 wp_ih_28_8 0 0.580545960153442
Vwn_ih_28_8 wn_ih_28_8 0 0.4194540398465581
Vwp_ih_29_8 wp_ih_29_8 0 0.5388466176076775
Vwn_ih_29_8 wn_ih_29_8 0 0.4611533823923225
Vwp_ih_30_8 wp_ih_30_8 0 0.3
Vwn_ih_30_8 wn_ih_30_8 0 0.7091506794261704
Vwp_ih_31_8 wp_ih_31_8 0 0.5720390823330233
Vwn_ih_31_8 wn_ih_31_8 0 0.4279609176669767
Vwp_ih_32_8 wp_ih_32_8 0 0.4982763489489696
Vwn_ih_32_8 wn_ih_32_8 0 0.5017236510510305
Vwp_ih_33_8 wp_ih_33_8 0 0.5334601732849179
Vwn_ih_33_8 wn_ih_33_8 0 0.46653982671508215
Vwp_ih_34_8 wp_ih_34_8 0 0.6134231847891201
Vwn_ih_34_8 wn_ih_34_8 0 0.38657681521088
Vwp_ih_35_8 wp_ih_35_8 0 0.4112135834060807
Vwn_ih_35_8 wn_ih_35_8 0 0.5887864165939193
Vwp_ih_36_8 wp_ih_36_8 0 0.585627705708696
Vwn_ih_36_8 wn_ih_36_8 0 0.41437229429130396
Vwp_ih_37_8 wp_ih_37_8 0 0.582062498238014
Vwn_ih_37_8 wn_ih_37_8 0 0.417937501761986
Vwp_ih_38_8 wp_ih_38_8 0 0.5913818887112213
Vwn_ih_38_8 wn_ih_38_8 0 0.4086181112887787
Vwp_ih_39_8 wp_ih_39_8 0 0.6963146933967408
Vwn_ih_39_8 wn_ih_39_8 0 0.30368530660325926
Vwp_ih_40_8 wp_ih_40_8 0 0.5790481811305636
Vwn_ih_40_8 wn_ih_40_8 0 0.4209518188694364
Vwp_ih_41_8 wp_ih_41_8 0 0.43261307475929756
Vwn_ih_41_8 wn_ih_41_8 0 0.5673869252407024
Vwp_ih_42_8 wp_ih_42_8 0 0.7158061304166258
Vwn_ih_42_8 wn_ih_42_8 0 0.3
Vwp_ih_43_8 wp_ih_43_8 0 0.3671224945274263
Vwn_ih_43_8 wn_ih_43_8 0 0.6328775054725737
Vwp_ih_44_8 wp_ih_44_8 0 0.44447316867703834
Vwn_ih_44_8 wn_ih_44_8 0 0.5555268313229617
Vwp_ih_45_8 wp_ih_45_8 0 0.38426363467947283
Vwn_ih_45_8 wn_ih_45_8 0 0.6157363653205272
Vwp_ih_46_8 wp_ih_46_8 0 0.4876687040549782
Vwn_ih_46_8 wn_ih_46_8 0 0.5123312959450218
Vwp_ih_47_8 wp_ih_47_8 0 0.6298663139852426
Vwn_ih_47_8 wn_ih_47_8 0 0.3701336860147574
Vwp_ih_48_8 wp_ih_48_8 0 0.6557343148208702
Vwn_ih_48_8 wn_ih_48_8 0 0.3442656851791298
Vwp_ih_49_8 wp_ih_49_8 0 0.5556220898964684
Vwn_ih_49_8 wn_ih_49_8 0 0.4443779101035316
Vwp_ih_50_8 wp_ih_50_8 0 0.4268730723702503
Vwn_ih_50_8 wn_ih_50_8 0 0.5731269276297497
Vwp_ih_51_8 wp_ih_51_8 0 0.43356552822193584
Vwn_ih_51_8 wn_ih_51_8 0 0.5664344717780642
Vwp_ih_52_8 wp_ih_52_8 0 0.4276164636010922
Vwn_ih_52_8 wn_ih_52_8 0 0.5723835363989078
Vwp_ih_53_8 wp_ih_53_8 0 0.6143408818788426
Vwn_ih_53_8 wn_ih_53_8 0 0.3856591181211574
Vwp_ih_54_8 wp_ih_54_8 0 0.3912152809267621
Vwn_ih_54_8 wn_ih_54_8 0 0.6087847190732378
Vwp_ih_55_8 wp_ih_55_8 0 0.6037431530494619
Vwn_ih_55_8 wn_ih_55_8 0 0.3962568469505381
Vwp_ih_56_8 wp_ih_56_8 0 0.49608871140508937
Vwn_ih_56_8 wn_ih_56_8 0 0.5039112885949106
Vwp_ih_57_8 wp_ih_57_8 0 0.5206461286942317
Vwn_ih_57_8 wn_ih_57_8 0 0.47935387130576834
Vwp_ih_58_8 wp_ih_58_8 0 0.6814062060680807
Vwn_ih_58_8 wn_ih_58_8 0 0.31859379393191933
Vwp_ih_59_8 wp_ih_59_8 0 0.4429599183131212
Vwn_ih_59_8 wn_ih_59_8 0 0.5570400816868788
Vwp_ih_60_8 wp_ih_60_8 0 0.6994074315376873
Vwn_ih_60_8 wn_ih_60_8 0 0.30059256846231275
Vwp_ih_61_8 wp_ih_61_8 0 0.3308656808751595
Vwn_ih_61_8 wn_ih_61_8 0 0.6691343191248404
Vwp_ih_62_8 wp_ih_62_8 0 0.40102835672761966
Vwn_ih_62_8 wn_ih_62_8 0 0.5989716432723804
Vwp_ih_63_8 wp_ih_63_8 0 0.3105930316278036
Vwn_ih_63_8 wn_ih_63_8 0 0.6894069683721964
Vwp_ho_8_0 wp_ho_8_0 0 0.3150237634908587
Vwn_ho_8_0 wn_ho_8_0 0 0.6849762365091413
Vwp_ho_8_1 wp_ho_8_1 0 0.5802349563912181
Vwn_ho_8_1 wn_ho_8_1 0 0.41976504360878186
Vwp_ho_8_2 wp_ho_8_2 0 0.49149074765526335
Vwn_ho_8_2 wn_ho_8_2 0 0.5085092523447367
Vwp_ho_8_3 wp_ho_8_3 0 0.4690892619032485
Vwn_ho_8_3 wn_ho_8_3 0 0.5309107380967515
Vwp_ho_8_4 wp_ho_8_4 0 0.388550685717732
Vwn_ho_8_4 wn_ho_8_4 0 0.611449314282268
Vwp_ih_0_9 wp_ih_0_9 0 0.4103861739140136
Vwn_ih_0_9 wn_ih_0_9 0 0.5896138260859864
Vwp_ih_1_9 wp_ih_1_9 0 0.5699458516654068
Vwn_ih_1_9 wn_ih_1_9 0 0.4300541483345932
Vwp_ih_2_9 wp_ih_2_9 0 0.5885274877956358
Vwn_ih_2_9 wn_ih_2_9 0 0.41147251220436426
Vwp_ih_3_9 wp_ih_3_9 0 0.5368130364168788
Vwn_ih_3_9 wn_ih_3_9 0 0.46318696358312117
Vwp_ih_4_9 wp_ih_4_9 0 0.5320510353998419
Vwn_ih_4_9 wn_ih_4_9 0 0.4679489646001581
Vwp_ih_5_9 wp_ih_5_9 0 0.35920076279510343
Vwn_ih_5_9 wn_ih_5_9 0 0.6407992372048965
Vwp_ih_6_9 wp_ih_6_9 0 0.3407801800488477
Vwn_ih_6_9 wn_ih_6_9 0 0.6592198199511523
Vwp_ih_7_9 wp_ih_7_9 0 0.5364668008984399
Vwn_ih_7_9 wn_ih_7_9 0 0.46353319910156016
Vwp_ih_8_9 wp_ih_8_9 0 0.6617368372767196
Vwn_ih_8_9 wn_ih_8_9 0 0.3382631627232804
Vwp_ih_9_9 wp_ih_9_9 0 0.45630382875623343
Vwn_ih_9_9 wn_ih_9_9 0 0.5436961712437666
Vwp_ih_10_9 wp_ih_10_9 0 0.3477728460091624
Vwn_ih_10_9 wn_ih_10_9 0 0.6522271539908375
Vwp_ih_11_9 wp_ih_11_9 0 0.31600634267002065
Vwn_ih_11_9 wn_ih_11_9 0 0.6839936573299794
Vwp_ih_12_9 wp_ih_12_9 0 0.4183217942463277
Vwn_ih_12_9 wn_ih_12_9 0 0.5816782057536722
Vwp_ih_13_9 wp_ih_13_9 0 0.6895452586602884
Vwn_ih_13_9 wn_ih_13_9 0 0.3104547413397117
Vwp_ih_14_9 wp_ih_14_9 0 0.4750712554961106
Vwn_ih_14_9 wn_ih_14_9 0 0.5249287445038894
Vwp_ih_15_9 wp_ih_15_9 0 0.3754467951132262
Vwn_ih_15_9 wn_ih_15_9 0 0.6245532048867738
Vwp_ih_16_9 wp_ih_16_9 0 0.4268634987002684
Vwn_ih_16_9 wn_ih_16_9 0 0.5731365012997316
Vwp_ih_17_9 wp_ih_17_9 0 0.4419746034436217
Vwn_ih_17_9 wn_ih_17_9 0 0.5580253965563783
Vwp_ih_18_9 wp_ih_18_9 0 0.5318736098266045
Vwn_ih_18_9 wn_ih_18_9 0 0.4681263901733955
Vwp_ih_19_9 wp_ih_19_9 0 0.42079802557093704
Vwn_ih_19_9 wn_ih_19_9 0 0.579201974429063
Vwp_ih_20_9 wp_ih_20_9 0 0.3932072510394596
Vwn_ih_20_9 wn_ih_20_9 0 0.6067927489605404
Vwp_ih_21_9 wp_ih_21_9 0 0.4774379618548428
Vwn_ih_21_9 wn_ih_21_9 0 0.5225620381451572
Vwp_ih_22_9 wp_ih_22_9 0 0.5562404389515467
Vwn_ih_22_9 wn_ih_22_9 0 0.4437595610484533
Vwp_ih_23_9 wp_ih_23_9 0 0.586045252151462
Vwn_ih_23_9 wn_ih_23_9 0 0.413954747848538
Vwp_ih_24_9 wp_ih_24_9 0 0.5660638419520636
Vwn_ih_24_9 wn_ih_24_9 0 0.43393615804793634
Vwp_ih_25_9 wp_ih_25_9 0 0.445100368439524
Vwn_ih_25_9 wn_ih_25_9 0 0.554899631560476
Vwp_ih_26_9 wp_ih_26_9 0 0.3
Vwn_ih_26_9 wn_ih_26_9 0 0.7034092421632154
Vwp_ih_27_9 wp_ih_27_9 0 0.40417806285476154
Vwn_ih_27_9 wn_ih_27_9 0 0.5958219371452385
Vwp_ih_28_9 wp_ih_28_9 0 0.5340897671931262
Vwn_ih_28_9 wn_ih_28_9 0 0.4659102328068738
Vwp_ih_29_9 wp_ih_29_9 0 0.3399637657388103
Vwn_ih_29_9 wn_ih_29_9 0 0.6600362342611896
Vwp_ih_30_9 wp_ih_30_9 0 0.5303143067579373
Vwn_ih_30_9 wn_ih_30_9 0 0.46968569324206266
Vwp_ih_31_9 wp_ih_31_9 0 0.4292028860987188
Vwn_ih_31_9 wn_ih_31_9 0 0.5707971139012812
Vwp_ih_32_9 wp_ih_32_9 0 0.43014032557963
Vwn_ih_32_9 wn_ih_32_9 0 0.56985967442037
Vwp_ih_33_9 wp_ih_33_9 0 0.6343408409626627
Vwn_ih_33_9 wn_ih_33_9 0 0.3656591590373373
Vwp_ih_34_9 wp_ih_34_9 0 0.5262479155854292
Vwn_ih_34_9 wn_ih_34_9 0 0.47375208441457084
Vwp_ih_35_9 wp_ih_35_9 0 0.6644307407391774
Vwn_ih_35_9 wn_ih_35_9 0 0.3355692592608226
Vwp_ih_36_9 wp_ih_36_9 0 0.3872896414444744
Vwn_ih_36_9 wn_ih_36_9 0 0.6127103585555256
Vwp_ih_37_9 wp_ih_37_9 0 0.6356889430557016
Vwn_ih_37_9 wn_ih_37_9 0 0.36431105694429844
Vwp_ih_38_9 wp_ih_38_9 0 0.6090896492290534
Vwn_ih_38_9 wn_ih_38_9 0 0.39091035077094666
Vwp_ih_39_9 wp_ih_39_9 0 0.3
Vwn_ih_39_9 wn_ih_39_9 0 0.8594003335837674
Vwp_ih_40_9 wp_ih_40_9 0 0.48940751458765464
Vwn_ih_40_9 wn_ih_40_9 0 0.5105924854123454
Vwp_ih_41_9 wp_ih_41_9 0 0.6850669290708314
Vwn_ih_41_9 wn_ih_41_9 0 0.31493307092916856
Vwp_ih_42_9 wp_ih_42_9 0 0.5933668857401595
Vwn_ih_42_9 wn_ih_42_9 0 0.4066331142598405
Vwp_ih_43_9 wp_ih_43_9 0 0.4470414612118455
Vwn_ih_43_9 wn_ih_43_9 0 0.5529585387881545
Vwp_ih_44_9 wp_ih_44_9 0 0.4720651531193811
Vwn_ih_44_9 wn_ih_44_9 0 0.527934846880619
Vwp_ih_45_9 wp_ih_45_9 0 0.3436341462515362
Vwn_ih_45_9 wn_ih_45_9 0 0.6563658537484638
Vwp_ih_46_9 wp_ih_46_9 0 0.5247550988072274
Vwn_ih_46_9 wn_ih_46_9 0 0.47524490119277263
Vwp_ih_47_9 wp_ih_47_9 0 0.3
Vwn_ih_47_9 wn_ih_47_9 0 0.7151806497470542
Vwp_ih_48_9 wp_ih_48_9 0 0.3781631907216617
Vwn_ih_48_9 wn_ih_48_9 0 0.6218368092783383
Vwp_ih_49_9 wp_ih_49_9 0 0.6342997232558578
Vwn_ih_49_9 wn_ih_49_9 0 0.3657002767441422
Vwp_ih_50_9 wp_ih_50_9 0 0.4975321947349612
Vwn_ih_50_9 wn_ih_50_9 0 0.5024678052650388
Vwp_ih_51_9 wp_ih_51_9 0 0.4563888741344293
Vwn_ih_51_9 wn_ih_51_9 0 0.5436111258655707
Vwp_ih_52_9 wp_ih_52_9 0 0.48729066523382675
Vwn_ih_52_9 wn_ih_52_9 0 0.5127093347661732
Vwp_ih_53_9 wp_ih_53_9 0 0.8290272814984643
Vwn_ih_53_9 wn_ih_53_9 0 0.3
Vwp_ih_54_9 wp_ih_54_9 0 0.6242225588909821
Vwn_ih_54_9 wn_ih_54_9 0 0.37577744110901795
Vwp_ih_55_9 wp_ih_55_9 0 0.40692303504852567
Vwn_ih_55_9 wn_ih_55_9 0 0.5930769649514743
Vwp_ih_56_9 wp_ih_56_9 0 0.7000099700588425
Vwn_ih_56_9 wn_ih_56_9 0 0.3
Vwp_ih_57_9 wp_ih_57_9 0 0.4893446074509734
Vwn_ih_57_9 wn_ih_57_9 0 0.5106553925490266
Vwp_ih_58_9 wp_ih_58_9 0 0.5887660320033157
Vwn_ih_58_9 wn_ih_58_9 0 0.4112339679966844
Vwp_ih_59_9 wp_ih_59_9 0 0.4296043456680029
Vwn_ih_59_9 wn_ih_59_9 0 0.5703956543319971
Vwp_ih_60_9 wp_ih_60_9 0 0.3874572814018389
Vwn_ih_60_9 wn_ih_60_9 0 0.6125427185981611
Vwp_ih_61_9 wp_ih_61_9 0 0.596229519350692
Vwn_ih_61_9 wn_ih_61_9 0 0.40377048064930804
Vwp_ih_62_9 wp_ih_62_9 0 0.40773359007602283
Vwn_ih_62_9 wn_ih_62_9 0 0.5922664099239772
Vwp_ih_63_9 wp_ih_63_9 0 0.40624182614022214
Vwn_ih_63_9 wn_ih_63_9 0 0.5937581738597779
Vwp_ho_9_0 wp_ho_9_0 0 0.6715567811926291
Vwn_ho_9_0 wn_ho_9_0 0 0.32844321880737093
Vwp_ho_9_1 wp_ho_9_1 0 0.5701475308203366
Vwn_ho_9_1 wn_ho_9_1 0 0.4298524691796633
Vwp_ho_9_2 wp_ho_9_2 0 0.563268274690747
Vwn_ho_9_2 wn_ho_9_2 0 0.4367317253092529
Vwp_ho_9_3 wp_ho_9_3 0 0.33593926230734195
Vwn_ho_9_3 wn_ho_9_3 0 0.664060737692658
Vwp_ho_9_4 wp_ho_9_4 0 0.3651222990120978
Vwn_ho_9_4 wn_ho_9_4 0 0.6348777009879022
Vwp_ih_0_10 wp_ih_0_10 0 0.6077401158991046
Vwn_ih_0_10 wn_ih_0_10 0 0.3922598841008954
Vwp_ih_1_10 wp_ih_1_10 0 0.3605517164366473
Vwn_ih_1_10 wn_ih_1_10 0 0.6394482835633527
Vwp_ih_2_10 wp_ih_2_10 0 0.32968975979027043
Vwn_ih_2_10 wn_ih_2_10 0 0.6703102402097296
Vwp_ih_3_10 wp_ih_3_10 0 0.5654065275619995
Vwn_ih_3_10 wn_ih_3_10 0 0.43459347243800056
Vwp_ih_4_10 wp_ih_4_10 0 0.3
Vwn_ih_4_10 wn_ih_4_10 0 0.7351857949631375
Vwp_ih_5_10 wp_ih_5_10 0 0.40979292119984456
Vwn_ih_5_10 wn_ih_5_10 0 0.5902070788001554
Vwp_ih_6_10 wp_ih_6_10 0 0.4561224665599365
Vwn_ih_6_10 wn_ih_6_10 0 0.5438775334400635
Vwp_ih_7_10 wp_ih_7_10 0 0.3385631612075546
Vwn_ih_7_10 wn_ih_7_10 0 0.6614368387924454
Vwp_ih_8_10 wp_ih_8_10 0 0.3659131374313518
Vwn_ih_8_10 wn_ih_8_10 0 0.6340868625686482
Vwp_ih_9_10 wp_ih_9_10 0 0.579904751412194
Vwn_ih_9_10 wn_ih_9_10 0 0.42009524858780595
Vwp_ih_10_10 wp_ih_10_10 0 0.5350943679346474
Vwn_ih_10_10 wn_ih_10_10 0 0.4649056320653527
Vwp_ih_11_10 wp_ih_11_10 0 0.3865146238039582
Vwn_ih_11_10 wn_ih_11_10 0 0.6134853761960418
Vwp_ih_12_10 wp_ih_12_10 0 0.5635382679242109
Vwn_ih_12_10 wn_ih_12_10 0 0.43646173207578903
Vwp_ih_13_10 wp_ih_13_10 0 0.6823134129212799
Vwn_ih_13_10 wn_ih_13_10 0 0.3176865870787201
Vwp_ih_14_10 wp_ih_14_10 0 0.3461098628079272
Vwn_ih_14_10 wn_ih_14_10 0 0.6538901371920728
Vwp_ih_15_10 wp_ih_15_10 0 0.5073506953810482
Vwn_ih_15_10 wn_ih_15_10 0 0.49264930461895184
Vwp_ih_16_10 wp_ih_16_10 0 0.7371981617039276
Vwn_ih_16_10 wn_ih_16_10 0 0.3
Vwp_ih_17_10 wp_ih_17_10 0 0.5733391866858103
Vwn_ih_17_10 wn_ih_17_10 0 0.4266608133141897
Vwp_ih_18_10 wp_ih_18_10 0 0.5976062148920828
Vwn_ih_18_10 wn_ih_18_10 0 0.40239378510791723
Vwp_ih_19_10 wp_ih_19_10 0 0.4759816795399815
Vwn_ih_19_10 wn_ih_19_10 0 0.5240183204600185
Vwp_ih_20_10 wp_ih_20_10 0 0.40424434926348585
Vwn_ih_20_10 wn_ih_20_10 0 0.5957556507365142
Vwp_ih_21_10 wp_ih_21_10 0 0.6372046033852834
Vwn_ih_21_10 wn_ih_21_10 0 0.3627953966147166
Vwp_ih_22_10 wp_ih_22_10 0 0.5784469932994438
Vwn_ih_22_10 wn_ih_22_10 0 0.42155300670055623
Vwp_ih_23_10 wp_ih_23_10 0 0.4938172177717756
Vwn_ih_23_10 wn_ih_23_10 0 0.5061827822282244
Vwp_ih_24_10 wp_ih_24_10 0 0.44415971302120033
Vwn_ih_24_10 wn_ih_24_10 0 0.5558402869787996
Vwp_ih_25_10 wp_ih_25_10 0 0.3
Vwn_ih_25_10 wn_ih_25_10 0 0.7097270274102937
Vwp_ih_26_10 wp_ih_26_10 0 0.5187087474942808
Vwn_ih_26_10 wn_ih_26_10 0 0.4812912525057193
Vwp_ih_27_10 wp_ih_27_10 0 0.41699446825235004
Vwn_ih_27_10 wn_ih_27_10 0 0.5830055317476499
Vwp_ih_28_10 wp_ih_28_10 0 0.48417748779427405
Vwn_ih_28_10 wn_ih_28_10 0 0.515822512205726
Vwp_ih_29_10 wp_ih_29_10 0 0.5805170461104101
Vwn_ih_29_10 wn_ih_29_10 0 0.41948295388958984
Vwp_ih_30_10 wp_ih_30_10 0 0.5984003246844329
Vwn_ih_30_10 wn_ih_30_10 0 0.4015996753155671
Vwp_ih_31_10 wp_ih_31_10 0 0.58628011628551
Vwn_ih_31_10 wn_ih_31_10 0 0.41371988371449
Vwp_ih_32_10 wp_ih_32_10 0 0.7706077198646331
Vwn_ih_32_10 wn_ih_32_10 0 0.3
Vwp_ih_33_10 wp_ih_33_10 0 0.639814223501618
Vwn_ih_33_10 wn_ih_33_10 0 0.36018577649838207
Vwp_ih_34_10 wp_ih_34_10 0 0.41047061890727565
Vwn_ih_34_10 wn_ih_34_10 0 0.5895293810927243
Vwp_ih_35_10 wp_ih_35_10 0 0.40180376917431465
Vwn_ih_35_10 wn_ih_35_10 0 0.5981962308256854
Vwp_ih_36_10 wp_ih_36_10 0 0.7793780869506779
Vwn_ih_36_10 wn_ih_36_10 0 0.3
Vwp_ih_37_10 wp_ih_37_10 0 0.4204008610048499
Vwn_ih_37_10 wn_ih_37_10 0 0.57959913899515
Vwp_ih_38_10 wp_ih_38_10 0 0.49470375889602036
Vwn_ih_38_10 wn_ih_38_10 0 0.5052962411039796
Vwp_ih_39_10 wp_ih_39_10 0 0.7093830905307631
Vwn_ih_39_10 wn_ih_39_10 0 0.3
Vwp_ih_40_10 wp_ih_40_10 0 0.7058379049394713
Vwn_ih_40_10 wn_ih_40_10 0 0.3
Vwp_ih_41_10 wp_ih_41_10 0 0.49344415650047896
Vwn_ih_41_10 wn_ih_41_10 0 0.506555843499521
Vwp_ih_42_10 wp_ih_42_10 0 0.5290331697846654
Vwn_ih_42_10 wn_ih_42_10 0 0.47096683021533464
Vwp_ih_43_10 wp_ih_43_10 0 0.3037868837503198
Vwn_ih_43_10 wn_ih_43_10 0 0.6962131162496802
Vwp_ih_44_10 wp_ih_44_10 0 0.3909981559373495
Vwn_ih_44_10 wn_ih_44_10 0 0.6090018440626505
Vwp_ih_45_10 wp_ih_45_10 0 0.4561689043868386
Vwn_ih_45_10 wn_ih_45_10 0 0.5438310956131613
Vwp_ih_46_10 wp_ih_46_10 0 0.49932077966135985
Vwn_ih_46_10 wn_ih_46_10 0 0.5006792203386402
Vwp_ih_47_10 wp_ih_47_10 0 0.4612015428731505
Vwn_ih_47_10 wn_ih_47_10 0 0.5387984571268495
Vwp_ih_48_10 wp_ih_48_10 0 0.5182752777890879
Vwn_ih_48_10 wn_ih_48_10 0 0.48172472221091217
Vwp_ih_49_10 wp_ih_49_10 0 0.7631241816674499
Vwn_ih_49_10 wn_ih_49_10 0 0.3
Vwp_ih_50_10 wp_ih_50_10 0 0.5557209033078835
Vwn_ih_50_10 wn_ih_50_10 0 0.4442790966921165
Vwp_ih_51_10 wp_ih_51_10 0 0.537044862530573
Vwn_ih_51_10 wn_ih_51_10 0 0.46295513746942696
Vwp_ih_52_10 wp_ih_52_10 0 0.50021916270697
Vwn_ih_52_10 wn_ih_52_10 0 0.49978083729303
Vwp_ih_53_10 wp_ih_53_10 0 0.4793710874000272
Vwn_ih_53_10 wn_ih_53_10 0 0.5206289125999728
Vwp_ih_54_10 wp_ih_54_10 0 0.64795335202517
Vwn_ih_54_10 wn_ih_54_10 0 0.35204664797483
Vwp_ih_55_10 wp_ih_55_10 0 0.3810486283141406
Vwn_ih_55_10 wn_ih_55_10 0 0.6189513716858593
Vwp_ih_56_10 wp_ih_56_10 0 0.48493045699207304
Vwn_ih_56_10 wn_ih_56_10 0 0.515069543007927
Vwp_ih_57_10 wp_ih_57_10 0 0.36850673226987013
Vwn_ih_57_10 wn_ih_57_10 0 0.6314932677301299
Vwp_ih_58_10 wp_ih_58_10 0 0.5104555642308073
Vwn_ih_58_10 wn_ih_58_10 0 0.48954443576919277
Vwp_ih_59_10 wp_ih_59_10 0 0.5142860386680355
Vwn_ih_59_10 wn_ih_59_10 0 0.4857139613319645
Vwp_ih_60_10 wp_ih_60_10 0 0.6104607809735682
Vwn_ih_60_10 wn_ih_60_10 0 0.38953921902643185
Vwp_ih_61_10 wp_ih_61_10 0 0.6437193944979784
Vwn_ih_61_10 wn_ih_61_10 0 0.35628060550202156
Vwp_ih_62_10 wp_ih_62_10 0 0.5795677199960191
Vwn_ih_62_10 wn_ih_62_10 0 0.4204322800039809
Vwp_ih_63_10 wp_ih_63_10 0 0.6946711144508427
Vwn_ih_63_10 wn_ih_63_10 0 0.30532888554915727
Vwp_ho_10_0 wp_ho_10_0 0 0.674965240117323
Vwn_ho_10_0 wn_ho_10_0 0 0.32503475988267705
Vwp_ho_10_1 wp_ho_10_1 0 0.5899128654879995
Vwn_ho_10_1 wn_ho_10_1 0 0.41008713451200046
Vwp_ho_10_2 wp_ho_10_2 0 0.569889185877076
Vwn_ho_10_2 wn_ho_10_2 0 0.4301108141229239
Vwp_ho_10_3 wp_ho_10_3 0 0.4968611856172438
Vwn_ho_10_3 wn_ho_10_3 0 0.5031388143827562
Vwp_ho_10_4 wp_ho_10_4 0 0.49231782674632235
Vwn_ho_10_4 wn_ho_10_4 0 0.5076821732536777
Vwp_ih_0_11 wp_ih_0_11 0 0.6906203921567371
Vwn_ih_0_11 wn_ih_0_11 0 0.3093796078432629
Vwp_ih_1_11 wp_ih_1_11 0 0.537843042566616
Vwn_ih_1_11 wn_ih_1_11 0 0.4621569574333841
Vwp_ih_2_11 wp_ih_2_11 0 0.5448016235150399
Vwn_ih_2_11 wn_ih_2_11 0 0.45519837648496003
Vwp_ih_3_11 wp_ih_3_11 0 0.3
Vwn_ih_3_11 wn_ih_3_11 0 0.732353803004216
Vwp_ih_4_11 wp_ih_4_11 0 0.5384291845673066
Vwn_ih_4_11 wn_ih_4_11 0 0.46157081543269346
Vwp_ih_5_11 wp_ih_5_11 0 0.4993890135346587
Vwn_ih_5_11 wn_ih_5_11 0 0.5006109864653413
Vwp_ih_6_11 wp_ih_6_11 0 0.3
Vwn_ih_6_11 wn_ih_6_11 0 0.702619425426019
Vwp_ih_7_11 wp_ih_7_11 0 0.4482336761789842
Vwn_ih_7_11 wn_ih_7_11 0 0.5517663238210158
Vwp_ih_8_11 wp_ih_8_11 0 0.6148908760126499
Vwn_ih_8_11 wn_ih_8_11 0 0.3851091239873501
Vwp_ih_9_11 wp_ih_9_11 0 0.35134708084197963
Vwn_ih_9_11 wn_ih_9_11 0 0.6486529191580204
Vwp_ih_10_11 wp_ih_10_11 0 0.6551541397621651
Vwn_ih_10_11 wn_ih_10_11 0 0.3448458602378349
Vwp_ih_11_11 wp_ih_11_11 0 0.5569759182485574
Vwn_ih_11_11 wn_ih_11_11 0 0.44302408175144253
Vwp_ih_12_11 wp_ih_12_11 0 0.47259342917077474
Vwn_ih_12_11 wn_ih_12_11 0 0.5274065708292253
Vwp_ih_13_11 wp_ih_13_11 0 0.48292072553855364
Vwn_ih_13_11 wn_ih_13_11 0 0.5170792744614463
Vwp_ih_14_11 wp_ih_14_11 0 0.5995912525099458
Vwn_ih_14_11 wn_ih_14_11 0 0.4004087474900542
Vwp_ih_15_11 wp_ih_15_11 0 0.3282326864587236
Vwn_ih_15_11 wn_ih_15_11 0 0.6717673135412764
Vwp_ih_16_11 wp_ih_16_11 0 0.744891432787633
Vwn_ih_16_11 wn_ih_16_11 0 0.3
Vwp_ih_17_11 wp_ih_17_11 0 0.40238965645586267
Vwn_ih_17_11 wn_ih_17_11 0 0.5976103435441373
Vwp_ih_18_11 wp_ih_18_11 0 0.4081660109663493
Vwn_ih_18_11 wn_ih_18_11 0 0.5918339890336507
Vwp_ih_19_11 wp_ih_19_11 0 0.6464921836627141
Vwn_ih_19_11 wn_ih_19_11 0 0.3535078163372859
Vwp_ih_20_11 wp_ih_20_11 0 0.5948062802014075
Vwn_ih_20_11 wn_ih_20_11 0 0.40519371979859253
Vwp_ih_21_11 wp_ih_21_11 0 0.6590470034779773
Vwn_ih_21_11 wn_ih_21_11 0 0.3409529965220227
Vwp_ih_22_11 wp_ih_22_11 0 0.6255177288637376
Vwn_ih_22_11 wn_ih_22_11 0 0.3744822711362624
Vwp_ih_23_11 wp_ih_23_11 0 0.5451675114557738
Vwn_ih_23_11 wn_ih_23_11 0 0.4548324885442262
Vwp_ih_24_11 wp_ih_24_11 0 0.3468339024052293
Vwn_ih_24_11 wn_ih_24_11 0 0.6531660975947706
Vwp_ih_25_11 wp_ih_25_11 0 0.44325921079535974
Vwn_ih_25_11 wn_ih_25_11 0 0.5567407892046403
Vwp_ih_26_11 wp_ih_26_11 0 0.5238127237546072
Vwn_ih_26_11 wn_ih_26_11 0 0.47618727624539287
Vwp_ih_27_11 wp_ih_27_11 0 0.49793809154475904
Vwn_ih_27_11 wn_ih_27_11 0 0.5020619084552409
Vwp_ih_28_11 wp_ih_28_11 0 0.3
Vwn_ih_28_11 wn_ih_28_11 0 0.7463339384819148
Vwp_ih_29_11 wp_ih_29_11 0 0.6253286431225986
Vwn_ih_29_11 wn_ih_29_11 0 0.3746713568774014
Vwp_ih_30_11 wp_ih_30_11 0 0.7077370954365753
Vwn_ih_30_11 wn_ih_30_11 0 0.3
Vwp_ih_31_11 wp_ih_31_11 0 0.6756914238430352
Vwn_ih_31_11 wn_ih_31_11 0 0.32430857615696485
Vwp_ih_32_11 wp_ih_32_11 0 0.3778568448227747
Vwn_ih_32_11 wn_ih_32_11 0 0.6221431551772253
Vwp_ih_33_11 wp_ih_33_11 0 0.5523160135686253
Vwn_ih_33_11 wn_ih_33_11 0 0.44768398643137475
Vwp_ih_34_11 wp_ih_34_11 0 0.3
Vwn_ih_34_11 wn_ih_34_11 0 0.7551797701501907
Vwp_ih_35_11 wp_ih_35_11 0 0.7028021770379651
Vwn_ih_35_11 wn_ih_35_11 0 0.3
Vwp_ih_36_11 wp_ih_36_11 0 0.3
Vwn_ih_36_11 wn_ih_36_11 0 0.7327852291734573
Vwp_ih_37_11 wp_ih_37_11 0 0.5492610515896644
Vwn_ih_37_11 wn_ih_37_11 0 0.45073894841033557
Vwp_ih_38_11 wp_ih_38_11 0 0.6395095626347727
Vwn_ih_38_11 wn_ih_38_11 0 0.36049043736522735
Vwp_ih_39_11 wp_ih_39_11 0 0.6549586077116882
Vwn_ih_39_11 wn_ih_39_11 0 0.34504139228831177
Vwp_ih_40_11 wp_ih_40_11 0 0.541276461765549
Vwn_ih_40_11 wn_ih_40_11 0 0.458723538234451
Vwp_ih_41_11 wp_ih_41_11 0 0.32892199410719103
Vwn_ih_41_11 wn_ih_41_11 0 0.671078005892809
Vwp_ih_42_11 wp_ih_42_11 0 0.48785890483468575
Vwn_ih_42_11 wn_ih_42_11 0 0.5121410951653143
Vwp_ih_43_11 wp_ih_43_11 0 0.4678017830978062
Vwn_ih_43_11 wn_ih_43_11 0 0.5321982169021938
Vwp_ih_44_11 wp_ih_44_11 0 0.5442030990856337
Vwn_ih_44_11 wn_ih_44_11 0 0.4557969009143663
Vwp_ih_45_11 wp_ih_45_11 0 0.6185295180818899
Vwn_ih_45_11 wn_ih_45_11 0 0.38147048191811006
Vwp_ih_46_11 wp_ih_46_11 0 0.5794449058769954
Vwn_ih_46_11 wn_ih_46_11 0 0.4205550941230046
Vwp_ih_47_11 wp_ih_47_11 0 0.7545939869203444
Vwn_ih_47_11 wn_ih_47_11 0 0.3
Vwp_ih_48_11 wp_ih_48_11 0 0.579326102614666
Vwn_ih_48_11 wn_ih_48_11 0 0.42067389738533395
Vwp_ih_49_11 wp_ih_49_11 0 0.453341899003294
Vwn_ih_49_11 wn_ih_49_11 0 0.546658100996706
Vwp_ih_50_11 wp_ih_50_11 0 0.6955975462592219
Vwn_ih_50_11 wn_ih_50_11 0 0.3044024537407781
Vwp_ih_51_11 wp_ih_51_11 0 0.46225663220664054
Vwn_ih_51_11 wn_ih_51_11 0 0.5377433677933595
Vwp_ih_52_11 wp_ih_52_11 0 0.5338236213145264
Vwn_ih_52_11 wn_ih_52_11 0 0.4661763786854735
Vwp_ih_53_11 wp_ih_53_11 0 0.5216933511636324
Vwn_ih_53_11 wn_ih_53_11 0 0.47830664883636764
Vwp_ih_54_11 wp_ih_54_11 0 0.3
Vwn_ih_54_11 wn_ih_54_11 0 0.7751877629972286
Vwp_ih_55_11 wp_ih_55_11 0 0.5332183944109139
Vwn_ih_55_11 wn_ih_55_11 0 0.4667816055890861
Vwp_ih_56_11 wp_ih_56_11 0 0.5347327944200712
Vwn_ih_56_11 wn_ih_56_11 0 0.46526720557992884
Vwp_ih_57_11 wp_ih_57_11 0 0.4748353934033142
Vwn_ih_57_11 wn_ih_57_11 0 0.5251646065966858
Vwp_ih_58_11 wp_ih_58_11 0 0.4830455629688964
Vwn_ih_58_11 wn_ih_58_11 0 0.5169544370311037
Vwp_ih_59_11 wp_ih_59_11 0 0.34587158077737834
Vwn_ih_59_11 wn_ih_59_11 0 0.6541284192226217
Vwp_ih_60_11 wp_ih_60_11 0 0.5098955970605604
Vwn_ih_60_11 wn_ih_60_11 0 0.4901044029394396
Vwp_ih_61_11 wp_ih_61_11 0 0.6803510583682234
Vwn_ih_61_11 wn_ih_61_11 0 0.3196489416317766
Vwp_ih_62_11 wp_ih_62_11 0 0.47872765183868193
Vwn_ih_62_11 wn_ih_62_11 0 0.5212723481613181
Vwp_ih_63_11 wp_ih_63_11 0 0.4373449098217316
Vwn_ih_63_11 wn_ih_63_11 0 0.5626550901782684
Vwp_ho_11_0 wp_ho_11_0 0 0.3674117606577848
Vwn_ho_11_0 wn_ho_11_0 0 0.6325882393422152
Vwp_ho_11_1 wp_ho_11_1 0 0.37225137869535496
Vwn_ho_11_1 wn_ho_11_1 0 0.627748621304645
Vwp_ho_11_2 wp_ho_11_2 0 0.5434905397155115
Vwn_ho_11_2 wn_ho_11_2 0 0.45650946028448847
Vwp_ho_11_3 wp_ho_11_3 0 0.6914842929078087
Vwn_ho_11_3 wn_ho_11_3 0 0.30851570709219134
Vwp_ho_11_4 wp_ho_11_4 0 0.5388335992960259
Vwn_ho_11_4 wn_ho_11_4 0 0.4611664007039741
Xcm_mh0 mhp0 mhn0 vdd cmld
Rnd_mh0 mhp0 mhn0 20k
Xcm_xh0 xhp0 xhn0 vdd cmld
Rnd_xh0 xhp0 xhn0 20k
X_ihm_0_0 a_xp0 a_xn0 wp_ih_0_0 wn_ih_0_0 mhp0 mhn0 vdd vbsyn gsyn
X_ihx_0_0 a_xp0 a_xn0 wp_ih_0_0 wn_ih_0_0 xhp0 xhn0 vdd vbsyn gsyn
X_ihm_1_0 a_xp1 a_xn1 wp_ih_1_0 wn_ih_1_0 mhp0 mhn0 vdd vbsyn gsyn
X_ihx_1_0 a_xp1 a_xn1 wp_ih_1_0 wn_ih_1_0 xhp0 xhn0 vdd vbsyn gsyn
X_ihm_2_0 a_xp2 a_xn2 wp_ih_2_0 wn_ih_2_0 mhp0 mhn0 vdd vbsyn gsyn
X_ihx_2_0 a_xp2 a_xn2 wp_ih_2_0 wn_ih_2_0 xhp0 xhn0 vdd vbsyn gsyn
X_ihm_3_0 a_xp3 a_xn3 wp_ih_3_0 wn_ih_3_0 mhp0 mhn0 vdd vbsyn gsyn
X_ihx_3_0 a_xp3 a_xn3 wp_ih_3_0 wn_ih_3_0 xhp0 xhn0 vdd vbsyn gsyn
X_ihm_4_0 a_xp4 a_xn4 wp_ih_4_0 wn_ih_4_0 mhp0 mhn0 vdd vbsyn gsyn
X_ihx_4_0 a_xp4 a_xn4 wp_ih_4_0 wn_ih_4_0 xhp0 xhn0 vdd vbsyn gsyn
X_ihm_5_0 a_xp5 a_xn5 wp_ih_5_0 wn_ih_5_0 mhp0 mhn0 vdd vbsyn gsyn
X_ihx_5_0 a_xp5 a_xn5 wp_ih_5_0 wn_ih_5_0 xhp0 xhn0 vdd vbsyn gsyn
X_ihm_6_0 a_xp6 a_xn6 wp_ih_6_0 wn_ih_6_0 mhp0 mhn0 vdd vbsyn gsyn
X_ihx_6_0 a_xp6 a_xn6 wp_ih_6_0 wn_ih_6_0 xhp0 xhn0 vdd vbsyn gsyn
X_ihm_7_0 a_xp7 a_xn7 wp_ih_7_0 wn_ih_7_0 mhp0 mhn0 vdd vbsyn gsyn
X_ihx_7_0 a_xp7 a_xn7 wp_ih_7_0 wn_ih_7_0 xhp0 xhn0 vdd vbsyn gsyn
X_ihm_8_0 a_xp8 a_xn8 wp_ih_8_0 wn_ih_8_0 mhp0 mhn0 vdd vbsyn gsyn
X_ihx_8_0 a_xp8 a_xn8 wp_ih_8_0 wn_ih_8_0 xhp0 xhn0 vdd vbsyn gsyn
X_ihm_9_0 a_xp9 a_xn9 wp_ih_9_0 wn_ih_9_0 mhp0 mhn0 vdd vbsyn gsyn
X_ihx_9_0 a_xp9 a_xn9 wp_ih_9_0 wn_ih_9_0 xhp0 xhn0 vdd vbsyn gsyn
X_ihm_10_0 a_xp10 a_xn10 wp_ih_10_0 wn_ih_10_0 mhp0 mhn0 vdd vbsyn gsyn
X_ihx_10_0 a_xp10 a_xn10 wp_ih_10_0 wn_ih_10_0 xhp0 xhn0 vdd vbsyn gsyn
X_ihm_11_0 a_xp11 a_xn11 wp_ih_11_0 wn_ih_11_0 mhp0 mhn0 vdd vbsyn gsyn
X_ihx_11_0 a_xp11 a_xn11 wp_ih_11_0 wn_ih_11_0 xhp0 xhn0 vdd vbsyn gsyn
X_ihm_12_0 a_xp12 a_xn12 wp_ih_12_0 wn_ih_12_0 mhp0 mhn0 vdd vbsyn gsyn
X_ihx_12_0 a_xp12 a_xn12 wp_ih_12_0 wn_ih_12_0 xhp0 xhn0 vdd vbsyn gsyn
X_ihm_13_0 a_xp13 a_xn13 wp_ih_13_0 wn_ih_13_0 mhp0 mhn0 vdd vbsyn gsyn
X_ihx_13_0 a_xp13 a_xn13 wp_ih_13_0 wn_ih_13_0 xhp0 xhn0 vdd vbsyn gsyn
X_ihm_14_0 a_xp14 a_xn14 wp_ih_14_0 wn_ih_14_0 mhp0 mhn0 vdd vbsyn gsyn
X_ihx_14_0 a_xp14 a_xn14 wp_ih_14_0 wn_ih_14_0 xhp0 xhn0 vdd vbsyn gsyn
X_ihm_15_0 a_xp15 a_xn15 wp_ih_15_0 wn_ih_15_0 mhp0 mhn0 vdd vbsyn gsyn
X_ihx_15_0 a_xp15 a_xn15 wp_ih_15_0 wn_ih_15_0 xhp0 xhn0 vdd vbsyn gsyn
X_ihm_16_0 a_xp16 a_xn16 wp_ih_16_0 wn_ih_16_0 mhp0 mhn0 vdd vbsyn gsyn
X_ihx_16_0 a_xp16 a_xn16 wp_ih_16_0 wn_ih_16_0 xhp0 xhn0 vdd vbsyn gsyn
X_ihm_17_0 a_xp17 a_xn17 wp_ih_17_0 wn_ih_17_0 mhp0 mhn0 vdd vbsyn gsyn
X_ihx_17_0 a_xp17 a_xn17 wp_ih_17_0 wn_ih_17_0 xhp0 xhn0 vdd vbsyn gsyn
X_ihm_18_0 a_xp18 a_xn18 wp_ih_18_0 wn_ih_18_0 mhp0 mhn0 vdd vbsyn gsyn
X_ihx_18_0 a_xp18 a_xn18 wp_ih_18_0 wn_ih_18_0 xhp0 xhn0 vdd vbsyn gsyn
X_ihm_19_0 a_xp19 a_xn19 wp_ih_19_0 wn_ih_19_0 mhp0 mhn0 vdd vbsyn gsyn
X_ihx_19_0 a_xp19 a_xn19 wp_ih_19_0 wn_ih_19_0 xhp0 xhn0 vdd vbsyn gsyn
X_ihm_20_0 a_xp20 a_xn20 wp_ih_20_0 wn_ih_20_0 mhp0 mhn0 vdd vbsyn gsyn
X_ihx_20_0 a_xp20 a_xn20 wp_ih_20_0 wn_ih_20_0 xhp0 xhn0 vdd vbsyn gsyn
X_ihm_21_0 a_xp21 a_xn21 wp_ih_21_0 wn_ih_21_0 mhp0 mhn0 vdd vbsyn gsyn
X_ihx_21_0 a_xp21 a_xn21 wp_ih_21_0 wn_ih_21_0 xhp0 xhn0 vdd vbsyn gsyn
X_ihm_22_0 a_xp22 a_xn22 wp_ih_22_0 wn_ih_22_0 mhp0 mhn0 vdd vbsyn gsyn
X_ihx_22_0 a_xp22 a_xn22 wp_ih_22_0 wn_ih_22_0 xhp0 xhn0 vdd vbsyn gsyn
X_ihm_23_0 a_xp23 a_xn23 wp_ih_23_0 wn_ih_23_0 mhp0 mhn0 vdd vbsyn gsyn
X_ihx_23_0 a_xp23 a_xn23 wp_ih_23_0 wn_ih_23_0 xhp0 xhn0 vdd vbsyn gsyn
X_ihm_24_0 a_xp24 a_xn24 wp_ih_24_0 wn_ih_24_0 mhp0 mhn0 vdd vbsyn gsyn
X_ihx_24_0 a_xp24 a_xn24 wp_ih_24_0 wn_ih_24_0 xhp0 xhn0 vdd vbsyn gsyn
X_ihm_25_0 a_xp25 a_xn25 wp_ih_25_0 wn_ih_25_0 mhp0 mhn0 vdd vbsyn gsyn
X_ihx_25_0 a_xp25 a_xn25 wp_ih_25_0 wn_ih_25_0 xhp0 xhn0 vdd vbsyn gsyn
X_ihm_26_0 a_xp26 a_xn26 wp_ih_26_0 wn_ih_26_0 mhp0 mhn0 vdd vbsyn gsyn
X_ihx_26_0 a_xp26 a_xn26 wp_ih_26_0 wn_ih_26_0 xhp0 xhn0 vdd vbsyn gsyn
X_ihm_27_0 a_xp27 a_xn27 wp_ih_27_0 wn_ih_27_0 mhp0 mhn0 vdd vbsyn gsyn
X_ihx_27_0 a_xp27 a_xn27 wp_ih_27_0 wn_ih_27_0 xhp0 xhn0 vdd vbsyn gsyn
X_ihm_28_0 a_xp28 a_xn28 wp_ih_28_0 wn_ih_28_0 mhp0 mhn0 vdd vbsyn gsyn
X_ihx_28_0 a_xp28 a_xn28 wp_ih_28_0 wn_ih_28_0 xhp0 xhn0 vdd vbsyn gsyn
X_ihm_29_0 a_xp29 a_xn29 wp_ih_29_0 wn_ih_29_0 mhp0 mhn0 vdd vbsyn gsyn
X_ihx_29_0 a_xp29 a_xn29 wp_ih_29_0 wn_ih_29_0 xhp0 xhn0 vdd vbsyn gsyn
X_ihm_30_0 a_xp30 a_xn30 wp_ih_30_0 wn_ih_30_0 mhp0 mhn0 vdd vbsyn gsyn
X_ihx_30_0 a_xp30 a_xn30 wp_ih_30_0 wn_ih_30_0 xhp0 xhn0 vdd vbsyn gsyn
X_ihm_31_0 a_xp31 a_xn31 wp_ih_31_0 wn_ih_31_0 mhp0 mhn0 vdd vbsyn gsyn
X_ihx_31_0 a_xp31 a_xn31 wp_ih_31_0 wn_ih_31_0 xhp0 xhn0 vdd vbsyn gsyn
X_ihm_32_0 a_xp32 a_xn32 wp_ih_32_0 wn_ih_32_0 mhp0 mhn0 vdd vbsyn gsyn
X_ihx_32_0 a_xp32 a_xn32 wp_ih_32_0 wn_ih_32_0 xhp0 xhn0 vdd vbsyn gsyn
X_ihm_33_0 a_xp33 a_xn33 wp_ih_33_0 wn_ih_33_0 mhp0 mhn0 vdd vbsyn gsyn
X_ihx_33_0 a_xp33 a_xn33 wp_ih_33_0 wn_ih_33_0 xhp0 xhn0 vdd vbsyn gsyn
X_ihm_34_0 a_xp34 a_xn34 wp_ih_34_0 wn_ih_34_0 mhp0 mhn0 vdd vbsyn gsyn
X_ihx_34_0 a_xp34 a_xn34 wp_ih_34_0 wn_ih_34_0 xhp0 xhn0 vdd vbsyn gsyn
X_ihm_35_0 a_xp35 a_xn35 wp_ih_35_0 wn_ih_35_0 mhp0 mhn0 vdd vbsyn gsyn
X_ihx_35_0 a_xp35 a_xn35 wp_ih_35_0 wn_ih_35_0 xhp0 xhn0 vdd vbsyn gsyn
X_ihm_36_0 a_xp36 a_xn36 wp_ih_36_0 wn_ih_36_0 mhp0 mhn0 vdd vbsyn gsyn
X_ihx_36_0 a_xp36 a_xn36 wp_ih_36_0 wn_ih_36_0 xhp0 xhn0 vdd vbsyn gsyn
X_ihm_37_0 a_xp37 a_xn37 wp_ih_37_0 wn_ih_37_0 mhp0 mhn0 vdd vbsyn gsyn
X_ihx_37_0 a_xp37 a_xn37 wp_ih_37_0 wn_ih_37_0 xhp0 xhn0 vdd vbsyn gsyn
X_ihm_38_0 a_xp38 a_xn38 wp_ih_38_0 wn_ih_38_0 mhp0 mhn0 vdd vbsyn gsyn
X_ihx_38_0 a_xp38 a_xn38 wp_ih_38_0 wn_ih_38_0 xhp0 xhn0 vdd vbsyn gsyn
X_ihm_39_0 a_xp39 a_xn39 wp_ih_39_0 wn_ih_39_0 mhp0 mhn0 vdd vbsyn gsyn
X_ihx_39_0 a_xp39 a_xn39 wp_ih_39_0 wn_ih_39_0 xhp0 xhn0 vdd vbsyn gsyn
X_ihm_40_0 a_xp40 a_xn40 wp_ih_40_0 wn_ih_40_0 mhp0 mhn0 vdd vbsyn gsyn
X_ihx_40_0 a_xp40 a_xn40 wp_ih_40_0 wn_ih_40_0 xhp0 xhn0 vdd vbsyn gsyn
X_ihm_41_0 a_xp41 a_xn41 wp_ih_41_0 wn_ih_41_0 mhp0 mhn0 vdd vbsyn gsyn
X_ihx_41_0 a_xp41 a_xn41 wp_ih_41_0 wn_ih_41_0 xhp0 xhn0 vdd vbsyn gsyn
X_ihm_42_0 a_xp42 a_xn42 wp_ih_42_0 wn_ih_42_0 mhp0 mhn0 vdd vbsyn gsyn
X_ihx_42_0 a_xp42 a_xn42 wp_ih_42_0 wn_ih_42_0 xhp0 xhn0 vdd vbsyn gsyn
X_ihm_43_0 a_xp43 a_xn43 wp_ih_43_0 wn_ih_43_0 mhp0 mhn0 vdd vbsyn gsyn
X_ihx_43_0 a_xp43 a_xn43 wp_ih_43_0 wn_ih_43_0 xhp0 xhn0 vdd vbsyn gsyn
X_ihm_44_0 a_xp44 a_xn44 wp_ih_44_0 wn_ih_44_0 mhp0 mhn0 vdd vbsyn gsyn
X_ihx_44_0 a_xp44 a_xn44 wp_ih_44_0 wn_ih_44_0 xhp0 xhn0 vdd vbsyn gsyn
X_ihm_45_0 a_xp45 a_xn45 wp_ih_45_0 wn_ih_45_0 mhp0 mhn0 vdd vbsyn gsyn
X_ihx_45_0 a_xp45 a_xn45 wp_ih_45_0 wn_ih_45_0 xhp0 xhn0 vdd vbsyn gsyn
X_ihm_46_0 a_xp46 a_xn46 wp_ih_46_0 wn_ih_46_0 mhp0 mhn0 vdd vbsyn gsyn
X_ihx_46_0 a_xp46 a_xn46 wp_ih_46_0 wn_ih_46_0 xhp0 xhn0 vdd vbsyn gsyn
X_ihm_47_0 a_xp47 a_xn47 wp_ih_47_0 wn_ih_47_0 mhp0 mhn0 vdd vbsyn gsyn
X_ihx_47_0 a_xp47 a_xn47 wp_ih_47_0 wn_ih_47_0 xhp0 xhn0 vdd vbsyn gsyn
X_ihm_48_0 a_xp48 a_xn48 wp_ih_48_0 wn_ih_48_0 mhp0 mhn0 vdd vbsyn gsyn
X_ihx_48_0 a_xp48 a_xn48 wp_ih_48_0 wn_ih_48_0 xhp0 xhn0 vdd vbsyn gsyn
X_ihm_49_0 a_xp49 a_xn49 wp_ih_49_0 wn_ih_49_0 mhp0 mhn0 vdd vbsyn gsyn
X_ihx_49_0 a_xp49 a_xn49 wp_ih_49_0 wn_ih_49_0 xhp0 xhn0 vdd vbsyn gsyn
X_ihm_50_0 a_xp50 a_xn50 wp_ih_50_0 wn_ih_50_0 mhp0 mhn0 vdd vbsyn gsyn
X_ihx_50_0 a_xp50 a_xn50 wp_ih_50_0 wn_ih_50_0 xhp0 xhn0 vdd vbsyn gsyn
X_ihm_51_0 a_xp51 a_xn51 wp_ih_51_0 wn_ih_51_0 mhp0 mhn0 vdd vbsyn gsyn
X_ihx_51_0 a_xp51 a_xn51 wp_ih_51_0 wn_ih_51_0 xhp0 xhn0 vdd vbsyn gsyn
X_ihm_52_0 a_xp52 a_xn52 wp_ih_52_0 wn_ih_52_0 mhp0 mhn0 vdd vbsyn gsyn
X_ihx_52_0 a_xp52 a_xn52 wp_ih_52_0 wn_ih_52_0 xhp0 xhn0 vdd vbsyn gsyn
X_ihm_53_0 a_xp53 a_xn53 wp_ih_53_0 wn_ih_53_0 mhp0 mhn0 vdd vbsyn gsyn
X_ihx_53_0 a_xp53 a_xn53 wp_ih_53_0 wn_ih_53_0 xhp0 xhn0 vdd vbsyn gsyn
X_ihm_54_0 a_xp54 a_xn54 wp_ih_54_0 wn_ih_54_0 mhp0 mhn0 vdd vbsyn gsyn
X_ihx_54_0 a_xp54 a_xn54 wp_ih_54_0 wn_ih_54_0 xhp0 xhn0 vdd vbsyn gsyn
X_ihm_55_0 a_xp55 a_xn55 wp_ih_55_0 wn_ih_55_0 mhp0 mhn0 vdd vbsyn gsyn
X_ihx_55_0 a_xp55 a_xn55 wp_ih_55_0 wn_ih_55_0 xhp0 xhn0 vdd vbsyn gsyn
X_ihm_56_0 a_xp56 a_xn56 wp_ih_56_0 wn_ih_56_0 mhp0 mhn0 vdd vbsyn gsyn
X_ihx_56_0 a_xp56 a_xn56 wp_ih_56_0 wn_ih_56_0 xhp0 xhn0 vdd vbsyn gsyn
X_ihm_57_0 a_xp57 a_xn57 wp_ih_57_0 wn_ih_57_0 mhp0 mhn0 vdd vbsyn gsyn
X_ihx_57_0 a_xp57 a_xn57 wp_ih_57_0 wn_ih_57_0 xhp0 xhn0 vdd vbsyn gsyn
X_ihm_58_0 a_xp58 a_xn58 wp_ih_58_0 wn_ih_58_0 mhp0 mhn0 vdd vbsyn gsyn
X_ihx_58_0 a_xp58 a_xn58 wp_ih_58_0 wn_ih_58_0 xhp0 xhn0 vdd vbsyn gsyn
X_ihm_59_0 a_xp59 a_xn59 wp_ih_59_0 wn_ih_59_0 mhp0 mhn0 vdd vbsyn gsyn
X_ihx_59_0 a_xp59 a_xn59 wp_ih_59_0 wn_ih_59_0 xhp0 xhn0 vdd vbsyn gsyn
X_ihm_60_0 a_xp60 a_xn60 wp_ih_60_0 wn_ih_60_0 mhp0 mhn0 vdd vbsyn gsyn
X_ihx_60_0 a_xp60 a_xn60 wp_ih_60_0 wn_ih_60_0 xhp0 xhn0 vdd vbsyn gsyn
X_ihm_61_0 a_xp61 a_xn61 wp_ih_61_0 wn_ih_61_0 mhp0 mhn0 vdd vbsyn gsyn
X_ihx_61_0 a_xp61 a_xn61 wp_ih_61_0 wn_ih_61_0 xhp0 xhn0 vdd vbsyn gsyn
X_ihm_62_0 a_xp62 a_xn62 wp_ih_62_0 wn_ih_62_0 mhp0 mhn0 vdd vbsyn gsyn
X_ihx_62_0 a_xp62 a_xn62 wp_ih_62_0 wn_ih_62_0 xhp0 xhn0 vdd vbsyn gsyn
X_ihm_63_0 a_xp63 a_xn63 wp_ih_63_0 wn_ih_63_0 mhp0 mhn0 vdd vbsyn gsyn
X_ihx_63_0 a_xp63 a_xn63 wp_ih_63_0 wn_ih_63_0 xhp0 xhn0 vdd vbsyn gsyn
Xn0 xhp0 xhn0 ahp0 ahn0 vdd vbneu dneuron
Xeh0 xhp0 xhn0 mhp0 mhn0 ehp0 ehn0 vdd gm esub
Xcm_mh1 mhp1 mhn1 vdd cmld
Rnd_mh1 mhp1 mhn1 20k
Xcm_xh1 xhp1 xhn1 vdd cmld
Rnd_xh1 xhp1 xhn1 20k
X_ihm_0_1 a_xp0 a_xn0 wp_ih_0_1 wn_ih_0_1 mhp1 mhn1 vdd vbsyn gsyn
X_ihx_0_1 a_xp0 a_xn0 wp_ih_0_1 wn_ih_0_1 xhp1 xhn1 vdd vbsyn gsyn
X_ihm_1_1 a_xp1 a_xn1 wp_ih_1_1 wn_ih_1_1 mhp1 mhn1 vdd vbsyn gsyn
X_ihx_1_1 a_xp1 a_xn1 wp_ih_1_1 wn_ih_1_1 xhp1 xhn1 vdd vbsyn gsyn
X_ihm_2_1 a_xp2 a_xn2 wp_ih_2_1 wn_ih_2_1 mhp1 mhn1 vdd vbsyn gsyn
X_ihx_2_1 a_xp2 a_xn2 wp_ih_2_1 wn_ih_2_1 xhp1 xhn1 vdd vbsyn gsyn
X_ihm_3_1 a_xp3 a_xn3 wp_ih_3_1 wn_ih_3_1 mhp1 mhn1 vdd vbsyn gsyn
X_ihx_3_1 a_xp3 a_xn3 wp_ih_3_1 wn_ih_3_1 xhp1 xhn1 vdd vbsyn gsyn
X_ihm_4_1 a_xp4 a_xn4 wp_ih_4_1 wn_ih_4_1 mhp1 mhn1 vdd vbsyn gsyn
X_ihx_4_1 a_xp4 a_xn4 wp_ih_4_1 wn_ih_4_1 xhp1 xhn1 vdd vbsyn gsyn
X_ihm_5_1 a_xp5 a_xn5 wp_ih_5_1 wn_ih_5_1 mhp1 mhn1 vdd vbsyn gsyn
X_ihx_5_1 a_xp5 a_xn5 wp_ih_5_1 wn_ih_5_1 xhp1 xhn1 vdd vbsyn gsyn
X_ihm_6_1 a_xp6 a_xn6 wp_ih_6_1 wn_ih_6_1 mhp1 mhn1 vdd vbsyn gsyn
X_ihx_6_1 a_xp6 a_xn6 wp_ih_6_1 wn_ih_6_1 xhp1 xhn1 vdd vbsyn gsyn
X_ihm_7_1 a_xp7 a_xn7 wp_ih_7_1 wn_ih_7_1 mhp1 mhn1 vdd vbsyn gsyn
X_ihx_7_1 a_xp7 a_xn7 wp_ih_7_1 wn_ih_7_1 xhp1 xhn1 vdd vbsyn gsyn
X_ihm_8_1 a_xp8 a_xn8 wp_ih_8_1 wn_ih_8_1 mhp1 mhn1 vdd vbsyn gsyn
X_ihx_8_1 a_xp8 a_xn8 wp_ih_8_1 wn_ih_8_1 xhp1 xhn1 vdd vbsyn gsyn
X_ihm_9_1 a_xp9 a_xn9 wp_ih_9_1 wn_ih_9_1 mhp1 mhn1 vdd vbsyn gsyn
X_ihx_9_1 a_xp9 a_xn9 wp_ih_9_1 wn_ih_9_1 xhp1 xhn1 vdd vbsyn gsyn
X_ihm_10_1 a_xp10 a_xn10 wp_ih_10_1 wn_ih_10_1 mhp1 mhn1 vdd vbsyn gsyn
X_ihx_10_1 a_xp10 a_xn10 wp_ih_10_1 wn_ih_10_1 xhp1 xhn1 vdd vbsyn gsyn
X_ihm_11_1 a_xp11 a_xn11 wp_ih_11_1 wn_ih_11_1 mhp1 mhn1 vdd vbsyn gsyn
X_ihx_11_1 a_xp11 a_xn11 wp_ih_11_1 wn_ih_11_1 xhp1 xhn1 vdd vbsyn gsyn
X_ihm_12_1 a_xp12 a_xn12 wp_ih_12_1 wn_ih_12_1 mhp1 mhn1 vdd vbsyn gsyn
X_ihx_12_1 a_xp12 a_xn12 wp_ih_12_1 wn_ih_12_1 xhp1 xhn1 vdd vbsyn gsyn
X_ihm_13_1 a_xp13 a_xn13 wp_ih_13_1 wn_ih_13_1 mhp1 mhn1 vdd vbsyn gsyn
X_ihx_13_1 a_xp13 a_xn13 wp_ih_13_1 wn_ih_13_1 xhp1 xhn1 vdd vbsyn gsyn
X_ihm_14_1 a_xp14 a_xn14 wp_ih_14_1 wn_ih_14_1 mhp1 mhn1 vdd vbsyn gsyn
X_ihx_14_1 a_xp14 a_xn14 wp_ih_14_1 wn_ih_14_1 xhp1 xhn1 vdd vbsyn gsyn
X_ihm_15_1 a_xp15 a_xn15 wp_ih_15_1 wn_ih_15_1 mhp1 mhn1 vdd vbsyn gsyn
X_ihx_15_1 a_xp15 a_xn15 wp_ih_15_1 wn_ih_15_1 xhp1 xhn1 vdd vbsyn gsyn
X_ihm_16_1 a_xp16 a_xn16 wp_ih_16_1 wn_ih_16_1 mhp1 mhn1 vdd vbsyn gsyn
X_ihx_16_1 a_xp16 a_xn16 wp_ih_16_1 wn_ih_16_1 xhp1 xhn1 vdd vbsyn gsyn
X_ihm_17_1 a_xp17 a_xn17 wp_ih_17_1 wn_ih_17_1 mhp1 mhn1 vdd vbsyn gsyn
X_ihx_17_1 a_xp17 a_xn17 wp_ih_17_1 wn_ih_17_1 xhp1 xhn1 vdd vbsyn gsyn
X_ihm_18_1 a_xp18 a_xn18 wp_ih_18_1 wn_ih_18_1 mhp1 mhn1 vdd vbsyn gsyn
X_ihx_18_1 a_xp18 a_xn18 wp_ih_18_1 wn_ih_18_1 xhp1 xhn1 vdd vbsyn gsyn
X_ihm_19_1 a_xp19 a_xn19 wp_ih_19_1 wn_ih_19_1 mhp1 mhn1 vdd vbsyn gsyn
X_ihx_19_1 a_xp19 a_xn19 wp_ih_19_1 wn_ih_19_1 xhp1 xhn1 vdd vbsyn gsyn
X_ihm_20_1 a_xp20 a_xn20 wp_ih_20_1 wn_ih_20_1 mhp1 mhn1 vdd vbsyn gsyn
X_ihx_20_1 a_xp20 a_xn20 wp_ih_20_1 wn_ih_20_1 xhp1 xhn1 vdd vbsyn gsyn
X_ihm_21_1 a_xp21 a_xn21 wp_ih_21_1 wn_ih_21_1 mhp1 mhn1 vdd vbsyn gsyn
X_ihx_21_1 a_xp21 a_xn21 wp_ih_21_1 wn_ih_21_1 xhp1 xhn1 vdd vbsyn gsyn
X_ihm_22_1 a_xp22 a_xn22 wp_ih_22_1 wn_ih_22_1 mhp1 mhn1 vdd vbsyn gsyn
X_ihx_22_1 a_xp22 a_xn22 wp_ih_22_1 wn_ih_22_1 xhp1 xhn1 vdd vbsyn gsyn
X_ihm_23_1 a_xp23 a_xn23 wp_ih_23_1 wn_ih_23_1 mhp1 mhn1 vdd vbsyn gsyn
X_ihx_23_1 a_xp23 a_xn23 wp_ih_23_1 wn_ih_23_1 xhp1 xhn1 vdd vbsyn gsyn
X_ihm_24_1 a_xp24 a_xn24 wp_ih_24_1 wn_ih_24_1 mhp1 mhn1 vdd vbsyn gsyn
X_ihx_24_1 a_xp24 a_xn24 wp_ih_24_1 wn_ih_24_1 xhp1 xhn1 vdd vbsyn gsyn
X_ihm_25_1 a_xp25 a_xn25 wp_ih_25_1 wn_ih_25_1 mhp1 mhn1 vdd vbsyn gsyn
X_ihx_25_1 a_xp25 a_xn25 wp_ih_25_1 wn_ih_25_1 xhp1 xhn1 vdd vbsyn gsyn
X_ihm_26_1 a_xp26 a_xn26 wp_ih_26_1 wn_ih_26_1 mhp1 mhn1 vdd vbsyn gsyn
X_ihx_26_1 a_xp26 a_xn26 wp_ih_26_1 wn_ih_26_1 xhp1 xhn1 vdd vbsyn gsyn
X_ihm_27_1 a_xp27 a_xn27 wp_ih_27_1 wn_ih_27_1 mhp1 mhn1 vdd vbsyn gsyn
X_ihx_27_1 a_xp27 a_xn27 wp_ih_27_1 wn_ih_27_1 xhp1 xhn1 vdd vbsyn gsyn
X_ihm_28_1 a_xp28 a_xn28 wp_ih_28_1 wn_ih_28_1 mhp1 mhn1 vdd vbsyn gsyn
X_ihx_28_1 a_xp28 a_xn28 wp_ih_28_1 wn_ih_28_1 xhp1 xhn1 vdd vbsyn gsyn
X_ihm_29_1 a_xp29 a_xn29 wp_ih_29_1 wn_ih_29_1 mhp1 mhn1 vdd vbsyn gsyn
X_ihx_29_1 a_xp29 a_xn29 wp_ih_29_1 wn_ih_29_1 xhp1 xhn1 vdd vbsyn gsyn
X_ihm_30_1 a_xp30 a_xn30 wp_ih_30_1 wn_ih_30_1 mhp1 mhn1 vdd vbsyn gsyn
X_ihx_30_1 a_xp30 a_xn30 wp_ih_30_1 wn_ih_30_1 xhp1 xhn1 vdd vbsyn gsyn
X_ihm_31_1 a_xp31 a_xn31 wp_ih_31_1 wn_ih_31_1 mhp1 mhn1 vdd vbsyn gsyn
X_ihx_31_1 a_xp31 a_xn31 wp_ih_31_1 wn_ih_31_1 xhp1 xhn1 vdd vbsyn gsyn
X_ihm_32_1 a_xp32 a_xn32 wp_ih_32_1 wn_ih_32_1 mhp1 mhn1 vdd vbsyn gsyn
X_ihx_32_1 a_xp32 a_xn32 wp_ih_32_1 wn_ih_32_1 xhp1 xhn1 vdd vbsyn gsyn
X_ihm_33_1 a_xp33 a_xn33 wp_ih_33_1 wn_ih_33_1 mhp1 mhn1 vdd vbsyn gsyn
X_ihx_33_1 a_xp33 a_xn33 wp_ih_33_1 wn_ih_33_1 xhp1 xhn1 vdd vbsyn gsyn
X_ihm_34_1 a_xp34 a_xn34 wp_ih_34_1 wn_ih_34_1 mhp1 mhn1 vdd vbsyn gsyn
X_ihx_34_1 a_xp34 a_xn34 wp_ih_34_1 wn_ih_34_1 xhp1 xhn1 vdd vbsyn gsyn
X_ihm_35_1 a_xp35 a_xn35 wp_ih_35_1 wn_ih_35_1 mhp1 mhn1 vdd vbsyn gsyn
X_ihx_35_1 a_xp35 a_xn35 wp_ih_35_1 wn_ih_35_1 xhp1 xhn1 vdd vbsyn gsyn
X_ihm_36_1 a_xp36 a_xn36 wp_ih_36_1 wn_ih_36_1 mhp1 mhn1 vdd vbsyn gsyn
X_ihx_36_1 a_xp36 a_xn36 wp_ih_36_1 wn_ih_36_1 xhp1 xhn1 vdd vbsyn gsyn
X_ihm_37_1 a_xp37 a_xn37 wp_ih_37_1 wn_ih_37_1 mhp1 mhn1 vdd vbsyn gsyn
X_ihx_37_1 a_xp37 a_xn37 wp_ih_37_1 wn_ih_37_1 xhp1 xhn1 vdd vbsyn gsyn
X_ihm_38_1 a_xp38 a_xn38 wp_ih_38_1 wn_ih_38_1 mhp1 mhn1 vdd vbsyn gsyn
X_ihx_38_1 a_xp38 a_xn38 wp_ih_38_1 wn_ih_38_1 xhp1 xhn1 vdd vbsyn gsyn
X_ihm_39_1 a_xp39 a_xn39 wp_ih_39_1 wn_ih_39_1 mhp1 mhn1 vdd vbsyn gsyn
X_ihx_39_1 a_xp39 a_xn39 wp_ih_39_1 wn_ih_39_1 xhp1 xhn1 vdd vbsyn gsyn
X_ihm_40_1 a_xp40 a_xn40 wp_ih_40_1 wn_ih_40_1 mhp1 mhn1 vdd vbsyn gsyn
X_ihx_40_1 a_xp40 a_xn40 wp_ih_40_1 wn_ih_40_1 xhp1 xhn1 vdd vbsyn gsyn
X_ihm_41_1 a_xp41 a_xn41 wp_ih_41_1 wn_ih_41_1 mhp1 mhn1 vdd vbsyn gsyn
X_ihx_41_1 a_xp41 a_xn41 wp_ih_41_1 wn_ih_41_1 xhp1 xhn1 vdd vbsyn gsyn
X_ihm_42_1 a_xp42 a_xn42 wp_ih_42_1 wn_ih_42_1 mhp1 mhn1 vdd vbsyn gsyn
X_ihx_42_1 a_xp42 a_xn42 wp_ih_42_1 wn_ih_42_1 xhp1 xhn1 vdd vbsyn gsyn
X_ihm_43_1 a_xp43 a_xn43 wp_ih_43_1 wn_ih_43_1 mhp1 mhn1 vdd vbsyn gsyn
X_ihx_43_1 a_xp43 a_xn43 wp_ih_43_1 wn_ih_43_1 xhp1 xhn1 vdd vbsyn gsyn
X_ihm_44_1 a_xp44 a_xn44 wp_ih_44_1 wn_ih_44_1 mhp1 mhn1 vdd vbsyn gsyn
X_ihx_44_1 a_xp44 a_xn44 wp_ih_44_1 wn_ih_44_1 xhp1 xhn1 vdd vbsyn gsyn
X_ihm_45_1 a_xp45 a_xn45 wp_ih_45_1 wn_ih_45_1 mhp1 mhn1 vdd vbsyn gsyn
X_ihx_45_1 a_xp45 a_xn45 wp_ih_45_1 wn_ih_45_1 xhp1 xhn1 vdd vbsyn gsyn
X_ihm_46_1 a_xp46 a_xn46 wp_ih_46_1 wn_ih_46_1 mhp1 mhn1 vdd vbsyn gsyn
X_ihx_46_1 a_xp46 a_xn46 wp_ih_46_1 wn_ih_46_1 xhp1 xhn1 vdd vbsyn gsyn
X_ihm_47_1 a_xp47 a_xn47 wp_ih_47_1 wn_ih_47_1 mhp1 mhn1 vdd vbsyn gsyn
X_ihx_47_1 a_xp47 a_xn47 wp_ih_47_1 wn_ih_47_1 xhp1 xhn1 vdd vbsyn gsyn
X_ihm_48_1 a_xp48 a_xn48 wp_ih_48_1 wn_ih_48_1 mhp1 mhn1 vdd vbsyn gsyn
X_ihx_48_1 a_xp48 a_xn48 wp_ih_48_1 wn_ih_48_1 xhp1 xhn1 vdd vbsyn gsyn
X_ihm_49_1 a_xp49 a_xn49 wp_ih_49_1 wn_ih_49_1 mhp1 mhn1 vdd vbsyn gsyn
X_ihx_49_1 a_xp49 a_xn49 wp_ih_49_1 wn_ih_49_1 xhp1 xhn1 vdd vbsyn gsyn
X_ihm_50_1 a_xp50 a_xn50 wp_ih_50_1 wn_ih_50_1 mhp1 mhn1 vdd vbsyn gsyn
X_ihx_50_1 a_xp50 a_xn50 wp_ih_50_1 wn_ih_50_1 xhp1 xhn1 vdd vbsyn gsyn
X_ihm_51_1 a_xp51 a_xn51 wp_ih_51_1 wn_ih_51_1 mhp1 mhn1 vdd vbsyn gsyn
X_ihx_51_1 a_xp51 a_xn51 wp_ih_51_1 wn_ih_51_1 xhp1 xhn1 vdd vbsyn gsyn
X_ihm_52_1 a_xp52 a_xn52 wp_ih_52_1 wn_ih_52_1 mhp1 mhn1 vdd vbsyn gsyn
X_ihx_52_1 a_xp52 a_xn52 wp_ih_52_1 wn_ih_52_1 xhp1 xhn1 vdd vbsyn gsyn
X_ihm_53_1 a_xp53 a_xn53 wp_ih_53_1 wn_ih_53_1 mhp1 mhn1 vdd vbsyn gsyn
X_ihx_53_1 a_xp53 a_xn53 wp_ih_53_1 wn_ih_53_1 xhp1 xhn1 vdd vbsyn gsyn
X_ihm_54_1 a_xp54 a_xn54 wp_ih_54_1 wn_ih_54_1 mhp1 mhn1 vdd vbsyn gsyn
X_ihx_54_1 a_xp54 a_xn54 wp_ih_54_1 wn_ih_54_1 xhp1 xhn1 vdd vbsyn gsyn
X_ihm_55_1 a_xp55 a_xn55 wp_ih_55_1 wn_ih_55_1 mhp1 mhn1 vdd vbsyn gsyn
X_ihx_55_1 a_xp55 a_xn55 wp_ih_55_1 wn_ih_55_1 xhp1 xhn1 vdd vbsyn gsyn
X_ihm_56_1 a_xp56 a_xn56 wp_ih_56_1 wn_ih_56_1 mhp1 mhn1 vdd vbsyn gsyn
X_ihx_56_1 a_xp56 a_xn56 wp_ih_56_1 wn_ih_56_1 xhp1 xhn1 vdd vbsyn gsyn
X_ihm_57_1 a_xp57 a_xn57 wp_ih_57_1 wn_ih_57_1 mhp1 mhn1 vdd vbsyn gsyn
X_ihx_57_1 a_xp57 a_xn57 wp_ih_57_1 wn_ih_57_1 xhp1 xhn1 vdd vbsyn gsyn
X_ihm_58_1 a_xp58 a_xn58 wp_ih_58_1 wn_ih_58_1 mhp1 mhn1 vdd vbsyn gsyn
X_ihx_58_1 a_xp58 a_xn58 wp_ih_58_1 wn_ih_58_1 xhp1 xhn1 vdd vbsyn gsyn
X_ihm_59_1 a_xp59 a_xn59 wp_ih_59_1 wn_ih_59_1 mhp1 mhn1 vdd vbsyn gsyn
X_ihx_59_1 a_xp59 a_xn59 wp_ih_59_1 wn_ih_59_1 xhp1 xhn1 vdd vbsyn gsyn
X_ihm_60_1 a_xp60 a_xn60 wp_ih_60_1 wn_ih_60_1 mhp1 mhn1 vdd vbsyn gsyn
X_ihx_60_1 a_xp60 a_xn60 wp_ih_60_1 wn_ih_60_1 xhp1 xhn1 vdd vbsyn gsyn
X_ihm_61_1 a_xp61 a_xn61 wp_ih_61_1 wn_ih_61_1 mhp1 mhn1 vdd vbsyn gsyn
X_ihx_61_1 a_xp61 a_xn61 wp_ih_61_1 wn_ih_61_1 xhp1 xhn1 vdd vbsyn gsyn
X_ihm_62_1 a_xp62 a_xn62 wp_ih_62_1 wn_ih_62_1 mhp1 mhn1 vdd vbsyn gsyn
X_ihx_62_1 a_xp62 a_xn62 wp_ih_62_1 wn_ih_62_1 xhp1 xhn1 vdd vbsyn gsyn
X_ihm_63_1 a_xp63 a_xn63 wp_ih_63_1 wn_ih_63_1 mhp1 mhn1 vdd vbsyn gsyn
X_ihx_63_1 a_xp63 a_xn63 wp_ih_63_1 wn_ih_63_1 xhp1 xhn1 vdd vbsyn gsyn
Xn1 xhp1 xhn1 ahp1 ahn1 vdd vbneu dneuron
Xeh1 xhp1 xhn1 mhp1 mhn1 ehp1 ehn1 vdd gm esub
Xcm_mh2 mhp2 mhn2 vdd cmld
Rnd_mh2 mhp2 mhn2 20k
Xcm_xh2 xhp2 xhn2 vdd cmld
Rnd_xh2 xhp2 xhn2 20k
X_ihm_0_2 a_xp0 a_xn0 wp_ih_0_2 wn_ih_0_2 mhp2 mhn2 vdd vbsyn gsyn
X_ihx_0_2 a_xp0 a_xn0 wp_ih_0_2 wn_ih_0_2 xhp2 xhn2 vdd vbsyn gsyn
X_ihm_1_2 a_xp1 a_xn1 wp_ih_1_2 wn_ih_1_2 mhp2 mhn2 vdd vbsyn gsyn
X_ihx_1_2 a_xp1 a_xn1 wp_ih_1_2 wn_ih_1_2 xhp2 xhn2 vdd vbsyn gsyn
X_ihm_2_2 a_xp2 a_xn2 wp_ih_2_2 wn_ih_2_2 mhp2 mhn2 vdd vbsyn gsyn
X_ihx_2_2 a_xp2 a_xn2 wp_ih_2_2 wn_ih_2_2 xhp2 xhn2 vdd vbsyn gsyn
X_ihm_3_2 a_xp3 a_xn3 wp_ih_3_2 wn_ih_3_2 mhp2 mhn2 vdd vbsyn gsyn
X_ihx_3_2 a_xp3 a_xn3 wp_ih_3_2 wn_ih_3_2 xhp2 xhn2 vdd vbsyn gsyn
X_ihm_4_2 a_xp4 a_xn4 wp_ih_4_2 wn_ih_4_2 mhp2 mhn2 vdd vbsyn gsyn
X_ihx_4_2 a_xp4 a_xn4 wp_ih_4_2 wn_ih_4_2 xhp2 xhn2 vdd vbsyn gsyn
X_ihm_5_2 a_xp5 a_xn5 wp_ih_5_2 wn_ih_5_2 mhp2 mhn2 vdd vbsyn gsyn
X_ihx_5_2 a_xp5 a_xn5 wp_ih_5_2 wn_ih_5_2 xhp2 xhn2 vdd vbsyn gsyn
X_ihm_6_2 a_xp6 a_xn6 wp_ih_6_2 wn_ih_6_2 mhp2 mhn2 vdd vbsyn gsyn
X_ihx_6_2 a_xp6 a_xn6 wp_ih_6_2 wn_ih_6_2 xhp2 xhn2 vdd vbsyn gsyn
X_ihm_7_2 a_xp7 a_xn7 wp_ih_7_2 wn_ih_7_2 mhp2 mhn2 vdd vbsyn gsyn
X_ihx_7_2 a_xp7 a_xn7 wp_ih_7_2 wn_ih_7_2 xhp2 xhn2 vdd vbsyn gsyn
X_ihm_8_2 a_xp8 a_xn8 wp_ih_8_2 wn_ih_8_2 mhp2 mhn2 vdd vbsyn gsyn
X_ihx_8_2 a_xp8 a_xn8 wp_ih_8_2 wn_ih_8_2 xhp2 xhn2 vdd vbsyn gsyn
X_ihm_9_2 a_xp9 a_xn9 wp_ih_9_2 wn_ih_9_2 mhp2 mhn2 vdd vbsyn gsyn
X_ihx_9_2 a_xp9 a_xn9 wp_ih_9_2 wn_ih_9_2 xhp2 xhn2 vdd vbsyn gsyn
X_ihm_10_2 a_xp10 a_xn10 wp_ih_10_2 wn_ih_10_2 mhp2 mhn2 vdd vbsyn gsyn
X_ihx_10_2 a_xp10 a_xn10 wp_ih_10_2 wn_ih_10_2 xhp2 xhn2 vdd vbsyn gsyn
X_ihm_11_2 a_xp11 a_xn11 wp_ih_11_2 wn_ih_11_2 mhp2 mhn2 vdd vbsyn gsyn
X_ihx_11_2 a_xp11 a_xn11 wp_ih_11_2 wn_ih_11_2 xhp2 xhn2 vdd vbsyn gsyn
X_ihm_12_2 a_xp12 a_xn12 wp_ih_12_2 wn_ih_12_2 mhp2 mhn2 vdd vbsyn gsyn
X_ihx_12_2 a_xp12 a_xn12 wp_ih_12_2 wn_ih_12_2 xhp2 xhn2 vdd vbsyn gsyn
X_ihm_13_2 a_xp13 a_xn13 wp_ih_13_2 wn_ih_13_2 mhp2 mhn2 vdd vbsyn gsyn
X_ihx_13_2 a_xp13 a_xn13 wp_ih_13_2 wn_ih_13_2 xhp2 xhn2 vdd vbsyn gsyn
X_ihm_14_2 a_xp14 a_xn14 wp_ih_14_2 wn_ih_14_2 mhp2 mhn2 vdd vbsyn gsyn
X_ihx_14_2 a_xp14 a_xn14 wp_ih_14_2 wn_ih_14_2 xhp2 xhn2 vdd vbsyn gsyn
X_ihm_15_2 a_xp15 a_xn15 wp_ih_15_2 wn_ih_15_2 mhp2 mhn2 vdd vbsyn gsyn
X_ihx_15_2 a_xp15 a_xn15 wp_ih_15_2 wn_ih_15_2 xhp2 xhn2 vdd vbsyn gsyn
X_ihm_16_2 a_xp16 a_xn16 wp_ih_16_2 wn_ih_16_2 mhp2 mhn2 vdd vbsyn gsyn
X_ihx_16_2 a_xp16 a_xn16 wp_ih_16_2 wn_ih_16_2 xhp2 xhn2 vdd vbsyn gsyn
X_ihm_17_2 a_xp17 a_xn17 wp_ih_17_2 wn_ih_17_2 mhp2 mhn2 vdd vbsyn gsyn
X_ihx_17_2 a_xp17 a_xn17 wp_ih_17_2 wn_ih_17_2 xhp2 xhn2 vdd vbsyn gsyn
X_ihm_18_2 a_xp18 a_xn18 wp_ih_18_2 wn_ih_18_2 mhp2 mhn2 vdd vbsyn gsyn
X_ihx_18_2 a_xp18 a_xn18 wp_ih_18_2 wn_ih_18_2 xhp2 xhn2 vdd vbsyn gsyn
X_ihm_19_2 a_xp19 a_xn19 wp_ih_19_2 wn_ih_19_2 mhp2 mhn2 vdd vbsyn gsyn
X_ihx_19_2 a_xp19 a_xn19 wp_ih_19_2 wn_ih_19_2 xhp2 xhn2 vdd vbsyn gsyn
X_ihm_20_2 a_xp20 a_xn20 wp_ih_20_2 wn_ih_20_2 mhp2 mhn2 vdd vbsyn gsyn
X_ihx_20_2 a_xp20 a_xn20 wp_ih_20_2 wn_ih_20_2 xhp2 xhn2 vdd vbsyn gsyn
X_ihm_21_2 a_xp21 a_xn21 wp_ih_21_2 wn_ih_21_2 mhp2 mhn2 vdd vbsyn gsyn
X_ihx_21_2 a_xp21 a_xn21 wp_ih_21_2 wn_ih_21_2 xhp2 xhn2 vdd vbsyn gsyn
X_ihm_22_2 a_xp22 a_xn22 wp_ih_22_2 wn_ih_22_2 mhp2 mhn2 vdd vbsyn gsyn
X_ihx_22_2 a_xp22 a_xn22 wp_ih_22_2 wn_ih_22_2 xhp2 xhn2 vdd vbsyn gsyn
X_ihm_23_2 a_xp23 a_xn23 wp_ih_23_2 wn_ih_23_2 mhp2 mhn2 vdd vbsyn gsyn
X_ihx_23_2 a_xp23 a_xn23 wp_ih_23_2 wn_ih_23_2 xhp2 xhn2 vdd vbsyn gsyn
X_ihm_24_2 a_xp24 a_xn24 wp_ih_24_2 wn_ih_24_2 mhp2 mhn2 vdd vbsyn gsyn
X_ihx_24_2 a_xp24 a_xn24 wp_ih_24_2 wn_ih_24_2 xhp2 xhn2 vdd vbsyn gsyn
X_ihm_25_2 a_xp25 a_xn25 wp_ih_25_2 wn_ih_25_2 mhp2 mhn2 vdd vbsyn gsyn
X_ihx_25_2 a_xp25 a_xn25 wp_ih_25_2 wn_ih_25_2 xhp2 xhn2 vdd vbsyn gsyn
X_ihm_26_2 a_xp26 a_xn26 wp_ih_26_2 wn_ih_26_2 mhp2 mhn2 vdd vbsyn gsyn
X_ihx_26_2 a_xp26 a_xn26 wp_ih_26_2 wn_ih_26_2 xhp2 xhn2 vdd vbsyn gsyn
X_ihm_27_2 a_xp27 a_xn27 wp_ih_27_2 wn_ih_27_2 mhp2 mhn2 vdd vbsyn gsyn
X_ihx_27_2 a_xp27 a_xn27 wp_ih_27_2 wn_ih_27_2 xhp2 xhn2 vdd vbsyn gsyn
X_ihm_28_2 a_xp28 a_xn28 wp_ih_28_2 wn_ih_28_2 mhp2 mhn2 vdd vbsyn gsyn
X_ihx_28_2 a_xp28 a_xn28 wp_ih_28_2 wn_ih_28_2 xhp2 xhn2 vdd vbsyn gsyn
X_ihm_29_2 a_xp29 a_xn29 wp_ih_29_2 wn_ih_29_2 mhp2 mhn2 vdd vbsyn gsyn
X_ihx_29_2 a_xp29 a_xn29 wp_ih_29_2 wn_ih_29_2 xhp2 xhn2 vdd vbsyn gsyn
X_ihm_30_2 a_xp30 a_xn30 wp_ih_30_2 wn_ih_30_2 mhp2 mhn2 vdd vbsyn gsyn
X_ihx_30_2 a_xp30 a_xn30 wp_ih_30_2 wn_ih_30_2 xhp2 xhn2 vdd vbsyn gsyn
X_ihm_31_2 a_xp31 a_xn31 wp_ih_31_2 wn_ih_31_2 mhp2 mhn2 vdd vbsyn gsyn
X_ihx_31_2 a_xp31 a_xn31 wp_ih_31_2 wn_ih_31_2 xhp2 xhn2 vdd vbsyn gsyn
X_ihm_32_2 a_xp32 a_xn32 wp_ih_32_2 wn_ih_32_2 mhp2 mhn2 vdd vbsyn gsyn
X_ihx_32_2 a_xp32 a_xn32 wp_ih_32_2 wn_ih_32_2 xhp2 xhn2 vdd vbsyn gsyn
X_ihm_33_2 a_xp33 a_xn33 wp_ih_33_2 wn_ih_33_2 mhp2 mhn2 vdd vbsyn gsyn
X_ihx_33_2 a_xp33 a_xn33 wp_ih_33_2 wn_ih_33_2 xhp2 xhn2 vdd vbsyn gsyn
X_ihm_34_2 a_xp34 a_xn34 wp_ih_34_2 wn_ih_34_2 mhp2 mhn2 vdd vbsyn gsyn
X_ihx_34_2 a_xp34 a_xn34 wp_ih_34_2 wn_ih_34_2 xhp2 xhn2 vdd vbsyn gsyn
X_ihm_35_2 a_xp35 a_xn35 wp_ih_35_2 wn_ih_35_2 mhp2 mhn2 vdd vbsyn gsyn
X_ihx_35_2 a_xp35 a_xn35 wp_ih_35_2 wn_ih_35_2 xhp2 xhn2 vdd vbsyn gsyn
X_ihm_36_2 a_xp36 a_xn36 wp_ih_36_2 wn_ih_36_2 mhp2 mhn2 vdd vbsyn gsyn
X_ihx_36_2 a_xp36 a_xn36 wp_ih_36_2 wn_ih_36_2 xhp2 xhn2 vdd vbsyn gsyn
X_ihm_37_2 a_xp37 a_xn37 wp_ih_37_2 wn_ih_37_2 mhp2 mhn2 vdd vbsyn gsyn
X_ihx_37_2 a_xp37 a_xn37 wp_ih_37_2 wn_ih_37_2 xhp2 xhn2 vdd vbsyn gsyn
X_ihm_38_2 a_xp38 a_xn38 wp_ih_38_2 wn_ih_38_2 mhp2 mhn2 vdd vbsyn gsyn
X_ihx_38_2 a_xp38 a_xn38 wp_ih_38_2 wn_ih_38_2 xhp2 xhn2 vdd vbsyn gsyn
X_ihm_39_2 a_xp39 a_xn39 wp_ih_39_2 wn_ih_39_2 mhp2 mhn2 vdd vbsyn gsyn
X_ihx_39_2 a_xp39 a_xn39 wp_ih_39_2 wn_ih_39_2 xhp2 xhn2 vdd vbsyn gsyn
X_ihm_40_2 a_xp40 a_xn40 wp_ih_40_2 wn_ih_40_2 mhp2 mhn2 vdd vbsyn gsyn
X_ihx_40_2 a_xp40 a_xn40 wp_ih_40_2 wn_ih_40_2 xhp2 xhn2 vdd vbsyn gsyn
X_ihm_41_2 a_xp41 a_xn41 wp_ih_41_2 wn_ih_41_2 mhp2 mhn2 vdd vbsyn gsyn
X_ihx_41_2 a_xp41 a_xn41 wp_ih_41_2 wn_ih_41_2 xhp2 xhn2 vdd vbsyn gsyn
X_ihm_42_2 a_xp42 a_xn42 wp_ih_42_2 wn_ih_42_2 mhp2 mhn2 vdd vbsyn gsyn
X_ihx_42_2 a_xp42 a_xn42 wp_ih_42_2 wn_ih_42_2 xhp2 xhn2 vdd vbsyn gsyn
X_ihm_43_2 a_xp43 a_xn43 wp_ih_43_2 wn_ih_43_2 mhp2 mhn2 vdd vbsyn gsyn
X_ihx_43_2 a_xp43 a_xn43 wp_ih_43_2 wn_ih_43_2 xhp2 xhn2 vdd vbsyn gsyn
X_ihm_44_2 a_xp44 a_xn44 wp_ih_44_2 wn_ih_44_2 mhp2 mhn2 vdd vbsyn gsyn
X_ihx_44_2 a_xp44 a_xn44 wp_ih_44_2 wn_ih_44_2 xhp2 xhn2 vdd vbsyn gsyn
X_ihm_45_2 a_xp45 a_xn45 wp_ih_45_2 wn_ih_45_2 mhp2 mhn2 vdd vbsyn gsyn
X_ihx_45_2 a_xp45 a_xn45 wp_ih_45_2 wn_ih_45_2 xhp2 xhn2 vdd vbsyn gsyn
X_ihm_46_2 a_xp46 a_xn46 wp_ih_46_2 wn_ih_46_2 mhp2 mhn2 vdd vbsyn gsyn
X_ihx_46_2 a_xp46 a_xn46 wp_ih_46_2 wn_ih_46_2 xhp2 xhn2 vdd vbsyn gsyn
X_ihm_47_2 a_xp47 a_xn47 wp_ih_47_2 wn_ih_47_2 mhp2 mhn2 vdd vbsyn gsyn
X_ihx_47_2 a_xp47 a_xn47 wp_ih_47_2 wn_ih_47_2 xhp2 xhn2 vdd vbsyn gsyn
X_ihm_48_2 a_xp48 a_xn48 wp_ih_48_2 wn_ih_48_2 mhp2 mhn2 vdd vbsyn gsyn
X_ihx_48_2 a_xp48 a_xn48 wp_ih_48_2 wn_ih_48_2 xhp2 xhn2 vdd vbsyn gsyn
X_ihm_49_2 a_xp49 a_xn49 wp_ih_49_2 wn_ih_49_2 mhp2 mhn2 vdd vbsyn gsyn
X_ihx_49_2 a_xp49 a_xn49 wp_ih_49_2 wn_ih_49_2 xhp2 xhn2 vdd vbsyn gsyn
X_ihm_50_2 a_xp50 a_xn50 wp_ih_50_2 wn_ih_50_2 mhp2 mhn2 vdd vbsyn gsyn
X_ihx_50_2 a_xp50 a_xn50 wp_ih_50_2 wn_ih_50_2 xhp2 xhn2 vdd vbsyn gsyn
X_ihm_51_2 a_xp51 a_xn51 wp_ih_51_2 wn_ih_51_2 mhp2 mhn2 vdd vbsyn gsyn
X_ihx_51_2 a_xp51 a_xn51 wp_ih_51_2 wn_ih_51_2 xhp2 xhn2 vdd vbsyn gsyn
X_ihm_52_2 a_xp52 a_xn52 wp_ih_52_2 wn_ih_52_2 mhp2 mhn2 vdd vbsyn gsyn
X_ihx_52_2 a_xp52 a_xn52 wp_ih_52_2 wn_ih_52_2 xhp2 xhn2 vdd vbsyn gsyn
X_ihm_53_2 a_xp53 a_xn53 wp_ih_53_2 wn_ih_53_2 mhp2 mhn2 vdd vbsyn gsyn
X_ihx_53_2 a_xp53 a_xn53 wp_ih_53_2 wn_ih_53_2 xhp2 xhn2 vdd vbsyn gsyn
X_ihm_54_2 a_xp54 a_xn54 wp_ih_54_2 wn_ih_54_2 mhp2 mhn2 vdd vbsyn gsyn
X_ihx_54_2 a_xp54 a_xn54 wp_ih_54_2 wn_ih_54_2 xhp2 xhn2 vdd vbsyn gsyn
X_ihm_55_2 a_xp55 a_xn55 wp_ih_55_2 wn_ih_55_2 mhp2 mhn2 vdd vbsyn gsyn
X_ihx_55_2 a_xp55 a_xn55 wp_ih_55_2 wn_ih_55_2 xhp2 xhn2 vdd vbsyn gsyn
X_ihm_56_2 a_xp56 a_xn56 wp_ih_56_2 wn_ih_56_2 mhp2 mhn2 vdd vbsyn gsyn
X_ihx_56_2 a_xp56 a_xn56 wp_ih_56_2 wn_ih_56_2 xhp2 xhn2 vdd vbsyn gsyn
X_ihm_57_2 a_xp57 a_xn57 wp_ih_57_2 wn_ih_57_2 mhp2 mhn2 vdd vbsyn gsyn
X_ihx_57_2 a_xp57 a_xn57 wp_ih_57_2 wn_ih_57_2 xhp2 xhn2 vdd vbsyn gsyn
X_ihm_58_2 a_xp58 a_xn58 wp_ih_58_2 wn_ih_58_2 mhp2 mhn2 vdd vbsyn gsyn
X_ihx_58_2 a_xp58 a_xn58 wp_ih_58_2 wn_ih_58_2 xhp2 xhn2 vdd vbsyn gsyn
X_ihm_59_2 a_xp59 a_xn59 wp_ih_59_2 wn_ih_59_2 mhp2 mhn2 vdd vbsyn gsyn
X_ihx_59_2 a_xp59 a_xn59 wp_ih_59_2 wn_ih_59_2 xhp2 xhn2 vdd vbsyn gsyn
X_ihm_60_2 a_xp60 a_xn60 wp_ih_60_2 wn_ih_60_2 mhp2 mhn2 vdd vbsyn gsyn
X_ihx_60_2 a_xp60 a_xn60 wp_ih_60_2 wn_ih_60_2 xhp2 xhn2 vdd vbsyn gsyn
X_ihm_61_2 a_xp61 a_xn61 wp_ih_61_2 wn_ih_61_2 mhp2 mhn2 vdd vbsyn gsyn
X_ihx_61_2 a_xp61 a_xn61 wp_ih_61_2 wn_ih_61_2 xhp2 xhn2 vdd vbsyn gsyn
X_ihm_62_2 a_xp62 a_xn62 wp_ih_62_2 wn_ih_62_2 mhp2 mhn2 vdd vbsyn gsyn
X_ihx_62_2 a_xp62 a_xn62 wp_ih_62_2 wn_ih_62_2 xhp2 xhn2 vdd vbsyn gsyn
X_ihm_63_2 a_xp63 a_xn63 wp_ih_63_2 wn_ih_63_2 mhp2 mhn2 vdd vbsyn gsyn
X_ihx_63_2 a_xp63 a_xn63 wp_ih_63_2 wn_ih_63_2 xhp2 xhn2 vdd vbsyn gsyn
Xn2 xhp2 xhn2 ahp2 ahn2 vdd vbneu dneuron
Xeh2 xhp2 xhn2 mhp2 mhn2 ehp2 ehn2 vdd gm esub
Xcm_mh3 mhp3 mhn3 vdd cmld
Rnd_mh3 mhp3 mhn3 20k
Xcm_xh3 xhp3 xhn3 vdd cmld
Rnd_xh3 xhp3 xhn3 20k
X_ihm_0_3 a_xp0 a_xn0 wp_ih_0_3 wn_ih_0_3 mhp3 mhn3 vdd vbsyn gsyn
X_ihx_0_3 a_xp0 a_xn0 wp_ih_0_3 wn_ih_0_3 xhp3 xhn3 vdd vbsyn gsyn
X_ihm_1_3 a_xp1 a_xn1 wp_ih_1_3 wn_ih_1_3 mhp3 mhn3 vdd vbsyn gsyn
X_ihx_1_3 a_xp1 a_xn1 wp_ih_1_3 wn_ih_1_3 xhp3 xhn3 vdd vbsyn gsyn
X_ihm_2_3 a_xp2 a_xn2 wp_ih_2_3 wn_ih_2_3 mhp3 mhn3 vdd vbsyn gsyn
X_ihx_2_3 a_xp2 a_xn2 wp_ih_2_3 wn_ih_2_3 xhp3 xhn3 vdd vbsyn gsyn
X_ihm_3_3 a_xp3 a_xn3 wp_ih_3_3 wn_ih_3_3 mhp3 mhn3 vdd vbsyn gsyn
X_ihx_3_3 a_xp3 a_xn3 wp_ih_3_3 wn_ih_3_3 xhp3 xhn3 vdd vbsyn gsyn
X_ihm_4_3 a_xp4 a_xn4 wp_ih_4_3 wn_ih_4_3 mhp3 mhn3 vdd vbsyn gsyn
X_ihx_4_3 a_xp4 a_xn4 wp_ih_4_3 wn_ih_4_3 xhp3 xhn3 vdd vbsyn gsyn
X_ihm_5_3 a_xp5 a_xn5 wp_ih_5_3 wn_ih_5_3 mhp3 mhn3 vdd vbsyn gsyn
X_ihx_5_3 a_xp5 a_xn5 wp_ih_5_3 wn_ih_5_3 xhp3 xhn3 vdd vbsyn gsyn
X_ihm_6_3 a_xp6 a_xn6 wp_ih_6_3 wn_ih_6_3 mhp3 mhn3 vdd vbsyn gsyn
X_ihx_6_3 a_xp6 a_xn6 wp_ih_6_3 wn_ih_6_3 xhp3 xhn3 vdd vbsyn gsyn
X_ihm_7_3 a_xp7 a_xn7 wp_ih_7_3 wn_ih_7_3 mhp3 mhn3 vdd vbsyn gsyn
X_ihx_7_3 a_xp7 a_xn7 wp_ih_7_3 wn_ih_7_3 xhp3 xhn3 vdd vbsyn gsyn
X_ihm_8_3 a_xp8 a_xn8 wp_ih_8_3 wn_ih_8_3 mhp3 mhn3 vdd vbsyn gsyn
X_ihx_8_3 a_xp8 a_xn8 wp_ih_8_3 wn_ih_8_3 xhp3 xhn3 vdd vbsyn gsyn
X_ihm_9_3 a_xp9 a_xn9 wp_ih_9_3 wn_ih_9_3 mhp3 mhn3 vdd vbsyn gsyn
X_ihx_9_3 a_xp9 a_xn9 wp_ih_9_3 wn_ih_9_3 xhp3 xhn3 vdd vbsyn gsyn
X_ihm_10_3 a_xp10 a_xn10 wp_ih_10_3 wn_ih_10_3 mhp3 mhn3 vdd vbsyn gsyn
X_ihx_10_3 a_xp10 a_xn10 wp_ih_10_3 wn_ih_10_3 xhp3 xhn3 vdd vbsyn gsyn
X_ihm_11_3 a_xp11 a_xn11 wp_ih_11_3 wn_ih_11_3 mhp3 mhn3 vdd vbsyn gsyn
X_ihx_11_3 a_xp11 a_xn11 wp_ih_11_3 wn_ih_11_3 xhp3 xhn3 vdd vbsyn gsyn
X_ihm_12_3 a_xp12 a_xn12 wp_ih_12_3 wn_ih_12_3 mhp3 mhn3 vdd vbsyn gsyn
X_ihx_12_3 a_xp12 a_xn12 wp_ih_12_3 wn_ih_12_3 xhp3 xhn3 vdd vbsyn gsyn
X_ihm_13_3 a_xp13 a_xn13 wp_ih_13_3 wn_ih_13_3 mhp3 mhn3 vdd vbsyn gsyn
X_ihx_13_3 a_xp13 a_xn13 wp_ih_13_3 wn_ih_13_3 xhp3 xhn3 vdd vbsyn gsyn
X_ihm_14_3 a_xp14 a_xn14 wp_ih_14_3 wn_ih_14_3 mhp3 mhn3 vdd vbsyn gsyn
X_ihx_14_3 a_xp14 a_xn14 wp_ih_14_3 wn_ih_14_3 xhp3 xhn3 vdd vbsyn gsyn
X_ihm_15_3 a_xp15 a_xn15 wp_ih_15_3 wn_ih_15_3 mhp3 mhn3 vdd vbsyn gsyn
X_ihx_15_3 a_xp15 a_xn15 wp_ih_15_3 wn_ih_15_3 xhp3 xhn3 vdd vbsyn gsyn
X_ihm_16_3 a_xp16 a_xn16 wp_ih_16_3 wn_ih_16_3 mhp3 mhn3 vdd vbsyn gsyn
X_ihx_16_3 a_xp16 a_xn16 wp_ih_16_3 wn_ih_16_3 xhp3 xhn3 vdd vbsyn gsyn
X_ihm_17_3 a_xp17 a_xn17 wp_ih_17_3 wn_ih_17_3 mhp3 mhn3 vdd vbsyn gsyn
X_ihx_17_3 a_xp17 a_xn17 wp_ih_17_3 wn_ih_17_3 xhp3 xhn3 vdd vbsyn gsyn
X_ihm_18_3 a_xp18 a_xn18 wp_ih_18_3 wn_ih_18_3 mhp3 mhn3 vdd vbsyn gsyn
X_ihx_18_3 a_xp18 a_xn18 wp_ih_18_3 wn_ih_18_3 xhp3 xhn3 vdd vbsyn gsyn
X_ihm_19_3 a_xp19 a_xn19 wp_ih_19_3 wn_ih_19_3 mhp3 mhn3 vdd vbsyn gsyn
X_ihx_19_3 a_xp19 a_xn19 wp_ih_19_3 wn_ih_19_3 xhp3 xhn3 vdd vbsyn gsyn
X_ihm_20_3 a_xp20 a_xn20 wp_ih_20_3 wn_ih_20_3 mhp3 mhn3 vdd vbsyn gsyn
X_ihx_20_3 a_xp20 a_xn20 wp_ih_20_3 wn_ih_20_3 xhp3 xhn3 vdd vbsyn gsyn
X_ihm_21_3 a_xp21 a_xn21 wp_ih_21_3 wn_ih_21_3 mhp3 mhn3 vdd vbsyn gsyn
X_ihx_21_3 a_xp21 a_xn21 wp_ih_21_3 wn_ih_21_3 xhp3 xhn3 vdd vbsyn gsyn
X_ihm_22_3 a_xp22 a_xn22 wp_ih_22_3 wn_ih_22_3 mhp3 mhn3 vdd vbsyn gsyn
X_ihx_22_3 a_xp22 a_xn22 wp_ih_22_3 wn_ih_22_3 xhp3 xhn3 vdd vbsyn gsyn
X_ihm_23_3 a_xp23 a_xn23 wp_ih_23_3 wn_ih_23_3 mhp3 mhn3 vdd vbsyn gsyn
X_ihx_23_3 a_xp23 a_xn23 wp_ih_23_3 wn_ih_23_3 xhp3 xhn3 vdd vbsyn gsyn
X_ihm_24_3 a_xp24 a_xn24 wp_ih_24_3 wn_ih_24_3 mhp3 mhn3 vdd vbsyn gsyn
X_ihx_24_3 a_xp24 a_xn24 wp_ih_24_3 wn_ih_24_3 xhp3 xhn3 vdd vbsyn gsyn
X_ihm_25_3 a_xp25 a_xn25 wp_ih_25_3 wn_ih_25_3 mhp3 mhn3 vdd vbsyn gsyn
X_ihx_25_3 a_xp25 a_xn25 wp_ih_25_3 wn_ih_25_3 xhp3 xhn3 vdd vbsyn gsyn
X_ihm_26_3 a_xp26 a_xn26 wp_ih_26_3 wn_ih_26_3 mhp3 mhn3 vdd vbsyn gsyn
X_ihx_26_3 a_xp26 a_xn26 wp_ih_26_3 wn_ih_26_3 xhp3 xhn3 vdd vbsyn gsyn
X_ihm_27_3 a_xp27 a_xn27 wp_ih_27_3 wn_ih_27_3 mhp3 mhn3 vdd vbsyn gsyn
X_ihx_27_3 a_xp27 a_xn27 wp_ih_27_3 wn_ih_27_3 xhp3 xhn3 vdd vbsyn gsyn
X_ihm_28_3 a_xp28 a_xn28 wp_ih_28_3 wn_ih_28_3 mhp3 mhn3 vdd vbsyn gsyn
X_ihx_28_3 a_xp28 a_xn28 wp_ih_28_3 wn_ih_28_3 xhp3 xhn3 vdd vbsyn gsyn
X_ihm_29_3 a_xp29 a_xn29 wp_ih_29_3 wn_ih_29_3 mhp3 mhn3 vdd vbsyn gsyn
X_ihx_29_3 a_xp29 a_xn29 wp_ih_29_3 wn_ih_29_3 xhp3 xhn3 vdd vbsyn gsyn
X_ihm_30_3 a_xp30 a_xn30 wp_ih_30_3 wn_ih_30_3 mhp3 mhn3 vdd vbsyn gsyn
X_ihx_30_3 a_xp30 a_xn30 wp_ih_30_3 wn_ih_30_3 xhp3 xhn3 vdd vbsyn gsyn
X_ihm_31_3 a_xp31 a_xn31 wp_ih_31_3 wn_ih_31_3 mhp3 mhn3 vdd vbsyn gsyn
X_ihx_31_3 a_xp31 a_xn31 wp_ih_31_3 wn_ih_31_3 xhp3 xhn3 vdd vbsyn gsyn
X_ihm_32_3 a_xp32 a_xn32 wp_ih_32_3 wn_ih_32_3 mhp3 mhn3 vdd vbsyn gsyn
X_ihx_32_3 a_xp32 a_xn32 wp_ih_32_3 wn_ih_32_3 xhp3 xhn3 vdd vbsyn gsyn
X_ihm_33_3 a_xp33 a_xn33 wp_ih_33_3 wn_ih_33_3 mhp3 mhn3 vdd vbsyn gsyn
X_ihx_33_3 a_xp33 a_xn33 wp_ih_33_3 wn_ih_33_3 xhp3 xhn3 vdd vbsyn gsyn
X_ihm_34_3 a_xp34 a_xn34 wp_ih_34_3 wn_ih_34_3 mhp3 mhn3 vdd vbsyn gsyn
X_ihx_34_3 a_xp34 a_xn34 wp_ih_34_3 wn_ih_34_3 xhp3 xhn3 vdd vbsyn gsyn
X_ihm_35_3 a_xp35 a_xn35 wp_ih_35_3 wn_ih_35_3 mhp3 mhn3 vdd vbsyn gsyn
X_ihx_35_3 a_xp35 a_xn35 wp_ih_35_3 wn_ih_35_3 xhp3 xhn3 vdd vbsyn gsyn
X_ihm_36_3 a_xp36 a_xn36 wp_ih_36_3 wn_ih_36_3 mhp3 mhn3 vdd vbsyn gsyn
X_ihx_36_3 a_xp36 a_xn36 wp_ih_36_3 wn_ih_36_3 xhp3 xhn3 vdd vbsyn gsyn
X_ihm_37_3 a_xp37 a_xn37 wp_ih_37_3 wn_ih_37_3 mhp3 mhn3 vdd vbsyn gsyn
X_ihx_37_3 a_xp37 a_xn37 wp_ih_37_3 wn_ih_37_3 xhp3 xhn3 vdd vbsyn gsyn
X_ihm_38_3 a_xp38 a_xn38 wp_ih_38_3 wn_ih_38_3 mhp3 mhn3 vdd vbsyn gsyn
X_ihx_38_3 a_xp38 a_xn38 wp_ih_38_3 wn_ih_38_3 xhp3 xhn3 vdd vbsyn gsyn
X_ihm_39_3 a_xp39 a_xn39 wp_ih_39_3 wn_ih_39_3 mhp3 mhn3 vdd vbsyn gsyn
X_ihx_39_3 a_xp39 a_xn39 wp_ih_39_3 wn_ih_39_3 xhp3 xhn3 vdd vbsyn gsyn
X_ihm_40_3 a_xp40 a_xn40 wp_ih_40_3 wn_ih_40_3 mhp3 mhn3 vdd vbsyn gsyn
X_ihx_40_3 a_xp40 a_xn40 wp_ih_40_3 wn_ih_40_3 xhp3 xhn3 vdd vbsyn gsyn
X_ihm_41_3 a_xp41 a_xn41 wp_ih_41_3 wn_ih_41_3 mhp3 mhn3 vdd vbsyn gsyn
X_ihx_41_3 a_xp41 a_xn41 wp_ih_41_3 wn_ih_41_3 xhp3 xhn3 vdd vbsyn gsyn
X_ihm_42_3 a_xp42 a_xn42 wp_ih_42_3 wn_ih_42_3 mhp3 mhn3 vdd vbsyn gsyn
X_ihx_42_3 a_xp42 a_xn42 wp_ih_42_3 wn_ih_42_3 xhp3 xhn3 vdd vbsyn gsyn
X_ihm_43_3 a_xp43 a_xn43 wp_ih_43_3 wn_ih_43_3 mhp3 mhn3 vdd vbsyn gsyn
X_ihx_43_3 a_xp43 a_xn43 wp_ih_43_3 wn_ih_43_3 xhp3 xhn3 vdd vbsyn gsyn
X_ihm_44_3 a_xp44 a_xn44 wp_ih_44_3 wn_ih_44_3 mhp3 mhn3 vdd vbsyn gsyn
X_ihx_44_3 a_xp44 a_xn44 wp_ih_44_3 wn_ih_44_3 xhp3 xhn3 vdd vbsyn gsyn
X_ihm_45_3 a_xp45 a_xn45 wp_ih_45_3 wn_ih_45_3 mhp3 mhn3 vdd vbsyn gsyn
X_ihx_45_3 a_xp45 a_xn45 wp_ih_45_3 wn_ih_45_3 xhp3 xhn3 vdd vbsyn gsyn
X_ihm_46_3 a_xp46 a_xn46 wp_ih_46_3 wn_ih_46_3 mhp3 mhn3 vdd vbsyn gsyn
X_ihx_46_3 a_xp46 a_xn46 wp_ih_46_3 wn_ih_46_3 xhp3 xhn3 vdd vbsyn gsyn
X_ihm_47_3 a_xp47 a_xn47 wp_ih_47_3 wn_ih_47_3 mhp3 mhn3 vdd vbsyn gsyn
X_ihx_47_3 a_xp47 a_xn47 wp_ih_47_3 wn_ih_47_3 xhp3 xhn3 vdd vbsyn gsyn
X_ihm_48_3 a_xp48 a_xn48 wp_ih_48_3 wn_ih_48_3 mhp3 mhn3 vdd vbsyn gsyn
X_ihx_48_3 a_xp48 a_xn48 wp_ih_48_3 wn_ih_48_3 xhp3 xhn3 vdd vbsyn gsyn
X_ihm_49_3 a_xp49 a_xn49 wp_ih_49_3 wn_ih_49_3 mhp3 mhn3 vdd vbsyn gsyn
X_ihx_49_3 a_xp49 a_xn49 wp_ih_49_3 wn_ih_49_3 xhp3 xhn3 vdd vbsyn gsyn
X_ihm_50_3 a_xp50 a_xn50 wp_ih_50_3 wn_ih_50_3 mhp3 mhn3 vdd vbsyn gsyn
X_ihx_50_3 a_xp50 a_xn50 wp_ih_50_3 wn_ih_50_3 xhp3 xhn3 vdd vbsyn gsyn
X_ihm_51_3 a_xp51 a_xn51 wp_ih_51_3 wn_ih_51_3 mhp3 mhn3 vdd vbsyn gsyn
X_ihx_51_3 a_xp51 a_xn51 wp_ih_51_3 wn_ih_51_3 xhp3 xhn3 vdd vbsyn gsyn
X_ihm_52_3 a_xp52 a_xn52 wp_ih_52_3 wn_ih_52_3 mhp3 mhn3 vdd vbsyn gsyn
X_ihx_52_3 a_xp52 a_xn52 wp_ih_52_3 wn_ih_52_3 xhp3 xhn3 vdd vbsyn gsyn
X_ihm_53_3 a_xp53 a_xn53 wp_ih_53_3 wn_ih_53_3 mhp3 mhn3 vdd vbsyn gsyn
X_ihx_53_3 a_xp53 a_xn53 wp_ih_53_3 wn_ih_53_3 xhp3 xhn3 vdd vbsyn gsyn
X_ihm_54_3 a_xp54 a_xn54 wp_ih_54_3 wn_ih_54_3 mhp3 mhn3 vdd vbsyn gsyn
X_ihx_54_3 a_xp54 a_xn54 wp_ih_54_3 wn_ih_54_3 xhp3 xhn3 vdd vbsyn gsyn
X_ihm_55_3 a_xp55 a_xn55 wp_ih_55_3 wn_ih_55_3 mhp3 mhn3 vdd vbsyn gsyn
X_ihx_55_3 a_xp55 a_xn55 wp_ih_55_3 wn_ih_55_3 xhp3 xhn3 vdd vbsyn gsyn
X_ihm_56_3 a_xp56 a_xn56 wp_ih_56_3 wn_ih_56_3 mhp3 mhn3 vdd vbsyn gsyn
X_ihx_56_3 a_xp56 a_xn56 wp_ih_56_3 wn_ih_56_3 xhp3 xhn3 vdd vbsyn gsyn
X_ihm_57_3 a_xp57 a_xn57 wp_ih_57_3 wn_ih_57_3 mhp3 mhn3 vdd vbsyn gsyn
X_ihx_57_3 a_xp57 a_xn57 wp_ih_57_3 wn_ih_57_3 xhp3 xhn3 vdd vbsyn gsyn
X_ihm_58_3 a_xp58 a_xn58 wp_ih_58_3 wn_ih_58_3 mhp3 mhn3 vdd vbsyn gsyn
X_ihx_58_3 a_xp58 a_xn58 wp_ih_58_3 wn_ih_58_3 xhp3 xhn3 vdd vbsyn gsyn
X_ihm_59_3 a_xp59 a_xn59 wp_ih_59_3 wn_ih_59_3 mhp3 mhn3 vdd vbsyn gsyn
X_ihx_59_3 a_xp59 a_xn59 wp_ih_59_3 wn_ih_59_3 xhp3 xhn3 vdd vbsyn gsyn
X_ihm_60_3 a_xp60 a_xn60 wp_ih_60_3 wn_ih_60_3 mhp3 mhn3 vdd vbsyn gsyn
X_ihx_60_3 a_xp60 a_xn60 wp_ih_60_3 wn_ih_60_3 xhp3 xhn3 vdd vbsyn gsyn
X_ihm_61_3 a_xp61 a_xn61 wp_ih_61_3 wn_ih_61_3 mhp3 mhn3 vdd vbsyn gsyn
X_ihx_61_3 a_xp61 a_xn61 wp_ih_61_3 wn_ih_61_3 xhp3 xhn3 vdd vbsyn gsyn
X_ihm_62_3 a_xp62 a_xn62 wp_ih_62_3 wn_ih_62_3 mhp3 mhn3 vdd vbsyn gsyn
X_ihx_62_3 a_xp62 a_xn62 wp_ih_62_3 wn_ih_62_3 xhp3 xhn3 vdd vbsyn gsyn
X_ihm_63_3 a_xp63 a_xn63 wp_ih_63_3 wn_ih_63_3 mhp3 mhn3 vdd vbsyn gsyn
X_ihx_63_3 a_xp63 a_xn63 wp_ih_63_3 wn_ih_63_3 xhp3 xhn3 vdd vbsyn gsyn
Xn3 xhp3 xhn3 ahp3 ahn3 vdd vbneu dneuron
Xeh3 xhp3 xhn3 mhp3 mhn3 ehp3 ehn3 vdd gm esub
Xcm_mh4 mhp4 mhn4 vdd cmld
Rnd_mh4 mhp4 mhn4 20k
Xcm_xh4 xhp4 xhn4 vdd cmld
Rnd_xh4 xhp4 xhn4 20k
X_ihm_0_4 a_xp0 a_xn0 wp_ih_0_4 wn_ih_0_4 mhp4 mhn4 vdd vbsyn gsyn
X_ihx_0_4 a_xp0 a_xn0 wp_ih_0_4 wn_ih_0_4 xhp4 xhn4 vdd vbsyn gsyn
X_ihm_1_4 a_xp1 a_xn1 wp_ih_1_4 wn_ih_1_4 mhp4 mhn4 vdd vbsyn gsyn
X_ihx_1_4 a_xp1 a_xn1 wp_ih_1_4 wn_ih_1_4 xhp4 xhn4 vdd vbsyn gsyn
X_ihm_2_4 a_xp2 a_xn2 wp_ih_2_4 wn_ih_2_4 mhp4 mhn4 vdd vbsyn gsyn
X_ihx_2_4 a_xp2 a_xn2 wp_ih_2_4 wn_ih_2_4 xhp4 xhn4 vdd vbsyn gsyn
X_ihm_3_4 a_xp3 a_xn3 wp_ih_3_4 wn_ih_3_4 mhp4 mhn4 vdd vbsyn gsyn
X_ihx_3_4 a_xp3 a_xn3 wp_ih_3_4 wn_ih_3_4 xhp4 xhn4 vdd vbsyn gsyn
X_ihm_4_4 a_xp4 a_xn4 wp_ih_4_4 wn_ih_4_4 mhp4 mhn4 vdd vbsyn gsyn
X_ihx_4_4 a_xp4 a_xn4 wp_ih_4_4 wn_ih_4_4 xhp4 xhn4 vdd vbsyn gsyn
X_ihm_5_4 a_xp5 a_xn5 wp_ih_5_4 wn_ih_5_4 mhp4 mhn4 vdd vbsyn gsyn
X_ihx_5_4 a_xp5 a_xn5 wp_ih_5_4 wn_ih_5_4 xhp4 xhn4 vdd vbsyn gsyn
X_ihm_6_4 a_xp6 a_xn6 wp_ih_6_4 wn_ih_6_4 mhp4 mhn4 vdd vbsyn gsyn
X_ihx_6_4 a_xp6 a_xn6 wp_ih_6_4 wn_ih_6_4 xhp4 xhn4 vdd vbsyn gsyn
X_ihm_7_4 a_xp7 a_xn7 wp_ih_7_4 wn_ih_7_4 mhp4 mhn4 vdd vbsyn gsyn
X_ihx_7_4 a_xp7 a_xn7 wp_ih_7_4 wn_ih_7_4 xhp4 xhn4 vdd vbsyn gsyn
X_ihm_8_4 a_xp8 a_xn8 wp_ih_8_4 wn_ih_8_4 mhp4 mhn4 vdd vbsyn gsyn
X_ihx_8_4 a_xp8 a_xn8 wp_ih_8_4 wn_ih_8_4 xhp4 xhn4 vdd vbsyn gsyn
X_ihm_9_4 a_xp9 a_xn9 wp_ih_9_4 wn_ih_9_4 mhp4 mhn4 vdd vbsyn gsyn
X_ihx_9_4 a_xp9 a_xn9 wp_ih_9_4 wn_ih_9_4 xhp4 xhn4 vdd vbsyn gsyn
X_ihm_10_4 a_xp10 a_xn10 wp_ih_10_4 wn_ih_10_4 mhp4 mhn4 vdd vbsyn gsyn
X_ihx_10_4 a_xp10 a_xn10 wp_ih_10_4 wn_ih_10_4 xhp4 xhn4 vdd vbsyn gsyn
X_ihm_11_4 a_xp11 a_xn11 wp_ih_11_4 wn_ih_11_4 mhp4 mhn4 vdd vbsyn gsyn
X_ihx_11_4 a_xp11 a_xn11 wp_ih_11_4 wn_ih_11_4 xhp4 xhn4 vdd vbsyn gsyn
X_ihm_12_4 a_xp12 a_xn12 wp_ih_12_4 wn_ih_12_4 mhp4 mhn4 vdd vbsyn gsyn
X_ihx_12_4 a_xp12 a_xn12 wp_ih_12_4 wn_ih_12_4 xhp4 xhn4 vdd vbsyn gsyn
X_ihm_13_4 a_xp13 a_xn13 wp_ih_13_4 wn_ih_13_4 mhp4 mhn4 vdd vbsyn gsyn
X_ihx_13_4 a_xp13 a_xn13 wp_ih_13_4 wn_ih_13_4 xhp4 xhn4 vdd vbsyn gsyn
X_ihm_14_4 a_xp14 a_xn14 wp_ih_14_4 wn_ih_14_4 mhp4 mhn4 vdd vbsyn gsyn
X_ihx_14_4 a_xp14 a_xn14 wp_ih_14_4 wn_ih_14_4 xhp4 xhn4 vdd vbsyn gsyn
X_ihm_15_4 a_xp15 a_xn15 wp_ih_15_4 wn_ih_15_4 mhp4 mhn4 vdd vbsyn gsyn
X_ihx_15_4 a_xp15 a_xn15 wp_ih_15_4 wn_ih_15_4 xhp4 xhn4 vdd vbsyn gsyn
X_ihm_16_4 a_xp16 a_xn16 wp_ih_16_4 wn_ih_16_4 mhp4 mhn4 vdd vbsyn gsyn
X_ihx_16_4 a_xp16 a_xn16 wp_ih_16_4 wn_ih_16_4 xhp4 xhn4 vdd vbsyn gsyn
X_ihm_17_4 a_xp17 a_xn17 wp_ih_17_4 wn_ih_17_4 mhp4 mhn4 vdd vbsyn gsyn
X_ihx_17_4 a_xp17 a_xn17 wp_ih_17_4 wn_ih_17_4 xhp4 xhn4 vdd vbsyn gsyn
X_ihm_18_4 a_xp18 a_xn18 wp_ih_18_4 wn_ih_18_4 mhp4 mhn4 vdd vbsyn gsyn
X_ihx_18_4 a_xp18 a_xn18 wp_ih_18_4 wn_ih_18_4 xhp4 xhn4 vdd vbsyn gsyn
X_ihm_19_4 a_xp19 a_xn19 wp_ih_19_4 wn_ih_19_4 mhp4 mhn4 vdd vbsyn gsyn
X_ihx_19_4 a_xp19 a_xn19 wp_ih_19_4 wn_ih_19_4 xhp4 xhn4 vdd vbsyn gsyn
X_ihm_20_4 a_xp20 a_xn20 wp_ih_20_4 wn_ih_20_4 mhp4 mhn4 vdd vbsyn gsyn
X_ihx_20_4 a_xp20 a_xn20 wp_ih_20_4 wn_ih_20_4 xhp4 xhn4 vdd vbsyn gsyn
X_ihm_21_4 a_xp21 a_xn21 wp_ih_21_4 wn_ih_21_4 mhp4 mhn4 vdd vbsyn gsyn
X_ihx_21_4 a_xp21 a_xn21 wp_ih_21_4 wn_ih_21_4 xhp4 xhn4 vdd vbsyn gsyn
X_ihm_22_4 a_xp22 a_xn22 wp_ih_22_4 wn_ih_22_4 mhp4 mhn4 vdd vbsyn gsyn
X_ihx_22_4 a_xp22 a_xn22 wp_ih_22_4 wn_ih_22_4 xhp4 xhn4 vdd vbsyn gsyn
X_ihm_23_4 a_xp23 a_xn23 wp_ih_23_4 wn_ih_23_4 mhp4 mhn4 vdd vbsyn gsyn
X_ihx_23_4 a_xp23 a_xn23 wp_ih_23_4 wn_ih_23_4 xhp4 xhn4 vdd vbsyn gsyn
X_ihm_24_4 a_xp24 a_xn24 wp_ih_24_4 wn_ih_24_4 mhp4 mhn4 vdd vbsyn gsyn
X_ihx_24_4 a_xp24 a_xn24 wp_ih_24_4 wn_ih_24_4 xhp4 xhn4 vdd vbsyn gsyn
X_ihm_25_4 a_xp25 a_xn25 wp_ih_25_4 wn_ih_25_4 mhp4 mhn4 vdd vbsyn gsyn
X_ihx_25_4 a_xp25 a_xn25 wp_ih_25_4 wn_ih_25_4 xhp4 xhn4 vdd vbsyn gsyn
X_ihm_26_4 a_xp26 a_xn26 wp_ih_26_4 wn_ih_26_4 mhp4 mhn4 vdd vbsyn gsyn
X_ihx_26_4 a_xp26 a_xn26 wp_ih_26_4 wn_ih_26_4 xhp4 xhn4 vdd vbsyn gsyn
X_ihm_27_4 a_xp27 a_xn27 wp_ih_27_4 wn_ih_27_4 mhp4 mhn4 vdd vbsyn gsyn
X_ihx_27_4 a_xp27 a_xn27 wp_ih_27_4 wn_ih_27_4 xhp4 xhn4 vdd vbsyn gsyn
X_ihm_28_4 a_xp28 a_xn28 wp_ih_28_4 wn_ih_28_4 mhp4 mhn4 vdd vbsyn gsyn
X_ihx_28_4 a_xp28 a_xn28 wp_ih_28_4 wn_ih_28_4 xhp4 xhn4 vdd vbsyn gsyn
X_ihm_29_4 a_xp29 a_xn29 wp_ih_29_4 wn_ih_29_4 mhp4 mhn4 vdd vbsyn gsyn
X_ihx_29_4 a_xp29 a_xn29 wp_ih_29_4 wn_ih_29_4 xhp4 xhn4 vdd vbsyn gsyn
X_ihm_30_4 a_xp30 a_xn30 wp_ih_30_4 wn_ih_30_4 mhp4 mhn4 vdd vbsyn gsyn
X_ihx_30_4 a_xp30 a_xn30 wp_ih_30_4 wn_ih_30_4 xhp4 xhn4 vdd vbsyn gsyn
X_ihm_31_4 a_xp31 a_xn31 wp_ih_31_4 wn_ih_31_4 mhp4 mhn4 vdd vbsyn gsyn
X_ihx_31_4 a_xp31 a_xn31 wp_ih_31_4 wn_ih_31_4 xhp4 xhn4 vdd vbsyn gsyn
X_ihm_32_4 a_xp32 a_xn32 wp_ih_32_4 wn_ih_32_4 mhp4 mhn4 vdd vbsyn gsyn
X_ihx_32_4 a_xp32 a_xn32 wp_ih_32_4 wn_ih_32_4 xhp4 xhn4 vdd vbsyn gsyn
X_ihm_33_4 a_xp33 a_xn33 wp_ih_33_4 wn_ih_33_4 mhp4 mhn4 vdd vbsyn gsyn
X_ihx_33_4 a_xp33 a_xn33 wp_ih_33_4 wn_ih_33_4 xhp4 xhn4 vdd vbsyn gsyn
X_ihm_34_4 a_xp34 a_xn34 wp_ih_34_4 wn_ih_34_4 mhp4 mhn4 vdd vbsyn gsyn
X_ihx_34_4 a_xp34 a_xn34 wp_ih_34_4 wn_ih_34_4 xhp4 xhn4 vdd vbsyn gsyn
X_ihm_35_4 a_xp35 a_xn35 wp_ih_35_4 wn_ih_35_4 mhp4 mhn4 vdd vbsyn gsyn
X_ihx_35_4 a_xp35 a_xn35 wp_ih_35_4 wn_ih_35_4 xhp4 xhn4 vdd vbsyn gsyn
X_ihm_36_4 a_xp36 a_xn36 wp_ih_36_4 wn_ih_36_4 mhp4 mhn4 vdd vbsyn gsyn
X_ihx_36_4 a_xp36 a_xn36 wp_ih_36_4 wn_ih_36_4 xhp4 xhn4 vdd vbsyn gsyn
X_ihm_37_4 a_xp37 a_xn37 wp_ih_37_4 wn_ih_37_4 mhp4 mhn4 vdd vbsyn gsyn
X_ihx_37_4 a_xp37 a_xn37 wp_ih_37_4 wn_ih_37_4 xhp4 xhn4 vdd vbsyn gsyn
X_ihm_38_4 a_xp38 a_xn38 wp_ih_38_4 wn_ih_38_4 mhp4 mhn4 vdd vbsyn gsyn
X_ihx_38_4 a_xp38 a_xn38 wp_ih_38_4 wn_ih_38_4 xhp4 xhn4 vdd vbsyn gsyn
X_ihm_39_4 a_xp39 a_xn39 wp_ih_39_4 wn_ih_39_4 mhp4 mhn4 vdd vbsyn gsyn
X_ihx_39_4 a_xp39 a_xn39 wp_ih_39_4 wn_ih_39_4 xhp4 xhn4 vdd vbsyn gsyn
X_ihm_40_4 a_xp40 a_xn40 wp_ih_40_4 wn_ih_40_4 mhp4 mhn4 vdd vbsyn gsyn
X_ihx_40_4 a_xp40 a_xn40 wp_ih_40_4 wn_ih_40_4 xhp4 xhn4 vdd vbsyn gsyn
X_ihm_41_4 a_xp41 a_xn41 wp_ih_41_4 wn_ih_41_4 mhp4 mhn4 vdd vbsyn gsyn
X_ihx_41_4 a_xp41 a_xn41 wp_ih_41_4 wn_ih_41_4 xhp4 xhn4 vdd vbsyn gsyn
X_ihm_42_4 a_xp42 a_xn42 wp_ih_42_4 wn_ih_42_4 mhp4 mhn4 vdd vbsyn gsyn
X_ihx_42_4 a_xp42 a_xn42 wp_ih_42_4 wn_ih_42_4 xhp4 xhn4 vdd vbsyn gsyn
X_ihm_43_4 a_xp43 a_xn43 wp_ih_43_4 wn_ih_43_4 mhp4 mhn4 vdd vbsyn gsyn
X_ihx_43_4 a_xp43 a_xn43 wp_ih_43_4 wn_ih_43_4 xhp4 xhn4 vdd vbsyn gsyn
X_ihm_44_4 a_xp44 a_xn44 wp_ih_44_4 wn_ih_44_4 mhp4 mhn4 vdd vbsyn gsyn
X_ihx_44_4 a_xp44 a_xn44 wp_ih_44_4 wn_ih_44_4 xhp4 xhn4 vdd vbsyn gsyn
X_ihm_45_4 a_xp45 a_xn45 wp_ih_45_4 wn_ih_45_4 mhp4 mhn4 vdd vbsyn gsyn
X_ihx_45_4 a_xp45 a_xn45 wp_ih_45_4 wn_ih_45_4 xhp4 xhn4 vdd vbsyn gsyn
X_ihm_46_4 a_xp46 a_xn46 wp_ih_46_4 wn_ih_46_4 mhp4 mhn4 vdd vbsyn gsyn
X_ihx_46_4 a_xp46 a_xn46 wp_ih_46_4 wn_ih_46_4 xhp4 xhn4 vdd vbsyn gsyn
X_ihm_47_4 a_xp47 a_xn47 wp_ih_47_4 wn_ih_47_4 mhp4 mhn4 vdd vbsyn gsyn
X_ihx_47_4 a_xp47 a_xn47 wp_ih_47_4 wn_ih_47_4 xhp4 xhn4 vdd vbsyn gsyn
X_ihm_48_4 a_xp48 a_xn48 wp_ih_48_4 wn_ih_48_4 mhp4 mhn4 vdd vbsyn gsyn
X_ihx_48_4 a_xp48 a_xn48 wp_ih_48_4 wn_ih_48_4 xhp4 xhn4 vdd vbsyn gsyn
X_ihm_49_4 a_xp49 a_xn49 wp_ih_49_4 wn_ih_49_4 mhp4 mhn4 vdd vbsyn gsyn
X_ihx_49_4 a_xp49 a_xn49 wp_ih_49_4 wn_ih_49_4 xhp4 xhn4 vdd vbsyn gsyn
X_ihm_50_4 a_xp50 a_xn50 wp_ih_50_4 wn_ih_50_4 mhp4 mhn4 vdd vbsyn gsyn
X_ihx_50_4 a_xp50 a_xn50 wp_ih_50_4 wn_ih_50_4 xhp4 xhn4 vdd vbsyn gsyn
X_ihm_51_4 a_xp51 a_xn51 wp_ih_51_4 wn_ih_51_4 mhp4 mhn4 vdd vbsyn gsyn
X_ihx_51_4 a_xp51 a_xn51 wp_ih_51_4 wn_ih_51_4 xhp4 xhn4 vdd vbsyn gsyn
X_ihm_52_4 a_xp52 a_xn52 wp_ih_52_4 wn_ih_52_4 mhp4 mhn4 vdd vbsyn gsyn
X_ihx_52_4 a_xp52 a_xn52 wp_ih_52_4 wn_ih_52_4 xhp4 xhn4 vdd vbsyn gsyn
X_ihm_53_4 a_xp53 a_xn53 wp_ih_53_4 wn_ih_53_4 mhp4 mhn4 vdd vbsyn gsyn
X_ihx_53_4 a_xp53 a_xn53 wp_ih_53_4 wn_ih_53_4 xhp4 xhn4 vdd vbsyn gsyn
X_ihm_54_4 a_xp54 a_xn54 wp_ih_54_4 wn_ih_54_4 mhp4 mhn4 vdd vbsyn gsyn
X_ihx_54_4 a_xp54 a_xn54 wp_ih_54_4 wn_ih_54_4 xhp4 xhn4 vdd vbsyn gsyn
X_ihm_55_4 a_xp55 a_xn55 wp_ih_55_4 wn_ih_55_4 mhp4 mhn4 vdd vbsyn gsyn
X_ihx_55_4 a_xp55 a_xn55 wp_ih_55_4 wn_ih_55_4 xhp4 xhn4 vdd vbsyn gsyn
X_ihm_56_4 a_xp56 a_xn56 wp_ih_56_4 wn_ih_56_4 mhp4 mhn4 vdd vbsyn gsyn
X_ihx_56_4 a_xp56 a_xn56 wp_ih_56_4 wn_ih_56_4 xhp4 xhn4 vdd vbsyn gsyn
X_ihm_57_4 a_xp57 a_xn57 wp_ih_57_4 wn_ih_57_4 mhp4 mhn4 vdd vbsyn gsyn
X_ihx_57_4 a_xp57 a_xn57 wp_ih_57_4 wn_ih_57_4 xhp4 xhn4 vdd vbsyn gsyn
X_ihm_58_4 a_xp58 a_xn58 wp_ih_58_4 wn_ih_58_4 mhp4 mhn4 vdd vbsyn gsyn
X_ihx_58_4 a_xp58 a_xn58 wp_ih_58_4 wn_ih_58_4 xhp4 xhn4 vdd vbsyn gsyn
X_ihm_59_4 a_xp59 a_xn59 wp_ih_59_4 wn_ih_59_4 mhp4 mhn4 vdd vbsyn gsyn
X_ihx_59_4 a_xp59 a_xn59 wp_ih_59_4 wn_ih_59_4 xhp4 xhn4 vdd vbsyn gsyn
X_ihm_60_4 a_xp60 a_xn60 wp_ih_60_4 wn_ih_60_4 mhp4 mhn4 vdd vbsyn gsyn
X_ihx_60_4 a_xp60 a_xn60 wp_ih_60_4 wn_ih_60_4 xhp4 xhn4 vdd vbsyn gsyn
X_ihm_61_4 a_xp61 a_xn61 wp_ih_61_4 wn_ih_61_4 mhp4 mhn4 vdd vbsyn gsyn
X_ihx_61_4 a_xp61 a_xn61 wp_ih_61_4 wn_ih_61_4 xhp4 xhn4 vdd vbsyn gsyn
X_ihm_62_4 a_xp62 a_xn62 wp_ih_62_4 wn_ih_62_4 mhp4 mhn4 vdd vbsyn gsyn
X_ihx_62_4 a_xp62 a_xn62 wp_ih_62_4 wn_ih_62_4 xhp4 xhn4 vdd vbsyn gsyn
X_ihm_63_4 a_xp63 a_xn63 wp_ih_63_4 wn_ih_63_4 mhp4 mhn4 vdd vbsyn gsyn
X_ihx_63_4 a_xp63 a_xn63 wp_ih_63_4 wn_ih_63_4 xhp4 xhn4 vdd vbsyn gsyn
Xn4 xhp4 xhn4 ahp4 ahn4 vdd vbneu dneuron
Xeh4 xhp4 xhn4 mhp4 mhn4 ehp4 ehn4 vdd gm esub
Xcm_mh5 mhp5 mhn5 vdd cmld
Rnd_mh5 mhp5 mhn5 20k
Xcm_xh5 xhp5 xhn5 vdd cmld
Rnd_xh5 xhp5 xhn5 20k
X_ihm_0_5 a_xp0 a_xn0 wp_ih_0_5 wn_ih_0_5 mhp5 mhn5 vdd vbsyn gsyn
X_ihx_0_5 a_xp0 a_xn0 wp_ih_0_5 wn_ih_0_5 xhp5 xhn5 vdd vbsyn gsyn
X_ihm_1_5 a_xp1 a_xn1 wp_ih_1_5 wn_ih_1_5 mhp5 mhn5 vdd vbsyn gsyn
X_ihx_1_5 a_xp1 a_xn1 wp_ih_1_5 wn_ih_1_5 xhp5 xhn5 vdd vbsyn gsyn
X_ihm_2_5 a_xp2 a_xn2 wp_ih_2_5 wn_ih_2_5 mhp5 mhn5 vdd vbsyn gsyn
X_ihx_2_5 a_xp2 a_xn2 wp_ih_2_5 wn_ih_2_5 xhp5 xhn5 vdd vbsyn gsyn
X_ihm_3_5 a_xp3 a_xn3 wp_ih_3_5 wn_ih_3_5 mhp5 mhn5 vdd vbsyn gsyn
X_ihx_3_5 a_xp3 a_xn3 wp_ih_3_5 wn_ih_3_5 xhp5 xhn5 vdd vbsyn gsyn
X_ihm_4_5 a_xp4 a_xn4 wp_ih_4_5 wn_ih_4_5 mhp5 mhn5 vdd vbsyn gsyn
X_ihx_4_5 a_xp4 a_xn4 wp_ih_4_5 wn_ih_4_5 xhp5 xhn5 vdd vbsyn gsyn
X_ihm_5_5 a_xp5 a_xn5 wp_ih_5_5 wn_ih_5_5 mhp5 mhn5 vdd vbsyn gsyn
X_ihx_5_5 a_xp5 a_xn5 wp_ih_5_5 wn_ih_5_5 xhp5 xhn5 vdd vbsyn gsyn
X_ihm_6_5 a_xp6 a_xn6 wp_ih_6_5 wn_ih_6_5 mhp5 mhn5 vdd vbsyn gsyn
X_ihx_6_5 a_xp6 a_xn6 wp_ih_6_5 wn_ih_6_5 xhp5 xhn5 vdd vbsyn gsyn
X_ihm_7_5 a_xp7 a_xn7 wp_ih_7_5 wn_ih_7_5 mhp5 mhn5 vdd vbsyn gsyn
X_ihx_7_5 a_xp7 a_xn7 wp_ih_7_5 wn_ih_7_5 xhp5 xhn5 vdd vbsyn gsyn
X_ihm_8_5 a_xp8 a_xn8 wp_ih_8_5 wn_ih_8_5 mhp5 mhn5 vdd vbsyn gsyn
X_ihx_8_5 a_xp8 a_xn8 wp_ih_8_5 wn_ih_8_5 xhp5 xhn5 vdd vbsyn gsyn
X_ihm_9_5 a_xp9 a_xn9 wp_ih_9_5 wn_ih_9_5 mhp5 mhn5 vdd vbsyn gsyn
X_ihx_9_5 a_xp9 a_xn9 wp_ih_9_5 wn_ih_9_5 xhp5 xhn5 vdd vbsyn gsyn
X_ihm_10_5 a_xp10 a_xn10 wp_ih_10_5 wn_ih_10_5 mhp5 mhn5 vdd vbsyn gsyn
X_ihx_10_5 a_xp10 a_xn10 wp_ih_10_5 wn_ih_10_5 xhp5 xhn5 vdd vbsyn gsyn
X_ihm_11_5 a_xp11 a_xn11 wp_ih_11_5 wn_ih_11_5 mhp5 mhn5 vdd vbsyn gsyn
X_ihx_11_5 a_xp11 a_xn11 wp_ih_11_5 wn_ih_11_5 xhp5 xhn5 vdd vbsyn gsyn
X_ihm_12_5 a_xp12 a_xn12 wp_ih_12_5 wn_ih_12_5 mhp5 mhn5 vdd vbsyn gsyn
X_ihx_12_5 a_xp12 a_xn12 wp_ih_12_5 wn_ih_12_5 xhp5 xhn5 vdd vbsyn gsyn
X_ihm_13_5 a_xp13 a_xn13 wp_ih_13_5 wn_ih_13_5 mhp5 mhn5 vdd vbsyn gsyn
X_ihx_13_5 a_xp13 a_xn13 wp_ih_13_5 wn_ih_13_5 xhp5 xhn5 vdd vbsyn gsyn
X_ihm_14_5 a_xp14 a_xn14 wp_ih_14_5 wn_ih_14_5 mhp5 mhn5 vdd vbsyn gsyn
X_ihx_14_5 a_xp14 a_xn14 wp_ih_14_5 wn_ih_14_5 xhp5 xhn5 vdd vbsyn gsyn
X_ihm_15_5 a_xp15 a_xn15 wp_ih_15_5 wn_ih_15_5 mhp5 mhn5 vdd vbsyn gsyn
X_ihx_15_5 a_xp15 a_xn15 wp_ih_15_5 wn_ih_15_5 xhp5 xhn5 vdd vbsyn gsyn
X_ihm_16_5 a_xp16 a_xn16 wp_ih_16_5 wn_ih_16_5 mhp5 mhn5 vdd vbsyn gsyn
X_ihx_16_5 a_xp16 a_xn16 wp_ih_16_5 wn_ih_16_5 xhp5 xhn5 vdd vbsyn gsyn
X_ihm_17_5 a_xp17 a_xn17 wp_ih_17_5 wn_ih_17_5 mhp5 mhn5 vdd vbsyn gsyn
X_ihx_17_5 a_xp17 a_xn17 wp_ih_17_5 wn_ih_17_5 xhp5 xhn5 vdd vbsyn gsyn
X_ihm_18_5 a_xp18 a_xn18 wp_ih_18_5 wn_ih_18_5 mhp5 mhn5 vdd vbsyn gsyn
X_ihx_18_5 a_xp18 a_xn18 wp_ih_18_5 wn_ih_18_5 xhp5 xhn5 vdd vbsyn gsyn
X_ihm_19_5 a_xp19 a_xn19 wp_ih_19_5 wn_ih_19_5 mhp5 mhn5 vdd vbsyn gsyn
X_ihx_19_5 a_xp19 a_xn19 wp_ih_19_5 wn_ih_19_5 xhp5 xhn5 vdd vbsyn gsyn
X_ihm_20_5 a_xp20 a_xn20 wp_ih_20_5 wn_ih_20_5 mhp5 mhn5 vdd vbsyn gsyn
X_ihx_20_5 a_xp20 a_xn20 wp_ih_20_5 wn_ih_20_5 xhp5 xhn5 vdd vbsyn gsyn
X_ihm_21_5 a_xp21 a_xn21 wp_ih_21_5 wn_ih_21_5 mhp5 mhn5 vdd vbsyn gsyn
X_ihx_21_5 a_xp21 a_xn21 wp_ih_21_5 wn_ih_21_5 xhp5 xhn5 vdd vbsyn gsyn
X_ihm_22_5 a_xp22 a_xn22 wp_ih_22_5 wn_ih_22_5 mhp5 mhn5 vdd vbsyn gsyn
X_ihx_22_5 a_xp22 a_xn22 wp_ih_22_5 wn_ih_22_5 xhp5 xhn5 vdd vbsyn gsyn
X_ihm_23_5 a_xp23 a_xn23 wp_ih_23_5 wn_ih_23_5 mhp5 mhn5 vdd vbsyn gsyn
X_ihx_23_5 a_xp23 a_xn23 wp_ih_23_5 wn_ih_23_5 xhp5 xhn5 vdd vbsyn gsyn
X_ihm_24_5 a_xp24 a_xn24 wp_ih_24_5 wn_ih_24_5 mhp5 mhn5 vdd vbsyn gsyn
X_ihx_24_5 a_xp24 a_xn24 wp_ih_24_5 wn_ih_24_5 xhp5 xhn5 vdd vbsyn gsyn
X_ihm_25_5 a_xp25 a_xn25 wp_ih_25_5 wn_ih_25_5 mhp5 mhn5 vdd vbsyn gsyn
X_ihx_25_5 a_xp25 a_xn25 wp_ih_25_5 wn_ih_25_5 xhp5 xhn5 vdd vbsyn gsyn
X_ihm_26_5 a_xp26 a_xn26 wp_ih_26_5 wn_ih_26_5 mhp5 mhn5 vdd vbsyn gsyn
X_ihx_26_5 a_xp26 a_xn26 wp_ih_26_5 wn_ih_26_5 xhp5 xhn5 vdd vbsyn gsyn
X_ihm_27_5 a_xp27 a_xn27 wp_ih_27_5 wn_ih_27_5 mhp5 mhn5 vdd vbsyn gsyn
X_ihx_27_5 a_xp27 a_xn27 wp_ih_27_5 wn_ih_27_5 xhp5 xhn5 vdd vbsyn gsyn
X_ihm_28_5 a_xp28 a_xn28 wp_ih_28_5 wn_ih_28_5 mhp5 mhn5 vdd vbsyn gsyn
X_ihx_28_5 a_xp28 a_xn28 wp_ih_28_5 wn_ih_28_5 xhp5 xhn5 vdd vbsyn gsyn
X_ihm_29_5 a_xp29 a_xn29 wp_ih_29_5 wn_ih_29_5 mhp5 mhn5 vdd vbsyn gsyn
X_ihx_29_5 a_xp29 a_xn29 wp_ih_29_5 wn_ih_29_5 xhp5 xhn5 vdd vbsyn gsyn
X_ihm_30_5 a_xp30 a_xn30 wp_ih_30_5 wn_ih_30_5 mhp5 mhn5 vdd vbsyn gsyn
X_ihx_30_5 a_xp30 a_xn30 wp_ih_30_5 wn_ih_30_5 xhp5 xhn5 vdd vbsyn gsyn
X_ihm_31_5 a_xp31 a_xn31 wp_ih_31_5 wn_ih_31_5 mhp5 mhn5 vdd vbsyn gsyn
X_ihx_31_5 a_xp31 a_xn31 wp_ih_31_5 wn_ih_31_5 xhp5 xhn5 vdd vbsyn gsyn
X_ihm_32_5 a_xp32 a_xn32 wp_ih_32_5 wn_ih_32_5 mhp5 mhn5 vdd vbsyn gsyn
X_ihx_32_5 a_xp32 a_xn32 wp_ih_32_5 wn_ih_32_5 xhp5 xhn5 vdd vbsyn gsyn
X_ihm_33_5 a_xp33 a_xn33 wp_ih_33_5 wn_ih_33_5 mhp5 mhn5 vdd vbsyn gsyn
X_ihx_33_5 a_xp33 a_xn33 wp_ih_33_5 wn_ih_33_5 xhp5 xhn5 vdd vbsyn gsyn
X_ihm_34_5 a_xp34 a_xn34 wp_ih_34_5 wn_ih_34_5 mhp5 mhn5 vdd vbsyn gsyn
X_ihx_34_5 a_xp34 a_xn34 wp_ih_34_5 wn_ih_34_5 xhp5 xhn5 vdd vbsyn gsyn
X_ihm_35_5 a_xp35 a_xn35 wp_ih_35_5 wn_ih_35_5 mhp5 mhn5 vdd vbsyn gsyn
X_ihx_35_5 a_xp35 a_xn35 wp_ih_35_5 wn_ih_35_5 xhp5 xhn5 vdd vbsyn gsyn
X_ihm_36_5 a_xp36 a_xn36 wp_ih_36_5 wn_ih_36_5 mhp5 mhn5 vdd vbsyn gsyn
X_ihx_36_5 a_xp36 a_xn36 wp_ih_36_5 wn_ih_36_5 xhp5 xhn5 vdd vbsyn gsyn
X_ihm_37_5 a_xp37 a_xn37 wp_ih_37_5 wn_ih_37_5 mhp5 mhn5 vdd vbsyn gsyn
X_ihx_37_5 a_xp37 a_xn37 wp_ih_37_5 wn_ih_37_5 xhp5 xhn5 vdd vbsyn gsyn
X_ihm_38_5 a_xp38 a_xn38 wp_ih_38_5 wn_ih_38_5 mhp5 mhn5 vdd vbsyn gsyn
X_ihx_38_5 a_xp38 a_xn38 wp_ih_38_5 wn_ih_38_5 xhp5 xhn5 vdd vbsyn gsyn
X_ihm_39_5 a_xp39 a_xn39 wp_ih_39_5 wn_ih_39_5 mhp5 mhn5 vdd vbsyn gsyn
X_ihx_39_5 a_xp39 a_xn39 wp_ih_39_5 wn_ih_39_5 xhp5 xhn5 vdd vbsyn gsyn
X_ihm_40_5 a_xp40 a_xn40 wp_ih_40_5 wn_ih_40_5 mhp5 mhn5 vdd vbsyn gsyn
X_ihx_40_5 a_xp40 a_xn40 wp_ih_40_5 wn_ih_40_5 xhp5 xhn5 vdd vbsyn gsyn
X_ihm_41_5 a_xp41 a_xn41 wp_ih_41_5 wn_ih_41_5 mhp5 mhn5 vdd vbsyn gsyn
X_ihx_41_5 a_xp41 a_xn41 wp_ih_41_5 wn_ih_41_5 xhp5 xhn5 vdd vbsyn gsyn
X_ihm_42_5 a_xp42 a_xn42 wp_ih_42_5 wn_ih_42_5 mhp5 mhn5 vdd vbsyn gsyn
X_ihx_42_5 a_xp42 a_xn42 wp_ih_42_5 wn_ih_42_5 xhp5 xhn5 vdd vbsyn gsyn
X_ihm_43_5 a_xp43 a_xn43 wp_ih_43_5 wn_ih_43_5 mhp5 mhn5 vdd vbsyn gsyn
X_ihx_43_5 a_xp43 a_xn43 wp_ih_43_5 wn_ih_43_5 xhp5 xhn5 vdd vbsyn gsyn
X_ihm_44_5 a_xp44 a_xn44 wp_ih_44_5 wn_ih_44_5 mhp5 mhn5 vdd vbsyn gsyn
X_ihx_44_5 a_xp44 a_xn44 wp_ih_44_5 wn_ih_44_5 xhp5 xhn5 vdd vbsyn gsyn
X_ihm_45_5 a_xp45 a_xn45 wp_ih_45_5 wn_ih_45_5 mhp5 mhn5 vdd vbsyn gsyn
X_ihx_45_5 a_xp45 a_xn45 wp_ih_45_5 wn_ih_45_5 xhp5 xhn5 vdd vbsyn gsyn
X_ihm_46_5 a_xp46 a_xn46 wp_ih_46_5 wn_ih_46_5 mhp5 mhn5 vdd vbsyn gsyn
X_ihx_46_5 a_xp46 a_xn46 wp_ih_46_5 wn_ih_46_5 xhp5 xhn5 vdd vbsyn gsyn
X_ihm_47_5 a_xp47 a_xn47 wp_ih_47_5 wn_ih_47_5 mhp5 mhn5 vdd vbsyn gsyn
X_ihx_47_5 a_xp47 a_xn47 wp_ih_47_5 wn_ih_47_5 xhp5 xhn5 vdd vbsyn gsyn
X_ihm_48_5 a_xp48 a_xn48 wp_ih_48_5 wn_ih_48_5 mhp5 mhn5 vdd vbsyn gsyn
X_ihx_48_5 a_xp48 a_xn48 wp_ih_48_5 wn_ih_48_5 xhp5 xhn5 vdd vbsyn gsyn
X_ihm_49_5 a_xp49 a_xn49 wp_ih_49_5 wn_ih_49_5 mhp5 mhn5 vdd vbsyn gsyn
X_ihx_49_5 a_xp49 a_xn49 wp_ih_49_5 wn_ih_49_5 xhp5 xhn5 vdd vbsyn gsyn
X_ihm_50_5 a_xp50 a_xn50 wp_ih_50_5 wn_ih_50_5 mhp5 mhn5 vdd vbsyn gsyn
X_ihx_50_5 a_xp50 a_xn50 wp_ih_50_5 wn_ih_50_5 xhp5 xhn5 vdd vbsyn gsyn
X_ihm_51_5 a_xp51 a_xn51 wp_ih_51_5 wn_ih_51_5 mhp5 mhn5 vdd vbsyn gsyn
X_ihx_51_5 a_xp51 a_xn51 wp_ih_51_5 wn_ih_51_5 xhp5 xhn5 vdd vbsyn gsyn
X_ihm_52_5 a_xp52 a_xn52 wp_ih_52_5 wn_ih_52_5 mhp5 mhn5 vdd vbsyn gsyn
X_ihx_52_5 a_xp52 a_xn52 wp_ih_52_5 wn_ih_52_5 xhp5 xhn5 vdd vbsyn gsyn
X_ihm_53_5 a_xp53 a_xn53 wp_ih_53_5 wn_ih_53_5 mhp5 mhn5 vdd vbsyn gsyn
X_ihx_53_5 a_xp53 a_xn53 wp_ih_53_5 wn_ih_53_5 xhp5 xhn5 vdd vbsyn gsyn
X_ihm_54_5 a_xp54 a_xn54 wp_ih_54_5 wn_ih_54_5 mhp5 mhn5 vdd vbsyn gsyn
X_ihx_54_5 a_xp54 a_xn54 wp_ih_54_5 wn_ih_54_5 xhp5 xhn5 vdd vbsyn gsyn
X_ihm_55_5 a_xp55 a_xn55 wp_ih_55_5 wn_ih_55_5 mhp5 mhn5 vdd vbsyn gsyn
X_ihx_55_5 a_xp55 a_xn55 wp_ih_55_5 wn_ih_55_5 xhp5 xhn5 vdd vbsyn gsyn
X_ihm_56_5 a_xp56 a_xn56 wp_ih_56_5 wn_ih_56_5 mhp5 mhn5 vdd vbsyn gsyn
X_ihx_56_5 a_xp56 a_xn56 wp_ih_56_5 wn_ih_56_5 xhp5 xhn5 vdd vbsyn gsyn
X_ihm_57_5 a_xp57 a_xn57 wp_ih_57_5 wn_ih_57_5 mhp5 mhn5 vdd vbsyn gsyn
X_ihx_57_5 a_xp57 a_xn57 wp_ih_57_5 wn_ih_57_5 xhp5 xhn5 vdd vbsyn gsyn
X_ihm_58_5 a_xp58 a_xn58 wp_ih_58_5 wn_ih_58_5 mhp5 mhn5 vdd vbsyn gsyn
X_ihx_58_5 a_xp58 a_xn58 wp_ih_58_5 wn_ih_58_5 xhp5 xhn5 vdd vbsyn gsyn
X_ihm_59_5 a_xp59 a_xn59 wp_ih_59_5 wn_ih_59_5 mhp5 mhn5 vdd vbsyn gsyn
X_ihx_59_5 a_xp59 a_xn59 wp_ih_59_5 wn_ih_59_5 xhp5 xhn5 vdd vbsyn gsyn
X_ihm_60_5 a_xp60 a_xn60 wp_ih_60_5 wn_ih_60_5 mhp5 mhn5 vdd vbsyn gsyn
X_ihx_60_5 a_xp60 a_xn60 wp_ih_60_5 wn_ih_60_5 xhp5 xhn5 vdd vbsyn gsyn
X_ihm_61_5 a_xp61 a_xn61 wp_ih_61_5 wn_ih_61_5 mhp5 mhn5 vdd vbsyn gsyn
X_ihx_61_5 a_xp61 a_xn61 wp_ih_61_5 wn_ih_61_5 xhp5 xhn5 vdd vbsyn gsyn
X_ihm_62_5 a_xp62 a_xn62 wp_ih_62_5 wn_ih_62_5 mhp5 mhn5 vdd vbsyn gsyn
X_ihx_62_5 a_xp62 a_xn62 wp_ih_62_5 wn_ih_62_5 xhp5 xhn5 vdd vbsyn gsyn
X_ihm_63_5 a_xp63 a_xn63 wp_ih_63_5 wn_ih_63_5 mhp5 mhn5 vdd vbsyn gsyn
X_ihx_63_5 a_xp63 a_xn63 wp_ih_63_5 wn_ih_63_5 xhp5 xhn5 vdd vbsyn gsyn
Xn5 xhp5 xhn5 ahp5 ahn5 vdd vbneu dneuron
Xeh5 xhp5 xhn5 mhp5 mhn5 ehp5 ehn5 vdd gm esub
Xcm_mh6 mhp6 mhn6 vdd cmld
Rnd_mh6 mhp6 mhn6 20k
Xcm_xh6 xhp6 xhn6 vdd cmld
Rnd_xh6 xhp6 xhn6 20k
X_ihm_0_6 a_xp0 a_xn0 wp_ih_0_6 wn_ih_0_6 mhp6 mhn6 vdd vbsyn gsyn
X_ihx_0_6 a_xp0 a_xn0 wp_ih_0_6 wn_ih_0_6 xhp6 xhn6 vdd vbsyn gsyn
X_ihm_1_6 a_xp1 a_xn1 wp_ih_1_6 wn_ih_1_6 mhp6 mhn6 vdd vbsyn gsyn
X_ihx_1_6 a_xp1 a_xn1 wp_ih_1_6 wn_ih_1_6 xhp6 xhn6 vdd vbsyn gsyn
X_ihm_2_6 a_xp2 a_xn2 wp_ih_2_6 wn_ih_2_6 mhp6 mhn6 vdd vbsyn gsyn
X_ihx_2_6 a_xp2 a_xn2 wp_ih_2_6 wn_ih_2_6 xhp6 xhn6 vdd vbsyn gsyn
X_ihm_3_6 a_xp3 a_xn3 wp_ih_3_6 wn_ih_3_6 mhp6 mhn6 vdd vbsyn gsyn
X_ihx_3_6 a_xp3 a_xn3 wp_ih_3_6 wn_ih_3_6 xhp6 xhn6 vdd vbsyn gsyn
X_ihm_4_6 a_xp4 a_xn4 wp_ih_4_6 wn_ih_4_6 mhp6 mhn6 vdd vbsyn gsyn
X_ihx_4_6 a_xp4 a_xn4 wp_ih_4_6 wn_ih_4_6 xhp6 xhn6 vdd vbsyn gsyn
X_ihm_5_6 a_xp5 a_xn5 wp_ih_5_6 wn_ih_5_6 mhp6 mhn6 vdd vbsyn gsyn
X_ihx_5_6 a_xp5 a_xn5 wp_ih_5_6 wn_ih_5_6 xhp6 xhn6 vdd vbsyn gsyn
X_ihm_6_6 a_xp6 a_xn6 wp_ih_6_6 wn_ih_6_6 mhp6 mhn6 vdd vbsyn gsyn
X_ihx_6_6 a_xp6 a_xn6 wp_ih_6_6 wn_ih_6_6 xhp6 xhn6 vdd vbsyn gsyn
X_ihm_7_6 a_xp7 a_xn7 wp_ih_7_6 wn_ih_7_6 mhp6 mhn6 vdd vbsyn gsyn
X_ihx_7_6 a_xp7 a_xn7 wp_ih_7_6 wn_ih_7_6 xhp6 xhn6 vdd vbsyn gsyn
X_ihm_8_6 a_xp8 a_xn8 wp_ih_8_6 wn_ih_8_6 mhp6 mhn6 vdd vbsyn gsyn
X_ihx_8_6 a_xp8 a_xn8 wp_ih_8_6 wn_ih_8_6 xhp6 xhn6 vdd vbsyn gsyn
X_ihm_9_6 a_xp9 a_xn9 wp_ih_9_6 wn_ih_9_6 mhp6 mhn6 vdd vbsyn gsyn
X_ihx_9_6 a_xp9 a_xn9 wp_ih_9_6 wn_ih_9_6 xhp6 xhn6 vdd vbsyn gsyn
X_ihm_10_6 a_xp10 a_xn10 wp_ih_10_6 wn_ih_10_6 mhp6 mhn6 vdd vbsyn gsyn
X_ihx_10_6 a_xp10 a_xn10 wp_ih_10_6 wn_ih_10_6 xhp6 xhn6 vdd vbsyn gsyn
X_ihm_11_6 a_xp11 a_xn11 wp_ih_11_6 wn_ih_11_6 mhp6 mhn6 vdd vbsyn gsyn
X_ihx_11_6 a_xp11 a_xn11 wp_ih_11_6 wn_ih_11_6 xhp6 xhn6 vdd vbsyn gsyn
X_ihm_12_6 a_xp12 a_xn12 wp_ih_12_6 wn_ih_12_6 mhp6 mhn6 vdd vbsyn gsyn
X_ihx_12_6 a_xp12 a_xn12 wp_ih_12_6 wn_ih_12_6 xhp6 xhn6 vdd vbsyn gsyn
X_ihm_13_6 a_xp13 a_xn13 wp_ih_13_6 wn_ih_13_6 mhp6 mhn6 vdd vbsyn gsyn
X_ihx_13_6 a_xp13 a_xn13 wp_ih_13_6 wn_ih_13_6 xhp6 xhn6 vdd vbsyn gsyn
X_ihm_14_6 a_xp14 a_xn14 wp_ih_14_6 wn_ih_14_6 mhp6 mhn6 vdd vbsyn gsyn
X_ihx_14_6 a_xp14 a_xn14 wp_ih_14_6 wn_ih_14_6 xhp6 xhn6 vdd vbsyn gsyn
X_ihm_15_6 a_xp15 a_xn15 wp_ih_15_6 wn_ih_15_6 mhp6 mhn6 vdd vbsyn gsyn
X_ihx_15_6 a_xp15 a_xn15 wp_ih_15_6 wn_ih_15_6 xhp6 xhn6 vdd vbsyn gsyn
X_ihm_16_6 a_xp16 a_xn16 wp_ih_16_6 wn_ih_16_6 mhp6 mhn6 vdd vbsyn gsyn
X_ihx_16_6 a_xp16 a_xn16 wp_ih_16_6 wn_ih_16_6 xhp6 xhn6 vdd vbsyn gsyn
X_ihm_17_6 a_xp17 a_xn17 wp_ih_17_6 wn_ih_17_6 mhp6 mhn6 vdd vbsyn gsyn
X_ihx_17_6 a_xp17 a_xn17 wp_ih_17_6 wn_ih_17_6 xhp6 xhn6 vdd vbsyn gsyn
X_ihm_18_6 a_xp18 a_xn18 wp_ih_18_6 wn_ih_18_6 mhp6 mhn6 vdd vbsyn gsyn
X_ihx_18_6 a_xp18 a_xn18 wp_ih_18_6 wn_ih_18_6 xhp6 xhn6 vdd vbsyn gsyn
X_ihm_19_6 a_xp19 a_xn19 wp_ih_19_6 wn_ih_19_6 mhp6 mhn6 vdd vbsyn gsyn
X_ihx_19_6 a_xp19 a_xn19 wp_ih_19_6 wn_ih_19_6 xhp6 xhn6 vdd vbsyn gsyn
X_ihm_20_6 a_xp20 a_xn20 wp_ih_20_6 wn_ih_20_6 mhp6 mhn6 vdd vbsyn gsyn
X_ihx_20_6 a_xp20 a_xn20 wp_ih_20_6 wn_ih_20_6 xhp6 xhn6 vdd vbsyn gsyn
X_ihm_21_6 a_xp21 a_xn21 wp_ih_21_6 wn_ih_21_6 mhp6 mhn6 vdd vbsyn gsyn
X_ihx_21_6 a_xp21 a_xn21 wp_ih_21_6 wn_ih_21_6 xhp6 xhn6 vdd vbsyn gsyn
X_ihm_22_6 a_xp22 a_xn22 wp_ih_22_6 wn_ih_22_6 mhp6 mhn6 vdd vbsyn gsyn
X_ihx_22_6 a_xp22 a_xn22 wp_ih_22_6 wn_ih_22_6 xhp6 xhn6 vdd vbsyn gsyn
X_ihm_23_6 a_xp23 a_xn23 wp_ih_23_6 wn_ih_23_6 mhp6 mhn6 vdd vbsyn gsyn
X_ihx_23_6 a_xp23 a_xn23 wp_ih_23_6 wn_ih_23_6 xhp6 xhn6 vdd vbsyn gsyn
X_ihm_24_6 a_xp24 a_xn24 wp_ih_24_6 wn_ih_24_6 mhp6 mhn6 vdd vbsyn gsyn
X_ihx_24_6 a_xp24 a_xn24 wp_ih_24_6 wn_ih_24_6 xhp6 xhn6 vdd vbsyn gsyn
X_ihm_25_6 a_xp25 a_xn25 wp_ih_25_6 wn_ih_25_6 mhp6 mhn6 vdd vbsyn gsyn
X_ihx_25_6 a_xp25 a_xn25 wp_ih_25_6 wn_ih_25_6 xhp6 xhn6 vdd vbsyn gsyn
X_ihm_26_6 a_xp26 a_xn26 wp_ih_26_6 wn_ih_26_6 mhp6 mhn6 vdd vbsyn gsyn
X_ihx_26_6 a_xp26 a_xn26 wp_ih_26_6 wn_ih_26_6 xhp6 xhn6 vdd vbsyn gsyn
X_ihm_27_6 a_xp27 a_xn27 wp_ih_27_6 wn_ih_27_6 mhp6 mhn6 vdd vbsyn gsyn
X_ihx_27_6 a_xp27 a_xn27 wp_ih_27_6 wn_ih_27_6 xhp6 xhn6 vdd vbsyn gsyn
X_ihm_28_6 a_xp28 a_xn28 wp_ih_28_6 wn_ih_28_6 mhp6 mhn6 vdd vbsyn gsyn
X_ihx_28_6 a_xp28 a_xn28 wp_ih_28_6 wn_ih_28_6 xhp6 xhn6 vdd vbsyn gsyn
X_ihm_29_6 a_xp29 a_xn29 wp_ih_29_6 wn_ih_29_6 mhp6 mhn6 vdd vbsyn gsyn
X_ihx_29_6 a_xp29 a_xn29 wp_ih_29_6 wn_ih_29_6 xhp6 xhn6 vdd vbsyn gsyn
X_ihm_30_6 a_xp30 a_xn30 wp_ih_30_6 wn_ih_30_6 mhp6 mhn6 vdd vbsyn gsyn
X_ihx_30_6 a_xp30 a_xn30 wp_ih_30_6 wn_ih_30_6 xhp6 xhn6 vdd vbsyn gsyn
X_ihm_31_6 a_xp31 a_xn31 wp_ih_31_6 wn_ih_31_6 mhp6 mhn6 vdd vbsyn gsyn
X_ihx_31_6 a_xp31 a_xn31 wp_ih_31_6 wn_ih_31_6 xhp6 xhn6 vdd vbsyn gsyn
X_ihm_32_6 a_xp32 a_xn32 wp_ih_32_6 wn_ih_32_6 mhp6 mhn6 vdd vbsyn gsyn
X_ihx_32_6 a_xp32 a_xn32 wp_ih_32_6 wn_ih_32_6 xhp6 xhn6 vdd vbsyn gsyn
X_ihm_33_6 a_xp33 a_xn33 wp_ih_33_6 wn_ih_33_6 mhp6 mhn6 vdd vbsyn gsyn
X_ihx_33_6 a_xp33 a_xn33 wp_ih_33_6 wn_ih_33_6 xhp6 xhn6 vdd vbsyn gsyn
X_ihm_34_6 a_xp34 a_xn34 wp_ih_34_6 wn_ih_34_6 mhp6 mhn6 vdd vbsyn gsyn
X_ihx_34_6 a_xp34 a_xn34 wp_ih_34_6 wn_ih_34_6 xhp6 xhn6 vdd vbsyn gsyn
X_ihm_35_6 a_xp35 a_xn35 wp_ih_35_6 wn_ih_35_6 mhp6 mhn6 vdd vbsyn gsyn
X_ihx_35_6 a_xp35 a_xn35 wp_ih_35_6 wn_ih_35_6 xhp6 xhn6 vdd vbsyn gsyn
X_ihm_36_6 a_xp36 a_xn36 wp_ih_36_6 wn_ih_36_6 mhp6 mhn6 vdd vbsyn gsyn
X_ihx_36_6 a_xp36 a_xn36 wp_ih_36_6 wn_ih_36_6 xhp6 xhn6 vdd vbsyn gsyn
X_ihm_37_6 a_xp37 a_xn37 wp_ih_37_6 wn_ih_37_6 mhp6 mhn6 vdd vbsyn gsyn
X_ihx_37_6 a_xp37 a_xn37 wp_ih_37_6 wn_ih_37_6 xhp6 xhn6 vdd vbsyn gsyn
X_ihm_38_6 a_xp38 a_xn38 wp_ih_38_6 wn_ih_38_6 mhp6 mhn6 vdd vbsyn gsyn
X_ihx_38_6 a_xp38 a_xn38 wp_ih_38_6 wn_ih_38_6 xhp6 xhn6 vdd vbsyn gsyn
X_ihm_39_6 a_xp39 a_xn39 wp_ih_39_6 wn_ih_39_6 mhp6 mhn6 vdd vbsyn gsyn
X_ihx_39_6 a_xp39 a_xn39 wp_ih_39_6 wn_ih_39_6 xhp6 xhn6 vdd vbsyn gsyn
X_ihm_40_6 a_xp40 a_xn40 wp_ih_40_6 wn_ih_40_6 mhp6 mhn6 vdd vbsyn gsyn
X_ihx_40_6 a_xp40 a_xn40 wp_ih_40_6 wn_ih_40_6 xhp6 xhn6 vdd vbsyn gsyn
X_ihm_41_6 a_xp41 a_xn41 wp_ih_41_6 wn_ih_41_6 mhp6 mhn6 vdd vbsyn gsyn
X_ihx_41_6 a_xp41 a_xn41 wp_ih_41_6 wn_ih_41_6 xhp6 xhn6 vdd vbsyn gsyn
X_ihm_42_6 a_xp42 a_xn42 wp_ih_42_6 wn_ih_42_6 mhp6 mhn6 vdd vbsyn gsyn
X_ihx_42_6 a_xp42 a_xn42 wp_ih_42_6 wn_ih_42_6 xhp6 xhn6 vdd vbsyn gsyn
X_ihm_43_6 a_xp43 a_xn43 wp_ih_43_6 wn_ih_43_6 mhp6 mhn6 vdd vbsyn gsyn
X_ihx_43_6 a_xp43 a_xn43 wp_ih_43_6 wn_ih_43_6 xhp6 xhn6 vdd vbsyn gsyn
X_ihm_44_6 a_xp44 a_xn44 wp_ih_44_6 wn_ih_44_6 mhp6 mhn6 vdd vbsyn gsyn
X_ihx_44_6 a_xp44 a_xn44 wp_ih_44_6 wn_ih_44_6 xhp6 xhn6 vdd vbsyn gsyn
X_ihm_45_6 a_xp45 a_xn45 wp_ih_45_6 wn_ih_45_6 mhp6 mhn6 vdd vbsyn gsyn
X_ihx_45_6 a_xp45 a_xn45 wp_ih_45_6 wn_ih_45_6 xhp6 xhn6 vdd vbsyn gsyn
X_ihm_46_6 a_xp46 a_xn46 wp_ih_46_6 wn_ih_46_6 mhp6 mhn6 vdd vbsyn gsyn
X_ihx_46_6 a_xp46 a_xn46 wp_ih_46_6 wn_ih_46_6 xhp6 xhn6 vdd vbsyn gsyn
X_ihm_47_6 a_xp47 a_xn47 wp_ih_47_6 wn_ih_47_6 mhp6 mhn6 vdd vbsyn gsyn
X_ihx_47_6 a_xp47 a_xn47 wp_ih_47_6 wn_ih_47_6 xhp6 xhn6 vdd vbsyn gsyn
X_ihm_48_6 a_xp48 a_xn48 wp_ih_48_6 wn_ih_48_6 mhp6 mhn6 vdd vbsyn gsyn
X_ihx_48_6 a_xp48 a_xn48 wp_ih_48_6 wn_ih_48_6 xhp6 xhn6 vdd vbsyn gsyn
X_ihm_49_6 a_xp49 a_xn49 wp_ih_49_6 wn_ih_49_6 mhp6 mhn6 vdd vbsyn gsyn
X_ihx_49_6 a_xp49 a_xn49 wp_ih_49_6 wn_ih_49_6 xhp6 xhn6 vdd vbsyn gsyn
X_ihm_50_6 a_xp50 a_xn50 wp_ih_50_6 wn_ih_50_6 mhp6 mhn6 vdd vbsyn gsyn
X_ihx_50_6 a_xp50 a_xn50 wp_ih_50_6 wn_ih_50_6 xhp6 xhn6 vdd vbsyn gsyn
X_ihm_51_6 a_xp51 a_xn51 wp_ih_51_6 wn_ih_51_6 mhp6 mhn6 vdd vbsyn gsyn
X_ihx_51_6 a_xp51 a_xn51 wp_ih_51_6 wn_ih_51_6 xhp6 xhn6 vdd vbsyn gsyn
X_ihm_52_6 a_xp52 a_xn52 wp_ih_52_6 wn_ih_52_6 mhp6 mhn6 vdd vbsyn gsyn
X_ihx_52_6 a_xp52 a_xn52 wp_ih_52_6 wn_ih_52_6 xhp6 xhn6 vdd vbsyn gsyn
X_ihm_53_6 a_xp53 a_xn53 wp_ih_53_6 wn_ih_53_6 mhp6 mhn6 vdd vbsyn gsyn
X_ihx_53_6 a_xp53 a_xn53 wp_ih_53_6 wn_ih_53_6 xhp6 xhn6 vdd vbsyn gsyn
X_ihm_54_6 a_xp54 a_xn54 wp_ih_54_6 wn_ih_54_6 mhp6 mhn6 vdd vbsyn gsyn
X_ihx_54_6 a_xp54 a_xn54 wp_ih_54_6 wn_ih_54_6 xhp6 xhn6 vdd vbsyn gsyn
X_ihm_55_6 a_xp55 a_xn55 wp_ih_55_6 wn_ih_55_6 mhp6 mhn6 vdd vbsyn gsyn
X_ihx_55_6 a_xp55 a_xn55 wp_ih_55_6 wn_ih_55_6 xhp6 xhn6 vdd vbsyn gsyn
X_ihm_56_6 a_xp56 a_xn56 wp_ih_56_6 wn_ih_56_6 mhp6 mhn6 vdd vbsyn gsyn
X_ihx_56_6 a_xp56 a_xn56 wp_ih_56_6 wn_ih_56_6 xhp6 xhn6 vdd vbsyn gsyn
X_ihm_57_6 a_xp57 a_xn57 wp_ih_57_6 wn_ih_57_6 mhp6 mhn6 vdd vbsyn gsyn
X_ihx_57_6 a_xp57 a_xn57 wp_ih_57_6 wn_ih_57_6 xhp6 xhn6 vdd vbsyn gsyn
X_ihm_58_6 a_xp58 a_xn58 wp_ih_58_6 wn_ih_58_6 mhp6 mhn6 vdd vbsyn gsyn
X_ihx_58_6 a_xp58 a_xn58 wp_ih_58_6 wn_ih_58_6 xhp6 xhn6 vdd vbsyn gsyn
X_ihm_59_6 a_xp59 a_xn59 wp_ih_59_6 wn_ih_59_6 mhp6 mhn6 vdd vbsyn gsyn
X_ihx_59_6 a_xp59 a_xn59 wp_ih_59_6 wn_ih_59_6 xhp6 xhn6 vdd vbsyn gsyn
X_ihm_60_6 a_xp60 a_xn60 wp_ih_60_6 wn_ih_60_6 mhp6 mhn6 vdd vbsyn gsyn
X_ihx_60_6 a_xp60 a_xn60 wp_ih_60_6 wn_ih_60_6 xhp6 xhn6 vdd vbsyn gsyn
X_ihm_61_6 a_xp61 a_xn61 wp_ih_61_6 wn_ih_61_6 mhp6 mhn6 vdd vbsyn gsyn
X_ihx_61_6 a_xp61 a_xn61 wp_ih_61_6 wn_ih_61_6 xhp6 xhn6 vdd vbsyn gsyn
X_ihm_62_6 a_xp62 a_xn62 wp_ih_62_6 wn_ih_62_6 mhp6 mhn6 vdd vbsyn gsyn
X_ihx_62_6 a_xp62 a_xn62 wp_ih_62_6 wn_ih_62_6 xhp6 xhn6 vdd vbsyn gsyn
X_ihm_63_6 a_xp63 a_xn63 wp_ih_63_6 wn_ih_63_6 mhp6 mhn6 vdd vbsyn gsyn
X_ihx_63_6 a_xp63 a_xn63 wp_ih_63_6 wn_ih_63_6 xhp6 xhn6 vdd vbsyn gsyn
Xn6 xhp6 xhn6 ahp6 ahn6 vdd vbneu dneuron
Xeh6 xhp6 xhn6 mhp6 mhn6 ehp6 ehn6 vdd gm esub
Xcm_mh7 mhp7 mhn7 vdd cmld
Rnd_mh7 mhp7 mhn7 20k
Xcm_xh7 xhp7 xhn7 vdd cmld
Rnd_xh7 xhp7 xhn7 20k
X_ihm_0_7 a_xp0 a_xn0 wp_ih_0_7 wn_ih_0_7 mhp7 mhn7 vdd vbsyn gsyn
X_ihx_0_7 a_xp0 a_xn0 wp_ih_0_7 wn_ih_0_7 xhp7 xhn7 vdd vbsyn gsyn
X_ihm_1_7 a_xp1 a_xn1 wp_ih_1_7 wn_ih_1_7 mhp7 mhn7 vdd vbsyn gsyn
X_ihx_1_7 a_xp1 a_xn1 wp_ih_1_7 wn_ih_1_7 xhp7 xhn7 vdd vbsyn gsyn
X_ihm_2_7 a_xp2 a_xn2 wp_ih_2_7 wn_ih_2_7 mhp7 mhn7 vdd vbsyn gsyn
X_ihx_2_7 a_xp2 a_xn2 wp_ih_2_7 wn_ih_2_7 xhp7 xhn7 vdd vbsyn gsyn
X_ihm_3_7 a_xp3 a_xn3 wp_ih_3_7 wn_ih_3_7 mhp7 mhn7 vdd vbsyn gsyn
X_ihx_3_7 a_xp3 a_xn3 wp_ih_3_7 wn_ih_3_7 xhp7 xhn7 vdd vbsyn gsyn
X_ihm_4_7 a_xp4 a_xn4 wp_ih_4_7 wn_ih_4_7 mhp7 mhn7 vdd vbsyn gsyn
X_ihx_4_7 a_xp4 a_xn4 wp_ih_4_7 wn_ih_4_7 xhp7 xhn7 vdd vbsyn gsyn
X_ihm_5_7 a_xp5 a_xn5 wp_ih_5_7 wn_ih_5_7 mhp7 mhn7 vdd vbsyn gsyn
X_ihx_5_7 a_xp5 a_xn5 wp_ih_5_7 wn_ih_5_7 xhp7 xhn7 vdd vbsyn gsyn
X_ihm_6_7 a_xp6 a_xn6 wp_ih_6_7 wn_ih_6_7 mhp7 mhn7 vdd vbsyn gsyn
X_ihx_6_7 a_xp6 a_xn6 wp_ih_6_7 wn_ih_6_7 xhp7 xhn7 vdd vbsyn gsyn
X_ihm_7_7 a_xp7 a_xn7 wp_ih_7_7 wn_ih_7_7 mhp7 mhn7 vdd vbsyn gsyn
X_ihx_7_7 a_xp7 a_xn7 wp_ih_7_7 wn_ih_7_7 xhp7 xhn7 vdd vbsyn gsyn
X_ihm_8_7 a_xp8 a_xn8 wp_ih_8_7 wn_ih_8_7 mhp7 mhn7 vdd vbsyn gsyn
X_ihx_8_7 a_xp8 a_xn8 wp_ih_8_7 wn_ih_8_7 xhp7 xhn7 vdd vbsyn gsyn
X_ihm_9_7 a_xp9 a_xn9 wp_ih_9_7 wn_ih_9_7 mhp7 mhn7 vdd vbsyn gsyn
X_ihx_9_7 a_xp9 a_xn9 wp_ih_9_7 wn_ih_9_7 xhp7 xhn7 vdd vbsyn gsyn
X_ihm_10_7 a_xp10 a_xn10 wp_ih_10_7 wn_ih_10_7 mhp7 mhn7 vdd vbsyn gsyn
X_ihx_10_7 a_xp10 a_xn10 wp_ih_10_7 wn_ih_10_7 xhp7 xhn7 vdd vbsyn gsyn
X_ihm_11_7 a_xp11 a_xn11 wp_ih_11_7 wn_ih_11_7 mhp7 mhn7 vdd vbsyn gsyn
X_ihx_11_7 a_xp11 a_xn11 wp_ih_11_7 wn_ih_11_7 xhp7 xhn7 vdd vbsyn gsyn
X_ihm_12_7 a_xp12 a_xn12 wp_ih_12_7 wn_ih_12_7 mhp7 mhn7 vdd vbsyn gsyn
X_ihx_12_7 a_xp12 a_xn12 wp_ih_12_7 wn_ih_12_7 xhp7 xhn7 vdd vbsyn gsyn
X_ihm_13_7 a_xp13 a_xn13 wp_ih_13_7 wn_ih_13_7 mhp7 mhn7 vdd vbsyn gsyn
X_ihx_13_7 a_xp13 a_xn13 wp_ih_13_7 wn_ih_13_7 xhp7 xhn7 vdd vbsyn gsyn
X_ihm_14_7 a_xp14 a_xn14 wp_ih_14_7 wn_ih_14_7 mhp7 mhn7 vdd vbsyn gsyn
X_ihx_14_7 a_xp14 a_xn14 wp_ih_14_7 wn_ih_14_7 xhp7 xhn7 vdd vbsyn gsyn
X_ihm_15_7 a_xp15 a_xn15 wp_ih_15_7 wn_ih_15_7 mhp7 mhn7 vdd vbsyn gsyn
X_ihx_15_7 a_xp15 a_xn15 wp_ih_15_7 wn_ih_15_7 xhp7 xhn7 vdd vbsyn gsyn
X_ihm_16_7 a_xp16 a_xn16 wp_ih_16_7 wn_ih_16_7 mhp7 mhn7 vdd vbsyn gsyn
X_ihx_16_7 a_xp16 a_xn16 wp_ih_16_7 wn_ih_16_7 xhp7 xhn7 vdd vbsyn gsyn
X_ihm_17_7 a_xp17 a_xn17 wp_ih_17_7 wn_ih_17_7 mhp7 mhn7 vdd vbsyn gsyn
X_ihx_17_7 a_xp17 a_xn17 wp_ih_17_7 wn_ih_17_7 xhp7 xhn7 vdd vbsyn gsyn
X_ihm_18_7 a_xp18 a_xn18 wp_ih_18_7 wn_ih_18_7 mhp7 mhn7 vdd vbsyn gsyn
X_ihx_18_7 a_xp18 a_xn18 wp_ih_18_7 wn_ih_18_7 xhp7 xhn7 vdd vbsyn gsyn
X_ihm_19_7 a_xp19 a_xn19 wp_ih_19_7 wn_ih_19_7 mhp7 mhn7 vdd vbsyn gsyn
X_ihx_19_7 a_xp19 a_xn19 wp_ih_19_7 wn_ih_19_7 xhp7 xhn7 vdd vbsyn gsyn
X_ihm_20_7 a_xp20 a_xn20 wp_ih_20_7 wn_ih_20_7 mhp7 mhn7 vdd vbsyn gsyn
X_ihx_20_7 a_xp20 a_xn20 wp_ih_20_7 wn_ih_20_7 xhp7 xhn7 vdd vbsyn gsyn
X_ihm_21_7 a_xp21 a_xn21 wp_ih_21_7 wn_ih_21_7 mhp7 mhn7 vdd vbsyn gsyn
X_ihx_21_7 a_xp21 a_xn21 wp_ih_21_7 wn_ih_21_7 xhp7 xhn7 vdd vbsyn gsyn
X_ihm_22_7 a_xp22 a_xn22 wp_ih_22_7 wn_ih_22_7 mhp7 mhn7 vdd vbsyn gsyn
X_ihx_22_7 a_xp22 a_xn22 wp_ih_22_7 wn_ih_22_7 xhp7 xhn7 vdd vbsyn gsyn
X_ihm_23_7 a_xp23 a_xn23 wp_ih_23_7 wn_ih_23_7 mhp7 mhn7 vdd vbsyn gsyn
X_ihx_23_7 a_xp23 a_xn23 wp_ih_23_7 wn_ih_23_7 xhp7 xhn7 vdd vbsyn gsyn
X_ihm_24_7 a_xp24 a_xn24 wp_ih_24_7 wn_ih_24_7 mhp7 mhn7 vdd vbsyn gsyn
X_ihx_24_7 a_xp24 a_xn24 wp_ih_24_7 wn_ih_24_7 xhp7 xhn7 vdd vbsyn gsyn
X_ihm_25_7 a_xp25 a_xn25 wp_ih_25_7 wn_ih_25_7 mhp7 mhn7 vdd vbsyn gsyn
X_ihx_25_7 a_xp25 a_xn25 wp_ih_25_7 wn_ih_25_7 xhp7 xhn7 vdd vbsyn gsyn
X_ihm_26_7 a_xp26 a_xn26 wp_ih_26_7 wn_ih_26_7 mhp7 mhn7 vdd vbsyn gsyn
X_ihx_26_7 a_xp26 a_xn26 wp_ih_26_7 wn_ih_26_7 xhp7 xhn7 vdd vbsyn gsyn
X_ihm_27_7 a_xp27 a_xn27 wp_ih_27_7 wn_ih_27_7 mhp7 mhn7 vdd vbsyn gsyn
X_ihx_27_7 a_xp27 a_xn27 wp_ih_27_7 wn_ih_27_7 xhp7 xhn7 vdd vbsyn gsyn
X_ihm_28_7 a_xp28 a_xn28 wp_ih_28_7 wn_ih_28_7 mhp7 mhn7 vdd vbsyn gsyn
X_ihx_28_7 a_xp28 a_xn28 wp_ih_28_7 wn_ih_28_7 xhp7 xhn7 vdd vbsyn gsyn
X_ihm_29_7 a_xp29 a_xn29 wp_ih_29_7 wn_ih_29_7 mhp7 mhn7 vdd vbsyn gsyn
X_ihx_29_7 a_xp29 a_xn29 wp_ih_29_7 wn_ih_29_7 xhp7 xhn7 vdd vbsyn gsyn
X_ihm_30_7 a_xp30 a_xn30 wp_ih_30_7 wn_ih_30_7 mhp7 mhn7 vdd vbsyn gsyn
X_ihx_30_7 a_xp30 a_xn30 wp_ih_30_7 wn_ih_30_7 xhp7 xhn7 vdd vbsyn gsyn
X_ihm_31_7 a_xp31 a_xn31 wp_ih_31_7 wn_ih_31_7 mhp7 mhn7 vdd vbsyn gsyn
X_ihx_31_7 a_xp31 a_xn31 wp_ih_31_7 wn_ih_31_7 xhp7 xhn7 vdd vbsyn gsyn
X_ihm_32_7 a_xp32 a_xn32 wp_ih_32_7 wn_ih_32_7 mhp7 mhn7 vdd vbsyn gsyn
X_ihx_32_7 a_xp32 a_xn32 wp_ih_32_7 wn_ih_32_7 xhp7 xhn7 vdd vbsyn gsyn
X_ihm_33_7 a_xp33 a_xn33 wp_ih_33_7 wn_ih_33_7 mhp7 mhn7 vdd vbsyn gsyn
X_ihx_33_7 a_xp33 a_xn33 wp_ih_33_7 wn_ih_33_7 xhp7 xhn7 vdd vbsyn gsyn
X_ihm_34_7 a_xp34 a_xn34 wp_ih_34_7 wn_ih_34_7 mhp7 mhn7 vdd vbsyn gsyn
X_ihx_34_7 a_xp34 a_xn34 wp_ih_34_7 wn_ih_34_7 xhp7 xhn7 vdd vbsyn gsyn
X_ihm_35_7 a_xp35 a_xn35 wp_ih_35_7 wn_ih_35_7 mhp7 mhn7 vdd vbsyn gsyn
X_ihx_35_7 a_xp35 a_xn35 wp_ih_35_7 wn_ih_35_7 xhp7 xhn7 vdd vbsyn gsyn
X_ihm_36_7 a_xp36 a_xn36 wp_ih_36_7 wn_ih_36_7 mhp7 mhn7 vdd vbsyn gsyn
X_ihx_36_7 a_xp36 a_xn36 wp_ih_36_7 wn_ih_36_7 xhp7 xhn7 vdd vbsyn gsyn
X_ihm_37_7 a_xp37 a_xn37 wp_ih_37_7 wn_ih_37_7 mhp7 mhn7 vdd vbsyn gsyn
X_ihx_37_7 a_xp37 a_xn37 wp_ih_37_7 wn_ih_37_7 xhp7 xhn7 vdd vbsyn gsyn
X_ihm_38_7 a_xp38 a_xn38 wp_ih_38_7 wn_ih_38_7 mhp7 mhn7 vdd vbsyn gsyn
X_ihx_38_7 a_xp38 a_xn38 wp_ih_38_7 wn_ih_38_7 xhp7 xhn7 vdd vbsyn gsyn
X_ihm_39_7 a_xp39 a_xn39 wp_ih_39_7 wn_ih_39_7 mhp7 mhn7 vdd vbsyn gsyn
X_ihx_39_7 a_xp39 a_xn39 wp_ih_39_7 wn_ih_39_7 xhp7 xhn7 vdd vbsyn gsyn
X_ihm_40_7 a_xp40 a_xn40 wp_ih_40_7 wn_ih_40_7 mhp7 mhn7 vdd vbsyn gsyn
X_ihx_40_7 a_xp40 a_xn40 wp_ih_40_7 wn_ih_40_7 xhp7 xhn7 vdd vbsyn gsyn
X_ihm_41_7 a_xp41 a_xn41 wp_ih_41_7 wn_ih_41_7 mhp7 mhn7 vdd vbsyn gsyn
X_ihx_41_7 a_xp41 a_xn41 wp_ih_41_7 wn_ih_41_7 xhp7 xhn7 vdd vbsyn gsyn
X_ihm_42_7 a_xp42 a_xn42 wp_ih_42_7 wn_ih_42_7 mhp7 mhn7 vdd vbsyn gsyn
X_ihx_42_7 a_xp42 a_xn42 wp_ih_42_7 wn_ih_42_7 xhp7 xhn7 vdd vbsyn gsyn
X_ihm_43_7 a_xp43 a_xn43 wp_ih_43_7 wn_ih_43_7 mhp7 mhn7 vdd vbsyn gsyn
X_ihx_43_7 a_xp43 a_xn43 wp_ih_43_7 wn_ih_43_7 xhp7 xhn7 vdd vbsyn gsyn
X_ihm_44_7 a_xp44 a_xn44 wp_ih_44_7 wn_ih_44_7 mhp7 mhn7 vdd vbsyn gsyn
X_ihx_44_7 a_xp44 a_xn44 wp_ih_44_7 wn_ih_44_7 xhp7 xhn7 vdd vbsyn gsyn
X_ihm_45_7 a_xp45 a_xn45 wp_ih_45_7 wn_ih_45_7 mhp7 mhn7 vdd vbsyn gsyn
X_ihx_45_7 a_xp45 a_xn45 wp_ih_45_7 wn_ih_45_7 xhp7 xhn7 vdd vbsyn gsyn
X_ihm_46_7 a_xp46 a_xn46 wp_ih_46_7 wn_ih_46_7 mhp7 mhn7 vdd vbsyn gsyn
X_ihx_46_7 a_xp46 a_xn46 wp_ih_46_7 wn_ih_46_7 xhp7 xhn7 vdd vbsyn gsyn
X_ihm_47_7 a_xp47 a_xn47 wp_ih_47_7 wn_ih_47_7 mhp7 mhn7 vdd vbsyn gsyn
X_ihx_47_7 a_xp47 a_xn47 wp_ih_47_7 wn_ih_47_7 xhp7 xhn7 vdd vbsyn gsyn
X_ihm_48_7 a_xp48 a_xn48 wp_ih_48_7 wn_ih_48_7 mhp7 mhn7 vdd vbsyn gsyn
X_ihx_48_7 a_xp48 a_xn48 wp_ih_48_7 wn_ih_48_7 xhp7 xhn7 vdd vbsyn gsyn
X_ihm_49_7 a_xp49 a_xn49 wp_ih_49_7 wn_ih_49_7 mhp7 mhn7 vdd vbsyn gsyn
X_ihx_49_7 a_xp49 a_xn49 wp_ih_49_7 wn_ih_49_7 xhp7 xhn7 vdd vbsyn gsyn
X_ihm_50_7 a_xp50 a_xn50 wp_ih_50_7 wn_ih_50_7 mhp7 mhn7 vdd vbsyn gsyn
X_ihx_50_7 a_xp50 a_xn50 wp_ih_50_7 wn_ih_50_7 xhp7 xhn7 vdd vbsyn gsyn
X_ihm_51_7 a_xp51 a_xn51 wp_ih_51_7 wn_ih_51_7 mhp7 mhn7 vdd vbsyn gsyn
X_ihx_51_7 a_xp51 a_xn51 wp_ih_51_7 wn_ih_51_7 xhp7 xhn7 vdd vbsyn gsyn
X_ihm_52_7 a_xp52 a_xn52 wp_ih_52_7 wn_ih_52_7 mhp7 mhn7 vdd vbsyn gsyn
X_ihx_52_7 a_xp52 a_xn52 wp_ih_52_7 wn_ih_52_7 xhp7 xhn7 vdd vbsyn gsyn
X_ihm_53_7 a_xp53 a_xn53 wp_ih_53_7 wn_ih_53_7 mhp7 mhn7 vdd vbsyn gsyn
X_ihx_53_7 a_xp53 a_xn53 wp_ih_53_7 wn_ih_53_7 xhp7 xhn7 vdd vbsyn gsyn
X_ihm_54_7 a_xp54 a_xn54 wp_ih_54_7 wn_ih_54_7 mhp7 mhn7 vdd vbsyn gsyn
X_ihx_54_7 a_xp54 a_xn54 wp_ih_54_7 wn_ih_54_7 xhp7 xhn7 vdd vbsyn gsyn
X_ihm_55_7 a_xp55 a_xn55 wp_ih_55_7 wn_ih_55_7 mhp7 mhn7 vdd vbsyn gsyn
X_ihx_55_7 a_xp55 a_xn55 wp_ih_55_7 wn_ih_55_7 xhp7 xhn7 vdd vbsyn gsyn
X_ihm_56_7 a_xp56 a_xn56 wp_ih_56_7 wn_ih_56_7 mhp7 mhn7 vdd vbsyn gsyn
X_ihx_56_7 a_xp56 a_xn56 wp_ih_56_7 wn_ih_56_7 xhp7 xhn7 vdd vbsyn gsyn
X_ihm_57_7 a_xp57 a_xn57 wp_ih_57_7 wn_ih_57_7 mhp7 mhn7 vdd vbsyn gsyn
X_ihx_57_7 a_xp57 a_xn57 wp_ih_57_7 wn_ih_57_7 xhp7 xhn7 vdd vbsyn gsyn
X_ihm_58_7 a_xp58 a_xn58 wp_ih_58_7 wn_ih_58_7 mhp7 mhn7 vdd vbsyn gsyn
X_ihx_58_7 a_xp58 a_xn58 wp_ih_58_7 wn_ih_58_7 xhp7 xhn7 vdd vbsyn gsyn
X_ihm_59_7 a_xp59 a_xn59 wp_ih_59_7 wn_ih_59_7 mhp7 mhn7 vdd vbsyn gsyn
X_ihx_59_7 a_xp59 a_xn59 wp_ih_59_7 wn_ih_59_7 xhp7 xhn7 vdd vbsyn gsyn
X_ihm_60_7 a_xp60 a_xn60 wp_ih_60_7 wn_ih_60_7 mhp7 mhn7 vdd vbsyn gsyn
X_ihx_60_7 a_xp60 a_xn60 wp_ih_60_7 wn_ih_60_7 xhp7 xhn7 vdd vbsyn gsyn
X_ihm_61_7 a_xp61 a_xn61 wp_ih_61_7 wn_ih_61_7 mhp7 mhn7 vdd vbsyn gsyn
X_ihx_61_7 a_xp61 a_xn61 wp_ih_61_7 wn_ih_61_7 xhp7 xhn7 vdd vbsyn gsyn
X_ihm_62_7 a_xp62 a_xn62 wp_ih_62_7 wn_ih_62_7 mhp7 mhn7 vdd vbsyn gsyn
X_ihx_62_7 a_xp62 a_xn62 wp_ih_62_7 wn_ih_62_7 xhp7 xhn7 vdd vbsyn gsyn
X_ihm_63_7 a_xp63 a_xn63 wp_ih_63_7 wn_ih_63_7 mhp7 mhn7 vdd vbsyn gsyn
X_ihx_63_7 a_xp63 a_xn63 wp_ih_63_7 wn_ih_63_7 xhp7 xhn7 vdd vbsyn gsyn
Xn7 xhp7 xhn7 ahp7 ahn7 vdd vbneu dneuron
Xeh7 xhp7 xhn7 mhp7 mhn7 ehp7 ehn7 vdd gm esub
Xcm_mh8 mhp8 mhn8 vdd cmld
Rnd_mh8 mhp8 mhn8 20k
Xcm_xh8 xhp8 xhn8 vdd cmld
Rnd_xh8 xhp8 xhn8 20k
X_ihm_0_8 a_xp0 a_xn0 wp_ih_0_8 wn_ih_0_8 mhp8 mhn8 vdd vbsyn gsyn
X_ihx_0_8 a_xp0 a_xn0 wp_ih_0_8 wn_ih_0_8 xhp8 xhn8 vdd vbsyn gsyn
X_ihm_1_8 a_xp1 a_xn1 wp_ih_1_8 wn_ih_1_8 mhp8 mhn8 vdd vbsyn gsyn
X_ihx_1_8 a_xp1 a_xn1 wp_ih_1_8 wn_ih_1_8 xhp8 xhn8 vdd vbsyn gsyn
X_ihm_2_8 a_xp2 a_xn2 wp_ih_2_8 wn_ih_2_8 mhp8 mhn8 vdd vbsyn gsyn
X_ihx_2_8 a_xp2 a_xn2 wp_ih_2_8 wn_ih_2_8 xhp8 xhn8 vdd vbsyn gsyn
X_ihm_3_8 a_xp3 a_xn3 wp_ih_3_8 wn_ih_3_8 mhp8 mhn8 vdd vbsyn gsyn
X_ihx_3_8 a_xp3 a_xn3 wp_ih_3_8 wn_ih_3_8 xhp8 xhn8 vdd vbsyn gsyn
X_ihm_4_8 a_xp4 a_xn4 wp_ih_4_8 wn_ih_4_8 mhp8 mhn8 vdd vbsyn gsyn
X_ihx_4_8 a_xp4 a_xn4 wp_ih_4_8 wn_ih_4_8 xhp8 xhn8 vdd vbsyn gsyn
X_ihm_5_8 a_xp5 a_xn5 wp_ih_5_8 wn_ih_5_8 mhp8 mhn8 vdd vbsyn gsyn
X_ihx_5_8 a_xp5 a_xn5 wp_ih_5_8 wn_ih_5_8 xhp8 xhn8 vdd vbsyn gsyn
X_ihm_6_8 a_xp6 a_xn6 wp_ih_6_8 wn_ih_6_8 mhp8 mhn8 vdd vbsyn gsyn
X_ihx_6_8 a_xp6 a_xn6 wp_ih_6_8 wn_ih_6_8 xhp8 xhn8 vdd vbsyn gsyn
X_ihm_7_8 a_xp7 a_xn7 wp_ih_7_8 wn_ih_7_8 mhp8 mhn8 vdd vbsyn gsyn
X_ihx_7_8 a_xp7 a_xn7 wp_ih_7_8 wn_ih_7_8 xhp8 xhn8 vdd vbsyn gsyn
X_ihm_8_8 a_xp8 a_xn8 wp_ih_8_8 wn_ih_8_8 mhp8 mhn8 vdd vbsyn gsyn
X_ihx_8_8 a_xp8 a_xn8 wp_ih_8_8 wn_ih_8_8 xhp8 xhn8 vdd vbsyn gsyn
X_ihm_9_8 a_xp9 a_xn9 wp_ih_9_8 wn_ih_9_8 mhp8 mhn8 vdd vbsyn gsyn
X_ihx_9_8 a_xp9 a_xn9 wp_ih_9_8 wn_ih_9_8 xhp8 xhn8 vdd vbsyn gsyn
X_ihm_10_8 a_xp10 a_xn10 wp_ih_10_8 wn_ih_10_8 mhp8 mhn8 vdd vbsyn gsyn
X_ihx_10_8 a_xp10 a_xn10 wp_ih_10_8 wn_ih_10_8 xhp8 xhn8 vdd vbsyn gsyn
X_ihm_11_8 a_xp11 a_xn11 wp_ih_11_8 wn_ih_11_8 mhp8 mhn8 vdd vbsyn gsyn
X_ihx_11_8 a_xp11 a_xn11 wp_ih_11_8 wn_ih_11_8 xhp8 xhn8 vdd vbsyn gsyn
X_ihm_12_8 a_xp12 a_xn12 wp_ih_12_8 wn_ih_12_8 mhp8 mhn8 vdd vbsyn gsyn
X_ihx_12_8 a_xp12 a_xn12 wp_ih_12_8 wn_ih_12_8 xhp8 xhn8 vdd vbsyn gsyn
X_ihm_13_8 a_xp13 a_xn13 wp_ih_13_8 wn_ih_13_8 mhp8 mhn8 vdd vbsyn gsyn
X_ihx_13_8 a_xp13 a_xn13 wp_ih_13_8 wn_ih_13_8 xhp8 xhn8 vdd vbsyn gsyn
X_ihm_14_8 a_xp14 a_xn14 wp_ih_14_8 wn_ih_14_8 mhp8 mhn8 vdd vbsyn gsyn
X_ihx_14_8 a_xp14 a_xn14 wp_ih_14_8 wn_ih_14_8 xhp8 xhn8 vdd vbsyn gsyn
X_ihm_15_8 a_xp15 a_xn15 wp_ih_15_8 wn_ih_15_8 mhp8 mhn8 vdd vbsyn gsyn
X_ihx_15_8 a_xp15 a_xn15 wp_ih_15_8 wn_ih_15_8 xhp8 xhn8 vdd vbsyn gsyn
X_ihm_16_8 a_xp16 a_xn16 wp_ih_16_8 wn_ih_16_8 mhp8 mhn8 vdd vbsyn gsyn
X_ihx_16_8 a_xp16 a_xn16 wp_ih_16_8 wn_ih_16_8 xhp8 xhn8 vdd vbsyn gsyn
X_ihm_17_8 a_xp17 a_xn17 wp_ih_17_8 wn_ih_17_8 mhp8 mhn8 vdd vbsyn gsyn
X_ihx_17_8 a_xp17 a_xn17 wp_ih_17_8 wn_ih_17_8 xhp8 xhn8 vdd vbsyn gsyn
X_ihm_18_8 a_xp18 a_xn18 wp_ih_18_8 wn_ih_18_8 mhp8 mhn8 vdd vbsyn gsyn
X_ihx_18_8 a_xp18 a_xn18 wp_ih_18_8 wn_ih_18_8 xhp8 xhn8 vdd vbsyn gsyn
X_ihm_19_8 a_xp19 a_xn19 wp_ih_19_8 wn_ih_19_8 mhp8 mhn8 vdd vbsyn gsyn
X_ihx_19_8 a_xp19 a_xn19 wp_ih_19_8 wn_ih_19_8 xhp8 xhn8 vdd vbsyn gsyn
X_ihm_20_8 a_xp20 a_xn20 wp_ih_20_8 wn_ih_20_8 mhp8 mhn8 vdd vbsyn gsyn
X_ihx_20_8 a_xp20 a_xn20 wp_ih_20_8 wn_ih_20_8 xhp8 xhn8 vdd vbsyn gsyn
X_ihm_21_8 a_xp21 a_xn21 wp_ih_21_8 wn_ih_21_8 mhp8 mhn8 vdd vbsyn gsyn
X_ihx_21_8 a_xp21 a_xn21 wp_ih_21_8 wn_ih_21_8 xhp8 xhn8 vdd vbsyn gsyn
X_ihm_22_8 a_xp22 a_xn22 wp_ih_22_8 wn_ih_22_8 mhp8 mhn8 vdd vbsyn gsyn
X_ihx_22_8 a_xp22 a_xn22 wp_ih_22_8 wn_ih_22_8 xhp8 xhn8 vdd vbsyn gsyn
X_ihm_23_8 a_xp23 a_xn23 wp_ih_23_8 wn_ih_23_8 mhp8 mhn8 vdd vbsyn gsyn
X_ihx_23_8 a_xp23 a_xn23 wp_ih_23_8 wn_ih_23_8 xhp8 xhn8 vdd vbsyn gsyn
X_ihm_24_8 a_xp24 a_xn24 wp_ih_24_8 wn_ih_24_8 mhp8 mhn8 vdd vbsyn gsyn
X_ihx_24_8 a_xp24 a_xn24 wp_ih_24_8 wn_ih_24_8 xhp8 xhn8 vdd vbsyn gsyn
X_ihm_25_8 a_xp25 a_xn25 wp_ih_25_8 wn_ih_25_8 mhp8 mhn8 vdd vbsyn gsyn
X_ihx_25_8 a_xp25 a_xn25 wp_ih_25_8 wn_ih_25_8 xhp8 xhn8 vdd vbsyn gsyn
X_ihm_26_8 a_xp26 a_xn26 wp_ih_26_8 wn_ih_26_8 mhp8 mhn8 vdd vbsyn gsyn
X_ihx_26_8 a_xp26 a_xn26 wp_ih_26_8 wn_ih_26_8 xhp8 xhn8 vdd vbsyn gsyn
X_ihm_27_8 a_xp27 a_xn27 wp_ih_27_8 wn_ih_27_8 mhp8 mhn8 vdd vbsyn gsyn
X_ihx_27_8 a_xp27 a_xn27 wp_ih_27_8 wn_ih_27_8 xhp8 xhn8 vdd vbsyn gsyn
X_ihm_28_8 a_xp28 a_xn28 wp_ih_28_8 wn_ih_28_8 mhp8 mhn8 vdd vbsyn gsyn
X_ihx_28_8 a_xp28 a_xn28 wp_ih_28_8 wn_ih_28_8 xhp8 xhn8 vdd vbsyn gsyn
X_ihm_29_8 a_xp29 a_xn29 wp_ih_29_8 wn_ih_29_8 mhp8 mhn8 vdd vbsyn gsyn
X_ihx_29_8 a_xp29 a_xn29 wp_ih_29_8 wn_ih_29_8 xhp8 xhn8 vdd vbsyn gsyn
X_ihm_30_8 a_xp30 a_xn30 wp_ih_30_8 wn_ih_30_8 mhp8 mhn8 vdd vbsyn gsyn
X_ihx_30_8 a_xp30 a_xn30 wp_ih_30_8 wn_ih_30_8 xhp8 xhn8 vdd vbsyn gsyn
X_ihm_31_8 a_xp31 a_xn31 wp_ih_31_8 wn_ih_31_8 mhp8 mhn8 vdd vbsyn gsyn
X_ihx_31_8 a_xp31 a_xn31 wp_ih_31_8 wn_ih_31_8 xhp8 xhn8 vdd vbsyn gsyn
X_ihm_32_8 a_xp32 a_xn32 wp_ih_32_8 wn_ih_32_8 mhp8 mhn8 vdd vbsyn gsyn
X_ihx_32_8 a_xp32 a_xn32 wp_ih_32_8 wn_ih_32_8 xhp8 xhn8 vdd vbsyn gsyn
X_ihm_33_8 a_xp33 a_xn33 wp_ih_33_8 wn_ih_33_8 mhp8 mhn8 vdd vbsyn gsyn
X_ihx_33_8 a_xp33 a_xn33 wp_ih_33_8 wn_ih_33_8 xhp8 xhn8 vdd vbsyn gsyn
X_ihm_34_8 a_xp34 a_xn34 wp_ih_34_8 wn_ih_34_8 mhp8 mhn8 vdd vbsyn gsyn
X_ihx_34_8 a_xp34 a_xn34 wp_ih_34_8 wn_ih_34_8 xhp8 xhn8 vdd vbsyn gsyn
X_ihm_35_8 a_xp35 a_xn35 wp_ih_35_8 wn_ih_35_8 mhp8 mhn8 vdd vbsyn gsyn
X_ihx_35_8 a_xp35 a_xn35 wp_ih_35_8 wn_ih_35_8 xhp8 xhn8 vdd vbsyn gsyn
X_ihm_36_8 a_xp36 a_xn36 wp_ih_36_8 wn_ih_36_8 mhp8 mhn8 vdd vbsyn gsyn
X_ihx_36_8 a_xp36 a_xn36 wp_ih_36_8 wn_ih_36_8 xhp8 xhn8 vdd vbsyn gsyn
X_ihm_37_8 a_xp37 a_xn37 wp_ih_37_8 wn_ih_37_8 mhp8 mhn8 vdd vbsyn gsyn
X_ihx_37_8 a_xp37 a_xn37 wp_ih_37_8 wn_ih_37_8 xhp8 xhn8 vdd vbsyn gsyn
X_ihm_38_8 a_xp38 a_xn38 wp_ih_38_8 wn_ih_38_8 mhp8 mhn8 vdd vbsyn gsyn
X_ihx_38_8 a_xp38 a_xn38 wp_ih_38_8 wn_ih_38_8 xhp8 xhn8 vdd vbsyn gsyn
X_ihm_39_8 a_xp39 a_xn39 wp_ih_39_8 wn_ih_39_8 mhp8 mhn8 vdd vbsyn gsyn
X_ihx_39_8 a_xp39 a_xn39 wp_ih_39_8 wn_ih_39_8 xhp8 xhn8 vdd vbsyn gsyn
X_ihm_40_8 a_xp40 a_xn40 wp_ih_40_8 wn_ih_40_8 mhp8 mhn8 vdd vbsyn gsyn
X_ihx_40_8 a_xp40 a_xn40 wp_ih_40_8 wn_ih_40_8 xhp8 xhn8 vdd vbsyn gsyn
X_ihm_41_8 a_xp41 a_xn41 wp_ih_41_8 wn_ih_41_8 mhp8 mhn8 vdd vbsyn gsyn
X_ihx_41_8 a_xp41 a_xn41 wp_ih_41_8 wn_ih_41_8 xhp8 xhn8 vdd vbsyn gsyn
X_ihm_42_8 a_xp42 a_xn42 wp_ih_42_8 wn_ih_42_8 mhp8 mhn8 vdd vbsyn gsyn
X_ihx_42_8 a_xp42 a_xn42 wp_ih_42_8 wn_ih_42_8 xhp8 xhn8 vdd vbsyn gsyn
X_ihm_43_8 a_xp43 a_xn43 wp_ih_43_8 wn_ih_43_8 mhp8 mhn8 vdd vbsyn gsyn
X_ihx_43_8 a_xp43 a_xn43 wp_ih_43_8 wn_ih_43_8 xhp8 xhn8 vdd vbsyn gsyn
X_ihm_44_8 a_xp44 a_xn44 wp_ih_44_8 wn_ih_44_8 mhp8 mhn8 vdd vbsyn gsyn
X_ihx_44_8 a_xp44 a_xn44 wp_ih_44_8 wn_ih_44_8 xhp8 xhn8 vdd vbsyn gsyn
X_ihm_45_8 a_xp45 a_xn45 wp_ih_45_8 wn_ih_45_8 mhp8 mhn8 vdd vbsyn gsyn
X_ihx_45_8 a_xp45 a_xn45 wp_ih_45_8 wn_ih_45_8 xhp8 xhn8 vdd vbsyn gsyn
X_ihm_46_8 a_xp46 a_xn46 wp_ih_46_8 wn_ih_46_8 mhp8 mhn8 vdd vbsyn gsyn
X_ihx_46_8 a_xp46 a_xn46 wp_ih_46_8 wn_ih_46_8 xhp8 xhn8 vdd vbsyn gsyn
X_ihm_47_8 a_xp47 a_xn47 wp_ih_47_8 wn_ih_47_8 mhp8 mhn8 vdd vbsyn gsyn
X_ihx_47_8 a_xp47 a_xn47 wp_ih_47_8 wn_ih_47_8 xhp8 xhn8 vdd vbsyn gsyn
X_ihm_48_8 a_xp48 a_xn48 wp_ih_48_8 wn_ih_48_8 mhp8 mhn8 vdd vbsyn gsyn
X_ihx_48_8 a_xp48 a_xn48 wp_ih_48_8 wn_ih_48_8 xhp8 xhn8 vdd vbsyn gsyn
X_ihm_49_8 a_xp49 a_xn49 wp_ih_49_8 wn_ih_49_8 mhp8 mhn8 vdd vbsyn gsyn
X_ihx_49_8 a_xp49 a_xn49 wp_ih_49_8 wn_ih_49_8 xhp8 xhn8 vdd vbsyn gsyn
X_ihm_50_8 a_xp50 a_xn50 wp_ih_50_8 wn_ih_50_8 mhp8 mhn8 vdd vbsyn gsyn
X_ihx_50_8 a_xp50 a_xn50 wp_ih_50_8 wn_ih_50_8 xhp8 xhn8 vdd vbsyn gsyn
X_ihm_51_8 a_xp51 a_xn51 wp_ih_51_8 wn_ih_51_8 mhp8 mhn8 vdd vbsyn gsyn
X_ihx_51_8 a_xp51 a_xn51 wp_ih_51_8 wn_ih_51_8 xhp8 xhn8 vdd vbsyn gsyn
X_ihm_52_8 a_xp52 a_xn52 wp_ih_52_8 wn_ih_52_8 mhp8 mhn8 vdd vbsyn gsyn
X_ihx_52_8 a_xp52 a_xn52 wp_ih_52_8 wn_ih_52_8 xhp8 xhn8 vdd vbsyn gsyn
X_ihm_53_8 a_xp53 a_xn53 wp_ih_53_8 wn_ih_53_8 mhp8 mhn8 vdd vbsyn gsyn
X_ihx_53_8 a_xp53 a_xn53 wp_ih_53_8 wn_ih_53_8 xhp8 xhn8 vdd vbsyn gsyn
X_ihm_54_8 a_xp54 a_xn54 wp_ih_54_8 wn_ih_54_8 mhp8 mhn8 vdd vbsyn gsyn
X_ihx_54_8 a_xp54 a_xn54 wp_ih_54_8 wn_ih_54_8 xhp8 xhn8 vdd vbsyn gsyn
X_ihm_55_8 a_xp55 a_xn55 wp_ih_55_8 wn_ih_55_8 mhp8 mhn8 vdd vbsyn gsyn
X_ihx_55_8 a_xp55 a_xn55 wp_ih_55_8 wn_ih_55_8 xhp8 xhn8 vdd vbsyn gsyn
X_ihm_56_8 a_xp56 a_xn56 wp_ih_56_8 wn_ih_56_8 mhp8 mhn8 vdd vbsyn gsyn
X_ihx_56_8 a_xp56 a_xn56 wp_ih_56_8 wn_ih_56_8 xhp8 xhn8 vdd vbsyn gsyn
X_ihm_57_8 a_xp57 a_xn57 wp_ih_57_8 wn_ih_57_8 mhp8 mhn8 vdd vbsyn gsyn
X_ihx_57_8 a_xp57 a_xn57 wp_ih_57_8 wn_ih_57_8 xhp8 xhn8 vdd vbsyn gsyn
X_ihm_58_8 a_xp58 a_xn58 wp_ih_58_8 wn_ih_58_8 mhp8 mhn8 vdd vbsyn gsyn
X_ihx_58_8 a_xp58 a_xn58 wp_ih_58_8 wn_ih_58_8 xhp8 xhn8 vdd vbsyn gsyn
X_ihm_59_8 a_xp59 a_xn59 wp_ih_59_8 wn_ih_59_8 mhp8 mhn8 vdd vbsyn gsyn
X_ihx_59_8 a_xp59 a_xn59 wp_ih_59_8 wn_ih_59_8 xhp8 xhn8 vdd vbsyn gsyn
X_ihm_60_8 a_xp60 a_xn60 wp_ih_60_8 wn_ih_60_8 mhp8 mhn8 vdd vbsyn gsyn
X_ihx_60_8 a_xp60 a_xn60 wp_ih_60_8 wn_ih_60_8 xhp8 xhn8 vdd vbsyn gsyn
X_ihm_61_8 a_xp61 a_xn61 wp_ih_61_8 wn_ih_61_8 mhp8 mhn8 vdd vbsyn gsyn
X_ihx_61_8 a_xp61 a_xn61 wp_ih_61_8 wn_ih_61_8 xhp8 xhn8 vdd vbsyn gsyn
X_ihm_62_8 a_xp62 a_xn62 wp_ih_62_8 wn_ih_62_8 mhp8 mhn8 vdd vbsyn gsyn
X_ihx_62_8 a_xp62 a_xn62 wp_ih_62_8 wn_ih_62_8 xhp8 xhn8 vdd vbsyn gsyn
X_ihm_63_8 a_xp63 a_xn63 wp_ih_63_8 wn_ih_63_8 mhp8 mhn8 vdd vbsyn gsyn
X_ihx_63_8 a_xp63 a_xn63 wp_ih_63_8 wn_ih_63_8 xhp8 xhn8 vdd vbsyn gsyn
Xn8 xhp8 xhn8 ahp8 ahn8 vdd vbneu dneuron
Xeh8 xhp8 xhn8 mhp8 mhn8 ehp8 ehn8 vdd gm esub
Xcm_mh9 mhp9 mhn9 vdd cmld
Rnd_mh9 mhp9 mhn9 20k
Xcm_xh9 xhp9 xhn9 vdd cmld
Rnd_xh9 xhp9 xhn9 20k
X_ihm_0_9 a_xp0 a_xn0 wp_ih_0_9 wn_ih_0_9 mhp9 mhn9 vdd vbsyn gsyn
X_ihx_0_9 a_xp0 a_xn0 wp_ih_0_9 wn_ih_0_9 xhp9 xhn9 vdd vbsyn gsyn
X_ihm_1_9 a_xp1 a_xn1 wp_ih_1_9 wn_ih_1_9 mhp9 mhn9 vdd vbsyn gsyn
X_ihx_1_9 a_xp1 a_xn1 wp_ih_1_9 wn_ih_1_9 xhp9 xhn9 vdd vbsyn gsyn
X_ihm_2_9 a_xp2 a_xn2 wp_ih_2_9 wn_ih_2_9 mhp9 mhn9 vdd vbsyn gsyn
X_ihx_2_9 a_xp2 a_xn2 wp_ih_2_9 wn_ih_2_9 xhp9 xhn9 vdd vbsyn gsyn
X_ihm_3_9 a_xp3 a_xn3 wp_ih_3_9 wn_ih_3_9 mhp9 mhn9 vdd vbsyn gsyn
X_ihx_3_9 a_xp3 a_xn3 wp_ih_3_9 wn_ih_3_9 xhp9 xhn9 vdd vbsyn gsyn
X_ihm_4_9 a_xp4 a_xn4 wp_ih_4_9 wn_ih_4_9 mhp9 mhn9 vdd vbsyn gsyn
X_ihx_4_9 a_xp4 a_xn4 wp_ih_4_9 wn_ih_4_9 xhp9 xhn9 vdd vbsyn gsyn
X_ihm_5_9 a_xp5 a_xn5 wp_ih_5_9 wn_ih_5_9 mhp9 mhn9 vdd vbsyn gsyn
X_ihx_5_9 a_xp5 a_xn5 wp_ih_5_9 wn_ih_5_9 xhp9 xhn9 vdd vbsyn gsyn
X_ihm_6_9 a_xp6 a_xn6 wp_ih_6_9 wn_ih_6_9 mhp9 mhn9 vdd vbsyn gsyn
X_ihx_6_9 a_xp6 a_xn6 wp_ih_6_9 wn_ih_6_9 xhp9 xhn9 vdd vbsyn gsyn
X_ihm_7_9 a_xp7 a_xn7 wp_ih_7_9 wn_ih_7_9 mhp9 mhn9 vdd vbsyn gsyn
X_ihx_7_9 a_xp7 a_xn7 wp_ih_7_9 wn_ih_7_9 xhp9 xhn9 vdd vbsyn gsyn
X_ihm_8_9 a_xp8 a_xn8 wp_ih_8_9 wn_ih_8_9 mhp9 mhn9 vdd vbsyn gsyn
X_ihx_8_9 a_xp8 a_xn8 wp_ih_8_9 wn_ih_8_9 xhp9 xhn9 vdd vbsyn gsyn
X_ihm_9_9 a_xp9 a_xn9 wp_ih_9_9 wn_ih_9_9 mhp9 mhn9 vdd vbsyn gsyn
X_ihx_9_9 a_xp9 a_xn9 wp_ih_9_9 wn_ih_9_9 xhp9 xhn9 vdd vbsyn gsyn
X_ihm_10_9 a_xp10 a_xn10 wp_ih_10_9 wn_ih_10_9 mhp9 mhn9 vdd vbsyn gsyn
X_ihx_10_9 a_xp10 a_xn10 wp_ih_10_9 wn_ih_10_9 xhp9 xhn9 vdd vbsyn gsyn
X_ihm_11_9 a_xp11 a_xn11 wp_ih_11_9 wn_ih_11_9 mhp9 mhn9 vdd vbsyn gsyn
X_ihx_11_9 a_xp11 a_xn11 wp_ih_11_9 wn_ih_11_9 xhp9 xhn9 vdd vbsyn gsyn
X_ihm_12_9 a_xp12 a_xn12 wp_ih_12_9 wn_ih_12_9 mhp9 mhn9 vdd vbsyn gsyn
X_ihx_12_9 a_xp12 a_xn12 wp_ih_12_9 wn_ih_12_9 xhp9 xhn9 vdd vbsyn gsyn
X_ihm_13_9 a_xp13 a_xn13 wp_ih_13_9 wn_ih_13_9 mhp9 mhn9 vdd vbsyn gsyn
X_ihx_13_9 a_xp13 a_xn13 wp_ih_13_9 wn_ih_13_9 xhp9 xhn9 vdd vbsyn gsyn
X_ihm_14_9 a_xp14 a_xn14 wp_ih_14_9 wn_ih_14_9 mhp9 mhn9 vdd vbsyn gsyn
X_ihx_14_9 a_xp14 a_xn14 wp_ih_14_9 wn_ih_14_9 xhp9 xhn9 vdd vbsyn gsyn
X_ihm_15_9 a_xp15 a_xn15 wp_ih_15_9 wn_ih_15_9 mhp9 mhn9 vdd vbsyn gsyn
X_ihx_15_9 a_xp15 a_xn15 wp_ih_15_9 wn_ih_15_9 xhp9 xhn9 vdd vbsyn gsyn
X_ihm_16_9 a_xp16 a_xn16 wp_ih_16_9 wn_ih_16_9 mhp9 mhn9 vdd vbsyn gsyn
X_ihx_16_9 a_xp16 a_xn16 wp_ih_16_9 wn_ih_16_9 xhp9 xhn9 vdd vbsyn gsyn
X_ihm_17_9 a_xp17 a_xn17 wp_ih_17_9 wn_ih_17_9 mhp9 mhn9 vdd vbsyn gsyn
X_ihx_17_9 a_xp17 a_xn17 wp_ih_17_9 wn_ih_17_9 xhp9 xhn9 vdd vbsyn gsyn
X_ihm_18_9 a_xp18 a_xn18 wp_ih_18_9 wn_ih_18_9 mhp9 mhn9 vdd vbsyn gsyn
X_ihx_18_9 a_xp18 a_xn18 wp_ih_18_9 wn_ih_18_9 xhp9 xhn9 vdd vbsyn gsyn
X_ihm_19_9 a_xp19 a_xn19 wp_ih_19_9 wn_ih_19_9 mhp9 mhn9 vdd vbsyn gsyn
X_ihx_19_9 a_xp19 a_xn19 wp_ih_19_9 wn_ih_19_9 xhp9 xhn9 vdd vbsyn gsyn
X_ihm_20_9 a_xp20 a_xn20 wp_ih_20_9 wn_ih_20_9 mhp9 mhn9 vdd vbsyn gsyn
X_ihx_20_9 a_xp20 a_xn20 wp_ih_20_9 wn_ih_20_9 xhp9 xhn9 vdd vbsyn gsyn
X_ihm_21_9 a_xp21 a_xn21 wp_ih_21_9 wn_ih_21_9 mhp9 mhn9 vdd vbsyn gsyn
X_ihx_21_9 a_xp21 a_xn21 wp_ih_21_9 wn_ih_21_9 xhp9 xhn9 vdd vbsyn gsyn
X_ihm_22_9 a_xp22 a_xn22 wp_ih_22_9 wn_ih_22_9 mhp9 mhn9 vdd vbsyn gsyn
X_ihx_22_9 a_xp22 a_xn22 wp_ih_22_9 wn_ih_22_9 xhp9 xhn9 vdd vbsyn gsyn
X_ihm_23_9 a_xp23 a_xn23 wp_ih_23_9 wn_ih_23_9 mhp9 mhn9 vdd vbsyn gsyn
X_ihx_23_9 a_xp23 a_xn23 wp_ih_23_9 wn_ih_23_9 xhp9 xhn9 vdd vbsyn gsyn
X_ihm_24_9 a_xp24 a_xn24 wp_ih_24_9 wn_ih_24_9 mhp9 mhn9 vdd vbsyn gsyn
X_ihx_24_9 a_xp24 a_xn24 wp_ih_24_9 wn_ih_24_9 xhp9 xhn9 vdd vbsyn gsyn
X_ihm_25_9 a_xp25 a_xn25 wp_ih_25_9 wn_ih_25_9 mhp9 mhn9 vdd vbsyn gsyn
X_ihx_25_9 a_xp25 a_xn25 wp_ih_25_9 wn_ih_25_9 xhp9 xhn9 vdd vbsyn gsyn
X_ihm_26_9 a_xp26 a_xn26 wp_ih_26_9 wn_ih_26_9 mhp9 mhn9 vdd vbsyn gsyn
X_ihx_26_9 a_xp26 a_xn26 wp_ih_26_9 wn_ih_26_9 xhp9 xhn9 vdd vbsyn gsyn
X_ihm_27_9 a_xp27 a_xn27 wp_ih_27_9 wn_ih_27_9 mhp9 mhn9 vdd vbsyn gsyn
X_ihx_27_9 a_xp27 a_xn27 wp_ih_27_9 wn_ih_27_9 xhp9 xhn9 vdd vbsyn gsyn
X_ihm_28_9 a_xp28 a_xn28 wp_ih_28_9 wn_ih_28_9 mhp9 mhn9 vdd vbsyn gsyn
X_ihx_28_9 a_xp28 a_xn28 wp_ih_28_9 wn_ih_28_9 xhp9 xhn9 vdd vbsyn gsyn
X_ihm_29_9 a_xp29 a_xn29 wp_ih_29_9 wn_ih_29_9 mhp9 mhn9 vdd vbsyn gsyn
X_ihx_29_9 a_xp29 a_xn29 wp_ih_29_9 wn_ih_29_9 xhp9 xhn9 vdd vbsyn gsyn
X_ihm_30_9 a_xp30 a_xn30 wp_ih_30_9 wn_ih_30_9 mhp9 mhn9 vdd vbsyn gsyn
X_ihx_30_9 a_xp30 a_xn30 wp_ih_30_9 wn_ih_30_9 xhp9 xhn9 vdd vbsyn gsyn
X_ihm_31_9 a_xp31 a_xn31 wp_ih_31_9 wn_ih_31_9 mhp9 mhn9 vdd vbsyn gsyn
X_ihx_31_9 a_xp31 a_xn31 wp_ih_31_9 wn_ih_31_9 xhp9 xhn9 vdd vbsyn gsyn
X_ihm_32_9 a_xp32 a_xn32 wp_ih_32_9 wn_ih_32_9 mhp9 mhn9 vdd vbsyn gsyn
X_ihx_32_9 a_xp32 a_xn32 wp_ih_32_9 wn_ih_32_9 xhp9 xhn9 vdd vbsyn gsyn
X_ihm_33_9 a_xp33 a_xn33 wp_ih_33_9 wn_ih_33_9 mhp9 mhn9 vdd vbsyn gsyn
X_ihx_33_9 a_xp33 a_xn33 wp_ih_33_9 wn_ih_33_9 xhp9 xhn9 vdd vbsyn gsyn
X_ihm_34_9 a_xp34 a_xn34 wp_ih_34_9 wn_ih_34_9 mhp9 mhn9 vdd vbsyn gsyn
X_ihx_34_9 a_xp34 a_xn34 wp_ih_34_9 wn_ih_34_9 xhp9 xhn9 vdd vbsyn gsyn
X_ihm_35_9 a_xp35 a_xn35 wp_ih_35_9 wn_ih_35_9 mhp9 mhn9 vdd vbsyn gsyn
X_ihx_35_9 a_xp35 a_xn35 wp_ih_35_9 wn_ih_35_9 xhp9 xhn9 vdd vbsyn gsyn
X_ihm_36_9 a_xp36 a_xn36 wp_ih_36_9 wn_ih_36_9 mhp9 mhn9 vdd vbsyn gsyn
X_ihx_36_9 a_xp36 a_xn36 wp_ih_36_9 wn_ih_36_9 xhp9 xhn9 vdd vbsyn gsyn
X_ihm_37_9 a_xp37 a_xn37 wp_ih_37_9 wn_ih_37_9 mhp9 mhn9 vdd vbsyn gsyn
X_ihx_37_9 a_xp37 a_xn37 wp_ih_37_9 wn_ih_37_9 xhp9 xhn9 vdd vbsyn gsyn
X_ihm_38_9 a_xp38 a_xn38 wp_ih_38_9 wn_ih_38_9 mhp9 mhn9 vdd vbsyn gsyn
X_ihx_38_9 a_xp38 a_xn38 wp_ih_38_9 wn_ih_38_9 xhp9 xhn9 vdd vbsyn gsyn
X_ihm_39_9 a_xp39 a_xn39 wp_ih_39_9 wn_ih_39_9 mhp9 mhn9 vdd vbsyn gsyn
X_ihx_39_9 a_xp39 a_xn39 wp_ih_39_9 wn_ih_39_9 xhp9 xhn9 vdd vbsyn gsyn
X_ihm_40_9 a_xp40 a_xn40 wp_ih_40_9 wn_ih_40_9 mhp9 mhn9 vdd vbsyn gsyn
X_ihx_40_9 a_xp40 a_xn40 wp_ih_40_9 wn_ih_40_9 xhp9 xhn9 vdd vbsyn gsyn
X_ihm_41_9 a_xp41 a_xn41 wp_ih_41_9 wn_ih_41_9 mhp9 mhn9 vdd vbsyn gsyn
X_ihx_41_9 a_xp41 a_xn41 wp_ih_41_9 wn_ih_41_9 xhp9 xhn9 vdd vbsyn gsyn
X_ihm_42_9 a_xp42 a_xn42 wp_ih_42_9 wn_ih_42_9 mhp9 mhn9 vdd vbsyn gsyn
X_ihx_42_9 a_xp42 a_xn42 wp_ih_42_9 wn_ih_42_9 xhp9 xhn9 vdd vbsyn gsyn
X_ihm_43_9 a_xp43 a_xn43 wp_ih_43_9 wn_ih_43_9 mhp9 mhn9 vdd vbsyn gsyn
X_ihx_43_9 a_xp43 a_xn43 wp_ih_43_9 wn_ih_43_9 xhp9 xhn9 vdd vbsyn gsyn
X_ihm_44_9 a_xp44 a_xn44 wp_ih_44_9 wn_ih_44_9 mhp9 mhn9 vdd vbsyn gsyn
X_ihx_44_9 a_xp44 a_xn44 wp_ih_44_9 wn_ih_44_9 xhp9 xhn9 vdd vbsyn gsyn
X_ihm_45_9 a_xp45 a_xn45 wp_ih_45_9 wn_ih_45_9 mhp9 mhn9 vdd vbsyn gsyn
X_ihx_45_9 a_xp45 a_xn45 wp_ih_45_9 wn_ih_45_9 xhp9 xhn9 vdd vbsyn gsyn
X_ihm_46_9 a_xp46 a_xn46 wp_ih_46_9 wn_ih_46_9 mhp9 mhn9 vdd vbsyn gsyn
X_ihx_46_9 a_xp46 a_xn46 wp_ih_46_9 wn_ih_46_9 xhp9 xhn9 vdd vbsyn gsyn
X_ihm_47_9 a_xp47 a_xn47 wp_ih_47_9 wn_ih_47_9 mhp9 mhn9 vdd vbsyn gsyn
X_ihx_47_9 a_xp47 a_xn47 wp_ih_47_9 wn_ih_47_9 xhp9 xhn9 vdd vbsyn gsyn
X_ihm_48_9 a_xp48 a_xn48 wp_ih_48_9 wn_ih_48_9 mhp9 mhn9 vdd vbsyn gsyn
X_ihx_48_9 a_xp48 a_xn48 wp_ih_48_9 wn_ih_48_9 xhp9 xhn9 vdd vbsyn gsyn
X_ihm_49_9 a_xp49 a_xn49 wp_ih_49_9 wn_ih_49_9 mhp9 mhn9 vdd vbsyn gsyn
X_ihx_49_9 a_xp49 a_xn49 wp_ih_49_9 wn_ih_49_9 xhp9 xhn9 vdd vbsyn gsyn
X_ihm_50_9 a_xp50 a_xn50 wp_ih_50_9 wn_ih_50_9 mhp9 mhn9 vdd vbsyn gsyn
X_ihx_50_9 a_xp50 a_xn50 wp_ih_50_9 wn_ih_50_9 xhp9 xhn9 vdd vbsyn gsyn
X_ihm_51_9 a_xp51 a_xn51 wp_ih_51_9 wn_ih_51_9 mhp9 mhn9 vdd vbsyn gsyn
X_ihx_51_9 a_xp51 a_xn51 wp_ih_51_9 wn_ih_51_9 xhp9 xhn9 vdd vbsyn gsyn
X_ihm_52_9 a_xp52 a_xn52 wp_ih_52_9 wn_ih_52_9 mhp9 mhn9 vdd vbsyn gsyn
X_ihx_52_9 a_xp52 a_xn52 wp_ih_52_9 wn_ih_52_9 xhp9 xhn9 vdd vbsyn gsyn
X_ihm_53_9 a_xp53 a_xn53 wp_ih_53_9 wn_ih_53_9 mhp9 mhn9 vdd vbsyn gsyn
X_ihx_53_9 a_xp53 a_xn53 wp_ih_53_9 wn_ih_53_9 xhp9 xhn9 vdd vbsyn gsyn
X_ihm_54_9 a_xp54 a_xn54 wp_ih_54_9 wn_ih_54_9 mhp9 mhn9 vdd vbsyn gsyn
X_ihx_54_9 a_xp54 a_xn54 wp_ih_54_9 wn_ih_54_9 xhp9 xhn9 vdd vbsyn gsyn
X_ihm_55_9 a_xp55 a_xn55 wp_ih_55_9 wn_ih_55_9 mhp9 mhn9 vdd vbsyn gsyn
X_ihx_55_9 a_xp55 a_xn55 wp_ih_55_9 wn_ih_55_9 xhp9 xhn9 vdd vbsyn gsyn
X_ihm_56_9 a_xp56 a_xn56 wp_ih_56_9 wn_ih_56_9 mhp9 mhn9 vdd vbsyn gsyn
X_ihx_56_9 a_xp56 a_xn56 wp_ih_56_9 wn_ih_56_9 xhp9 xhn9 vdd vbsyn gsyn
X_ihm_57_9 a_xp57 a_xn57 wp_ih_57_9 wn_ih_57_9 mhp9 mhn9 vdd vbsyn gsyn
X_ihx_57_9 a_xp57 a_xn57 wp_ih_57_9 wn_ih_57_9 xhp9 xhn9 vdd vbsyn gsyn
X_ihm_58_9 a_xp58 a_xn58 wp_ih_58_9 wn_ih_58_9 mhp9 mhn9 vdd vbsyn gsyn
X_ihx_58_9 a_xp58 a_xn58 wp_ih_58_9 wn_ih_58_9 xhp9 xhn9 vdd vbsyn gsyn
X_ihm_59_9 a_xp59 a_xn59 wp_ih_59_9 wn_ih_59_9 mhp9 mhn9 vdd vbsyn gsyn
X_ihx_59_9 a_xp59 a_xn59 wp_ih_59_9 wn_ih_59_9 xhp9 xhn9 vdd vbsyn gsyn
X_ihm_60_9 a_xp60 a_xn60 wp_ih_60_9 wn_ih_60_9 mhp9 mhn9 vdd vbsyn gsyn
X_ihx_60_9 a_xp60 a_xn60 wp_ih_60_9 wn_ih_60_9 xhp9 xhn9 vdd vbsyn gsyn
X_ihm_61_9 a_xp61 a_xn61 wp_ih_61_9 wn_ih_61_9 mhp9 mhn9 vdd vbsyn gsyn
X_ihx_61_9 a_xp61 a_xn61 wp_ih_61_9 wn_ih_61_9 xhp9 xhn9 vdd vbsyn gsyn
X_ihm_62_9 a_xp62 a_xn62 wp_ih_62_9 wn_ih_62_9 mhp9 mhn9 vdd vbsyn gsyn
X_ihx_62_9 a_xp62 a_xn62 wp_ih_62_9 wn_ih_62_9 xhp9 xhn9 vdd vbsyn gsyn
X_ihm_63_9 a_xp63 a_xn63 wp_ih_63_9 wn_ih_63_9 mhp9 mhn9 vdd vbsyn gsyn
X_ihx_63_9 a_xp63 a_xn63 wp_ih_63_9 wn_ih_63_9 xhp9 xhn9 vdd vbsyn gsyn
Xn9 xhp9 xhn9 ahp9 ahn9 vdd vbneu dneuron
Xeh9 xhp9 xhn9 mhp9 mhn9 ehp9 ehn9 vdd gm esub
Xcm_mh10 mhp10 mhn10 vdd cmld
Rnd_mh10 mhp10 mhn10 20k
Xcm_xh10 xhp10 xhn10 vdd cmld
Rnd_xh10 xhp10 xhn10 20k
X_ihm_0_10 a_xp0 a_xn0 wp_ih_0_10 wn_ih_0_10 mhp10 mhn10 vdd vbsyn gsyn
X_ihx_0_10 a_xp0 a_xn0 wp_ih_0_10 wn_ih_0_10 xhp10 xhn10 vdd vbsyn gsyn
X_ihm_1_10 a_xp1 a_xn1 wp_ih_1_10 wn_ih_1_10 mhp10 mhn10 vdd vbsyn gsyn
X_ihx_1_10 a_xp1 a_xn1 wp_ih_1_10 wn_ih_1_10 xhp10 xhn10 vdd vbsyn gsyn
X_ihm_2_10 a_xp2 a_xn2 wp_ih_2_10 wn_ih_2_10 mhp10 mhn10 vdd vbsyn gsyn
X_ihx_2_10 a_xp2 a_xn2 wp_ih_2_10 wn_ih_2_10 xhp10 xhn10 vdd vbsyn gsyn
X_ihm_3_10 a_xp3 a_xn3 wp_ih_3_10 wn_ih_3_10 mhp10 mhn10 vdd vbsyn gsyn
X_ihx_3_10 a_xp3 a_xn3 wp_ih_3_10 wn_ih_3_10 xhp10 xhn10 vdd vbsyn gsyn
X_ihm_4_10 a_xp4 a_xn4 wp_ih_4_10 wn_ih_4_10 mhp10 mhn10 vdd vbsyn gsyn
X_ihx_4_10 a_xp4 a_xn4 wp_ih_4_10 wn_ih_4_10 xhp10 xhn10 vdd vbsyn gsyn
X_ihm_5_10 a_xp5 a_xn5 wp_ih_5_10 wn_ih_5_10 mhp10 mhn10 vdd vbsyn gsyn
X_ihx_5_10 a_xp5 a_xn5 wp_ih_5_10 wn_ih_5_10 xhp10 xhn10 vdd vbsyn gsyn
X_ihm_6_10 a_xp6 a_xn6 wp_ih_6_10 wn_ih_6_10 mhp10 mhn10 vdd vbsyn gsyn
X_ihx_6_10 a_xp6 a_xn6 wp_ih_6_10 wn_ih_6_10 xhp10 xhn10 vdd vbsyn gsyn
X_ihm_7_10 a_xp7 a_xn7 wp_ih_7_10 wn_ih_7_10 mhp10 mhn10 vdd vbsyn gsyn
X_ihx_7_10 a_xp7 a_xn7 wp_ih_7_10 wn_ih_7_10 xhp10 xhn10 vdd vbsyn gsyn
X_ihm_8_10 a_xp8 a_xn8 wp_ih_8_10 wn_ih_8_10 mhp10 mhn10 vdd vbsyn gsyn
X_ihx_8_10 a_xp8 a_xn8 wp_ih_8_10 wn_ih_8_10 xhp10 xhn10 vdd vbsyn gsyn
X_ihm_9_10 a_xp9 a_xn9 wp_ih_9_10 wn_ih_9_10 mhp10 mhn10 vdd vbsyn gsyn
X_ihx_9_10 a_xp9 a_xn9 wp_ih_9_10 wn_ih_9_10 xhp10 xhn10 vdd vbsyn gsyn
X_ihm_10_10 a_xp10 a_xn10 wp_ih_10_10 wn_ih_10_10 mhp10 mhn10 vdd vbsyn gsyn
X_ihx_10_10 a_xp10 a_xn10 wp_ih_10_10 wn_ih_10_10 xhp10 xhn10 vdd vbsyn gsyn
X_ihm_11_10 a_xp11 a_xn11 wp_ih_11_10 wn_ih_11_10 mhp10 mhn10 vdd vbsyn gsyn
X_ihx_11_10 a_xp11 a_xn11 wp_ih_11_10 wn_ih_11_10 xhp10 xhn10 vdd vbsyn gsyn
X_ihm_12_10 a_xp12 a_xn12 wp_ih_12_10 wn_ih_12_10 mhp10 mhn10 vdd vbsyn gsyn
X_ihx_12_10 a_xp12 a_xn12 wp_ih_12_10 wn_ih_12_10 xhp10 xhn10 vdd vbsyn gsyn
X_ihm_13_10 a_xp13 a_xn13 wp_ih_13_10 wn_ih_13_10 mhp10 mhn10 vdd vbsyn gsyn
X_ihx_13_10 a_xp13 a_xn13 wp_ih_13_10 wn_ih_13_10 xhp10 xhn10 vdd vbsyn gsyn
X_ihm_14_10 a_xp14 a_xn14 wp_ih_14_10 wn_ih_14_10 mhp10 mhn10 vdd vbsyn gsyn
X_ihx_14_10 a_xp14 a_xn14 wp_ih_14_10 wn_ih_14_10 xhp10 xhn10 vdd vbsyn gsyn
X_ihm_15_10 a_xp15 a_xn15 wp_ih_15_10 wn_ih_15_10 mhp10 mhn10 vdd vbsyn gsyn
X_ihx_15_10 a_xp15 a_xn15 wp_ih_15_10 wn_ih_15_10 xhp10 xhn10 vdd vbsyn gsyn
X_ihm_16_10 a_xp16 a_xn16 wp_ih_16_10 wn_ih_16_10 mhp10 mhn10 vdd vbsyn gsyn
X_ihx_16_10 a_xp16 a_xn16 wp_ih_16_10 wn_ih_16_10 xhp10 xhn10 vdd vbsyn gsyn
X_ihm_17_10 a_xp17 a_xn17 wp_ih_17_10 wn_ih_17_10 mhp10 mhn10 vdd vbsyn gsyn
X_ihx_17_10 a_xp17 a_xn17 wp_ih_17_10 wn_ih_17_10 xhp10 xhn10 vdd vbsyn gsyn
X_ihm_18_10 a_xp18 a_xn18 wp_ih_18_10 wn_ih_18_10 mhp10 mhn10 vdd vbsyn gsyn
X_ihx_18_10 a_xp18 a_xn18 wp_ih_18_10 wn_ih_18_10 xhp10 xhn10 vdd vbsyn gsyn
X_ihm_19_10 a_xp19 a_xn19 wp_ih_19_10 wn_ih_19_10 mhp10 mhn10 vdd vbsyn gsyn
X_ihx_19_10 a_xp19 a_xn19 wp_ih_19_10 wn_ih_19_10 xhp10 xhn10 vdd vbsyn gsyn
X_ihm_20_10 a_xp20 a_xn20 wp_ih_20_10 wn_ih_20_10 mhp10 mhn10 vdd vbsyn gsyn
X_ihx_20_10 a_xp20 a_xn20 wp_ih_20_10 wn_ih_20_10 xhp10 xhn10 vdd vbsyn gsyn
X_ihm_21_10 a_xp21 a_xn21 wp_ih_21_10 wn_ih_21_10 mhp10 mhn10 vdd vbsyn gsyn
X_ihx_21_10 a_xp21 a_xn21 wp_ih_21_10 wn_ih_21_10 xhp10 xhn10 vdd vbsyn gsyn
X_ihm_22_10 a_xp22 a_xn22 wp_ih_22_10 wn_ih_22_10 mhp10 mhn10 vdd vbsyn gsyn
X_ihx_22_10 a_xp22 a_xn22 wp_ih_22_10 wn_ih_22_10 xhp10 xhn10 vdd vbsyn gsyn
X_ihm_23_10 a_xp23 a_xn23 wp_ih_23_10 wn_ih_23_10 mhp10 mhn10 vdd vbsyn gsyn
X_ihx_23_10 a_xp23 a_xn23 wp_ih_23_10 wn_ih_23_10 xhp10 xhn10 vdd vbsyn gsyn
X_ihm_24_10 a_xp24 a_xn24 wp_ih_24_10 wn_ih_24_10 mhp10 mhn10 vdd vbsyn gsyn
X_ihx_24_10 a_xp24 a_xn24 wp_ih_24_10 wn_ih_24_10 xhp10 xhn10 vdd vbsyn gsyn
X_ihm_25_10 a_xp25 a_xn25 wp_ih_25_10 wn_ih_25_10 mhp10 mhn10 vdd vbsyn gsyn
X_ihx_25_10 a_xp25 a_xn25 wp_ih_25_10 wn_ih_25_10 xhp10 xhn10 vdd vbsyn gsyn
X_ihm_26_10 a_xp26 a_xn26 wp_ih_26_10 wn_ih_26_10 mhp10 mhn10 vdd vbsyn gsyn
X_ihx_26_10 a_xp26 a_xn26 wp_ih_26_10 wn_ih_26_10 xhp10 xhn10 vdd vbsyn gsyn
X_ihm_27_10 a_xp27 a_xn27 wp_ih_27_10 wn_ih_27_10 mhp10 mhn10 vdd vbsyn gsyn
X_ihx_27_10 a_xp27 a_xn27 wp_ih_27_10 wn_ih_27_10 xhp10 xhn10 vdd vbsyn gsyn
X_ihm_28_10 a_xp28 a_xn28 wp_ih_28_10 wn_ih_28_10 mhp10 mhn10 vdd vbsyn gsyn
X_ihx_28_10 a_xp28 a_xn28 wp_ih_28_10 wn_ih_28_10 xhp10 xhn10 vdd vbsyn gsyn
X_ihm_29_10 a_xp29 a_xn29 wp_ih_29_10 wn_ih_29_10 mhp10 mhn10 vdd vbsyn gsyn
X_ihx_29_10 a_xp29 a_xn29 wp_ih_29_10 wn_ih_29_10 xhp10 xhn10 vdd vbsyn gsyn
X_ihm_30_10 a_xp30 a_xn30 wp_ih_30_10 wn_ih_30_10 mhp10 mhn10 vdd vbsyn gsyn
X_ihx_30_10 a_xp30 a_xn30 wp_ih_30_10 wn_ih_30_10 xhp10 xhn10 vdd vbsyn gsyn
X_ihm_31_10 a_xp31 a_xn31 wp_ih_31_10 wn_ih_31_10 mhp10 mhn10 vdd vbsyn gsyn
X_ihx_31_10 a_xp31 a_xn31 wp_ih_31_10 wn_ih_31_10 xhp10 xhn10 vdd vbsyn gsyn
X_ihm_32_10 a_xp32 a_xn32 wp_ih_32_10 wn_ih_32_10 mhp10 mhn10 vdd vbsyn gsyn
X_ihx_32_10 a_xp32 a_xn32 wp_ih_32_10 wn_ih_32_10 xhp10 xhn10 vdd vbsyn gsyn
X_ihm_33_10 a_xp33 a_xn33 wp_ih_33_10 wn_ih_33_10 mhp10 mhn10 vdd vbsyn gsyn
X_ihx_33_10 a_xp33 a_xn33 wp_ih_33_10 wn_ih_33_10 xhp10 xhn10 vdd vbsyn gsyn
X_ihm_34_10 a_xp34 a_xn34 wp_ih_34_10 wn_ih_34_10 mhp10 mhn10 vdd vbsyn gsyn
X_ihx_34_10 a_xp34 a_xn34 wp_ih_34_10 wn_ih_34_10 xhp10 xhn10 vdd vbsyn gsyn
X_ihm_35_10 a_xp35 a_xn35 wp_ih_35_10 wn_ih_35_10 mhp10 mhn10 vdd vbsyn gsyn
X_ihx_35_10 a_xp35 a_xn35 wp_ih_35_10 wn_ih_35_10 xhp10 xhn10 vdd vbsyn gsyn
X_ihm_36_10 a_xp36 a_xn36 wp_ih_36_10 wn_ih_36_10 mhp10 mhn10 vdd vbsyn gsyn
X_ihx_36_10 a_xp36 a_xn36 wp_ih_36_10 wn_ih_36_10 xhp10 xhn10 vdd vbsyn gsyn
X_ihm_37_10 a_xp37 a_xn37 wp_ih_37_10 wn_ih_37_10 mhp10 mhn10 vdd vbsyn gsyn
X_ihx_37_10 a_xp37 a_xn37 wp_ih_37_10 wn_ih_37_10 xhp10 xhn10 vdd vbsyn gsyn
X_ihm_38_10 a_xp38 a_xn38 wp_ih_38_10 wn_ih_38_10 mhp10 mhn10 vdd vbsyn gsyn
X_ihx_38_10 a_xp38 a_xn38 wp_ih_38_10 wn_ih_38_10 xhp10 xhn10 vdd vbsyn gsyn
X_ihm_39_10 a_xp39 a_xn39 wp_ih_39_10 wn_ih_39_10 mhp10 mhn10 vdd vbsyn gsyn
X_ihx_39_10 a_xp39 a_xn39 wp_ih_39_10 wn_ih_39_10 xhp10 xhn10 vdd vbsyn gsyn
X_ihm_40_10 a_xp40 a_xn40 wp_ih_40_10 wn_ih_40_10 mhp10 mhn10 vdd vbsyn gsyn
X_ihx_40_10 a_xp40 a_xn40 wp_ih_40_10 wn_ih_40_10 xhp10 xhn10 vdd vbsyn gsyn
X_ihm_41_10 a_xp41 a_xn41 wp_ih_41_10 wn_ih_41_10 mhp10 mhn10 vdd vbsyn gsyn
X_ihx_41_10 a_xp41 a_xn41 wp_ih_41_10 wn_ih_41_10 xhp10 xhn10 vdd vbsyn gsyn
X_ihm_42_10 a_xp42 a_xn42 wp_ih_42_10 wn_ih_42_10 mhp10 mhn10 vdd vbsyn gsyn
X_ihx_42_10 a_xp42 a_xn42 wp_ih_42_10 wn_ih_42_10 xhp10 xhn10 vdd vbsyn gsyn
X_ihm_43_10 a_xp43 a_xn43 wp_ih_43_10 wn_ih_43_10 mhp10 mhn10 vdd vbsyn gsyn
X_ihx_43_10 a_xp43 a_xn43 wp_ih_43_10 wn_ih_43_10 xhp10 xhn10 vdd vbsyn gsyn
X_ihm_44_10 a_xp44 a_xn44 wp_ih_44_10 wn_ih_44_10 mhp10 mhn10 vdd vbsyn gsyn
X_ihx_44_10 a_xp44 a_xn44 wp_ih_44_10 wn_ih_44_10 xhp10 xhn10 vdd vbsyn gsyn
X_ihm_45_10 a_xp45 a_xn45 wp_ih_45_10 wn_ih_45_10 mhp10 mhn10 vdd vbsyn gsyn
X_ihx_45_10 a_xp45 a_xn45 wp_ih_45_10 wn_ih_45_10 xhp10 xhn10 vdd vbsyn gsyn
X_ihm_46_10 a_xp46 a_xn46 wp_ih_46_10 wn_ih_46_10 mhp10 mhn10 vdd vbsyn gsyn
X_ihx_46_10 a_xp46 a_xn46 wp_ih_46_10 wn_ih_46_10 xhp10 xhn10 vdd vbsyn gsyn
X_ihm_47_10 a_xp47 a_xn47 wp_ih_47_10 wn_ih_47_10 mhp10 mhn10 vdd vbsyn gsyn
X_ihx_47_10 a_xp47 a_xn47 wp_ih_47_10 wn_ih_47_10 xhp10 xhn10 vdd vbsyn gsyn
X_ihm_48_10 a_xp48 a_xn48 wp_ih_48_10 wn_ih_48_10 mhp10 mhn10 vdd vbsyn gsyn
X_ihx_48_10 a_xp48 a_xn48 wp_ih_48_10 wn_ih_48_10 xhp10 xhn10 vdd vbsyn gsyn
X_ihm_49_10 a_xp49 a_xn49 wp_ih_49_10 wn_ih_49_10 mhp10 mhn10 vdd vbsyn gsyn
X_ihx_49_10 a_xp49 a_xn49 wp_ih_49_10 wn_ih_49_10 xhp10 xhn10 vdd vbsyn gsyn
X_ihm_50_10 a_xp50 a_xn50 wp_ih_50_10 wn_ih_50_10 mhp10 mhn10 vdd vbsyn gsyn
X_ihx_50_10 a_xp50 a_xn50 wp_ih_50_10 wn_ih_50_10 xhp10 xhn10 vdd vbsyn gsyn
X_ihm_51_10 a_xp51 a_xn51 wp_ih_51_10 wn_ih_51_10 mhp10 mhn10 vdd vbsyn gsyn
X_ihx_51_10 a_xp51 a_xn51 wp_ih_51_10 wn_ih_51_10 xhp10 xhn10 vdd vbsyn gsyn
X_ihm_52_10 a_xp52 a_xn52 wp_ih_52_10 wn_ih_52_10 mhp10 mhn10 vdd vbsyn gsyn
X_ihx_52_10 a_xp52 a_xn52 wp_ih_52_10 wn_ih_52_10 xhp10 xhn10 vdd vbsyn gsyn
X_ihm_53_10 a_xp53 a_xn53 wp_ih_53_10 wn_ih_53_10 mhp10 mhn10 vdd vbsyn gsyn
X_ihx_53_10 a_xp53 a_xn53 wp_ih_53_10 wn_ih_53_10 xhp10 xhn10 vdd vbsyn gsyn
X_ihm_54_10 a_xp54 a_xn54 wp_ih_54_10 wn_ih_54_10 mhp10 mhn10 vdd vbsyn gsyn
X_ihx_54_10 a_xp54 a_xn54 wp_ih_54_10 wn_ih_54_10 xhp10 xhn10 vdd vbsyn gsyn
X_ihm_55_10 a_xp55 a_xn55 wp_ih_55_10 wn_ih_55_10 mhp10 mhn10 vdd vbsyn gsyn
X_ihx_55_10 a_xp55 a_xn55 wp_ih_55_10 wn_ih_55_10 xhp10 xhn10 vdd vbsyn gsyn
X_ihm_56_10 a_xp56 a_xn56 wp_ih_56_10 wn_ih_56_10 mhp10 mhn10 vdd vbsyn gsyn
X_ihx_56_10 a_xp56 a_xn56 wp_ih_56_10 wn_ih_56_10 xhp10 xhn10 vdd vbsyn gsyn
X_ihm_57_10 a_xp57 a_xn57 wp_ih_57_10 wn_ih_57_10 mhp10 mhn10 vdd vbsyn gsyn
X_ihx_57_10 a_xp57 a_xn57 wp_ih_57_10 wn_ih_57_10 xhp10 xhn10 vdd vbsyn gsyn
X_ihm_58_10 a_xp58 a_xn58 wp_ih_58_10 wn_ih_58_10 mhp10 mhn10 vdd vbsyn gsyn
X_ihx_58_10 a_xp58 a_xn58 wp_ih_58_10 wn_ih_58_10 xhp10 xhn10 vdd vbsyn gsyn
X_ihm_59_10 a_xp59 a_xn59 wp_ih_59_10 wn_ih_59_10 mhp10 mhn10 vdd vbsyn gsyn
X_ihx_59_10 a_xp59 a_xn59 wp_ih_59_10 wn_ih_59_10 xhp10 xhn10 vdd vbsyn gsyn
X_ihm_60_10 a_xp60 a_xn60 wp_ih_60_10 wn_ih_60_10 mhp10 mhn10 vdd vbsyn gsyn
X_ihx_60_10 a_xp60 a_xn60 wp_ih_60_10 wn_ih_60_10 xhp10 xhn10 vdd vbsyn gsyn
X_ihm_61_10 a_xp61 a_xn61 wp_ih_61_10 wn_ih_61_10 mhp10 mhn10 vdd vbsyn gsyn
X_ihx_61_10 a_xp61 a_xn61 wp_ih_61_10 wn_ih_61_10 xhp10 xhn10 vdd vbsyn gsyn
X_ihm_62_10 a_xp62 a_xn62 wp_ih_62_10 wn_ih_62_10 mhp10 mhn10 vdd vbsyn gsyn
X_ihx_62_10 a_xp62 a_xn62 wp_ih_62_10 wn_ih_62_10 xhp10 xhn10 vdd vbsyn gsyn
X_ihm_63_10 a_xp63 a_xn63 wp_ih_63_10 wn_ih_63_10 mhp10 mhn10 vdd vbsyn gsyn
X_ihx_63_10 a_xp63 a_xn63 wp_ih_63_10 wn_ih_63_10 xhp10 xhn10 vdd vbsyn gsyn
Xn10 xhp10 xhn10 ahp10 ahn10 vdd vbneu dneuron
Xeh10 xhp10 xhn10 mhp10 mhn10 ehp10 ehn10 vdd gm esub
Xcm_mh11 mhp11 mhn11 vdd cmld
Rnd_mh11 mhp11 mhn11 20k
Xcm_xh11 xhp11 xhn11 vdd cmld
Rnd_xh11 xhp11 xhn11 20k
X_ihm_0_11 a_xp0 a_xn0 wp_ih_0_11 wn_ih_0_11 mhp11 mhn11 vdd vbsyn gsyn
X_ihx_0_11 a_xp0 a_xn0 wp_ih_0_11 wn_ih_0_11 xhp11 xhn11 vdd vbsyn gsyn
X_ihm_1_11 a_xp1 a_xn1 wp_ih_1_11 wn_ih_1_11 mhp11 mhn11 vdd vbsyn gsyn
X_ihx_1_11 a_xp1 a_xn1 wp_ih_1_11 wn_ih_1_11 xhp11 xhn11 vdd vbsyn gsyn
X_ihm_2_11 a_xp2 a_xn2 wp_ih_2_11 wn_ih_2_11 mhp11 mhn11 vdd vbsyn gsyn
X_ihx_2_11 a_xp2 a_xn2 wp_ih_2_11 wn_ih_2_11 xhp11 xhn11 vdd vbsyn gsyn
X_ihm_3_11 a_xp3 a_xn3 wp_ih_3_11 wn_ih_3_11 mhp11 mhn11 vdd vbsyn gsyn
X_ihx_3_11 a_xp3 a_xn3 wp_ih_3_11 wn_ih_3_11 xhp11 xhn11 vdd vbsyn gsyn
X_ihm_4_11 a_xp4 a_xn4 wp_ih_4_11 wn_ih_4_11 mhp11 mhn11 vdd vbsyn gsyn
X_ihx_4_11 a_xp4 a_xn4 wp_ih_4_11 wn_ih_4_11 xhp11 xhn11 vdd vbsyn gsyn
X_ihm_5_11 a_xp5 a_xn5 wp_ih_5_11 wn_ih_5_11 mhp11 mhn11 vdd vbsyn gsyn
X_ihx_5_11 a_xp5 a_xn5 wp_ih_5_11 wn_ih_5_11 xhp11 xhn11 vdd vbsyn gsyn
X_ihm_6_11 a_xp6 a_xn6 wp_ih_6_11 wn_ih_6_11 mhp11 mhn11 vdd vbsyn gsyn
X_ihx_6_11 a_xp6 a_xn6 wp_ih_6_11 wn_ih_6_11 xhp11 xhn11 vdd vbsyn gsyn
X_ihm_7_11 a_xp7 a_xn7 wp_ih_7_11 wn_ih_7_11 mhp11 mhn11 vdd vbsyn gsyn
X_ihx_7_11 a_xp7 a_xn7 wp_ih_7_11 wn_ih_7_11 xhp11 xhn11 vdd vbsyn gsyn
X_ihm_8_11 a_xp8 a_xn8 wp_ih_8_11 wn_ih_8_11 mhp11 mhn11 vdd vbsyn gsyn
X_ihx_8_11 a_xp8 a_xn8 wp_ih_8_11 wn_ih_8_11 xhp11 xhn11 vdd vbsyn gsyn
X_ihm_9_11 a_xp9 a_xn9 wp_ih_9_11 wn_ih_9_11 mhp11 mhn11 vdd vbsyn gsyn
X_ihx_9_11 a_xp9 a_xn9 wp_ih_9_11 wn_ih_9_11 xhp11 xhn11 vdd vbsyn gsyn
X_ihm_10_11 a_xp10 a_xn10 wp_ih_10_11 wn_ih_10_11 mhp11 mhn11 vdd vbsyn gsyn
X_ihx_10_11 a_xp10 a_xn10 wp_ih_10_11 wn_ih_10_11 xhp11 xhn11 vdd vbsyn gsyn
X_ihm_11_11 a_xp11 a_xn11 wp_ih_11_11 wn_ih_11_11 mhp11 mhn11 vdd vbsyn gsyn
X_ihx_11_11 a_xp11 a_xn11 wp_ih_11_11 wn_ih_11_11 xhp11 xhn11 vdd vbsyn gsyn
X_ihm_12_11 a_xp12 a_xn12 wp_ih_12_11 wn_ih_12_11 mhp11 mhn11 vdd vbsyn gsyn
X_ihx_12_11 a_xp12 a_xn12 wp_ih_12_11 wn_ih_12_11 xhp11 xhn11 vdd vbsyn gsyn
X_ihm_13_11 a_xp13 a_xn13 wp_ih_13_11 wn_ih_13_11 mhp11 mhn11 vdd vbsyn gsyn
X_ihx_13_11 a_xp13 a_xn13 wp_ih_13_11 wn_ih_13_11 xhp11 xhn11 vdd vbsyn gsyn
X_ihm_14_11 a_xp14 a_xn14 wp_ih_14_11 wn_ih_14_11 mhp11 mhn11 vdd vbsyn gsyn
X_ihx_14_11 a_xp14 a_xn14 wp_ih_14_11 wn_ih_14_11 xhp11 xhn11 vdd vbsyn gsyn
X_ihm_15_11 a_xp15 a_xn15 wp_ih_15_11 wn_ih_15_11 mhp11 mhn11 vdd vbsyn gsyn
X_ihx_15_11 a_xp15 a_xn15 wp_ih_15_11 wn_ih_15_11 xhp11 xhn11 vdd vbsyn gsyn
X_ihm_16_11 a_xp16 a_xn16 wp_ih_16_11 wn_ih_16_11 mhp11 mhn11 vdd vbsyn gsyn
X_ihx_16_11 a_xp16 a_xn16 wp_ih_16_11 wn_ih_16_11 xhp11 xhn11 vdd vbsyn gsyn
X_ihm_17_11 a_xp17 a_xn17 wp_ih_17_11 wn_ih_17_11 mhp11 mhn11 vdd vbsyn gsyn
X_ihx_17_11 a_xp17 a_xn17 wp_ih_17_11 wn_ih_17_11 xhp11 xhn11 vdd vbsyn gsyn
X_ihm_18_11 a_xp18 a_xn18 wp_ih_18_11 wn_ih_18_11 mhp11 mhn11 vdd vbsyn gsyn
X_ihx_18_11 a_xp18 a_xn18 wp_ih_18_11 wn_ih_18_11 xhp11 xhn11 vdd vbsyn gsyn
X_ihm_19_11 a_xp19 a_xn19 wp_ih_19_11 wn_ih_19_11 mhp11 mhn11 vdd vbsyn gsyn
X_ihx_19_11 a_xp19 a_xn19 wp_ih_19_11 wn_ih_19_11 xhp11 xhn11 vdd vbsyn gsyn
X_ihm_20_11 a_xp20 a_xn20 wp_ih_20_11 wn_ih_20_11 mhp11 mhn11 vdd vbsyn gsyn
X_ihx_20_11 a_xp20 a_xn20 wp_ih_20_11 wn_ih_20_11 xhp11 xhn11 vdd vbsyn gsyn
X_ihm_21_11 a_xp21 a_xn21 wp_ih_21_11 wn_ih_21_11 mhp11 mhn11 vdd vbsyn gsyn
X_ihx_21_11 a_xp21 a_xn21 wp_ih_21_11 wn_ih_21_11 xhp11 xhn11 vdd vbsyn gsyn
X_ihm_22_11 a_xp22 a_xn22 wp_ih_22_11 wn_ih_22_11 mhp11 mhn11 vdd vbsyn gsyn
X_ihx_22_11 a_xp22 a_xn22 wp_ih_22_11 wn_ih_22_11 xhp11 xhn11 vdd vbsyn gsyn
X_ihm_23_11 a_xp23 a_xn23 wp_ih_23_11 wn_ih_23_11 mhp11 mhn11 vdd vbsyn gsyn
X_ihx_23_11 a_xp23 a_xn23 wp_ih_23_11 wn_ih_23_11 xhp11 xhn11 vdd vbsyn gsyn
X_ihm_24_11 a_xp24 a_xn24 wp_ih_24_11 wn_ih_24_11 mhp11 mhn11 vdd vbsyn gsyn
X_ihx_24_11 a_xp24 a_xn24 wp_ih_24_11 wn_ih_24_11 xhp11 xhn11 vdd vbsyn gsyn
X_ihm_25_11 a_xp25 a_xn25 wp_ih_25_11 wn_ih_25_11 mhp11 mhn11 vdd vbsyn gsyn
X_ihx_25_11 a_xp25 a_xn25 wp_ih_25_11 wn_ih_25_11 xhp11 xhn11 vdd vbsyn gsyn
X_ihm_26_11 a_xp26 a_xn26 wp_ih_26_11 wn_ih_26_11 mhp11 mhn11 vdd vbsyn gsyn
X_ihx_26_11 a_xp26 a_xn26 wp_ih_26_11 wn_ih_26_11 xhp11 xhn11 vdd vbsyn gsyn
X_ihm_27_11 a_xp27 a_xn27 wp_ih_27_11 wn_ih_27_11 mhp11 mhn11 vdd vbsyn gsyn
X_ihx_27_11 a_xp27 a_xn27 wp_ih_27_11 wn_ih_27_11 xhp11 xhn11 vdd vbsyn gsyn
X_ihm_28_11 a_xp28 a_xn28 wp_ih_28_11 wn_ih_28_11 mhp11 mhn11 vdd vbsyn gsyn
X_ihx_28_11 a_xp28 a_xn28 wp_ih_28_11 wn_ih_28_11 xhp11 xhn11 vdd vbsyn gsyn
X_ihm_29_11 a_xp29 a_xn29 wp_ih_29_11 wn_ih_29_11 mhp11 mhn11 vdd vbsyn gsyn
X_ihx_29_11 a_xp29 a_xn29 wp_ih_29_11 wn_ih_29_11 xhp11 xhn11 vdd vbsyn gsyn
X_ihm_30_11 a_xp30 a_xn30 wp_ih_30_11 wn_ih_30_11 mhp11 mhn11 vdd vbsyn gsyn
X_ihx_30_11 a_xp30 a_xn30 wp_ih_30_11 wn_ih_30_11 xhp11 xhn11 vdd vbsyn gsyn
X_ihm_31_11 a_xp31 a_xn31 wp_ih_31_11 wn_ih_31_11 mhp11 mhn11 vdd vbsyn gsyn
X_ihx_31_11 a_xp31 a_xn31 wp_ih_31_11 wn_ih_31_11 xhp11 xhn11 vdd vbsyn gsyn
X_ihm_32_11 a_xp32 a_xn32 wp_ih_32_11 wn_ih_32_11 mhp11 mhn11 vdd vbsyn gsyn
X_ihx_32_11 a_xp32 a_xn32 wp_ih_32_11 wn_ih_32_11 xhp11 xhn11 vdd vbsyn gsyn
X_ihm_33_11 a_xp33 a_xn33 wp_ih_33_11 wn_ih_33_11 mhp11 mhn11 vdd vbsyn gsyn
X_ihx_33_11 a_xp33 a_xn33 wp_ih_33_11 wn_ih_33_11 xhp11 xhn11 vdd vbsyn gsyn
X_ihm_34_11 a_xp34 a_xn34 wp_ih_34_11 wn_ih_34_11 mhp11 mhn11 vdd vbsyn gsyn
X_ihx_34_11 a_xp34 a_xn34 wp_ih_34_11 wn_ih_34_11 xhp11 xhn11 vdd vbsyn gsyn
X_ihm_35_11 a_xp35 a_xn35 wp_ih_35_11 wn_ih_35_11 mhp11 mhn11 vdd vbsyn gsyn
X_ihx_35_11 a_xp35 a_xn35 wp_ih_35_11 wn_ih_35_11 xhp11 xhn11 vdd vbsyn gsyn
X_ihm_36_11 a_xp36 a_xn36 wp_ih_36_11 wn_ih_36_11 mhp11 mhn11 vdd vbsyn gsyn
X_ihx_36_11 a_xp36 a_xn36 wp_ih_36_11 wn_ih_36_11 xhp11 xhn11 vdd vbsyn gsyn
X_ihm_37_11 a_xp37 a_xn37 wp_ih_37_11 wn_ih_37_11 mhp11 mhn11 vdd vbsyn gsyn
X_ihx_37_11 a_xp37 a_xn37 wp_ih_37_11 wn_ih_37_11 xhp11 xhn11 vdd vbsyn gsyn
X_ihm_38_11 a_xp38 a_xn38 wp_ih_38_11 wn_ih_38_11 mhp11 mhn11 vdd vbsyn gsyn
X_ihx_38_11 a_xp38 a_xn38 wp_ih_38_11 wn_ih_38_11 xhp11 xhn11 vdd vbsyn gsyn
X_ihm_39_11 a_xp39 a_xn39 wp_ih_39_11 wn_ih_39_11 mhp11 mhn11 vdd vbsyn gsyn
X_ihx_39_11 a_xp39 a_xn39 wp_ih_39_11 wn_ih_39_11 xhp11 xhn11 vdd vbsyn gsyn
X_ihm_40_11 a_xp40 a_xn40 wp_ih_40_11 wn_ih_40_11 mhp11 mhn11 vdd vbsyn gsyn
X_ihx_40_11 a_xp40 a_xn40 wp_ih_40_11 wn_ih_40_11 xhp11 xhn11 vdd vbsyn gsyn
X_ihm_41_11 a_xp41 a_xn41 wp_ih_41_11 wn_ih_41_11 mhp11 mhn11 vdd vbsyn gsyn
X_ihx_41_11 a_xp41 a_xn41 wp_ih_41_11 wn_ih_41_11 xhp11 xhn11 vdd vbsyn gsyn
X_ihm_42_11 a_xp42 a_xn42 wp_ih_42_11 wn_ih_42_11 mhp11 mhn11 vdd vbsyn gsyn
X_ihx_42_11 a_xp42 a_xn42 wp_ih_42_11 wn_ih_42_11 xhp11 xhn11 vdd vbsyn gsyn
X_ihm_43_11 a_xp43 a_xn43 wp_ih_43_11 wn_ih_43_11 mhp11 mhn11 vdd vbsyn gsyn
X_ihx_43_11 a_xp43 a_xn43 wp_ih_43_11 wn_ih_43_11 xhp11 xhn11 vdd vbsyn gsyn
X_ihm_44_11 a_xp44 a_xn44 wp_ih_44_11 wn_ih_44_11 mhp11 mhn11 vdd vbsyn gsyn
X_ihx_44_11 a_xp44 a_xn44 wp_ih_44_11 wn_ih_44_11 xhp11 xhn11 vdd vbsyn gsyn
X_ihm_45_11 a_xp45 a_xn45 wp_ih_45_11 wn_ih_45_11 mhp11 mhn11 vdd vbsyn gsyn
X_ihx_45_11 a_xp45 a_xn45 wp_ih_45_11 wn_ih_45_11 xhp11 xhn11 vdd vbsyn gsyn
X_ihm_46_11 a_xp46 a_xn46 wp_ih_46_11 wn_ih_46_11 mhp11 mhn11 vdd vbsyn gsyn
X_ihx_46_11 a_xp46 a_xn46 wp_ih_46_11 wn_ih_46_11 xhp11 xhn11 vdd vbsyn gsyn
X_ihm_47_11 a_xp47 a_xn47 wp_ih_47_11 wn_ih_47_11 mhp11 mhn11 vdd vbsyn gsyn
X_ihx_47_11 a_xp47 a_xn47 wp_ih_47_11 wn_ih_47_11 xhp11 xhn11 vdd vbsyn gsyn
X_ihm_48_11 a_xp48 a_xn48 wp_ih_48_11 wn_ih_48_11 mhp11 mhn11 vdd vbsyn gsyn
X_ihx_48_11 a_xp48 a_xn48 wp_ih_48_11 wn_ih_48_11 xhp11 xhn11 vdd vbsyn gsyn
X_ihm_49_11 a_xp49 a_xn49 wp_ih_49_11 wn_ih_49_11 mhp11 mhn11 vdd vbsyn gsyn
X_ihx_49_11 a_xp49 a_xn49 wp_ih_49_11 wn_ih_49_11 xhp11 xhn11 vdd vbsyn gsyn
X_ihm_50_11 a_xp50 a_xn50 wp_ih_50_11 wn_ih_50_11 mhp11 mhn11 vdd vbsyn gsyn
X_ihx_50_11 a_xp50 a_xn50 wp_ih_50_11 wn_ih_50_11 xhp11 xhn11 vdd vbsyn gsyn
X_ihm_51_11 a_xp51 a_xn51 wp_ih_51_11 wn_ih_51_11 mhp11 mhn11 vdd vbsyn gsyn
X_ihx_51_11 a_xp51 a_xn51 wp_ih_51_11 wn_ih_51_11 xhp11 xhn11 vdd vbsyn gsyn
X_ihm_52_11 a_xp52 a_xn52 wp_ih_52_11 wn_ih_52_11 mhp11 mhn11 vdd vbsyn gsyn
X_ihx_52_11 a_xp52 a_xn52 wp_ih_52_11 wn_ih_52_11 xhp11 xhn11 vdd vbsyn gsyn
X_ihm_53_11 a_xp53 a_xn53 wp_ih_53_11 wn_ih_53_11 mhp11 mhn11 vdd vbsyn gsyn
X_ihx_53_11 a_xp53 a_xn53 wp_ih_53_11 wn_ih_53_11 xhp11 xhn11 vdd vbsyn gsyn
X_ihm_54_11 a_xp54 a_xn54 wp_ih_54_11 wn_ih_54_11 mhp11 mhn11 vdd vbsyn gsyn
X_ihx_54_11 a_xp54 a_xn54 wp_ih_54_11 wn_ih_54_11 xhp11 xhn11 vdd vbsyn gsyn
X_ihm_55_11 a_xp55 a_xn55 wp_ih_55_11 wn_ih_55_11 mhp11 mhn11 vdd vbsyn gsyn
X_ihx_55_11 a_xp55 a_xn55 wp_ih_55_11 wn_ih_55_11 xhp11 xhn11 vdd vbsyn gsyn
X_ihm_56_11 a_xp56 a_xn56 wp_ih_56_11 wn_ih_56_11 mhp11 mhn11 vdd vbsyn gsyn
X_ihx_56_11 a_xp56 a_xn56 wp_ih_56_11 wn_ih_56_11 xhp11 xhn11 vdd vbsyn gsyn
X_ihm_57_11 a_xp57 a_xn57 wp_ih_57_11 wn_ih_57_11 mhp11 mhn11 vdd vbsyn gsyn
X_ihx_57_11 a_xp57 a_xn57 wp_ih_57_11 wn_ih_57_11 xhp11 xhn11 vdd vbsyn gsyn
X_ihm_58_11 a_xp58 a_xn58 wp_ih_58_11 wn_ih_58_11 mhp11 mhn11 vdd vbsyn gsyn
X_ihx_58_11 a_xp58 a_xn58 wp_ih_58_11 wn_ih_58_11 xhp11 xhn11 vdd vbsyn gsyn
X_ihm_59_11 a_xp59 a_xn59 wp_ih_59_11 wn_ih_59_11 mhp11 mhn11 vdd vbsyn gsyn
X_ihx_59_11 a_xp59 a_xn59 wp_ih_59_11 wn_ih_59_11 xhp11 xhn11 vdd vbsyn gsyn
X_ihm_60_11 a_xp60 a_xn60 wp_ih_60_11 wn_ih_60_11 mhp11 mhn11 vdd vbsyn gsyn
X_ihx_60_11 a_xp60 a_xn60 wp_ih_60_11 wn_ih_60_11 xhp11 xhn11 vdd vbsyn gsyn
X_ihm_61_11 a_xp61 a_xn61 wp_ih_61_11 wn_ih_61_11 mhp11 mhn11 vdd vbsyn gsyn
X_ihx_61_11 a_xp61 a_xn61 wp_ih_61_11 wn_ih_61_11 xhp11 xhn11 vdd vbsyn gsyn
X_ihm_62_11 a_xp62 a_xn62 wp_ih_62_11 wn_ih_62_11 mhp11 mhn11 vdd vbsyn gsyn
X_ihx_62_11 a_xp62 a_xn62 wp_ih_62_11 wn_ih_62_11 xhp11 xhn11 vdd vbsyn gsyn
X_ihm_63_11 a_xp63 a_xn63 wp_ih_63_11 wn_ih_63_11 mhp11 mhn11 vdd vbsyn gsyn
X_ihx_63_11 a_xp63 a_xn63 wp_ih_63_11 wn_ih_63_11 xhp11 xhn11 vdd vbsyn gsyn
Xn11 xhp11 xhn11 ahp11 ahn11 vdd vbneu dneuron
Xeh11 xhp11 xhn11 mhp11 mhn11 ehp11 ehn11 vdd gm esub
Xcm_mo0 mop0 mon0 vdd cmld
Rnd_mo0 mop0 mon0 20k
X_ho_0_0 ahp0 ahn0 wp_ho_0_0 wn_ho_0_0 mop0 mon0 vdd vbsyn gsyn
X_ho_1_0 ahp1 ahn1 wp_ho_1_0 wn_ho_1_0 mop0 mon0 vdd vbsyn gsyn
X_ho_2_0 ahp2 ahn2 wp_ho_2_0 wn_ho_2_0 mop0 mon0 vdd vbsyn gsyn
X_ho_3_0 ahp3 ahn3 wp_ho_3_0 wn_ho_3_0 mop0 mon0 vdd vbsyn gsyn
X_ho_4_0 ahp4 ahn4 wp_ho_4_0 wn_ho_4_0 mop0 mon0 vdd vbsyn gsyn
X_ho_5_0 ahp5 ahn5 wp_ho_5_0 wn_ho_5_0 mop0 mon0 vdd vbsyn gsyn
X_ho_6_0 ahp6 ahn6 wp_ho_6_0 wn_ho_6_0 mop0 mon0 vdd vbsyn gsyn
X_ho_7_0 ahp7 ahn7 wp_ho_7_0 wn_ho_7_0 mop0 mon0 vdd vbsyn gsyn
X_ho_8_0 ahp8 ahn8 wp_ho_8_0 wn_ho_8_0 mop0 mon0 vdd vbsyn gsyn
X_ho_9_0 ahp9 ahn9 wp_ho_9_0 wn_ho_9_0 mop0 mon0 vdd vbsyn gsyn
X_ho_10_0 ahp10 ahn10 wp_ho_10_0 wn_ho_10_0 mop0 mon0 vdd vbsyn gsyn
X_ho_11_0 ahp11 ahn11 wp_ho_11_0 wn_ho_11_0 mop0 mon0 vdd vbsyn gsyn
Xcm_mo1 mop1 mon1 vdd cmld
Rnd_mo1 mop1 mon1 20k
X_ho_0_1 ahp0 ahn0 wp_ho_0_1 wn_ho_0_1 mop1 mon1 vdd vbsyn gsyn
X_ho_1_1 ahp1 ahn1 wp_ho_1_1 wn_ho_1_1 mop1 mon1 vdd vbsyn gsyn
X_ho_2_1 ahp2 ahn2 wp_ho_2_1 wn_ho_2_1 mop1 mon1 vdd vbsyn gsyn
X_ho_3_1 ahp3 ahn3 wp_ho_3_1 wn_ho_3_1 mop1 mon1 vdd vbsyn gsyn
X_ho_4_1 ahp4 ahn4 wp_ho_4_1 wn_ho_4_1 mop1 mon1 vdd vbsyn gsyn
X_ho_5_1 ahp5 ahn5 wp_ho_5_1 wn_ho_5_1 mop1 mon1 vdd vbsyn gsyn
X_ho_6_1 ahp6 ahn6 wp_ho_6_1 wn_ho_6_1 mop1 mon1 vdd vbsyn gsyn
X_ho_7_1 ahp7 ahn7 wp_ho_7_1 wn_ho_7_1 mop1 mon1 vdd vbsyn gsyn
X_ho_8_1 ahp8 ahn8 wp_ho_8_1 wn_ho_8_1 mop1 mon1 vdd vbsyn gsyn
X_ho_9_1 ahp9 ahn9 wp_ho_9_1 wn_ho_9_1 mop1 mon1 vdd vbsyn gsyn
X_ho_10_1 ahp10 ahn10 wp_ho_10_1 wn_ho_10_1 mop1 mon1 vdd vbsyn gsyn
X_ho_11_1 ahp11 ahn11 wp_ho_11_1 wn_ho_11_1 mop1 mon1 vdd vbsyn gsyn
Xcm_mo2 mop2 mon2 vdd cmld
Rnd_mo2 mop2 mon2 20k
X_ho_0_2 ahp0 ahn0 wp_ho_0_2 wn_ho_0_2 mop2 mon2 vdd vbsyn gsyn
X_ho_1_2 ahp1 ahn1 wp_ho_1_2 wn_ho_1_2 mop2 mon2 vdd vbsyn gsyn
X_ho_2_2 ahp2 ahn2 wp_ho_2_2 wn_ho_2_2 mop2 mon2 vdd vbsyn gsyn
X_ho_3_2 ahp3 ahn3 wp_ho_3_2 wn_ho_3_2 mop2 mon2 vdd vbsyn gsyn
X_ho_4_2 ahp4 ahn4 wp_ho_4_2 wn_ho_4_2 mop2 mon2 vdd vbsyn gsyn
X_ho_5_2 ahp5 ahn5 wp_ho_5_2 wn_ho_5_2 mop2 mon2 vdd vbsyn gsyn
X_ho_6_2 ahp6 ahn6 wp_ho_6_2 wn_ho_6_2 mop2 mon2 vdd vbsyn gsyn
X_ho_7_2 ahp7 ahn7 wp_ho_7_2 wn_ho_7_2 mop2 mon2 vdd vbsyn gsyn
X_ho_8_2 ahp8 ahn8 wp_ho_8_2 wn_ho_8_2 mop2 mon2 vdd vbsyn gsyn
X_ho_9_2 ahp9 ahn9 wp_ho_9_2 wn_ho_9_2 mop2 mon2 vdd vbsyn gsyn
X_ho_10_2 ahp10 ahn10 wp_ho_10_2 wn_ho_10_2 mop2 mon2 vdd vbsyn gsyn
X_ho_11_2 ahp11 ahn11 wp_ho_11_2 wn_ho_11_2 mop2 mon2 vdd vbsyn gsyn
Xcm_mo3 mop3 mon3 vdd cmld
Rnd_mo3 mop3 mon3 20k
X_ho_0_3 ahp0 ahn0 wp_ho_0_3 wn_ho_0_3 mop3 mon3 vdd vbsyn gsyn
X_ho_1_3 ahp1 ahn1 wp_ho_1_3 wn_ho_1_3 mop3 mon3 vdd vbsyn gsyn
X_ho_2_3 ahp2 ahn2 wp_ho_2_3 wn_ho_2_3 mop3 mon3 vdd vbsyn gsyn
X_ho_3_3 ahp3 ahn3 wp_ho_3_3 wn_ho_3_3 mop3 mon3 vdd vbsyn gsyn
X_ho_4_3 ahp4 ahn4 wp_ho_4_3 wn_ho_4_3 mop3 mon3 vdd vbsyn gsyn
X_ho_5_3 ahp5 ahn5 wp_ho_5_3 wn_ho_5_3 mop3 mon3 vdd vbsyn gsyn
X_ho_6_3 ahp6 ahn6 wp_ho_6_3 wn_ho_6_3 mop3 mon3 vdd vbsyn gsyn
X_ho_7_3 ahp7 ahn7 wp_ho_7_3 wn_ho_7_3 mop3 mon3 vdd vbsyn gsyn
X_ho_8_3 ahp8 ahn8 wp_ho_8_3 wn_ho_8_3 mop3 mon3 vdd vbsyn gsyn
X_ho_9_3 ahp9 ahn9 wp_ho_9_3 wn_ho_9_3 mop3 mon3 vdd vbsyn gsyn
X_ho_10_3 ahp10 ahn10 wp_ho_10_3 wn_ho_10_3 mop3 mon3 vdd vbsyn gsyn
X_ho_11_3 ahp11 ahn11 wp_ho_11_3 wn_ho_11_3 mop3 mon3 vdd vbsyn gsyn
Xcm_mo4 mop4 mon4 vdd cmld
Rnd_mo4 mop4 mon4 20k
X_ho_0_4 ahp0 ahn0 wp_ho_0_4 wn_ho_0_4 mop4 mon4 vdd vbsyn gsyn
X_ho_1_4 ahp1 ahn1 wp_ho_1_4 wn_ho_1_4 mop4 mon4 vdd vbsyn gsyn
X_ho_2_4 ahp2 ahn2 wp_ho_2_4 wn_ho_2_4 mop4 mon4 vdd vbsyn gsyn
X_ho_3_4 ahp3 ahn3 wp_ho_3_4 wn_ho_3_4 mop4 mon4 vdd vbsyn gsyn
X_ho_4_4 ahp4 ahn4 wp_ho_4_4 wn_ho_4_4 mop4 mon4 vdd vbsyn gsyn
X_ho_5_4 ahp5 ahn5 wp_ho_5_4 wn_ho_5_4 mop4 mon4 vdd vbsyn gsyn
X_ho_6_4 ahp6 ahn6 wp_ho_6_4 wn_ho_6_4 mop4 mon4 vdd vbsyn gsyn
X_ho_7_4 ahp7 ahn7 wp_ho_7_4 wn_ho_7_4 mop4 mon4 vdd vbsyn gsyn
X_ho_8_4 ahp8 ahn8 wp_ho_8_4 wn_ho_8_4 mop4 mon4 vdd vbsyn gsyn
X_ho_9_4 ahp9 ahn9 wp_ho_9_4 wn_ho_9_4 mop4 mon4 vdd vbsyn gsyn
X_ho_10_4 ahp10 ahn10 wp_ho_10_4 wn_ho_10_4 mop4 mon4 vdd vbsyn gsyn
X_ho_11_4 ahp11 ahn11 wp_ho_11_4 wn_ho_11_4 mop4 mon4 vdd vbsyn gsyn
.options gmin=1e-12 reltol=1e-3 itl1=500 rshunt=1e9
.end
