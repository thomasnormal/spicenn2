deep current-mode EP
Vmid nmid 0 0.5
Vt vt 0 0.5
Va_x1 a_x1 0 0.5
Va_x2 a_x2 0 0.5
B_1_0 0 u_L1_0 I=(1.62975)*(V(a_x1)-0.5)+(-0.60480)*(V(a_x2)-0.5)+(-0.39847)*(V(L2_0)-0.5)+(-0.31844)*(V(L2_1)-0.5)+(0.57729)*(V(L2_2)-0.5)+(0.43441)*(V(L2_3)-0.5)+(-0.53284)*(V(L2_4)-0.5)+(0.62009)*(V(L2_5)-0.5)+(-0.10858)*(V(L2_6)-0.5)+(0.28400)*(V(L2_7)-0.5)+(0.06318)*0.4
R_1_0 u_L1_0 nmid 1
Ba_1_0 L1_0 0 V=0.5+0.5*tanh(6.0*(V(u_L1_0)-0.5))
B_1_1 0 u_L1_1 I=(-1.28894)*(V(a_x1)-0.5)+(0.55129)*(V(a_x2)-0.5)+(0.09452)*(V(L2_0)-0.5)+(0.54302)*(V(L2_1)-0.5)+(-0.32893)*(V(L2_2)-0.5)+(-0.37071)*(V(L2_3)-0.5)+(0.15737)*(V(L2_4)-0.5)+(-0.08020)*(V(L2_5)-0.5)+(0.54488)*(V(L2_6)-0.5)+(-0.26959)*(V(L2_7)-0.5)+(-0.59642)*0.4
R_1_1 u_L1_1 nmid 1
Ba_1_1 L1_1 0 V=0.5+0.5*tanh(6.0*(V(u_L1_1)-0.5))
B_1_2 0 u_L1_2 I=(1.40141)*(V(a_x1)-0.5)+(-0.24155)*(V(a_x2)-0.5)+(-0.39121)*(V(L2_0)-0.5)+(-0.15528)*(V(L2_1)-0.5)+(0.30681)*(V(L2_2)-0.5)+(0.67686)*(V(L2_3)-0.5)+(-1.44601)*(V(L2_4)-0.5)+(0.65794)*(V(L2_5)-0.5)+(-0.30773)*(V(L2_6)-0.5)+(0.26728)*(V(L2_7)-0.5)+(-0.54450)*0.4
R_1_2 u_L1_2 nmid 1
Ba_1_2 L1_2 0 V=0.5+0.5*tanh(6.0*(V(u_L1_2)-0.5))
B_1_3 0 u_L1_3 I=(-1.38895)*(V(a_x1)-0.5)+(0.55337)*(V(a_x2)-0.5)+(0.54374)*(V(L2_0)-0.5)+(0.76293)*(V(L2_1)-0.5)+(-0.39339)*(V(L2_2)-0.5)+(-0.67005)*(V(L2_3)-0.5)+(0.40975)*(V(L2_4)-0.5)+(-0.33575)*(V(L2_5)-0.5)+(0.54606)*(V(L2_6)-0.5)+(-0.36497)*(V(L2_7)-0.5)+(0.09635)*0.4
R_1_3 u_L1_3 nmid 1
Ba_1_3 L1_3 0 V=0.5+0.5*tanh(6.0*(V(u_L1_3)-0.5))
B_1_4 0 u_L1_4 I=(-1.48863)*(V(a_x1)-0.5)+(-0.09014)*(V(a_x2)-0.5)+(0.31817)*(V(L2_0)-0.5)+(0.61261)*(V(L2_1)-0.5)+(-0.43010)*(V(L2_2)-0.5)+(-0.65832)*(V(L2_3)-0.5)+(0.81581)*(V(L2_4)-0.5)+(-0.61481)*(V(L2_5)-0.5)+(0.36876)*(V(L2_6)-0.5)+(-0.48068)*(V(L2_7)-0.5)+(0.37246)*0.4
R_1_4 u_L1_4 nmid 1
Ba_1_4 L1_4 0 V=0.5+0.5*tanh(6.0*(V(u_L1_4)-0.5))
B_1_5 0 u_L1_5 I=(1.47925)*(V(a_x1)-0.5)+(-0.46454)*(V(a_x2)-0.5)+(-0.18939)*(V(L2_0)-0.5)+(-1.03962)*(V(L2_1)-0.5)+(0.59382)*(V(L2_2)-0.5)+(0.53700)*(V(L2_3)-0.5)+(-0.71837)*(V(L2_4)-0.5)+(0.50619)*(V(L2_5)-0.5)+(-0.75921)*(V(L2_6)-0.5)+(0.44762)*(V(L2_7)-0.5)+(0.20161)*0.4
R_1_5 u_L1_5 nmid 1
Ba_1_5 L1_5 0 V=0.5+0.5*tanh(6.0*(V(u_L1_5)-0.5))
B_1_6 0 u_L1_6 I=(1.15043)*(V(a_x1)-0.5)+(-0.26196)*(V(a_x2)-0.5)+(-0.87715)*(V(L2_0)-0.5)+(-0.73475)*(V(L2_1)-0.5)+(0.34976)*(V(L2_2)-0.5)+(0.62797)*(V(L2_3)-0.5)+(-0.93346)*(V(L2_4)-0.5)+(0.68057)*(V(L2_5)-0.5)+(-0.29941)*(V(L2_6)-0.5)+(0.18319)*(V(L2_7)-0.5)+(-0.80280)*0.4
R_1_6 u_L1_6 nmid 1
Ba_1_6 L1_6 0 V=0.5+0.5*tanh(6.0*(V(u_L1_6)-0.5))
B_1_7 0 u_L1_7 I=(-1.23068)*(V(a_x1)-0.5)+(-0.60379)*(V(a_x2)-0.5)+(0.49405)*(V(L2_0)-0.5)+(0.08827)*(V(L2_1)-0.5)+(-0.19001)*(V(L2_2)-0.5)+(-0.55309)*(V(L2_3)-0.5)+(0.85505)*(V(L2_4)-0.5)+(-0.50770)*(V(L2_5)-0.5)+(0.25360)*(V(L2_6)-0.5)+(-0.60715)*(V(L2_7)-0.5)+(0.30724)*0.4
R_1_7 u_L1_7 nmid 1
Ba_1_7 L1_7 0 V=0.5+0.5*tanh(6.0*(V(u_L1_7)-0.5))
B_2_0 0 u_L2_0 I=(-0.39847)*(V(L1_0)-0.5)+(0.09452)*(V(L1_1)-0.5)+(-0.39121)*(V(L1_2)-0.5)+(0.54374)*(V(L1_3)-0.5)+(0.31817)*(V(L1_4)-0.5)+(-0.18939)*(V(L1_5)-0.5)+(-0.87715)*(V(L1_6)-0.5)+(0.49405)*(V(L1_7)-0.5)+(0.01346)*(V(u_L3_0)-0.5)+(0.89436)*0.4
R_2_0 u_L2_0 nmid 1
Ba_2_0 L2_0 0 V=0.5+0.5*tanh(6.0*(V(u_L2_0)-0.5))
B_2_1 0 u_L2_1 I=(-0.31844)*(V(L1_0)-0.5)+(0.54302)*(V(L1_1)-0.5)+(-0.15528)*(V(L1_2)-0.5)+(0.76293)*(V(L1_3)-0.5)+(0.61261)*(V(L1_4)-0.5)+(-1.03962)*(V(L1_5)-0.5)+(-0.73475)*(V(L1_6)-0.5)+(0.08827)*(V(L1_7)-0.5)+(0.21447)*(V(u_L3_0)-0.5)+(0.19646)*0.4
R_2_1 u_L2_1 nmid 1
Ba_2_1 L2_1 0 V=0.5+0.5*tanh(6.0*(V(u_L2_1)-0.5))
B_2_2 0 u_L2_2 I=(0.57729)*(V(L1_0)-0.5)+(-0.32893)*(V(L1_1)-0.5)+(0.30681)*(V(L1_2)-0.5)+(-0.39339)*(V(L1_3)-0.5)+(-0.43010)*(V(L1_4)-0.5)+(0.59382)*(V(L1_5)-0.5)+(0.34976)*(V(L1_6)-0.5)+(-0.19001)*(V(L1_7)-0.5)+(0.08325)*(V(u_L3_0)-0.5)+(-0.13588)*0.4
R_2_2 u_L2_2 nmid 1
Ba_2_2 L2_2 0 V=0.5+0.5*tanh(6.0*(V(u_L2_2)-0.5))
B_2_3 0 u_L2_3 I=(0.43441)*(V(L1_0)-0.5)+(-0.37071)*(V(L1_1)-0.5)+(0.67686)*(V(L1_2)-0.5)+(-0.67005)*(V(L1_3)-0.5)+(-0.65832)*(V(L1_4)-0.5)+(0.53700)*(V(L1_5)-0.5)+(0.62797)*(V(L1_6)-0.5)+(-0.55309)*(V(L1_7)-0.5)+(0.38193)*(V(u_L3_0)-0.5)+(-0.31987)*0.4
R_2_3 u_L2_3 nmid 1
Ba_2_3 L2_3 0 V=0.5+0.5*tanh(6.0*(V(u_L2_3)-0.5))
B_2_4 0 u_L2_4 I=(-0.53284)*(V(L1_0)-0.5)+(0.15737)*(V(L1_1)-0.5)+(-1.44601)*(V(L1_2)-0.5)+(0.40975)*(V(L1_3)-0.5)+(0.81581)*(V(L1_4)-0.5)+(-0.71837)*(V(L1_5)-0.5)+(-0.93346)*(V(L1_6)-0.5)+(0.85505)*(V(L1_7)-0.5)+(0.02397)*(V(u_L3_0)-0.5)+(0.40078)*0.4
R_2_4 u_L2_4 nmid 1
Ba_2_4 L2_4 0 V=0.5+0.5*tanh(6.0*(V(u_L2_4)-0.5))
B_2_5 0 u_L2_5 I=(0.62009)*(V(L1_0)-0.5)+(-0.08020)*(V(L1_1)-0.5)+(0.65794)*(V(L1_2)-0.5)+(-0.33575)*(V(L1_3)-0.5)+(-0.61481)*(V(L1_4)-0.5)+(0.50619)*(V(L1_5)-0.5)+(0.68057)*(V(L1_6)-0.5)+(-0.50770)*(V(L1_7)-0.5)+(0.08209)*(V(u_L3_0)-0.5)+(-0.38601)*0.4
R_2_5 u_L2_5 nmid 1
Ba_2_5 L2_5 0 V=0.5+0.5*tanh(6.0*(V(u_L2_5)-0.5))
B_2_6 0 u_L2_6 I=(-0.10858)*(V(L1_0)-0.5)+(0.54488)*(V(L1_1)-0.5)+(-0.30773)*(V(L1_2)-0.5)+(0.54606)*(V(L1_3)-0.5)+(0.36876)*(V(L1_4)-0.5)+(-0.75921)*(V(L1_5)-0.5)+(-0.29941)*(V(L1_6)-0.5)+(0.25360)*(V(L1_7)-0.5)+(-0.03265)*(V(u_L3_0)-0.5)+(0.08897)*0.4
R_2_6 u_L2_6 nmid 1
Ba_2_6 L2_6 0 V=0.5+0.5*tanh(6.0*(V(u_L2_6)-0.5))
B_2_7 0 u_L2_7 I=(0.28400)*(V(L1_0)-0.5)+(-0.26959)*(V(L1_1)-0.5)+(0.26728)*(V(L1_2)-0.5)+(-0.36497)*(V(L1_3)-0.5)+(-0.48068)*(V(L1_4)-0.5)+(0.44762)*(V(L1_5)-0.5)+(0.18319)*(V(L1_6)-0.5)+(-0.60715)*(V(L1_7)-0.5)+(0.13792)*(V(u_L3_0)-0.5)+(-0.57864)*0.4
R_2_7 u_L2_7 nmid 1
Ba_2_7 L2_7 0 V=0.5+0.5*tanh(6.0*(V(u_L2_7)-0.5))
B_3_0 0 u_L3_0 I=(0.01346)*(V(L2_0)-0.5)+(0.21447)*(V(L2_1)-0.5)+(0.08325)*(V(L2_2)-0.5)+(0.38193)*(V(L2_3)-0.5)+(0.02397)*(V(L2_4)-0.5)+(0.08209)*(V(L2_5)-0.5)+(-0.03265)*(V(L2_6)-0.5)+(0.13792)*(V(L2_7)-0.5)+(0.28992)*0.4
R_3_0 u_L3_0 nmid 1
Rb u_L3_0 vt 1e9
.control
alter Va_x1 0.1
alter Va_x2 0.1
alter Rb 1e9
op
wrdata df0.dat v(u_L1_0) v(u_L1_1) v(u_L1_2) v(u_L1_3) v(u_L1_4) v(u_L1_5) v(u_L1_6) v(u_L1_7) v(u_L2_0) v(u_L2_1) v(u_L2_2) v(u_L2_3) v(u_L2_4) v(u_L2_5) v(u_L2_6) v(u_L2_7) v(u_L3_0) v(L1_0) v(L1_1) v(L1_2) v(L1_3) v(L1_4) v(L1_5) v(L1_6) v(L1_7) v(L2_0) v(L2_1) v(L2_2) v(L2_3) v(L2_4) v(L2_5) v(L2_6) v(L2_7)
alter Vt 0.15
alter Rb 8.0
op
wrdata dn0.dat v(u_L1_0) v(u_L1_1) v(u_L1_2) v(u_L1_3) v(u_L1_4) v(u_L1_5) v(u_L1_6) v(u_L1_7) v(u_L2_0) v(u_L2_1) v(u_L2_2) v(u_L2_3) v(u_L2_4) v(u_L2_5) v(u_L2_6) v(u_L2_7) v(u_L3_0) v(L1_0) v(L1_1) v(L1_2) v(L1_3) v(L1_4) v(L1_5) v(L1_6) v(L1_7) v(L2_0) v(L2_1) v(L2_2) v(L2_3) v(L2_4) v(L2_5) v(L2_6) v(L2_7)
alter Va_x1 0.1
alter Va_x2 0.9
alter Rb 1e9
op
wrdata df1.dat v(u_L1_0) v(u_L1_1) v(u_L1_2) v(u_L1_3) v(u_L1_4) v(u_L1_5) v(u_L1_6) v(u_L1_7) v(u_L2_0) v(u_L2_1) v(u_L2_2) v(u_L2_3) v(u_L2_4) v(u_L2_5) v(u_L2_6) v(u_L2_7) v(u_L3_0) v(L1_0) v(L1_1) v(L1_2) v(L1_3) v(L1_4) v(L1_5) v(L1_6) v(L1_7) v(L2_0) v(L2_1) v(L2_2) v(L2_3) v(L2_4) v(L2_5) v(L2_6) v(L2_7)
alter Vt 0.85
alter Rb 8.0
op
wrdata dn1.dat v(u_L1_0) v(u_L1_1) v(u_L1_2) v(u_L1_3) v(u_L1_4) v(u_L1_5) v(u_L1_6) v(u_L1_7) v(u_L2_0) v(u_L2_1) v(u_L2_2) v(u_L2_3) v(u_L2_4) v(u_L2_5) v(u_L2_6) v(u_L2_7) v(u_L3_0) v(L1_0) v(L1_1) v(L1_2) v(L1_3) v(L1_4) v(L1_5) v(L1_6) v(L1_7) v(L2_0) v(L2_1) v(L2_2) v(L2_3) v(L2_4) v(L2_5) v(L2_6) v(L2_7)
alter Va_x1 0.9
alter Va_x2 0.1
alter Rb 1e9
op
wrdata df2.dat v(u_L1_0) v(u_L1_1) v(u_L1_2) v(u_L1_3) v(u_L1_4) v(u_L1_5) v(u_L1_6) v(u_L1_7) v(u_L2_0) v(u_L2_1) v(u_L2_2) v(u_L2_3) v(u_L2_4) v(u_L2_5) v(u_L2_6) v(u_L2_7) v(u_L3_0) v(L1_0) v(L1_1) v(L1_2) v(L1_3) v(L1_4) v(L1_5) v(L1_6) v(L1_7) v(L2_0) v(L2_1) v(L2_2) v(L2_3) v(L2_4) v(L2_5) v(L2_6) v(L2_7)
alter Vt 0.85
alter Rb 8.0
op
wrdata dn2.dat v(u_L1_0) v(u_L1_1) v(u_L1_2) v(u_L1_3) v(u_L1_4) v(u_L1_5) v(u_L1_6) v(u_L1_7) v(u_L2_0) v(u_L2_1) v(u_L2_2) v(u_L2_3) v(u_L2_4) v(u_L2_5) v(u_L2_6) v(u_L2_7) v(u_L3_0) v(L1_0) v(L1_1) v(L1_2) v(L1_3) v(L1_4) v(L1_5) v(L1_6) v(L1_7) v(L2_0) v(L2_1) v(L2_2) v(L2_3) v(L2_4) v(L2_5) v(L2_6) v(L2_7)
alter Va_x1 0.9
alter Va_x2 0.9
alter Rb 1e9
op
wrdata df3.dat v(u_L1_0) v(u_L1_1) v(u_L1_2) v(u_L1_3) v(u_L1_4) v(u_L1_5) v(u_L1_6) v(u_L1_7) v(u_L2_0) v(u_L2_1) v(u_L2_2) v(u_L2_3) v(u_L2_4) v(u_L2_5) v(u_L2_6) v(u_L2_7) v(u_L3_0) v(L1_0) v(L1_1) v(L1_2) v(L1_3) v(L1_4) v(L1_5) v(L1_6) v(L1_7) v(L2_0) v(L2_1) v(L2_2) v(L2_3) v(L2_4) v(L2_5) v(L2_6) v(L2_7)
alter Vt 0.15
alter Rb 8.0
op
wrdata dn3.dat v(u_L1_0) v(u_L1_1) v(u_L1_2) v(u_L1_3) v(u_L1_4) v(u_L1_5) v(u_L1_6) v(u_L1_7) v(u_L2_0) v(u_L2_1) v(u_L2_2) v(u_L2_3) v(u_L2_4) v(u_L2_5) v(u_L2_6) v(u_L2_7) v(u_L3_0) v(L1_0) v(L1_1) v(L1_2) v(L1_3) v(L1_4) v(L1_5) v(L1_6) v(L1_7) v(L2_0) v(L2_1) v(L2_2) v(L2_3) v(L2_4) v(L2_5) v(L2_6) v(L2_7)
.endc
.end
