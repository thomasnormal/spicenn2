PC inference
.model NNR NMOS (LEVEL=1 VTO=0.2 KP=120u LAMBDA=0.02 GAMMA=0 PHI=0.7)
.model PNR PMOS (LEVEL=1 VTO=-0.2 KP=40u LAMBDA=0.02 GAMMA=0 PHI=0.7)
.subckt dsyn inp inn outp outn wp wn vdd
M1 outp inp tp 0 NNR W=200u L=100u
M2 outn inn tp 0 NNR W=200u L=100u
Mtp tp wp 0 0 NNR W=200u L=100u
M3 outn inp tn 0 NNR W=200u L=100u
M4 outp inn tn 0 NNR W=200u L=100u
Mtn tn wn 0 0 NNR W=200u L=100u
.ends
.subckt dneuron up un ap an vdd vbn
M1 an up tn 0 NNR W=200u L=100u
M2 ap un tn 0 NNR W=200u L=100u
Mt tn vbn 0 0 NNR W=200u L=100u
RLa vdd ap 800k
RLb vdd an 800k
.ends
.subckt esub xp xn mp mn ep en vdd vbn
Mt nt vbn 0 0 NNR W=400u L=100u
M1x ep xn nt 0 NNR W=200u L=100u
M2x en xp nt 0 NNR W=200u L=100u
M1m ep mp nt 0 NNR W=200u L=100u
M2m en mn nt 0 NNR W=200u L=100u
RLp vdd ep 50k
RLn vdd en 50k
.ends
Vdd vdd 0 1.0
Vgm gm 0 0.6
Vx1p a_xp1 0 0.8
Vx1n a_xn1 0 0.2
Vx2p a_xp2 0 0.8
Vx2n a_xn2 0 0.2
Mlp_mh0 mhp0 mhp0 vdd vdd PNR W=3000u L=100u
Mln_mh0 mhn0 mhn0 vdd vdd PNR W=3000u L=100u
Vwp_ih_1_0 wp_ih_1_0 0 0.5173
Vwn_ih_1_0 wn_ih_1_0 0 0.4827
X_ih_1_0 a_xp1 a_xn1 mhp0 mhn0 wp_ih_1_0 wn_ih_1_0 vdd dsyn
Vwp_ih_2_0 wp_ih_2_0 0 0.5411
Vwn_ih_2_0 wn_ih_2_0 0 0.4589
X_ih_2_0 a_xp2 a_xn2 mhp0 mhn0 wp_ih_2_0 wn_ih_2_0 vdd dsyn
Cxhp0 xhp0 0 0.4p
Cxhn0 xhn0 0 0.4p
Rpup0 mhp0 xhp0 100k
Rpun0 mhn0 xhn0 100k
Xn0 xhp0 xhn0 ahp0 ahn0 vdd gm dneuron
Xeh0 xhp0 xhn0 mhp0 mhn0 ehp0 ehn0 vdd gm esub
Mlp_mh1 mhp1 mhp1 vdd vdd PNR W=3000u L=100u
Mln_mh1 mhn1 mhn1 vdd vdd PNR W=3000u L=100u
Vwp_ih_1_1 wp_ih_1_1 0 0.4348
Vwn_ih_1_1 wn_ih_1_1 0 0.5652
X_ih_1_1 a_xp1 a_xn1 mhp1 mhn1 wp_ih_1_1 wn_ih_1_1 vdd dsyn
Vwp_ih_2_1 wp_ih_2_1 0 0.5453
Vwn_ih_2_1 wn_ih_2_1 0 0.4547
X_ih_2_1 a_xp2 a_xn2 mhp1 mhn1 wp_ih_2_1 wn_ih_2_1 vdd dsyn
Cxhp1 xhp1 0 0.4p
Cxhn1 xhn1 0 0.4p
Rpup1 mhp1 xhp1 100k
Rpun1 mhn1 xhn1 100k
Xn1 xhp1 xhn1 ahp1 ahn1 vdd gm dneuron
Xeh1 xhp1 xhn1 mhp1 mhn1 ehp1 ehn1 vdd gm esub
Mlp_mh2 mhp2 mhp2 vdd vdd PNR W=3000u L=100u
Mln_mh2 mhn2 mhn2 vdd vdd PNR W=3000u L=100u
Vwp_ih_1_2 wp_ih_1_2 0 0.4732
Vwn_ih_1_2 wn_ih_1_2 0 0.5268
X_ih_1_2 a_xp1 a_xn1 mhp2 mhn2 wp_ih_1_2 wn_ih_1_2 vdd dsyn
Vwp_ih_2_2 wp_ih_2_2 0 0.5291
Vwn_ih_2_2 wn_ih_2_2 0 0.4709
X_ih_2_2 a_xp2 a_xn2 mhp2 mhn2 wp_ih_2_2 wn_ih_2_2 vdd dsyn
Cxhp2 xhp2 0 0.4p
Cxhn2 xhn2 0 0.4p
Rpup2 mhp2 xhp2 100k
Rpun2 mhn2 xhn2 100k
Xn2 xhp2 xhn2 ahp2 ahn2 vdd gm dneuron
Xeh2 xhp2 xhn2 mhp2 mhn2 ehp2 ehn2 vdd gm esub
Mlp_mh3 mhp3 mhp3 vdd vdd PNR W=3000u L=100u
Mln_mh3 mhn3 mhn3 vdd vdd PNR W=3000u L=100u
Vwp_ih_1_3 wp_ih_1_3 0 0.5147
Vwn_ih_1_3 wn_ih_1_3 0 0.4853
X_ih_1_3 a_xp1 a_xn1 mhp3 mhn3 wp_ih_1_3 wn_ih_1_3 vdd dsyn
Vwp_ih_2_3 wp_ih_2_3 0 0.5014
Vwn_ih_2_3 wn_ih_2_3 0 0.4986
X_ih_2_3 a_xp2 a_xn2 mhp3 mhn3 wp_ih_2_3 wn_ih_2_3 vdd dsyn
Cxhp3 xhp3 0 0.4p
Cxhn3 xhn3 0 0.4p
Rpup3 mhp3 xhp3 100k
Rpun3 mhn3 xhn3 100k
Xn3 xhp3 xhn3 ahp3 ahn3 vdd gm dneuron
Xeh3 xhp3 xhn3 mhp3 mhn3 ehp3 ehn3 vdd gm esub
Mlp_mh4 mhp4 mhp4 vdd vdd PNR W=3000u L=100u
Mln_mh4 mhn4 mhn4 vdd vdd PNR W=3000u L=100u
Vwp_ih_1_4 wp_ih_1_4 0 0.4632
Vwn_ih_1_4 wn_ih_1_4 0 0.5368
X_ih_1_4 a_xp1 a_xn1 mhp4 mhn4 wp_ih_1_4 wn_ih_1_4 vdd dsyn
Vwp_ih_2_4 wp_ih_2_4 0 0.4919
Vwn_ih_2_4 wn_ih_2_4 0 0.5081
X_ih_2_4 a_xp2 a_xn2 mhp4 mhn4 wp_ih_2_4 wn_ih_2_4 vdd dsyn
Cxhp4 xhp4 0 0.4p
Cxhn4 xhn4 0 0.4p
Rpup4 mhp4 xhp4 100k
Rpun4 mhn4 xhn4 100k
Xn4 xhp4 xhn4 ahp4 ahn4 vdd gm dneuron
Xeh4 xhp4 xhn4 mhp4 mhn4 ehp4 ehn4 vdd gm esub
Mlp_mh5 mhp5 mhp5 vdd vdd PNR W=3000u L=100u
Mln_mh5 mhn5 mhn5 vdd vdd PNR W=3000u L=100u
Vwp_ih_1_5 wp_ih_1_5 0 0.5299
Vwn_ih_1_5 wn_ih_1_5 0 0.4701
X_ih_1_5 a_xp1 a_xn1 mhp5 mhn5 wp_ih_1_5 wn_ih_1_5 vdd dsyn
Vwp_ih_2_5 wp_ih_2_5 0 0.5020
Vwn_ih_2_5 wn_ih_2_5 0 0.4980
X_ih_2_5 a_xp2 a_xn2 mhp5 mhn5 wp_ih_2_5 wn_ih_2_5 vdd dsyn
Cxhp5 xhp5 0 0.4p
Cxhn5 xhn5 0 0.4p
Rpup5 mhp5 xhp5 100k
Rpun5 mhn5 xhn5 100k
Xn5 xhp5 xhn5 ahp5 ahn5 vdd gm dneuron
Xeh5 xhp5 xhn5 mhp5 mhn5 ehp5 ehn5 vdd gm esub
Mlp_mo mop mop vdd vdd PNR W=3000u L=100u
Mln_mo mon mon vdd vdd PNR W=3000u L=100u
Vwp_ho_0 wp_ho_0 0 0.5165
Vwn_ho_0 wn_ho_0 0 0.4835
X_ho_0 ahp0 ahn0 mop mon wp_ho_0 wn_ho_0 vdd dsyn
Vwp_ho_1 wp_ho_1 0 0.5223
Vwn_ho_1 wn_ho_1 0 0.4777
X_ho_1 ahp1 ahn1 mop mon wp_ho_1 wn_ho_1 vdd dsyn
Vwp_ho_2 wp_ho_2 0 0.5182
Vwn_ho_2 wn_ho_2 0 0.4818
X_ho_2 ahp2 ahn2 mop mon wp_ho_2 wn_ho_2 vdd dsyn
Vwp_ho_3 wp_ho_3 0 0.5273
Vwn_ho_3 wn_ho_3 0 0.4727
X_ho_3 ahp3 ahn3 mop mon wp_ho_3 wn_ho_3 vdd dsyn
Vwp_ho_4 wp_ho_4 0 0.4759
Vwn_ho_4 wn_ho_4 0 0.5241
X_ho_4 ahp4 ahn4 mop mon wp_ho_4 wn_ho_4 vdd dsyn
Vwp_ho_5 wp_ho_5 0 0.4854
Vwn_ho_5 wn_ho_5 0 0.5146
X_ho_5 ahp5 ahn5 mop mon wp_ho_5 wn_ho_5 vdd dsyn
Cxop xop 0 0.4p
Cxon xon 0 0.4p
Rpuo_p mop xop 100k
Rpuo_n mon xon 100k
Xeo xop xon mop mon eop eon vdd gm esub
Vwp_bk_0 wp_bk_0 0 0.5165
Vwn_bk_0 wn_bk_0 0 0.4835
X_bk_0 eop eon xhp0 xhn0 wp_bk_0 wn_bk_0 vdd dsyn
Vwp_bk_1 wp_bk_1 0 0.5223
Vwn_bk_1 wn_bk_1 0 0.4777
X_bk_1 eop eon xhp1 xhn1 wp_bk_1 wn_bk_1 vdd dsyn
Vwp_bk_2 wp_bk_2 0 0.5182
Vwn_bk_2 wn_bk_2 0 0.4818
X_bk_2 eop eon xhp2 xhn2 wp_bk_2 wn_bk_2 vdd dsyn
Vwp_bk_3 wp_bk_3 0 0.5273
Vwn_bk_3 wn_bk_3 0 0.4727
X_bk_3 eop eon xhp3 xhn3 wp_bk_3 wn_bk_3 vdd dsyn
Vwp_bk_4 wp_bk_4 0 0.4759
Vwn_bk_4 wn_bk_4 0 0.5241
X_bk_4 eop eon xhp4 xhn4 wp_bk_4 wn_bk_4 vdd dsyn
Vwp_bk_5 wp_bk_5 0 0.4854
Vwn_bk_5 wn_bk_5 0 0.5146
X_bk_5 eop eon xhp5 xhn5 wp_bk_5 wn_bk_5 vdd dsyn
.control
op
wrdata pcpci.dat v(xhp0) v(xhn0) v(ehp0) v(ehn0) v(xhp1) v(xhn1) v(ehp1) v(ehn1) v(xhp2) v(xhn2) v(ehp2) v(ehn2) v(xhp3) v(xhn3) v(ehp3) v(ehn3) v(xhp4) v(xhn4) v(ehp4) v(ehn4) v(xhp5) v(xhn5) v(ehp5) v(ehn5) v(mop) v(mon) v(eop) v(eon)
.endc
.end
