multi-class differential current-mode EP
.model NNR NMOS (LEVEL=1 VTO=0.2  KP=120u LAMBDA=0.02 GAMMA=0 PHI=0.7)
.model PNR PMOS (LEVEL=1 VTO=-0.2 KP=40u  LAMBDA=0.02 GAMMA=0 PHI=0.7)
.subckt dsyn inp inn outp outn wp wn vdd
M1 outp inp tp 0 NNR W=200u L=100u
M2 outn inn tp 0 NNR W=200u L=100u
Mtp tp wp 0 0 NNR W=200u L=100u
M3 outn inp tn 0 NNR W=200u L=100u
M4 outp inn tn 0 NNR W=200u L=100u
Mtn tn wn 0 0 NNR W=200u L=100u
.ends
.subckt dneuron up un ap an vdd vbn
M1 an up tn 0 NNR W=200u L=100u
M2 ap un tn 0 NNR W=200u L=100u
Mt tn vbn 0 0 NNR W=200u L=100u
RLa vdd ap 800k
RLb vdd an 800k
.ends

Vdd vdd 0 1.0
Vbn vbn 0 0.30
Vbp_hi bp_hi 0 0.8
Vbp_lo bp_lo 0 0.2
Vaxp0 a_xp0 0 0.5
Vaxn0 a_xn0 0 0.5
Vaxp1 a_xp1 0 0.5
Vaxn1 a_xn1 0 0.5
Vaxp2 a_xp2 0 0.5
Vaxn2 a_xn2 0 0.5
Vaxp3 a_xp3 0 0.5
Vaxn3 a_xn3 0 0.5
Vtp0 vtp0 0 0.5
Vtn0 vtn0 0 0.5
Vtp1 vtp1 0 0.5
Vtn1 vtn1 0 0.5
Vtp2 vtp2 0 0.5
Vtn2 vtn2 0 0.5
Mlp_h0 up_h0 up_h0 vdd vdd PNR W=2400u L=100u
Mln_h0 un_h0 un_h0 vdd vdd PNR W=2400u L=100u
Xn_h0 up_h0 un_h0 ap_h0 an_h0 vdd vbn dneuron
Vwp_ih_0_0 wp_ih_0_0 0 0.4148
Vwn_ih_0_0 wn_ih_0_0 0 0.4252
X_ih_0_0 a_xp0 a_xn0 up_h0 un_h0 wp_ih_0_0 wn_ih_0_0 vdd dsyn
Vwp_ih_1_0 wp_ih_1_0 0 0.3820
Vwn_ih_1_0 wn_ih_1_0 0 0.4580
X_ih_1_0 a_xp1 a_xn1 up_h0 un_h0 wp_ih_1_0 wn_ih_1_0 vdd dsyn
Vwp_ih_2_0 wp_ih_2_0 0 0.4133
Vwn_ih_2_0 wn_ih_2_0 0 0.4267
X_ih_2_0 a_xp2 a_xn2 up_h0 un_h0 wp_ih_2_0 wn_ih_2_0 vdd dsyn
Vwp_ih_3_0 wp_ih_3_0 0 0.3747
Vwn_ih_3_0 wn_ih_3_0 0 0.4653
X_ih_3_0 a_xp3 a_xn3 up_h0 un_h0 wp_ih_3_0 wn_ih_3_0 vdd dsyn
Vwp_bk_0_0 wp_bk_0_0 0 0.4295
Vwn_bk_0_0 wn_bk_0_0 0 0.4105
X_bk_0_0 up_o0 un_o0 up_h0 un_h0 wp_bk_0_0 wn_bk_0_0 vdd dsyn
Vwp_bk_0_1 wp_bk_0_1 0 0.4765
Vwn_bk_0_1 wn_bk_0_1 0 0.3635
X_bk_0_1 up_o1 un_o1 up_h0 un_h0 wp_bk_0_1 wn_bk_0_1 vdd dsyn
Vwp_bk_0_2 wp_bk_0_2 0 0.3782
Vwn_bk_0_2 wn_bk_0_2 0 0.4618
X_bk_0_2 up_o2 un_o2 up_h0 un_h0 wp_bk_0_2 wn_bk_0_2 vdd dsyn
Vwp_bh_0 wp_bh_0 0 0.4914
Vwn_bh_0 wn_bh_0 0 0.3486
X_bh_0 bp_hi bp_lo up_h0 un_h0 wp_bh_0 wn_bh_0 vdd dsyn
Mlp_h1 up_h1 up_h1 vdd vdd PNR W=2400u L=100u
Mln_h1 un_h1 un_h1 vdd vdd PNR W=2400u L=100u
Xn_h1 up_h1 un_h1 ap_h1 an_h1 vdd vbn dneuron
Vwp_ih_0_1 wp_ih_0_1 0 0.3866
Vwn_ih_0_1 wn_ih_0_1 0 0.4534
X_ih_0_1 a_xp0 a_xn0 up_h1 un_h1 wp_ih_0_1 wn_ih_0_1 vdd dsyn
Vwp_ih_1_1 wp_ih_1_1 0 0.4277
Vwn_ih_1_1 wn_ih_1_1 0 0.4123
X_ih_1_1 a_xp1 a_xn1 up_h1 un_h1 wp_ih_1_1 wn_ih_1_1 vdd dsyn
Vwp_ih_2_1 wp_ih_2_1 0 0.3782
Vwn_ih_2_1 wn_ih_2_1 0 0.4618
X_ih_2_1 a_xp2 a_xn2 up_h1 un_h1 wp_ih_2_1 wn_ih_2_1 vdd dsyn
Vwp_ih_3_1 wp_ih_3_1 0 0.4089
Vwn_ih_3_1 wn_ih_3_1 0 0.4311
X_ih_3_1 a_xp3 a_xn3 up_h1 un_h1 wp_ih_3_1 wn_ih_3_1 vdd dsyn
Vwp_bk_1_0 wp_bk_1_0 0 0.4224
Vwn_bk_1_0 wn_bk_1_0 0 0.4176
X_bk_1_0 up_o0 un_o0 up_h1 un_h1 wp_bk_1_0 wn_bk_1_0 vdd dsyn
Vwp_bk_1_1 wp_bk_1_1 0 0.3983
Vwn_bk_1_1 wn_bk_1_1 0 0.4417
X_bk_1_1 up_o1 un_o1 up_h1 un_h1 wp_bk_1_1 wn_bk_1_1 vdd dsyn
Vwp_bk_1_2 wp_bk_1_2 0 0.3849
Vwn_bk_1_2 wn_bk_1_2 0 0.4551
X_bk_1_2 up_o2 un_o2 up_h1 un_h1 wp_bk_1_2 wn_bk_1_2 vdd dsyn
Vwp_bh_1 wp_bh_1 0 0.3861
Vwn_bh_1 wn_bh_1 0 0.4539
X_bh_1 bp_hi bp_lo up_h1 un_h1 wp_bh_1 wn_bh_1 vdd dsyn
Mlp_h2 up_h2 up_h2 vdd vdd PNR W=2400u L=100u
Mln_h2 un_h2 un_h2 vdd vdd PNR W=2400u L=100u
Xn_h2 up_h2 un_h2 ap_h2 an_h2 vdd vbn dneuron
Vwp_ih_0_2 wp_ih_0_2 0 0.3789
Vwn_ih_0_2 wn_ih_0_2 0 0.4611
X_ih_0_2 a_xp0 a_xn0 up_h2 un_h2 wp_ih_0_2 wn_ih_0_2 vdd dsyn
Vwp_ih_1_2 wp_ih_1_2 0 0.3415
Vwn_ih_1_2 wn_ih_1_2 0 0.4985
X_ih_1_2 a_xp1 a_xn1 up_h2 un_h2 wp_ih_1_2 wn_ih_1_2 vdd dsyn
Vwp_ih_2_2 wp_ih_2_2 0 0.4019
Vwn_ih_2_2 wn_ih_2_2 0 0.4381
X_ih_2_2 a_xp2 a_xn2 up_h2 un_h2 wp_ih_2_2 wn_ih_2_2 vdd dsyn
Vwp_ih_3_2 wp_ih_3_2 0 0.4401
Vwn_ih_3_2 wn_ih_3_2 0 0.3999
X_ih_3_2 a_xp3 a_xn3 up_h2 un_h2 wp_ih_3_2 wn_ih_3_2 vdd dsyn
Vwp_bk_2_0 wp_bk_2_0 0 0.4654
Vwn_bk_2_0 wn_bk_2_0 0 0.3746
X_bk_2_0 up_o0 un_o0 up_h2 un_h2 wp_bk_2_0 wn_bk_2_0 vdd dsyn
Vwp_bk_2_1 wp_bk_2_1 0 0.4524
Vwn_bk_2_1 wn_bk_2_1 0 0.3876
X_bk_2_1 up_o1 un_o1 up_h2 un_h2 wp_bk_2_1 wn_bk_2_1 vdd dsyn
Vwp_bk_2_2 wp_bk_2_2 0 0.5429
Vwn_bk_2_2 wn_bk_2_2 0 0.3000
X_bk_2_2 up_o2 un_o2 up_h2 un_h2 wp_bk_2_2 wn_bk_2_2 vdd dsyn
Vwp_bh_2 wp_bh_2 0 0.4359
Vwn_bh_2 wn_bh_2 0 0.4041
X_bh_2 bp_hi bp_lo up_h2 un_h2 wp_bh_2 wn_bh_2 vdd dsyn
Mlp_h3 up_h3 up_h3 vdd vdd PNR W=2400u L=100u
Mln_h3 un_h3 un_h3 vdd vdd PNR W=2400u L=100u
Xn_h3 up_h3 un_h3 ap_h3 an_h3 vdd vbn dneuron
Vwp_ih_0_3 wp_ih_0_3 0 0.3972
Vwn_ih_0_3 wn_ih_0_3 0 0.4428
X_ih_0_3 a_xp0 a_xn0 up_h3 un_h3 wp_ih_0_3 wn_ih_0_3 vdd dsyn
Vwp_ih_1_3 wp_ih_1_3 0 0.5136
Vwn_ih_1_3 wn_ih_1_3 0 0.3264
X_ih_1_3 a_xp1 a_xn1 up_h3 un_h3 wp_ih_1_3 wn_ih_1_3 vdd dsyn
Vwp_ih_2_3 wp_ih_2_3 0 0.3676
Vwn_ih_2_3 wn_ih_2_3 0 0.4724
X_ih_2_3 a_xp2 a_xn2 up_h3 un_h3 wp_ih_2_3 wn_ih_2_3 vdd dsyn
Vwp_ih_3_3 wp_ih_3_3 0 0.4684
Vwn_ih_3_3 wn_ih_3_3 0 0.3716
X_ih_3_3 a_xp3 a_xn3 up_h3 un_h3 wp_ih_3_3 wn_ih_3_3 vdd dsyn
Vwp_bk_3_0 wp_bk_3_0 0 0.3722
Vwn_bk_3_0 wn_bk_3_0 0 0.4678
X_bk_3_0 up_o0 un_o0 up_h3 un_h3 wp_bk_3_0 wn_bk_3_0 vdd dsyn
Vwp_bk_3_1 wp_bk_3_1 0 0.4377
Vwn_bk_3_1 wn_bk_3_1 0 0.4023
X_bk_3_1 up_o1 un_o1 up_h3 un_h3 wp_bk_3_1 wn_bk_3_1 vdd dsyn
Vwp_bk_3_2 wp_bk_3_2 0 0.3216
Vwn_bk_3_2 wn_bk_3_2 0 0.5184
X_bk_3_2 up_o2 un_o2 up_h3 un_h3 wp_bk_3_2 wn_bk_3_2 vdd dsyn
Vwp_bh_3 wp_bh_3 0 0.4650
Vwn_bh_3 wn_bh_3 0 0.3750
X_bh_3 bp_hi bp_lo up_h3 un_h3 wp_bh_3 wn_bh_3 vdd dsyn
Mlp_h4 up_h4 up_h4 vdd vdd PNR W=2400u L=100u
Mln_h4 un_h4 un_h4 vdd vdd PNR W=2400u L=100u
Xn_h4 up_h4 un_h4 ap_h4 an_h4 vdd vbn dneuron
Vwp_ih_0_4 wp_ih_0_4 0 0.4121
Vwn_ih_0_4 wn_ih_0_4 0 0.4279
X_ih_0_4 a_xp0 a_xn0 up_h4 un_h4 wp_ih_0_4 wn_ih_0_4 vdd dsyn
Vwp_ih_1_4 wp_ih_1_4 0 0.3716
Vwn_ih_1_4 wn_ih_1_4 0 0.4684
X_ih_1_4 a_xp1 a_xn1 up_h4 un_h4 wp_ih_1_4 wn_ih_1_4 vdd dsyn
Vwp_ih_2_4 wp_ih_2_4 0 0.5039
Vwn_ih_2_4 wn_ih_2_4 0 0.3361
X_ih_2_4 a_xp2 a_xn2 up_h4 un_h4 wp_ih_2_4 wn_ih_2_4 vdd dsyn
Vwp_ih_3_4 wp_ih_3_4 0 0.4583
Vwn_ih_3_4 wn_ih_3_4 0 0.3817
X_ih_3_4 a_xp3 a_xn3 up_h4 un_h4 wp_ih_3_4 wn_ih_3_4 vdd dsyn
Vwp_bk_4_0 wp_bk_4_0 0 0.4223
Vwn_bk_4_0 wn_bk_4_0 0 0.4177
X_bk_4_0 up_o0 un_o0 up_h4 un_h4 wp_bk_4_0 wn_bk_4_0 vdd dsyn
Vwp_bk_4_1 wp_bk_4_1 0 0.3827
Vwn_bk_4_1 wn_bk_4_1 0 0.4573
X_bk_4_1 up_o1 un_o1 up_h4 un_h4 wp_bk_4_1 wn_bk_4_1 vdd dsyn
Vwp_bk_4_2 wp_bk_4_2 0 0.4178
Vwn_bk_4_2 wn_bk_4_2 0 0.4222
X_bk_4_2 up_o2 un_o2 up_h4 un_h4 wp_bk_4_2 wn_bk_4_2 vdd dsyn
Vwp_bh_4 wp_bh_4 0 0.4118
Vwn_bh_4 wn_bh_4 0 0.4282
X_bh_4 bp_hi bp_lo up_h4 un_h4 wp_bh_4 wn_bh_4 vdd dsyn
Mlp_h5 up_h5 up_h5 vdd vdd PNR W=2400u L=100u
Mln_h5 un_h5 un_h5 vdd vdd PNR W=2400u L=100u
Xn_h5 up_h5 un_h5 ap_h5 an_h5 vdd vbn dneuron
Vwp_ih_0_5 wp_ih_0_5 0 0.4562
Vwn_ih_0_5 wn_ih_0_5 0 0.3838
X_ih_0_5 a_xp0 a_xn0 up_h5 un_h5 wp_ih_0_5 wn_ih_0_5 vdd dsyn
Vwp_ih_1_5 wp_ih_1_5 0 0.4599
Vwn_ih_1_5 wn_ih_1_5 0 0.3801
X_ih_1_5 a_xp1 a_xn1 up_h5 un_h5 wp_ih_1_5 wn_ih_1_5 vdd dsyn
Vwp_ih_2_5 wp_ih_2_5 0 0.3866
Vwn_ih_2_5 wn_ih_2_5 0 0.4534
X_ih_2_5 a_xp2 a_xn2 up_h5 un_h5 wp_ih_2_5 wn_ih_2_5 vdd dsyn
Vwp_ih_3_5 wp_ih_3_5 0 0.3925
Vwn_ih_3_5 wn_ih_3_5 0 0.4475
X_ih_3_5 a_xp3 a_xn3 up_h5 un_h5 wp_ih_3_5 wn_ih_3_5 vdd dsyn
Vwp_bk_5_0 wp_bk_5_0 0 0.3934
Vwn_bk_5_0 wn_bk_5_0 0 0.4466
X_bk_5_0 up_o0 un_o0 up_h5 un_h5 wp_bk_5_0 wn_bk_5_0 vdd dsyn
Vwp_bk_5_1 wp_bk_5_1 0 0.3525
Vwn_bk_5_1 wn_bk_5_1 0 0.4875
X_bk_5_1 up_o1 un_o1 up_h5 un_h5 wp_bk_5_1 wn_bk_5_1 vdd dsyn
Vwp_bk_5_2 wp_bk_5_2 0 0.3904
Vwn_bk_5_2 wn_bk_5_2 0 0.4496
X_bk_5_2 up_o2 un_o2 up_h5 un_h5 wp_bk_5_2 wn_bk_5_2 vdd dsyn
Vwp_bh_5 wp_bh_5 0 0.4154
Vwn_bh_5 wn_bh_5 0 0.4246
X_bh_5 bp_hi bp_lo up_h5 un_h5 wp_bh_5 wn_bh_5 vdd dsyn
Mlp_h6 up_h6 up_h6 vdd vdd PNR W=2400u L=100u
Mln_h6 un_h6 un_h6 vdd vdd PNR W=2400u L=100u
Xn_h6 up_h6 un_h6 ap_h6 an_h6 vdd vbn dneuron
Vwp_ih_0_6 wp_ih_0_6 0 0.4545
Vwn_ih_0_6 wn_ih_0_6 0 0.3855
X_ih_0_6 a_xp0 a_xn0 up_h6 un_h6 wp_ih_0_6 wn_ih_0_6 vdd dsyn
Vwp_ih_1_6 wp_ih_1_6 0 0.4860
Vwn_ih_1_6 wn_ih_1_6 0 0.3540
X_ih_1_6 a_xp1 a_xn1 up_h6 un_h6 wp_ih_1_6 wn_ih_1_6 vdd dsyn
Vwp_ih_2_6 wp_ih_2_6 0 0.3796
Vwn_ih_2_6 wn_ih_2_6 0 0.4604
X_ih_2_6 a_xp2 a_xn2 up_h6 un_h6 wp_ih_2_6 wn_ih_2_6 vdd dsyn
Vwp_ih_3_6 wp_ih_3_6 0 0.4475
Vwn_ih_3_6 wn_ih_3_6 0 0.3925
X_ih_3_6 a_xp3 a_xn3 up_h6 un_h6 wp_ih_3_6 wn_ih_3_6 vdd dsyn
Vwp_bk_6_0 wp_bk_6_0 0 0.3978
Vwn_bk_6_0 wn_bk_6_0 0 0.4422
X_bk_6_0 up_o0 un_o0 up_h6 un_h6 wp_bk_6_0 wn_bk_6_0 vdd dsyn
Vwp_bk_6_1 wp_bk_6_1 0 0.5238
Vwn_bk_6_1 wn_bk_6_1 0 0.3162
X_bk_6_1 up_o1 un_o1 up_h6 un_h6 wp_bk_6_1 wn_bk_6_1 vdd dsyn
Vwp_bk_6_2 wp_bk_6_2 0 0.4176
Vwn_bk_6_2 wn_bk_6_2 0 0.4224
X_bk_6_2 up_o2 un_o2 up_h6 un_h6 wp_bk_6_2 wn_bk_6_2 vdd dsyn
Vwp_bh_6 wp_bh_6 0 0.4451
Vwn_bh_6 wn_bh_6 0 0.3949
X_bh_6 bp_hi bp_lo up_h6 un_h6 wp_bh_6 wn_bh_6 vdd dsyn
Mlp_h7 up_h7 up_h7 vdd vdd PNR W=2400u L=100u
Mln_h7 un_h7 un_h7 vdd vdd PNR W=2400u L=100u
Xn_h7 up_h7 un_h7 ap_h7 an_h7 vdd vbn dneuron
Vwp_ih_0_7 wp_ih_0_7 0 0.3732
Vwn_ih_0_7 wn_ih_0_7 0 0.4668
X_ih_0_7 a_xp0 a_xn0 up_h7 un_h7 wp_ih_0_7 wn_ih_0_7 vdd dsyn
Vwp_ih_1_7 wp_ih_1_7 0 0.3795
Vwn_ih_1_7 wn_ih_1_7 0 0.4605
X_ih_1_7 a_xp1 a_xn1 up_h7 un_h7 wp_ih_1_7 wn_ih_1_7 vdd dsyn
Vwp_ih_2_7 wp_ih_2_7 0 0.4301
Vwn_ih_2_7 wn_ih_2_7 0 0.4099
X_ih_2_7 a_xp2 a_xn2 up_h7 un_h7 wp_ih_2_7 wn_ih_2_7 vdd dsyn
Vwp_ih_3_7 wp_ih_3_7 0 0.4008
Vwn_ih_3_7 wn_ih_3_7 0 0.4392
X_ih_3_7 a_xp3 a_xn3 up_h7 un_h7 wp_ih_3_7 wn_ih_3_7 vdd dsyn
Vwp_bk_7_0 wp_bk_7_0 0 0.4377
Vwn_bk_7_0 wn_bk_7_0 0 0.4023
X_bk_7_0 up_o0 un_o0 up_h7 un_h7 wp_bk_7_0 wn_bk_7_0 vdd dsyn
Vwp_bk_7_1 wp_bk_7_1 0 0.3419
Vwn_bk_7_1 wn_bk_7_1 0 0.4981
X_bk_7_1 up_o1 un_o1 up_h7 un_h7 wp_bk_7_1 wn_bk_7_1 vdd dsyn
Vwp_bk_7_2 wp_bk_7_2 0 0.4531
Vwn_bk_7_2 wn_bk_7_2 0 0.3869
X_bk_7_2 up_o2 un_o2 up_h7 un_h7 wp_bk_7_2 wn_bk_7_2 vdd dsyn
Vwp_bh_7 wp_bh_7 0 0.3750
Vwn_bh_7 wn_bh_7 0 0.4650
X_bh_7 bp_hi bp_lo up_h7 un_h7 wp_bh_7 wn_bh_7 vdd dsyn
Mlp_h8 up_h8 up_h8 vdd vdd PNR W=2400u L=100u
Mln_h8 un_h8 un_h8 vdd vdd PNR W=2400u L=100u
Xn_h8 up_h8 un_h8 ap_h8 an_h8 vdd vbn dneuron
Vwp_ih_0_8 wp_ih_0_8 0 0.5061
Vwn_ih_0_8 wn_ih_0_8 0 0.3339
X_ih_0_8 a_xp0 a_xn0 up_h8 un_h8 wp_ih_0_8 wn_ih_0_8 vdd dsyn
Vwp_ih_1_8 wp_ih_1_8 0 0.4056
Vwn_ih_1_8 wn_ih_1_8 0 0.4344
X_ih_1_8 a_xp1 a_xn1 up_h8 un_h8 wp_ih_1_8 wn_ih_1_8 vdd dsyn
Vwp_ih_2_8 wp_ih_2_8 0 0.4749
Vwn_ih_2_8 wn_ih_2_8 0 0.3651
X_ih_2_8 a_xp2 a_xn2 up_h8 un_h8 wp_ih_2_8 wn_ih_2_8 vdd dsyn
Vwp_ih_3_8 wp_ih_3_8 0 0.3503
Vwn_ih_3_8 wn_ih_3_8 0 0.4897
X_ih_3_8 a_xp3 a_xn3 up_h8 un_h8 wp_ih_3_8 wn_ih_3_8 vdd dsyn
Vwp_bk_8_0 wp_bk_8_0 0 0.4414
Vwn_bk_8_0 wn_bk_8_0 0 0.3986
X_bk_8_0 up_o0 un_o0 up_h8 un_h8 wp_bk_8_0 wn_bk_8_0 vdd dsyn
Vwp_bk_8_1 wp_bk_8_1 0 0.3756
Vwn_bk_8_1 wn_bk_8_1 0 0.4644
X_bk_8_1 up_o1 un_o1 up_h8 un_h8 wp_bk_8_1 wn_bk_8_1 vdd dsyn
Vwp_bk_8_2 wp_bk_8_2 0 0.3957
Vwn_bk_8_2 wn_bk_8_2 0 0.4443
X_bk_8_2 up_o2 un_o2 up_h8 un_h8 wp_bk_8_2 wn_bk_8_2 vdd dsyn
Vwp_bh_8 wp_bh_8 0 0.4212
Vwn_bh_8 wn_bh_8 0 0.4188
X_bh_8 bp_hi bp_lo up_h8 un_h8 wp_bh_8 wn_bh_8 vdd dsyn
Mlp_h9 up_h9 up_h9 vdd vdd PNR W=2400u L=100u
Mln_h9 un_h9 un_h9 vdd vdd PNR W=2400u L=100u
Xn_h9 up_h9 un_h9 ap_h9 an_h9 vdd vbn dneuron
Vwp_ih_0_9 wp_ih_0_9 0 0.4041
Vwn_ih_0_9 wn_ih_0_9 0 0.4359
X_ih_0_9 a_xp0 a_xn0 up_h9 un_h9 wp_ih_0_9 wn_ih_0_9 vdd dsyn
Vwp_ih_1_9 wp_ih_1_9 0 0.4332
Vwn_ih_1_9 wn_ih_1_9 0 0.4068
X_ih_1_9 a_xp1 a_xn1 up_h9 un_h9 wp_ih_1_9 wn_ih_1_9 vdd dsyn
Vwp_ih_2_9 wp_ih_2_9 0 0.4574
Vwn_ih_2_9 wn_ih_2_9 0 0.3826
X_ih_2_9 a_xp2 a_xn2 up_h9 un_h9 wp_ih_2_9 wn_ih_2_9 vdd dsyn
Vwp_ih_3_9 wp_ih_3_9 0 0.4526
Vwn_ih_3_9 wn_ih_3_9 0 0.3874
X_ih_3_9 a_xp3 a_xn3 up_h9 un_h9 wp_ih_3_9 wn_ih_3_9 vdd dsyn
Vwp_bk_9_0 wp_bk_9_0 0 0.4156
Vwn_bk_9_0 wn_bk_9_0 0 0.4244
X_bk_9_0 up_o0 un_o0 up_h9 un_h9 wp_bk_9_0 wn_bk_9_0 vdd dsyn
Vwp_bk_9_1 wp_bk_9_1 0 0.3518
Vwn_bk_9_1 wn_bk_9_1 0 0.4882
X_bk_9_1 up_o1 un_o1 up_h9 un_h9 wp_bk_9_1 wn_bk_9_1 vdd dsyn
Vwp_bk_9_2 wp_bk_9_2 0 0.3798
Vwn_bk_9_2 wn_bk_9_2 0 0.4602
X_bk_9_2 up_o2 un_o2 up_h9 un_h9 wp_bk_9_2 wn_bk_9_2 vdd dsyn
Vwp_bh_9 wp_bh_9 0 0.4102
Vwn_bh_9 wn_bh_9 0 0.4298
X_bh_9 bp_hi bp_lo up_h9 un_h9 wp_bh_9 wn_bh_9 vdd dsyn
Mlp_o0 up_o0 up_o0 vdd vdd PNR W=3300u L=100u
Mln_o0 un_o0 un_o0 vdd vdd PNR W=3300u L=100u
Vwp_fo_0_0 wp_fo_0_0 0 0.4295
Vwn_fo_0_0 wn_fo_0_0 0 0.4105
X_fo_0_0 ap_h0 an_h0 up_o0 un_o0 wp_fo_0_0 wn_fo_0_0 vdd dsyn
Vwp_fo_1_0 wp_fo_1_0 0 0.4224
Vwn_fo_1_0 wn_fo_1_0 0 0.4176
X_fo_1_0 ap_h1 an_h1 up_o0 un_o0 wp_fo_1_0 wn_fo_1_0 vdd dsyn
Vwp_fo_2_0 wp_fo_2_0 0 0.4654
Vwn_fo_2_0 wn_fo_2_0 0 0.3746
X_fo_2_0 ap_h2 an_h2 up_o0 un_o0 wp_fo_2_0 wn_fo_2_0 vdd dsyn
Vwp_fo_3_0 wp_fo_3_0 0 0.3722
Vwn_fo_3_0 wn_fo_3_0 0 0.4678
X_fo_3_0 ap_h3 an_h3 up_o0 un_o0 wp_fo_3_0 wn_fo_3_0 vdd dsyn
Vwp_fo_4_0 wp_fo_4_0 0 0.4223
Vwn_fo_4_0 wn_fo_4_0 0 0.4177
X_fo_4_0 ap_h4 an_h4 up_o0 un_o0 wp_fo_4_0 wn_fo_4_0 vdd dsyn
Vwp_fo_5_0 wp_fo_5_0 0 0.3934
Vwn_fo_5_0 wn_fo_5_0 0 0.4466
X_fo_5_0 ap_h5 an_h5 up_o0 un_o0 wp_fo_5_0 wn_fo_5_0 vdd dsyn
Vwp_fo_6_0 wp_fo_6_0 0 0.3978
Vwn_fo_6_0 wn_fo_6_0 0 0.4422
X_fo_6_0 ap_h6 an_h6 up_o0 un_o0 wp_fo_6_0 wn_fo_6_0 vdd dsyn
Vwp_fo_7_0 wp_fo_7_0 0 0.4377
Vwn_fo_7_0 wn_fo_7_0 0 0.4023
X_fo_7_0 ap_h7 an_h7 up_o0 un_o0 wp_fo_7_0 wn_fo_7_0 vdd dsyn
Vwp_fo_8_0 wp_fo_8_0 0 0.4414
Vwn_fo_8_0 wn_fo_8_0 0 0.3986
X_fo_8_0 ap_h8 an_h8 up_o0 un_o0 wp_fo_8_0 wn_fo_8_0 vdd dsyn
Vwp_fo_9_0 wp_fo_9_0 0 0.4156
Vwn_fo_9_0 wn_fo_9_0 0 0.4244
X_fo_9_0 ap_h9 an_h9 up_o0 un_o0 wp_fo_9_0 wn_fo_9_0 vdd dsyn
Vwp_bo_0 wp_bo_0 0 0.3139
Vwn_bo_0 wn_bo_0 0 0.5261
X_bo_0 bp_hi bp_lo up_o0 un_o0 wp_bo_0 wn_bo_0 vdd dsyn
Rbp0 up_o0 vtp0 1e10
Rbn0 un_o0 vtn0 1e10
Mlp_o1 up_o1 up_o1 vdd vdd PNR W=3300u L=100u
Mln_o1 un_o1 un_o1 vdd vdd PNR W=3300u L=100u
Vwp_fo_0_1 wp_fo_0_1 0 0.4765
Vwn_fo_0_1 wn_fo_0_1 0 0.3635
X_fo_0_1 ap_h0 an_h0 up_o1 un_o1 wp_fo_0_1 wn_fo_0_1 vdd dsyn
Vwp_fo_1_1 wp_fo_1_1 0 0.3983
Vwn_fo_1_1 wn_fo_1_1 0 0.4417
X_fo_1_1 ap_h1 an_h1 up_o1 un_o1 wp_fo_1_1 wn_fo_1_1 vdd dsyn
Vwp_fo_2_1 wp_fo_2_1 0 0.4524
Vwn_fo_2_1 wn_fo_2_1 0 0.3876
X_fo_2_1 ap_h2 an_h2 up_o1 un_o1 wp_fo_2_1 wn_fo_2_1 vdd dsyn
Vwp_fo_3_1 wp_fo_3_1 0 0.4377
Vwn_fo_3_1 wn_fo_3_1 0 0.4023
X_fo_3_1 ap_h3 an_h3 up_o1 un_o1 wp_fo_3_1 wn_fo_3_1 vdd dsyn
Vwp_fo_4_1 wp_fo_4_1 0 0.3827
Vwn_fo_4_1 wn_fo_4_1 0 0.4573
X_fo_4_1 ap_h4 an_h4 up_o1 un_o1 wp_fo_4_1 wn_fo_4_1 vdd dsyn
Vwp_fo_5_1 wp_fo_5_1 0 0.3525
Vwn_fo_5_1 wn_fo_5_1 0 0.4875
X_fo_5_1 ap_h5 an_h5 up_o1 un_o1 wp_fo_5_1 wn_fo_5_1 vdd dsyn
Vwp_fo_6_1 wp_fo_6_1 0 0.5238
Vwn_fo_6_1 wn_fo_6_1 0 0.3162
X_fo_6_1 ap_h6 an_h6 up_o1 un_o1 wp_fo_6_1 wn_fo_6_1 vdd dsyn
Vwp_fo_7_1 wp_fo_7_1 0 0.3419
Vwn_fo_7_1 wn_fo_7_1 0 0.4981
X_fo_7_1 ap_h7 an_h7 up_o1 un_o1 wp_fo_7_1 wn_fo_7_1 vdd dsyn
Vwp_fo_8_1 wp_fo_8_1 0 0.3756
Vwn_fo_8_1 wn_fo_8_1 0 0.4644
X_fo_8_1 ap_h8 an_h8 up_o1 un_o1 wp_fo_8_1 wn_fo_8_1 vdd dsyn
Vwp_fo_9_1 wp_fo_9_1 0 0.3518
Vwn_fo_9_1 wn_fo_9_1 0 0.4882
X_fo_9_1 ap_h9 an_h9 up_o1 un_o1 wp_fo_9_1 wn_fo_9_1 vdd dsyn
Vwp_bo_1 wp_bo_1 0 0.4576
Vwn_bo_1 wn_bo_1 0 0.3824
X_bo_1 bp_hi bp_lo up_o1 un_o1 wp_bo_1 wn_bo_1 vdd dsyn
Rbp1 up_o1 vtp1 1e10
Rbn1 un_o1 vtn1 1e10
Mlp_o2 up_o2 up_o2 vdd vdd PNR W=3300u L=100u
Mln_o2 un_o2 un_o2 vdd vdd PNR W=3300u L=100u
Vwp_fo_0_2 wp_fo_0_2 0 0.3782
Vwn_fo_0_2 wn_fo_0_2 0 0.4618
X_fo_0_2 ap_h0 an_h0 up_o2 un_o2 wp_fo_0_2 wn_fo_0_2 vdd dsyn
Vwp_fo_1_2 wp_fo_1_2 0 0.3849
Vwn_fo_1_2 wn_fo_1_2 0 0.4551
X_fo_1_2 ap_h1 an_h1 up_o2 un_o2 wp_fo_1_2 wn_fo_1_2 vdd dsyn
Vwp_fo_2_2 wp_fo_2_2 0 0.5429
Vwn_fo_2_2 wn_fo_2_2 0 0.3000
X_fo_2_2 ap_h2 an_h2 up_o2 un_o2 wp_fo_2_2 wn_fo_2_2 vdd dsyn
Vwp_fo_3_2 wp_fo_3_2 0 0.3216
Vwn_fo_3_2 wn_fo_3_2 0 0.5184
X_fo_3_2 ap_h3 an_h3 up_o2 un_o2 wp_fo_3_2 wn_fo_3_2 vdd dsyn
Vwp_fo_4_2 wp_fo_4_2 0 0.4178
Vwn_fo_4_2 wn_fo_4_2 0 0.4222
X_fo_4_2 ap_h4 an_h4 up_o2 un_o2 wp_fo_4_2 wn_fo_4_2 vdd dsyn
Vwp_fo_5_2 wp_fo_5_2 0 0.3904
Vwn_fo_5_2 wn_fo_5_2 0 0.4496
X_fo_5_2 ap_h5 an_h5 up_o2 un_o2 wp_fo_5_2 wn_fo_5_2 vdd dsyn
Vwp_fo_6_2 wp_fo_6_2 0 0.4176
Vwn_fo_6_2 wn_fo_6_2 0 0.4224
X_fo_6_2 ap_h6 an_h6 up_o2 un_o2 wp_fo_6_2 wn_fo_6_2 vdd dsyn
Vwp_fo_7_2 wp_fo_7_2 0 0.4531
Vwn_fo_7_2 wn_fo_7_2 0 0.3869
X_fo_7_2 ap_h7 an_h7 up_o2 un_o2 wp_fo_7_2 wn_fo_7_2 vdd dsyn
Vwp_fo_8_2 wp_fo_8_2 0 0.3957
Vwn_fo_8_2 wn_fo_8_2 0 0.4443
X_fo_8_2 ap_h8 an_h8 up_o2 un_o2 wp_fo_8_2 wn_fo_8_2 vdd dsyn
Vwp_fo_9_2 wp_fo_9_2 0 0.3798
Vwn_fo_9_2 wn_fo_9_2 0 0.4602
X_fo_9_2 ap_h9 an_h9 up_o2 un_o2 wp_fo_9_2 wn_fo_9_2 vdd dsyn
Vwp_bo_2 wp_bo_2 0 0.4080
Vwn_bo_2 wn_bo_2 0 0.4320
X_bo_2 bp_hi bp_lo up_o2 un_o2 wp_bo_2 wn_bo_2 vdd dsyn
Rbp2 up_o2 vtp2 1e10
Rbn2 un_o2 vtn2 1e10
.control
alter Vaxp0 0.2
alter Vaxn0 0.8
alter Vaxp1 0.2
alter Vaxn1 0.8
alter Vaxp2 0.2
alter Vaxn2 0.8
alter Vaxp3 0.2
alter Vaxn3 0.8
alter Rbp0 1e10
alter Rbp1 1e10
alter Rbp2 1e10
alter Rbn0 1e10
alter Rbn1 1e10
alter Rbn2 1e10
op
wrdata mf0.dat v(ap_h0) v(an_h0) v(ap_h1) v(an_h1) v(ap_h2) v(an_h2) v(ap_h3) v(an_h3) v(ap_h4) v(an_h4) v(ap_h5) v(an_h5) v(ap_h6) v(an_h6) v(ap_h7) v(an_h7) v(ap_h8) v(an_h8) v(ap_h9) v(an_h9) v(up_o0) v(un_o0) v(up_o1) v(un_o1) v(up_o2) v(un_o2)
alter Vtp0 0.6
alter Vtn0 0.4
alter Vtp1 0.4
alter Vtn1 0.6
alter Vtp2 0.4
alter Vtn2 0.6
alter Rbp0 200000.0
alter Rbp1 200000.0
alter Rbp2 200000.0
alter Rbn0 200000.0
alter Rbn1 200000.0
alter Rbn2 200000.0
op
wrdata mn0.dat v(ap_h0) v(an_h0) v(ap_h1) v(an_h1) v(ap_h2) v(an_h2) v(ap_h3) v(an_h3) v(ap_h4) v(an_h4) v(ap_h5) v(an_h5) v(ap_h6) v(an_h6) v(ap_h7) v(an_h7) v(ap_h8) v(an_h8) v(ap_h9) v(an_h9) v(up_o0) v(un_o0) v(up_o1) v(un_o1) v(up_o2) v(un_o2)
alter Vaxp0 0.2
alter Vaxn0 0.8
alter Vaxp1 0.2
alter Vaxn1 0.8
alter Vaxp2 0.2
alter Vaxn2 0.8
alter Vaxp3 0.8
alter Vaxn3 0.2
alter Rbp0 1e10
alter Rbp1 1e10
alter Rbp2 1e10
alter Rbn0 1e10
alter Rbn1 1e10
alter Rbn2 1e10
op
wrdata mf1.dat v(ap_h0) v(an_h0) v(ap_h1) v(an_h1) v(ap_h2) v(an_h2) v(ap_h3) v(an_h3) v(ap_h4) v(an_h4) v(ap_h5) v(an_h5) v(ap_h6) v(an_h6) v(ap_h7) v(an_h7) v(ap_h8) v(an_h8) v(ap_h9) v(an_h9) v(up_o0) v(un_o0) v(up_o1) v(un_o1) v(up_o2) v(un_o2)
alter Vtp0 0.4
alter Vtn0 0.6
alter Vtp1 0.6
alter Vtn1 0.4
alter Vtp2 0.4
alter Vtn2 0.6
alter Rbp0 200000.0
alter Rbp1 200000.0
alter Rbp2 200000.0
alter Rbn0 200000.0
alter Rbn1 200000.0
alter Rbn2 200000.0
op
wrdata mn1.dat v(ap_h0) v(an_h0) v(ap_h1) v(an_h1) v(ap_h2) v(an_h2) v(ap_h3) v(an_h3) v(ap_h4) v(an_h4) v(ap_h5) v(an_h5) v(ap_h6) v(an_h6) v(ap_h7) v(an_h7) v(ap_h8) v(an_h8) v(ap_h9) v(an_h9) v(up_o0) v(un_o0) v(up_o1) v(un_o1) v(up_o2) v(un_o2)
alter Vaxp0 0.2
alter Vaxn0 0.8
alter Vaxp1 0.2
alter Vaxn1 0.8
alter Vaxp2 0.8
alter Vaxn2 0.2
alter Vaxp3 0.2
alter Vaxn3 0.8
alter Rbp0 1e10
alter Rbp1 1e10
alter Rbp2 1e10
alter Rbn0 1e10
alter Rbn1 1e10
alter Rbn2 1e10
op
wrdata mf2.dat v(ap_h0) v(an_h0) v(ap_h1) v(an_h1) v(ap_h2) v(an_h2) v(ap_h3) v(an_h3) v(ap_h4) v(an_h4) v(ap_h5) v(an_h5) v(ap_h6) v(an_h6) v(ap_h7) v(an_h7) v(ap_h8) v(an_h8) v(ap_h9) v(an_h9) v(up_o0) v(un_o0) v(up_o1) v(un_o1) v(up_o2) v(un_o2)
alter Vtp0 0.4
alter Vtn0 0.6
alter Vtp1 0.6
alter Vtn1 0.4
alter Vtp2 0.4
alter Vtn2 0.6
alter Rbp0 200000.0
alter Rbp1 200000.0
alter Rbp2 200000.0
alter Rbn0 200000.0
alter Rbn1 200000.0
alter Rbn2 200000.0
op
wrdata mn2.dat v(ap_h0) v(an_h0) v(ap_h1) v(an_h1) v(ap_h2) v(an_h2) v(ap_h3) v(an_h3) v(ap_h4) v(an_h4) v(ap_h5) v(an_h5) v(ap_h6) v(an_h6) v(ap_h7) v(an_h7) v(ap_h8) v(an_h8) v(ap_h9) v(an_h9) v(up_o0) v(un_o0) v(up_o1) v(un_o1) v(up_o2) v(un_o2)
alter Vaxp0 0.2
alter Vaxn0 0.8
alter Vaxp1 0.2
alter Vaxn1 0.8
alter Vaxp2 0.8
alter Vaxn2 0.2
alter Vaxp3 0.8
alter Vaxn3 0.2
alter Rbp0 1e10
alter Rbp1 1e10
alter Rbp2 1e10
alter Rbn0 1e10
alter Rbn1 1e10
alter Rbn2 1e10
op
wrdata mf3.dat v(ap_h0) v(an_h0) v(ap_h1) v(an_h1) v(ap_h2) v(an_h2) v(ap_h3) v(an_h3) v(ap_h4) v(an_h4) v(ap_h5) v(an_h5) v(ap_h6) v(an_h6) v(ap_h7) v(an_h7) v(ap_h8) v(an_h8) v(ap_h9) v(an_h9) v(up_o0) v(un_o0) v(up_o1) v(un_o1) v(up_o2) v(un_o2)
alter Vtp0 0.4
alter Vtn0 0.6
alter Vtp1 0.4
alter Vtn1 0.6
alter Vtp2 0.6
alter Vtn2 0.4
alter Rbp0 200000.0
alter Rbp1 200000.0
alter Rbp2 200000.0
alter Rbn0 200000.0
alter Rbn1 200000.0
alter Rbn2 200000.0
op
wrdata mn3.dat v(ap_h0) v(an_h0) v(ap_h1) v(an_h1) v(ap_h2) v(an_h2) v(ap_h3) v(an_h3) v(ap_h4) v(an_h4) v(ap_h5) v(an_h5) v(ap_h6) v(an_h6) v(ap_h7) v(an_h7) v(ap_h8) v(an_h8) v(ap_h9) v(an_h9) v(up_o0) v(un_o0) v(up_o1) v(un_o1) v(up_o2) v(un_o2)
alter Vaxp0 0.2
alter Vaxn0 0.8
alter Vaxp1 0.8
alter Vaxn1 0.2
alter Vaxp2 0.2
alter Vaxn2 0.8
alter Vaxp3 0.2
alter Vaxn3 0.8
alter Rbp0 1e10
alter Rbp1 1e10
alter Rbp2 1e10
alter Rbn0 1e10
alter Rbn1 1e10
alter Rbn2 1e10
op
wrdata mf4.dat v(ap_h0) v(an_h0) v(ap_h1) v(an_h1) v(ap_h2) v(an_h2) v(ap_h3) v(an_h3) v(ap_h4) v(an_h4) v(ap_h5) v(an_h5) v(ap_h6) v(an_h6) v(ap_h7) v(an_h7) v(ap_h8) v(an_h8) v(ap_h9) v(an_h9) v(up_o0) v(un_o0) v(up_o1) v(un_o1) v(up_o2) v(un_o2)
alter Vtp0 0.4
alter Vtn0 0.6
alter Vtp1 0.6
alter Vtn1 0.4
alter Vtp2 0.4
alter Vtn2 0.6
alter Rbp0 200000.0
alter Rbp1 200000.0
alter Rbp2 200000.0
alter Rbn0 200000.0
alter Rbn1 200000.0
alter Rbn2 200000.0
op
wrdata mn4.dat v(ap_h0) v(an_h0) v(ap_h1) v(an_h1) v(ap_h2) v(an_h2) v(ap_h3) v(an_h3) v(ap_h4) v(an_h4) v(ap_h5) v(an_h5) v(ap_h6) v(an_h6) v(ap_h7) v(an_h7) v(ap_h8) v(an_h8) v(ap_h9) v(an_h9) v(up_o0) v(un_o0) v(up_o1) v(un_o1) v(up_o2) v(un_o2)
alter Vaxp0 0.2
alter Vaxn0 0.8
alter Vaxp1 0.8
alter Vaxn1 0.2
alter Vaxp2 0.2
alter Vaxn2 0.8
alter Vaxp3 0.8
alter Vaxn3 0.2
alter Rbp0 1e10
alter Rbp1 1e10
alter Rbp2 1e10
alter Rbn0 1e10
alter Rbn1 1e10
alter Rbn2 1e10
op
wrdata mf5.dat v(ap_h0) v(an_h0) v(ap_h1) v(an_h1) v(ap_h2) v(an_h2) v(ap_h3) v(an_h3) v(ap_h4) v(an_h4) v(ap_h5) v(an_h5) v(ap_h6) v(an_h6) v(ap_h7) v(an_h7) v(ap_h8) v(an_h8) v(ap_h9) v(an_h9) v(up_o0) v(un_o0) v(up_o1) v(un_o1) v(up_o2) v(un_o2)
alter Vtp0 0.4
alter Vtn0 0.6
alter Vtp1 0.4
alter Vtn1 0.6
alter Vtp2 0.6
alter Vtn2 0.4
alter Rbp0 200000.0
alter Rbp1 200000.0
alter Rbp2 200000.0
alter Rbn0 200000.0
alter Rbn1 200000.0
alter Rbn2 200000.0
op
wrdata mn5.dat v(ap_h0) v(an_h0) v(ap_h1) v(an_h1) v(ap_h2) v(an_h2) v(ap_h3) v(an_h3) v(ap_h4) v(an_h4) v(ap_h5) v(an_h5) v(ap_h6) v(an_h6) v(ap_h7) v(an_h7) v(ap_h8) v(an_h8) v(ap_h9) v(an_h9) v(up_o0) v(un_o0) v(up_o1) v(un_o1) v(up_o2) v(un_o2)
alter Vaxp0 0.2
alter Vaxn0 0.8
alter Vaxp1 0.8
alter Vaxn1 0.2
alter Vaxp2 0.8
alter Vaxn2 0.2
alter Vaxp3 0.2
alter Vaxn3 0.8
alter Rbp0 1e10
alter Rbp1 1e10
alter Rbp2 1e10
alter Rbn0 1e10
alter Rbn1 1e10
alter Rbn2 1e10
op
wrdata mf6.dat v(ap_h0) v(an_h0) v(ap_h1) v(an_h1) v(ap_h2) v(an_h2) v(ap_h3) v(an_h3) v(ap_h4) v(an_h4) v(ap_h5) v(an_h5) v(ap_h6) v(an_h6) v(ap_h7) v(an_h7) v(ap_h8) v(an_h8) v(ap_h9) v(an_h9) v(up_o0) v(un_o0) v(up_o1) v(un_o1) v(up_o2) v(un_o2)
alter Vtp0 0.4
alter Vtn0 0.6
alter Vtp1 0.4
alter Vtn1 0.6
alter Vtp2 0.6
alter Vtn2 0.4
alter Rbp0 200000.0
alter Rbp1 200000.0
alter Rbp2 200000.0
alter Rbn0 200000.0
alter Rbn1 200000.0
alter Rbn2 200000.0
op
wrdata mn6.dat v(ap_h0) v(an_h0) v(ap_h1) v(an_h1) v(ap_h2) v(an_h2) v(ap_h3) v(an_h3) v(ap_h4) v(an_h4) v(ap_h5) v(an_h5) v(ap_h6) v(an_h6) v(ap_h7) v(an_h7) v(ap_h8) v(an_h8) v(ap_h9) v(an_h9) v(up_o0) v(un_o0) v(up_o1) v(un_o1) v(up_o2) v(un_o2)
alter Vaxp0 0.2
alter Vaxn0 0.8
alter Vaxp1 0.8
alter Vaxn1 0.2
alter Vaxp2 0.8
alter Vaxn2 0.2
alter Vaxp3 0.8
alter Vaxn3 0.2
alter Rbp0 1e10
alter Rbp1 1e10
alter Rbp2 1e10
alter Rbn0 1e10
alter Rbn1 1e10
alter Rbn2 1e10
op
wrdata mf7.dat v(ap_h0) v(an_h0) v(ap_h1) v(an_h1) v(ap_h2) v(an_h2) v(ap_h3) v(an_h3) v(ap_h4) v(an_h4) v(ap_h5) v(an_h5) v(ap_h6) v(an_h6) v(ap_h7) v(an_h7) v(ap_h8) v(an_h8) v(ap_h9) v(an_h9) v(up_o0) v(un_o0) v(up_o1) v(un_o1) v(up_o2) v(un_o2)
alter Vtp0 0.6
alter Vtn0 0.4
alter Vtp1 0.4
alter Vtn1 0.6
alter Vtp2 0.4
alter Vtn2 0.6
alter Rbp0 200000.0
alter Rbp1 200000.0
alter Rbp2 200000.0
alter Rbn0 200000.0
alter Rbn1 200000.0
alter Rbn2 200000.0
op
wrdata mn7.dat v(ap_h0) v(an_h0) v(ap_h1) v(an_h1) v(ap_h2) v(an_h2) v(ap_h3) v(an_h3) v(ap_h4) v(an_h4) v(ap_h5) v(an_h5) v(ap_h6) v(an_h6) v(ap_h7) v(an_h7) v(ap_h8) v(an_h8) v(ap_h9) v(an_h9) v(up_o0) v(un_o0) v(up_o1) v(un_o1) v(up_o2) v(un_o2)
alter Vaxp0 0.8
alter Vaxn0 0.2
alter Vaxp1 0.2
alter Vaxn1 0.8
alter Vaxp2 0.2
alter Vaxn2 0.8
alter Vaxp3 0.2
alter Vaxn3 0.8
alter Rbp0 1e10
alter Rbp1 1e10
alter Rbp2 1e10
alter Rbn0 1e10
alter Rbn1 1e10
alter Rbn2 1e10
op
wrdata mf8.dat v(ap_h0) v(an_h0) v(ap_h1) v(an_h1) v(ap_h2) v(an_h2) v(ap_h3) v(an_h3) v(ap_h4) v(an_h4) v(ap_h5) v(an_h5) v(ap_h6) v(an_h6) v(ap_h7) v(an_h7) v(ap_h8) v(an_h8) v(ap_h9) v(an_h9) v(up_o0) v(un_o0) v(up_o1) v(un_o1) v(up_o2) v(un_o2)
alter Vtp0 0.4
alter Vtn0 0.6
alter Vtp1 0.6
alter Vtn1 0.4
alter Vtp2 0.4
alter Vtn2 0.6
alter Rbp0 200000.0
alter Rbp1 200000.0
alter Rbp2 200000.0
alter Rbn0 200000.0
alter Rbn1 200000.0
alter Rbn2 200000.0
op
wrdata mn8.dat v(ap_h0) v(an_h0) v(ap_h1) v(an_h1) v(ap_h2) v(an_h2) v(ap_h3) v(an_h3) v(ap_h4) v(an_h4) v(ap_h5) v(an_h5) v(ap_h6) v(an_h6) v(ap_h7) v(an_h7) v(ap_h8) v(an_h8) v(ap_h9) v(an_h9) v(up_o0) v(un_o0) v(up_o1) v(un_o1) v(up_o2) v(un_o2)
alter Vaxp0 0.8
alter Vaxn0 0.2
alter Vaxp1 0.2
alter Vaxn1 0.8
alter Vaxp2 0.2
alter Vaxn2 0.8
alter Vaxp3 0.8
alter Vaxn3 0.2
alter Rbp0 1e10
alter Rbp1 1e10
alter Rbp2 1e10
alter Rbn0 1e10
alter Rbn1 1e10
alter Rbn2 1e10
op
wrdata mf9.dat v(ap_h0) v(an_h0) v(ap_h1) v(an_h1) v(ap_h2) v(an_h2) v(ap_h3) v(an_h3) v(ap_h4) v(an_h4) v(ap_h5) v(an_h5) v(ap_h6) v(an_h6) v(ap_h7) v(an_h7) v(ap_h8) v(an_h8) v(ap_h9) v(an_h9) v(up_o0) v(un_o0) v(up_o1) v(un_o1) v(up_o2) v(un_o2)
alter Vtp0 0.4
alter Vtn0 0.6
alter Vtp1 0.4
alter Vtn1 0.6
alter Vtp2 0.6
alter Vtn2 0.4
alter Rbp0 200000.0
alter Rbp1 200000.0
alter Rbp2 200000.0
alter Rbn0 200000.0
alter Rbn1 200000.0
alter Rbn2 200000.0
op
wrdata mn9.dat v(ap_h0) v(an_h0) v(ap_h1) v(an_h1) v(ap_h2) v(an_h2) v(ap_h3) v(an_h3) v(ap_h4) v(an_h4) v(ap_h5) v(an_h5) v(ap_h6) v(an_h6) v(ap_h7) v(an_h7) v(ap_h8) v(an_h8) v(ap_h9) v(an_h9) v(up_o0) v(un_o0) v(up_o1) v(un_o1) v(up_o2) v(un_o2)
alter Vaxp0 0.8
alter Vaxn0 0.2
alter Vaxp1 0.2
alter Vaxn1 0.8
alter Vaxp2 0.8
alter Vaxn2 0.2
alter Vaxp3 0.2
alter Vaxn3 0.8
alter Rbp0 1e10
alter Rbp1 1e10
alter Rbp2 1e10
alter Rbn0 1e10
alter Rbn1 1e10
alter Rbn2 1e10
op
wrdata mf10.dat v(ap_h0) v(an_h0) v(ap_h1) v(an_h1) v(ap_h2) v(an_h2) v(ap_h3) v(an_h3) v(ap_h4) v(an_h4) v(ap_h5) v(an_h5) v(ap_h6) v(an_h6) v(ap_h7) v(an_h7) v(ap_h8) v(an_h8) v(ap_h9) v(an_h9) v(up_o0) v(un_o0) v(up_o1) v(un_o1) v(up_o2) v(un_o2)
alter Vtp0 0.4
alter Vtn0 0.6
alter Vtp1 0.4
alter Vtn1 0.6
alter Vtp2 0.6
alter Vtn2 0.4
alter Rbp0 200000.0
alter Rbp1 200000.0
alter Rbp2 200000.0
alter Rbn0 200000.0
alter Rbn1 200000.0
alter Rbn2 200000.0
op
wrdata mn10.dat v(ap_h0) v(an_h0) v(ap_h1) v(an_h1) v(ap_h2) v(an_h2) v(ap_h3) v(an_h3) v(ap_h4) v(an_h4) v(ap_h5) v(an_h5) v(ap_h6) v(an_h6) v(ap_h7) v(an_h7) v(ap_h8) v(an_h8) v(ap_h9) v(an_h9) v(up_o0) v(un_o0) v(up_o1) v(un_o1) v(up_o2) v(un_o2)
alter Vaxp0 0.8
alter Vaxn0 0.2
alter Vaxp1 0.2
alter Vaxn1 0.8
alter Vaxp2 0.8
alter Vaxn2 0.2
alter Vaxp3 0.8
alter Vaxn3 0.2
alter Rbp0 1e10
alter Rbp1 1e10
alter Rbp2 1e10
alter Rbn0 1e10
alter Rbn1 1e10
alter Rbn2 1e10
op
wrdata mf11.dat v(ap_h0) v(an_h0) v(ap_h1) v(an_h1) v(ap_h2) v(an_h2) v(ap_h3) v(an_h3) v(ap_h4) v(an_h4) v(ap_h5) v(an_h5) v(ap_h6) v(an_h6) v(ap_h7) v(an_h7) v(ap_h8) v(an_h8) v(ap_h9) v(an_h9) v(up_o0) v(un_o0) v(up_o1) v(un_o1) v(up_o2) v(un_o2)
alter Vtp0 0.6
alter Vtn0 0.4
alter Vtp1 0.4
alter Vtn1 0.6
alter Vtp2 0.4
alter Vtn2 0.6
alter Rbp0 200000.0
alter Rbp1 200000.0
alter Rbp2 200000.0
alter Rbn0 200000.0
alter Rbn1 200000.0
alter Rbn2 200000.0
op
wrdata mn11.dat v(ap_h0) v(an_h0) v(ap_h1) v(an_h1) v(ap_h2) v(an_h2) v(ap_h3) v(an_h3) v(ap_h4) v(an_h4) v(ap_h5) v(an_h5) v(ap_h6) v(an_h6) v(ap_h7) v(an_h7) v(ap_h8) v(an_h8) v(ap_h9) v(an_h9) v(up_o0) v(un_o0) v(up_o1) v(un_o1) v(up_o2) v(un_o2)
alter Vaxp0 0.8
alter Vaxn0 0.2
alter Vaxp1 0.8
alter Vaxn1 0.2
alter Vaxp2 0.2
alter Vaxn2 0.8
alter Vaxp3 0.2
alter Vaxn3 0.8
alter Rbp0 1e10
alter Rbp1 1e10
alter Rbp2 1e10
alter Rbn0 1e10
alter Rbn1 1e10
alter Rbn2 1e10
op
wrdata mf12.dat v(ap_h0) v(an_h0) v(ap_h1) v(an_h1) v(ap_h2) v(an_h2) v(ap_h3) v(an_h3) v(ap_h4) v(an_h4) v(ap_h5) v(an_h5) v(ap_h6) v(an_h6) v(ap_h7) v(an_h7) v(ap_h8) v(an_h8) v(ap_h9) v(an_h9) v(up_o0) v(un_o0) v(up_o1) v(un_o1) v(up_o2) v(un_o2)
alter Vtp0 0.4
alter Vtn0 0.6
alter Vtp1 0.4
alter Vtn1 0.6
alter Vtp2 0.6
alter Vtn2 0.4
alter Rbp0 200000.0
alter Rbp1 200000.0
alter Rbp2 200000.0
alter Rbn0 200000.0
alter Rbn1 200000.0
alter Rbn2 200000.0
op
wrdata mn12.dat v(ap_h0) v(an_h0) v(ap_h1) v(an_h1) v(ap_h2) v(an_h2) v(ap_h3) v(an_h3) v(ap_h4) v(an_h4) v(ap_h5) v(an_h5) v(ap_h6) v(an_h6) v(ap_h7) v(an_h7) v(ap_h8) v(an_h8) v(ap_h9) v(an_h9) v(up_o0) v(un_o0) v(up_o1) v(un_o1) v(up_o2) v(un_o2)
alter Vaxp0 0.8
alter Vaxn0 0.2
alter Vaxp1 0.8
alter Vaxn1 0.2
alter Vaxp2 0.2
alter Vaxn2 0.8
alter Vaxp3 0.8
alter Vaxn3 0.2
alter Rbp0 1e10
alter Rbp1 1e10
alter Rbp2 1e10
alter Rbn0 1e10
alter Rbn1 1e10
alter Rbn2 1e10
op
wrdata mf13.dat v(ap_h0) v(an_h0) v(ap_h1) v(an_h1) v(ap_h2) v(an_h2) v(ap_h3) v(an_h3) v(ap_h4) v(an_h4) v(ap_h5) v(an_h5) v(ap_h6) v(an_h6) v(ap_h7) v(an_h7) v(ap_h8) v(an_h8) v(ap_h9) v(an_h9) v(up_o0) v(un_o0) v(up_o1) v(un_o1) v(up_o2) v(un_o2)
alter Vtp0 0.6
alter Vtn0 0.4
alter Vtp1 0.4
alter Vtn1 0.6
alter Vtp2 0.4
alter Vtn2 0.6
alter Rbp0 200000.0
alter Rbp1 200000.0
alter Rbp2 200000.0
alter Rbn0 200000.0
alter Rbn1 200000.0
alter Rbn2 200000.0
op
wrdata mn13.dat v(ap_h0) v(an_h0) v(ap_h1) v(an_h1) v(ap_h2) v(an_h2) v(ap_h3) v(an_h3) v(ap_h4) v(an_h4) v(ap_h5) v(an_h5) v(ap_h6) v(an_h6) v(ap_h7) v(an_h7) v(ap_h8) v(an_h8) v(ap_h9) v(an_h9) v(up_o0) v(un_o0) v(up_o1) v(un_o1) v(up_o2) v(un_o2)
alter Vaxp0 0.8
alter Vaxn0 0.2
alter Vaxp1 0.8
alter Vaxn1 0.2
alter Vaxp2 0.8
alter Vaxn2 0.2
alter Vaxp3 0.2
alter Vaxn3 0.8
alter Rbp0 1e10
alter Rbp1 1e10
alter Rbp2 1e10
alter Rbn0 1e10
alter Rbn1 1e10
alter Rbn2 1e10
op
wrdata mf14.dat v(ap_h0) v(an_h0) v(ap_h1) v(an_h1) v(ap_h2) v(an_h2) v(ap_h3) v(an_h3) v(ap_h4) v(an_h4) v(ap_h5) v(an_h5) v(ap_h6) v(an_h6) v(ap_h7) v(an_h7) v(ap_h8) v(an_h8) v(ap_h9) v(an_h9) v(up_o0) v(un_o0) v(up_o1) v(un_o1) v(up_o2) v(un_o2)
alter Vtp0 0.6
alter Vtn0 0.4
alter Vtp1 0.4
alter Vtn1 0.6
alter Vtp2 0.4
alter Vtn2 0.6
alter Rbp0 200000.0
alter Rbp1 200000.0
alter Rbp2 200000.0
alter Rbn0 200000.0
alter Rbn1 200000.0
alter Rbn2 200000.0
op
wrdata mn14.dat v(ap_h0) v(an_h0) v(ap_h1) v(an_h1) v(ap_h2) v(an_h2) v(ap_h3) v(an_h3) v(ap_h4) v(an_h4) v(ap_h5) v(an_h5) v(ap_h6) v(an_h6) v(ap_h7) v(an_h7) v(ap_h8) v(an_h8) v(ap_h9) v(an_h9) v(up_o0) v(un_o0) v(up_o1) v(un_o1) v(up_o2) v(un_o2)
alter Vaxp0 0.8
alter Vaxn0 0.2
alter Vaxp1 0.8
alter Vaxn1 0.2
alter Vaxp2 0.8
alter Vaxn2 0.2
alter Vaxp3 0.8
alter Vaxn3 0.2
alter Rbp0 1e10
alter Rbp1 1e10
alter Rbp2 1e10
alter Rbn0 1e10
alter Rbn1 1e10
alter Rbn2 1e10
op
wrdata mf15.dat v(ap_h0) v(an_h0) v(ap_h1) v(an_h1) v(ap_h2) v(an_h2) v(ap_h3) v(an_h3) v(ap_h4) v(an_h4) v(ap_h5) v(an_h5) v(ap_h6) v(an_h6) v(ap_h7) v(an_h7) v(ap_h8) v(an_h8) v(ap_h9) v(an_h9) v(up_o0) v(un_o0) v(up_o1) v(un_o1) v(up_o2) v(un_o2)
alter Vtp0 0.4
alter Vtn0 0.6
alter Vtp1 0.6
alter Vtn1 0.4
alter Vtp2 0.4
alter Vtn2 0.6
alter Rbp0 200000.0
alter Rbp1 200000.0
alter Rbp2 200000.0
alter Rbn0 200000.0
alter Rbn1 200000.0
alter Rbn2 200000.0
op
wrdata mn15.dat v(ap_h0) v(an_h0) v(ap_h1) v(an_h1) v(ap_h2) v(an_h2) v(ap_h3) v(an_h3) v(ap_h4) v(an_h4) v(ap_h5) v(an_h5) v(ap_h6) v(an_h6) v(ap_h7) v(an_h7) v(ap_h8) v(an_h8) v(ap_h9) v(an_h9) v(up_o0) v(un_o0) v(up_o1) v(un_o1) v(up_o2) v(un_o2)
.endc
.end
