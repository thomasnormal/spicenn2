xbar
.model NNR NMOS (LEVEL=1 VTO=0.2 KP=120u LAMBDA=0.02 GAMMA=0 PHI=0.7)
.model PNR PMOS (LEVEL=1 VTO=-0.2 KP=40u LAMBDA=0.02 GAMMA=0 PHI=0.7)
.subckt xsyn vxp vxn wp wn colp coln
M1 colp wp vxp 0 NNR W=200u L=100u
M2 colp wn vxn 0 NNR W=200u L=100u
M3 coln wp vxn 0 NNR W=200u L=100u
M4 coln wn vxp 0 NNR W=200u L=100u
.ends
.subckt cmld p n vdd
Rcs1 p cmx 300k
Rcs2 n cmx 300k
MLp p cmx vdd vdd PNR W=1000u L=100u
MLn n cmx vdd vdd PNR W=1000u L=100u
.ends
.subckt dneuron up un ap an vdd vbn
M1 an up tn 0 NNR W=200u L=100u
M2 ap un tn 0 NNR W=200u L=100u
Mt tn vbn 0 0 NNR W=200u L=100u
Xcm ap an vdd cmld
.ends
Vdd vdd 0 1.0
Vbneu vbneu 0 0.35
Vref vref 0 0.5
Vxp0 a_xp0 0 0.5
Vxn0 a_xn0 0 0.5
Vxp1 a_xp1 0 0.5
Vxn1 a_xn1 0 0.5
Vxp2 a_xp2 0 0.5
Vxn2 a_xn2 0 0.5
Vxp3 a_xp3 0 0.5
Vxn3 a_xn3 0 0.5
Vxp4 a_xp4 0 0.5
Vxn4 a_xn4 0 0.5
Vxp5 a_xp5 0 0.5
Vxn5 a_xn5 0 0.5
Vxp6 a_xp6 0 0.5
Vxn6 a_xn6 0 0.5
Vxp7 a_xp7 0 0.5
Vxn7 a_xn7 0 0.5
Vxp8 a_xp8 0 0.5
Vxn8 a_xn8 0 0.5
Vxp9 a_xp9 0 0.5
Vxn9 a_xn9 0 0.5
Vxp10 a_xp10 0 0.5
Vxn10 a_xn10 0 0.5
Vxp11 a_xp11 0 0.5
Vxn11 a_xn11 0 0.5
Vxp12 a_xp12 0 0.5
Vxn12 a_xn12 0 0.5
Vxp13 a_xp13 0 0.5
Vxn13 a_xn13 0 0.5
Vxp14 a_xp14 0 0.5
Vxn14 a_xn14 0 0.5
Vxp15 a_xp15 0 0.5
Vxn15 a_xn15 0 0.5
Vwp_ih_0_0 wp_ih_0_0 0 0.7671639354487032
Vwn_ih_0_0 wn_ih_0_0 0 0.8328360645512969
Vwp_ih_1_0 wp_ih_1_0 0 0.7594166791869195
Vwn_ih_1_0 wn_ih_1_0 0 0.8405833208130806
Vwp_ih_2_0 wp_ih_2_0 0 0.7478560387514338
Vwn_ih_2_0 wn_ih_2_0 0 0.8521439612485663
Vwp_ih_3_0 wp_ih_3_0 0 0.7889847469929806
Vwn_ih_3_0 wn_ih_3_0 0 0.8110152530070195
Vwp_ih_4_0 wp_ih_4_0 0 0.8160008318216592
Vwn_ih_4_0 wn_ih_4_0 0 0.7839991681783409
Vwp_ih_5_0 wp_ih_5_0 0 0.8192487515167844
Vwn_ih_5_0 wn_ih_5_0 0 0.7807512484832156
Vwp_ih_6_0 wp_ih_6_0 0 0.8218259161494018
Vwn_ih_6_0 wn_ih_6_0 0 0.7781740838505983
Vwp_ih_7_0 wp_ih_7_0 0 0.7880125257939298
Vwn_ih_7_0 wn_ih_7_0 0 0.8119874742060703
Vwp_ih_8_0 wp_ih_8_0 0 0.8045740657786662
Vwn_ih_8_0 wn_ih_8_0 0 0.7954259342213339
Vwp_ih_9_0 wp_ih_9_0 0 0.8646000613159017
Vwn_ih_9_0 wn_ih_9_0 0 0.7353999386840984
Vwp_ih_10_0 wp_ih_10_0 0 0.7781906169077911
Vwn_ih_10_0 wn_ih_10_0 0 0.821809383092209
Vwp_ih_11_0 wp_ih_11_0 0 0.7462249179865053
Vwn_ih_11_0 wn_ih_11_0 0 0.8537750820134948
Vwp_ih_12_0 wp_ih_12_0 0 0.8018386025543673
Vwn_ih_12_0 wn_ih_12_0 0 0.7981613974456327
Vwp_ih_13_0 wp_ih_13_0 0 0.8176768857810137
Vwn_ih_13_0 wn_ih_13_0 0 0.7823231142189864
Vwp_ih_14_0 wp_ih_14_0 0 0.7460381974974795
Vwn_ih_14_0 wn_ih_14_0 0 0.8539618025025206
Vwp_ih_15_0 wp_ih_15_0 0 0.8052248069512721
Vwn_ih_15_0 wn_ih_15_0 0 0.794775193048728
Vwp_ho_0_0 wp_ho_0_0 0 0.7565032024559228
Vwn_ho_0_0 wn_ho_0_0 0 0.8434967975440772
Vwp_ho_0_1 wp_ho_0_1 0 0.7667025843870001
Vwn_ho_0_1 wn_ho_0_1 0 0.833297415613
Vwp_ho_0_2 wp_ho_0_2 0 0.8347485321136549
Vwn_ho_0_2 wn_ho_0_2 0 0.7652514678863452
Vwp_ho_0_3 wp_ho_0_3 0 0.7927385127723645
Vwn_ho_0_3 wn_ho_0_3 0 0.8072614872276356
Vwp_ho_0_4 wp_ho_0_4 0 0.8052606376329275
Vwn_ho_0_4 wn_ho_0_4 0 0.7947393623670725
Vwp_ih_0_1 wp_ih_0_1 0 0.7412168433918992
Vwn_ih_0_1 wn_ih_0_1 0 0.8587831566081009
Vwp_ih_1_1 wp_ih_1_1 0 0.8403325259732748
Vwn_ih_1_1 wn_ih_1_1 0 0.7596674740267253
Vwp_ih_2_1 wp_ih_2_1 0 0.8063092084619791
Vwn_ih_2_1 wn_ih_2_1 0 0.793690791538021
Vwp_ih_3_1 wp_ih_3_1 0 0.8444583358722851
Vwn_ih_3_1 wn_ih_3_1 0 0.755541664127715
Vwp_ih_4_1 wp_ih_4_1 0 0.803791719524781
Vwn_ih_4_1 wn_ih_4_1 0 0.7962082804752191
Vwp_ih_5_1 wp_ih_5_1 0 0.7950867622473825
Vwn_ih_5_1 wn_ih_5_1 0 0.8049132377526176
Vwp_ih_6_1 wp_ih_6_1 0 0.7557560611306755
Vwn_ih_6_1 wn_ih_6_1 0 0.8442439388693246
Vwp_ih_7_1 wp_ih_7_1 0 0.7397177026776534
Vwn_ih_7_1 wn_ih_7_1 0 0.8602822973223467
Vwp_ih_8_1 wp_ih_8_1 0 0.7534657522476526
Vwn_ih_8_1 wn_ih_8_1 0 0.8465342477523475
Vwp_ih_9_1 wp_ih_9_1 0 0.7936002704667687
Vwn_ih_9_1 wn_ih_9_1 0 0.8063997295332314
Vwp_ih_10_1 wp_ih_10_1 0 0.7873088599782996
Vwn_ih_10_1 wn_ih_10_1 0 0.8126911400217005
Vwp_ih_11_1 wp_ih_11_1 0 0.8407726550231223
Vwn_ih_11_1 wn_ih_11_1 0 0.7592273449768778
Vwp_ih_12_1 wp_ih_12_1 0 0.8122083353127715
Vwn_ih_12_1 wn_ih_12_1 0 0.7877916646872286
Vwp_ih_13_1 wp_ih_13_1 0 0.8302834685663372
Vwn_ih_13_1 wn_ih_13_1 0 0.7697165314336629
Vwp_ih_14_1 wp_ih_14_1 0 0.7700313107127904
Vwn_ih_14_1 wn_ih_14_1 0 0.8299686892872097
Vwp_ih_15_1 wp_ih_15_1 0 0.8215442039903461
Vwn_ih_15_1 wn_ih_15_1 0 0.778455796009654
Vwp_ho_1_0 wp_ho_1_0 0 0.9
Vwn_ho_1_0 wn_ho_1_0 0 0.7000000000000001
Vwp_ho_1_1 wp_ho_1_1 0 0.803944220329116
Vwn_ho_1_1 wn_ho_1_1 0 0.796055779670884
Vwp_ho_1_2 wp_ho_1_2 0 0.8285213762587038
Vwn_ho_1_2 wn_ho_1_2 0 0.7714786237412963
Vwp_ho_1_3 wp_ho_1_3 0 0.8671199611761603
Vwn_ho_1_3 wn_ho_1_3 0 0.7328800388238398
Vwp_ho_1_4 wp_ho_1_4 0 0.769635532243129
Vwn_ho_1_4 wn_ho_1_4 0 0.8303644677568711
Vwp_ih_0_2 wp_ih_0_2 0 0.7704231493676424
Vwn_ih_0_2 wn_ih_0_2 0 0.8295768506323576
Vwp_ih_1_2 wp_ih_1_2 0 0.781517442510614
Vwn_ih_1_2 wn_ih_1_2 0 0.8184825574893861
Vwp_ih_2_2 wp_ih_2_2 0 0.7771810404034345
Vwn_ih_2_2 wn_ih_2_2 0 0.8228189595965656
Vwp_ih_3_2 wp_ih_3_2 0 0.8130148547415702
Vwn_ih_3_2 wn_ih_3_2 0 0.7869851452584299
Vwp_ih_4_2 wp_ih_4_2 0 0.8162261776020918
Vwn_ih_4_2 wn_ih_4_2 0 0.7837738223979083
Vwp_ih_5_2 wp_ih_5_2 0 0.8338445556842395
Vwn_ih_5_2 wn_ih_5_2 0 0.7661554443157605
Vwp_ih_6_2 wp_ih_6_2 0 0.8211508212425181
Vwn_ih_6_2 wn_ih_6_2 0 0.7788491787574819
Vwp_ih_7_2 wp_ih_7_2 0 0.7979519099209765
Vwn_ih_7_2 wn_ih_7_2 0 0.8020480900790236
Vwp_ih_8_2 wp_ih_8_2 0 0.7826893412259349
Vwn_ih_8_2 wn_ih_8_2 0 0.8173106587740652
Vwp_ih_9_2 wp_ih_9_2 0 0.8303451445456134
Vwn_ih_9_2 wn_ih_9_2 0 0.7696548554543867
Vwp_ih_10_2 wp_ih_10_2 0 0.78384528046408
Vwn_ih_10_2 wn_ih_10_2 0 0.8161547195359201
Vwp_ih_11_2 wp_ih_11_2 0 0.7884128336056411
Vwn_ih_11_2 wn_ih_11_2 0 0.811587166394359
Vwp_ih_12_2 wp_ih_12_2 0 0.8124053147254767
Vwn_ih_12_2 wn_ih_12_2 0 0.7875946852745234
Vwp_ih_13_2 wp_ih_13_2 0 0.8020590465575775
Vwn_ih_13_2 wn_ih_13_2 0 0.7979409534424226
Vwp_ih_14_2 wp_ih_14_2 0 0.7999731185535814
Vwn_ih_14_2 wn_ih_14_2 0 0.8000268814464186
Vwp_ih_15_2 wp_ih_15_2 0 0.8290978979468201
Vwn_ih_15_2 wn_ih_15_2 0 0.77090210205318
Vwp_ho_2_0 wp_ho_2_0 0 0.726725933907545
Vwn_ho_2_0 wn_ho_2_0 0 0.8732740660924551
Vwp_ho_2_1 wp_ho_2_1 0 0.9
Vwn_ho_2_1 wn_ho_2_1 0 0.7000000000000001
Vwp_ho_2_2 wp_ho_2_2 0 0.8441401490977525
Vwn_ho_2_2 wn_ho_2_2 0 0.7558598509022476
Vwp_ho_2_3 wp_ho_2_3 0 0.8012948504327211
Vwn_ho_2_3 wn_ho_2_3 0 0.798705149567279
Vwp_ho_2_4 wp_ho_2_4 0 0.829536557295474
Vwn_ho_2_4 wn_ho_2_4 0 0.770463442704526
Vwp_ih_0_3 wp_ih_0_3 0 0.8647491065417433
Vwn_ih_0_3 wn_ih_0_3 0 0.7352508934582568
Vwp_ih_1_3 wp_ih_1_3 0 0.7938637610999535
Vwn_ih_1_3 wn_ih_1_3 0 0.8061362389000466
Vwp_ih_2_3 wp_ih_2_3 0 0.8607876152442742
Vwn_ih_2_3 wn_ih_2_3 0 0.7392123847557259
Vwp_ih_3_3 wp_ih_3_3 0 0.8164649784394167
Vwn_ih_3_3 wn_ih_3_3 0 0.7835350215605834
Vwp_ih_4_3 wp_ih_4_3 0 0.7923163011849591
Vwn_ih_4_3 wn_ih_4_3 0 0.807683698815041
Vwp_ih_5_3 wp_ih_5_3 0 0.8428928025564076
Vwn_ih_5_3 wn_ih_5_3 0 0.7571071974435925
Vwp_ih_6_3 wp_ih_6_3 0 0.8228549069640202
Vwn_ih_6_3 wn_ih_6_3 0 0.7771450930359799
Vwp_ih_7_3 wp_ih_7_3 0 0.7317831987224275
Vwn_ih_7_3 wn_ih_7_3 0 0.8682168012775726
Vwp_ih_8_3 wp_ih_8_3 0 0.7427347304372272
Vwn_ih_8_3 wn_ih_8_3 0 0.8572652695627729
Vwp_ih_9_3 wp_ih_9_3 0 0.7982598824793167
Vwn_ih_9_3 wn_ih_9_3 0 0.8017401175206834
Vwp_ih_10_3 wp_ih_10_3 0 0.7496061717166725
Vwn_ih_10_3 wn_ih_10_3 0 0.8503938282833275
Vwp_ih_11_3 wp_ih_11_3 0 0.7622212859192596
Vwn_ih_11_3 wn_ih_11_3 0 0.8377787140807404
Vwp_ih_12_3 wp_ih_12_3 0 0.7700368573979189
Vwn_ih_12_3 wn_ih_12_3 0 0.8299631426020811
Vwp_ih_13_3 wp_ih_13_3 0 0.7870883554992314
Vwn_ih_13_3 wn_ih_13_3 0 0.8129116445007687
Vwp_ih_14_3 wp_ih_14_3 0 0.7929419680314705
Vwn_ih_14_3 wn_ih_14_3 0 0.8070580319685295
Vwp_ih_15_3 wp_ih_15_3 0 0.7855567529714935
Vwn_ih_15_3 wn_ih_15_3 0 0.8144432470285066
Vwp_ho_3_0 wp_ho_3_0 0 0.800915918718352
Vwn_ho_3_0 wn_ho_3_0 0 0.7990840812816481
Vwp_ho_3_1 wp_ho_3_1 0 0.8504163897493371
Vwn_ho_3_1 wn_ho_3_1 0 0.749583610250663
Vwp_ho_3_2 wp_ho_3_2 0 0.7469415008381809
Vwn_ho_3_2 wn_ho_3_2 0 0.8530584991618192
Vwp_ho_3_3 wp_ho_3_3 0 0.8468544583629569
Vwn_ho_3_3 wn_ho_3_3 0 0.7531455416370432
Vwp_ho_3_4 wp_ho_3_4 0 0.7759107890249177
Vwn_ho_3_4 wn_ho_3_4 0 0.8240892109750824
Vwp_ih_0_4 wp_ih_0_4 0 0.7961398166081135
Vwn_ih_0_4 wn_ih_0_4 0 0.8038601833918866
Vwp_ih_1_4 wp_ih_1_4 0 0.7966817544738072
Vwn_ih_1_4 wn_ih_1_4 0 0.8033182455261929
Vwp_ih_2_4 wp_ih_2_4 0 0.811505335257086
Vwn_ih_2_4 wn_ih_2_4 0 0.7884946647429141
Vwp_ih_3_4 wp_ih_3_4 0 0.811376792293833
Vwn_ih_3_4 wn_ih_3_4 0 0.7886232077061671
Vwp_ih_4_4 wp_ih_4_4 0 0.7870667661600812
Vwn_ih_4_4 wn_ih_4_4 0 0.8129332338399189
Vwp_ih_5_4 wp_ih_5_4 0 0.7982039379439733
Vwn_ih_5_4 wn_ih_5_4 0 0.8017960620560268
Vwp_ih_6_4 wp_ih_6_4 0 0.8115856365752288
Vwn_ih_6_4 wn_ih_6_4 0 0.7884143634247713
Vwp_ih_7_4 wp_ih_7_4 0 0.8057653272120723
Vwn_ih_7_4 wn_ih_7_4 0 0.7942346727879278
Vwp_ih_8_4 wp_ih_8_4 0 0.815386178933986
Vwn_ih_8_4 wn_ih_8_4 0 0.7846138210660141
Vwp_ih_9_4 wp_ih_9_4 0 0.8205043397104435
Vwn_ih_9_4 wn_ih_9_4 0 0.7794956602895566
Vwp_ih_10_4 wp_ih_10_4 0 0.7801146141371498
Vwn_ih_10_4 wn_ih_10_4 0 0.8198853858628503
Vwp_ih_11_4 wp_ih_11_4 0 0.7838110241067556
Vwn_ih_11_4 wn_ih_11_4 0 0.8161889758932445
Vwp_ih_12_4 wp_ih_12_4 0 0.8056750721884376
Vwn_ih_12_4 wn_ih_12_4 0 0.7943249278115625
Vwp_ih_13_4 wp_ih_13_4 0 0.8128866257332269
Vwn_ih_13_4 wn_ih_13_4 0 0.7871133742667732
Vwp_ih_14_4 wp_ih_14_4 0 0.8316675085618129
Vwn_ih_14_4 wn_ih_14_4 0 0.7683324914381872
Vwp_ih_15_4 wp_ih_15_4 0 0.7989232080930702
Vwn_ih_15_4 wn_ih_15_4 0 0.8010767919069299
Vwp_ho_4_0 wp_ho_4_0 0 0.8124861116040155
Vwn_ho_4_0 wn_ho_4_0 0 0.7875138883959846
Vwp_ho_4_1 wp_ho_4_1 0 0.8228864641791053
Vwn_ho_4_1 wn_ho_4_1 0 0.7771135358208948
Vwp_ho_4_2 wp_ho_4_2 0 0.864405774339986
Vwn_ho_4_2 wn_ho_4_2 0 0.7355942256600141
Vwp_ho_4_3 wp_ho_4_3 0 0.7747897321729047
Vwn_ho_4_3 wn_ho_4_3 0 0.8252102678270954
Vwp_ho_4_4 wp_ho_4_4 0 0.7297402354923208
Vwn_ho_4_4 wn_ho_4_4 0 0.8702597645076793
Vwp_ih_0_5 wp_ih_0_5 0 0.7135464086191712
Vwn_ih_0_5 wn_ih_0_5 0 0.8864535913808289
Vwp_ih_1_5 wp_ih_1_5 0 0.712278490969547
Vwn_ih_1_5 wn_ih_1_5 0 0.8877215090304531
Vwp_ih_2_5 wp_ih_2_5 0 0.8467335475785707
Vwn_ih_2_5 wn_ih_2_5 0 0.7532664524214294
Vwp_ih_3_5 wp_ih_3_5 0 0.795327296814263
Vwn_ih_3_5 wn_ih_3_5 0 0.8046727031857371
Vwp_ih_4_5 wp_ih_4_5 0 0.7802572072880387
Vwn_ih_4_5 wn_ih_4_5 0 0.8197427927119614
Vwp_ih_5_5 wp_ih_5_5 0 0.8630511284924056
Vwn_ih_5_5 wn_ih_5_5 0 0.7369488715075945
Vwp_ih_6_5 wp_ih_6_5 0 0.8353445157089481
Vwn_ih_6_5 wn_ih_6_5 0 0.764655484291052
Vwp_ih_7_5 wp_ih_7_5 0 0.8217246679901974
Vwn_ih_7_5 wn_ih_7_5 0 0.7782753320098027
Vwp_ih_8_5 wp_ih_8_5 0 0.8095425877353684
Vwn_ih_8_5 wn_ih_8_5 0 0.7904574122646317
Vwp_ih_9_5 wp_ih_9_5 0 0.8490346840630006
Vwn_ih_9_5 wn_ih_9_5 0 0.7509653159369994
Vwp_ih_10_5 wp_ih_10_5 0 0.7967094607779052
Vwn_ih_10_5 wn_ih_10_5 0 0.8032905392220949
Vwp_ih_11_5 wp_ih_11_5 0 0.8058631513518327
Vwn_ih_11_5 wn_ih_11_5 0 0.7941368486481674
Vwp_ih_12_5 wp_ih_12_5 0 0.766836722933211
Vwn_ih_12_5 wn_ih_12_5 0 0.833163277066789
Vwp_ih_13_5 wp_ih_13_5 0 0.7881723575683705
Vwn_ih_13_5 wn_ih_13_5 0 0.8118276424316296
Vwp_ih_14_5 wp_ih_14_5 0 0.7327574584737045
Vwn_ih_14_5 wn_ih_14_5 0 0.8672425415262955
Vwp_ih_15_5 wp_ih_15_5 0 0.7311045107333065
Vwn_ih_15_5 wn_ih_15_5 0 0.8688954892666936
Vwp_ho_5_0 wp_ho_5_0 0 0.7626468111911606
Vwn_ho_5_0 wn_ho_5_0 0 0.8373531888088395
Vwp_ho_5_1 wp_ho_5_1 0 0.7239897147567429
Vwn_ho_5_1 wn_ho_5_1 0 0.8760102852432572
Vwp_ho_5_2 wp_ho_5_2 0 0.7984789595972901
Vwn_ho_5_2 wn_ho_5_2 0 0.80152104040271
Vwp_ho_5_3 wp_ho_5_3 0 0.7694989967061503
Vwn_ho_5_3 wn_ho_5_3 0 0.8305010032938498
Vwp_ho_5_4 wp_ho_5_4 0 0.7276396589792695
Vwn_ho_5_4 wn_ho_5_4 0 0.8723603410207306
Vwp_ih_0_6 wp_ih_0_6 0 0.8672318992472838
Vwn_ih_0_6 wn_ih_0_6 0 0.7327681007527163
Vwp_ih_1_6 wp_ih_1_6 0 0.8619172814909453
Vwn_ih_1_6 wn_ih_1_6 0 0.7380827185090548
Vwp_ih_2_6 wp_ih_2_6 0 0.8076143269276858
Vwn_ih_2_6 wn_ih_2_6 0 0.7923856730723143
Vwp_ih_3_6 wp_ih_3_6 0 0.8173260461357785
Vwn_ih_3_6 wn_ih_3_6 0 0.7826739538642216
Vwp_ih_4_6 wp_ih_4_6 0 0.8137646010832253
Vwn_ih_4_6 wn_ih_4_6 0 0.7862353989167747
Vwp_ih_5_6 wp_ih_5_6 0 0.7513701895184015
Vwn_ih_5_6 wn_ih_5_6 0 0.8486298104815986
Vwp_ih_6_6 wp_ih_6_6 0 0.7932553230360865
Vwn_ih_6_6 wn_ih_6_6 0 0.8067446769639136
Vwp_ih_7_6 wp_ih_7_6 0 0.7161479695211028
Vwn_ih_7_6 wn_ih_7_6 0 0.8838520304788973
Vwp_ih_8_6 wp_ih_8_6 0 0.7331653439345266
Vwn_ih_8_6 wn_ih_8_6 0 0.8668346560654735
Vwp_ih_9_6 wp_ih_9_6 0 0.7047292399196902
Vwn_ih_9_6 wn_ih_9_6 0 0.8952707600803099
Vwp_ih_10_6 wp_ih_10_6 0 0.826533973038089
Vwn_ih_10_6 wn_ih_10_6 0 0.7734660269619111
Vwp_ih_11_6 wp_ih_11_6 0 0.8468138923353603
Vwn_ih_11_6 wn_ih_11_6 0 0.7531861076646398
Vwp_ih_12_6 wp_ih_12_6 0 0.8154780274157069
Vwn_ih_12_6 wn_ih_12_6 0 0.7845219725842932
Vwp_ih_13_6 wp_ih_13_6 0 0.8265092193121336
Vwn_ih_13_6 wn_ih_13_6 0 0.7734907806878665
Vwp_ih_14_6 wp_ih_14_6 0 0.8576860102064027
Vwn_ih_14_6 wn_ih_14_6 0 0.7423139897935974
Vwp_ih_15_6 wp_ih_15_6 0 0.868677667936332
Vwn_ih_15_6 wn_ih_15_6 0 0.731322332063668
Vwp_ho_6_0 wp_ho_6_0 0 0.7709912751343534
Vwn_ho_6_0 wn_ho_6_0 0 0.8290087248656467
Vwp_ho_6_1 wp_ho_6_1 0 0.740388841159756
Vwn_ho_6_1 wn_ho_6_1 0 0.8596111588402441
Vwp_ho_6_2 wp_ho_6_2 0 0.7962158210491388
Vwn_ho_6_2 wn_ho_6_2 0 0.8037841789508613
Vwp_ho_6_3 wp_ho_6_3 0 0.8567503199125538
Vwn_ho_6_3 wn_ho_6_3 0 0.7432496800874463
Vwp_ho_6_4 wp_ho_6_4 0 0.7983621331403911
Vwn_ho_6_4 wn_ho_6_4 0 0.801637866859609
Vwp_ih_0_7 wp_ih_0_7 0 0.7978456993014768
Vwn_ih_0_7 wn_ih_0_7 0 0.8021543006985233
Vwp_ih_1_7 wp_ih_1_7 0 0.7843160059543636
Vwn_ih_1_7 wn_ih_1_7 0 0.8156839940456365
Vwp_ih_2_7 wp_ih_2_7 0 0.7465254110516787
Vwn_ih_2_7 wn_ih_2_7 0 0.8534745889483214
Vwp_ih_3_7 wp_ih_3_7 0 0.7824328688760699
Vwn_ih_3_7 wn_ih_3_7 0 0.8175671311239302
Vwp_ih_4_7 wp_ih_4_7 0 0.8482666388307762
Vwn_ih_4_7 wn_ih_4_7 0 0.7517333611692238
Vwp_ih_5_7 wp_ih_5_7 0 0.8153496966681567
Vwn_ih_5_7 wn_ih_5_7 0 0.7846503033318434
Vwp_ih_6_7 wp_ih_6_7 0 0.7777767072444525
Vwn_ih_6_7 wn_ih_6_7 0 0.8222232927555476
Vwp_ih_7_7 wp_ih_7_7 0 0.8510319737577977
Vwn_ih_7_7 wn_ih_7_7 0 0.7489680262422024
Vwp_ih_8_7 wp_ih_8_7 0 0.8491149079456174
Vwn_ih_8_7 wn_ih_8_7 0 0.7508850920543827
Vwp_ih_9_7 wp_ih_9_7 0 0.8082274622959199
Vwn_ih_9_7 wn_ih_9_7 0 0.7917725377040802
Vwp_ih_10_7 wp_ih_10_7 0 0.8017929476856345
Vwn_ih_10_7 wn_ih_10_7 0 0.7982070523143656
Vwp_ih_11_7 wp_ih_11_7 0 0.772843705014152
Vwn_ih_11_7 wn_ih_11_7 0 0.8271562949858481
Vwp_ih_12_7 wp_ih_12_7 0 0.7929696913363933
Vwn_ih_12_7 wn_ih_12_7 0 0.8070303086636068
Vwp_ih_13_7 wp_ih_13_7 0 0.7987527564732402
Vwn_ih_13_7 wn_ih_13_7 0 0.8012472435267599
Vwp_ih_14_7 wp_ih_14_7 0 0.8339297301983454
Vwn_ih_14_7 wn_ih_14_7 0 0.7660702698016547
Vwp_ih_15_7 wp_ih_15_7 0 0.8268770449140128
Vwn_ih_15_7 wn_ih_15_7 0 0.7731229550859873
Vwp_ho_7_0 wp_ho_7_0 0 0.7563229389372971
Vwn_ho_7_0 wn_ho_7_0 0 0.843677061062703
Vwp_ho_7_1 wp_ho_7_1 0 0.7166646672139985
Vwn_ho_7_1 wn_ho_7_1 0 0.8833353327860016
Vwp_ho_7_2 wp_ho_7_2 0 0.867409556061886
Vwn_ho_7_2 wn_ho_7_2 0 0.7325904439381141
Vwp_ho_7_3 wp_ho_7_3 0 0.8109937848994399
Vwn_ho_7_3 wn_ho_7_3 0 0.7890062151005602
Vwp_ho_7_4 wp_ho_7_4 0 0.7985784937588899
Vwn_ho_7_4 wn_ho_7_4 0 0.8014215062411102
Vwp_ih_0_8 wp_ih_0_8 0 0.8163258147813176
Vwn_ih_0_8 wn_ih_0_8 0 0.7836741852186825
Vwp_ih_1_8 wp_ih_1_8 0 0.8023615884470707
Vwn_ih_1_8 wn_ih_1_8 0 0.7976384115529294
Vwp_ih_2_8 wp_ih_2_8 0 0.7605700991714759
Vwn_ih_2_8 wn_ih_2_8 0 0.8394299008285242
Vwp_ih_3_8 wp_ih_3_8 0 0.8117262353213561
Vwn_ih_3_8 wn_ih_3_8 0 0.788273764678644
Vwp_ih_4_8 wp_ih_4_8 0 0.8108023755190554
Vwn_ih_4_8 wn_ih_4_8 0 0.7891976244809447
Vwp_ih_5_8 wp_ih_5_8 0 0.8192779588944933
Vwn_ih_5_8 wn_ih_5_8 0 0.7807220411055068
Vwp_ih_6_8 wp_ih_6_8 0 0.7675713163698594
Vwn_ih_6_8 wn_ih_6_8 0 0.8324286836301407
Vwp_ih_7_8 wp_ih_7_8 0 0.788749062777462
Vwn_ih_7_8 wn_ih_7_8 0 0.811250937222538
Vwp_ih_8_8 wp_ih_8_8 0 0.7936406449955934
Vwn_ih_8_8 wn_ih_8_8 0 0.8063593550044067
Vwp_ih_9_8 wp_ih_9_8 0 0.7430827718272279
Vwn_ih_9_8 wn_ih_9_8 0 0.8569172281727722
Vwp_ih_10_8 wp_ih_10_8 0 0.7993602657794749
Vwn_ih_10_8 wn_ih_10_8 0 0.8006397342205251
Vwp_ih_11_8 wp_ih_11_8 0 0.8175896505960252
Vwn_ih_11_8 wn_ih_11_8 0 0.7824103494039749
Vwp_ih_12_8 wp_ih_12_8 0 0.8016473941917392
Vwn_ih_12_8 wn_ih_12_8 0 0.7983526058082608
Vwp_ih_13_8 wp_ih_13_8 0 0.7706416243331975
Vwn_ih_13_8 wn_ih_13_8 0 0.8293583756668026
Vwp_ih_14_8 wp_ih_14_8 0 0.8244559387894759
Vwn_ih_14_8 wn_ih_14_8 0 0.7755440612105242
Vwp_ih_15_8 wp_ih_15_8 0 0.8001514309690924
Vwn_ih_15_8 wn_ih_15_8 0 0.7998485690309077
Vwp_ho_8_0 wp_ho_8_0 0 0.8264756979815634
Vwn_ho_8_0 wn_ho_8_0 0 0.7735243020184367
Vwp_ho_8_1 wp_ho_8_1 0 0.8306283798914292
Vwn_ho_8_1 wn_ho_8_1 0 0.7693716201085709
Vwp_ho_8_2 wp_ho_8_2 0 0.8488549342293956
Vwn_ho_8_2 wn_ho_8_2 0 0.7511450657706045
Vwp_ho_8_3 wp_ho_8_3 0 0.7243012013082549
Vwn_ho_8_3 wn_ho_8_3 0 0.8756987986917452
Vwp_ho_8_4 wp_ho_8_4 0 0.7974556211890433
Vwn_ho_8_4 wn_ho_8_4 0 0.8025443788109567
Vwp_ih_0_9 wp_ih_0_9 0 0.7275742080537166
Vwn_ih_0_9 wn_ih_0_9 0 0.8724257919462834
Vwp_ih_1_9 wp_ih_1_9 0 0.8075863988067897
Vwn_ih_1_9 wn_ih_1_9 0 0.7924136011932104
Vwp_ih_2_9 wp_ih_2_9 0 0.7757556602895975
Vwn_ih_2_9 wn_ih_2_9 0 0.8242443397104026
Vwp_ih_3_9 wp_ih_3_9 0 0.8024265555656701
Vwn_ih_3_9 wn_ih_3_9 0 0.79757344443433
Vwp_ih_4_9 wp_ih_4_9 0 0.7819948000106405
Vwn_ih_4_9 wn_ih_4_9 0 0.8180051999893596
Vwp_ih_5_9 wp_ih_5_9 0 0.8455166300815083
Vwn_ih_5_9 wn_ih_5_9 0 0.7544833699184917
Vwp_ih_6_9 wp_ih_6_9 0 0.7425689102811655
Vwn_ih_6_9 wn_ih_6_9 0 0.8574310897188346
Vwp_ih_7_9 wp_ih_7_9 0 0.8180898598352719
Vwn_ih_7_9 wn_ih_7_9 0 0.7819101401647282
Vwp_ih_8_9 wp_ih_8_9 0 0.8230600471271221
Vwn_ih_8_9 wn_ih_8_9 0 0.776939952872878
Vwp_ih_9_9 wp_ih_9_9 0 0.8360099397253223
Vwn_ih_9_9 wn_ih_9_9 0 0.7639900602746778
Vwp_ih_10_9 wp_ih_10_9 0 0.7920364775675225
Vwn_ih_10_9 wn_ih_10_9 0 0.8079635224324776
Vwp_ih_11_9 wp_ih_11_9 0 0.8508099302040356
Vwn_ih_11_9 wn_ih_11_9 0 0.7491900697959645
Vwp_ih_12_9 wp_ih_12_9 0 0.8112877493681855
Vwn_ih_12_9 wn_ih_12_9 0 0.7887122506318146
Vwp_ih_13_9 wp_ih_13_9 0 0.8137612570173253
Vwn_ih_13_9 wn_ih_13_9 0 0.7862387429826748
Vwp_ih_14_9 wp_ih_14_9 0 0.7633922716482604
Vwn_ih_14_9 wn_ih_14_9 0 0.8366077283517397
Vwp_ih_15_9 wp_ih_15_9 0 0.7763257614668813
Vwn_ih_15_9 wn_ih_15_9 0 0.8236742385331188
Vwp_ho_9_0 wp_ho_9_0 0 0.7467208474665454
Vwn_ho_9_0 wn_ho_9_0 0 0.8532791525334547
Vwp_ho_9_1 wp_ho_9_1 0 0.8066531264067146
Vwn_ho_9_1 wn_ho_9_1 0 0.7933468735932855
Vwp_ho_9_2 wp_ho_9_2 0 0.7083425163745418
Vwn_ho_9_2 wn_ho_9_2 0 0.8916574836254583
Vwp_ho_9_3 wp_ho_9_3 0 0.83511351535651
Vwn_ho_9_3 wn_ho_9_3 0 0.7648864846434901
Vwp_ho_9_4 wp_ho_9_4 0 0.7746862060055781
Vwn_ho_9_4 wn_ho_9_4 0 0.825313793994422
Vwp_ih_0_10 wp_ih_0_10 0 0.8656605690747547
Vwn_ih_0_10 wn_ih_0_10 0 0.7343394309252453
Vwp_ih_1_10 wp_ih_1_10 0 0.7781337459634458
Vwn_ih_1_10 wn_ih_1_10 0 0.8218662540365543
Vwp_ih_2_10 wp_ih_2_10 0 0.8141383756186195
Vwn_ih_2_10 wn_ih_2_10 0 0.7858616243813806
Vwp_ih_3_10 wp_ih_3_10 0 0.7824346381123154
Vwn_ih_3_10 wn_ih_3_10 0 0.8175653618876847
Vwp_ih_4_10 wp_ih_4_10 0 0.8693007286337089
Vwn_ih_4_10 wn_ih_4_10 0 0.7306992713662912
Vwp_ih_5_10 wp_ih_5_10 0 0.8004147836094068
Vwn_ih_5_10 wn_ih_5_10 0 0.7995852163905933
Vwp_ih_6_10 wp_ih_6_10 0 0.8387559539207678
Vwn_ih_6_10 wn_ih_6_10 0 0.7612440460792322
Vwp_ih_7_10 wp_ih_7_10 0 0.8580194749443563
Vwn_ih_7_10 wn_ih_7_10 0 0.7419805250556438
Vwp_ih_8_10 wp_ih_8_10 0 0.8468779963536165
Vwn_ih_8_10 wn_ih_8_10 0 0.7531220036463836
Vwp_ih_9_10 wp_ih_9_10 0 0.7451129715709816
Vwn_ih_9_10 wn_ih_9_10 0 0.8548870284290185
Vwp_ih_10_10 wp_ih_10_10 0 0.8302950159207163
Vwn_ih_10_10 wn_ih_10_10 0 0.7697049840792838
Vwp_ih_11_10 wp_ih_11_10 0 0.8426337335176146
Vwn_ih_11_10 wn_ih_11_10 0 0.7573662664823855
Vwp_ih_12_10 wp_ih_12_10 0 0.8265144508397803
Vwn_ih_12_10 wn_ih_12_10 0 0.7734855491602198
Vwp_ih_13_10 wp_ih_13_10 0 0.7472602385210959
Vwn_ih_13_10 wn_ih_13_10 0 0.8527397614789042
Vwp_ih_14_10 wp_ih_14_10 0 0.8517482562207782
Vwn_ih_14_10 wn_ih_14_10 0 0.7482517437792219
Vwp_ih_15_10 wp_ih_15_10 0 0.7778748086810187
Vwn_ih_15_10 wn_ih_15_10 0 0.8221251913189814
Vwp_ho_10_0 wp_ho_10_0 0 0.8084489326737028
Vwn_ho_10_0 wn_ho_10_0 0 0.7915510673262973
Vwp_ho_10_1 wp_ho_10_1 0 0.7859096478464969
Vwn_ho_10_1 wn_ho_10_1 0 0.8140903521535032
Vwp_ho_10_2 wp_ho_10_2 0 0.8366063876200385
Vwn_ho_10_2 wn_ho_10_2 0 0.7633936123799616
Vwp_ho_10_3 wp_ho_10_3 0 0.8646742234457295
Vwn_ho_10_3 wn_ho_10_3 0 0.7353257765542706
Vwp_ho_10_4 wp_ho_10_4 0 0.8137967622599656
Vwn_ho_10_4 wn_ho_10_4 0 0.7862032377400345
Vwp_ih_0_11 wp_ih_0_11 0 0.7644377687362924
Vwn_ih_0_11 wn_ih_0_11 0 0.8355622312637077
Vwp_ih_1_11 wp_ih_1_11 0 0.753007077661791
Vwn_ih_1_11 wn_ih_1_11 0 0.8469929223382091
Vwp_ih_2_11 wp_ih_2_11 0 0.7305391751893819
Vwn_ih_2_11 wn_ih_2_11 0 0.8694608248106181
Vwp_ih_3_11 wp_ih_3_11 0 0.8041947581663773
Vwn_ih_3_11 wn_ih_3_11 0 0.7958052418336228
Vwp_ih_4_11 wp_ih_4_11 0 0.7749558446195033
Vwn_ih_4_11 wn_ih_4_11 0 0.8250441553804968
Vwp_ih_5_11 wp_ih_5_11 0 0.8215236117743857
Vwn_ih_5_11 wn_ih_5_11 0 0.7784763882256144
Vwp_ih_6_11 wp_ih_6_11 0 0.8347415519760815
Vwn_ih_6_11 wn_ih_6_11 0 0.7652584480239186
Vwp_ih_7_11 wp_ih_7_11 0 0.7838109728411484
Vwn_ih_7_11 wn_ih_7_11 0 0.8161890271588517
Vwp_ih_8_11 wp_ih_8_11 0 0.7605315130230299
Vwn_ih_8_11 wn_ih_8_11 0 0.8394684869769702
Vwp_ih_9_11 wp_ih_9_11 0 0.7893785814764945
Vwn_ih_9_11 wn_ih_9_11 0 0.8106214185235056
Vwp_ih_10_11 wp_ih_10_11 0 0.8836316932716378
Vwn_ih_10_11 wn_ih_10_11 0 0.7163683067283623
Vwp_ih_11_11 wp_ih_11_11 0 0.7561044770571755
Vwn_ih_11_11 wn_ih_11_11 0 0.8438955229428245
Vwp_ih_12_11 wp_ih_12_11 0 0.808499094470798
Vwn_ih_12_11 wn_ih_12_11 0 0.791500905529202
Vwp_ih_13_11 wp_ih_13_11 0 0.7557998032978066
Vwn_ih_13_11 wn_ih_13_11 0 0.8442001967021935
Vwp_ih_14_11 wp_ih_14_11 0 0.8116319636373971
Vwn_ih_14_11 wn_ih_14_11 0 0.788368036362603
Vwp_ih_15_11 wp_ih_15_11 0 0.7814597848124977
Vwn_ih_15_11 wn_ih_15_11 0 0.8185402151875024
Vwp_ho_11_0 wp_ho_11_0 0 0.8265550100583481
Vwn_ho_11_0 wn_ho_11_0 0 0.773444989941652
Vwp_ho_11_1 wp_ho_11_1 0 0.883055215928986
Vwn_ho_11_1 wn_ho_11_1 0 0.7169447840710141
Vwp_ho_11_2 wp_ho_11_2 0 0.7906192625344038
Vwn_ho_11_2 wn_ho_11_2 0 0.8093807374655962
Vwp_ho_11_3 wp_ho_11_3 0 0.8488594012297445
Vwn_ho_11_3 wn_ho_11_3 0 0.7511405987702556
Vwp_ho_11_4 wp_ho_11_4 0 0.8319354914549275
Vwn_ho_11_4 wn_ho_11_4 0 0.7680645085450726
Vwp_ih_0_12 wp_ih_0_12 0 0.7653091276044308
Vwn_ih_0_12 wn_ih_0_12 0 0.8346908723955693
Vwp_ih_1_12 wp_ih_1_12 0 0.7000000000000001
Vwn_ih_1_12 wn_ih_1_12 0 0.9
Vwp_ih_2_12 wp_ih_2_12 0 0.747589357597354
Vwn_ih_2_12 wn_ih_2_12 0 0.8524106424026461
Vwp_ih_3_12 wp_ih_3_12 0 0.7000000000000001
Vwn_ih_3_12 wn_ih_3_12 0 0.9
Vwp_ih_4_12 wp_ih_4_12 0 0.8595056975287141
Vwn_ih_4_12 wn_ih_4_12 0 0.740494302471286
Vwp_ih_5_12 wp_ih_5_12 0 0.9
Vwn_ih_5_12 wn_ih_5_12 0 0.7000000000000001
Vwp_ih_6_12 wp_ih_6_12 0 0.834317394683078
Vwn_ih_6_12 wn_ih_6_12 0 0.7656826053169221
Vwp_ih_7_12 wp_ih_7_12 0 0.9
Vwn_ih_7_12 wn_ih_7_12 0 0.7000000000000001
Vwp_ih_8_12 wp_ih_8_12 0 0.8865583134404389
Vwn_ih_8_12 wn_ih_8_12 0 0.7134416865595612
Vwp_ih_9_12 wp_ih_9_12 0 0.7804940153674776
Vwn_ih_9_12 wn_ih_9_12 0 0.8195059846325224
Vwp_ih_10_12 wp_ih_10_12 0 0.7511810592437967
Vwn_ih_10_12 wn_ih_10_12 0 0.8488189407562033
Vwp_ih_11_12 wp_ih_11_12 0 0.7545073151510997
Vwn_ih_11_12 wn_ih_11_12 0 0.8454926848489004
Vwp_ih_12_12 wp_ih_12_12 0 0.7000000000000001
Vwn_ih_12_12 wn_ih_12_12 0 0.9
Vwp_ih_13_12 wp_ih_13_12 0 0.785344200118119
Vwn_ih_13_12 wn_ih_13_12 0 0.8146557998818811
Vwp_ih_14_12 wp_ih_14_12 0 0.8391925637919827
Vwn_ih_14_12 wn_ih_14_12 0 0.7608074362080174
Vwp_ih_15_12 wp_ih_15_12 0 0.7114182465766135
Vwn_ih_15_12 wn_ih_15_12 0 0.8885817534233866
Vwp_ho_12_0 wp_ho_12_0 0 0.8172659312023837
Vwn_ho_12_0 wn_ho_12_0 0 0.7827340687976164
Vwp_ho_12_1 wp_ho_12_1 0 0.800580534270836
Vwn_ho_12_1 wn_ho_12_1 0 0.7994194657291641
Vwp_ho_12_2 wp_ho_12_2 0 0.7038906951241646
Vwn_ho_12_2 wn_ho_12_2 0 0.8961093048758355
Vwp_ho_12_3 wp_ho_12_3 0 0.7675022276250139
Vwn_ho_12_3 wn_ho_12_3 0 0.8324977723749862
Vwp_ho_12_4 wp_ho_12_4 0 0.7137819242550125
Vwn_ho_12_4 wn_ho_12_4 0 0.8862180757449876
Vwp_ih_0_13 wp_ih_0_13 0 0.7554252997968413
Vwn_ih_0_13 wn_ih_0_13 0 0.8445747002031588
Vwp_ih_1_13 wp_ih_1_13 0 0.744292309477002
Vwn_ih_1_13 wn_ih_1_13 0 0.8557076905229981
Vwp_ih_2_13 wp_ih_2_13 0 0.8087629941670544
Vwn_ih_2_13 wn_ih_2_13 0 0.7912370058329457
Vwp_ih_3_13 wp_ih_3_13 0 0.826674850440762
Vwn_ih_3_13 wn_ih_3_13 0 0.773325149559238
Vwp_ih_4_13 wp_ih_4_13 0 0.8833443196634881
Vwn_ih_4_13 wn_ih_4_13 0 0.716655680336512
Vwp_ih_5_13 wp_ih_5_13 0 0.9
Vwn_ih_5_13 wn_ih_5_13 0 0.7000000000000001
Vwp_ih_6_13 wp_ih_6_13 0 0.7128749295679976
Vwn_ih_6_13 wn_ih_6_13 0 0.8871250704320025
Vwp_ih_7_13 wp_ih_7_13 0 0.9
Vwn_ih_7_13 wn_ih_7_13 0 0.7000000000000001
Vwp_ih_8_13 wp_ih_8_13 0 0.8820983078560461
Vwn_ih_8_13 wn_ih_8_13 0 0.7179016921439539
Vwp_ih_9_13 wp_ih_9_13 0 0.7878131866832259
Vwn_ih_9_13 wn_ih_9_13 0 0.8121868133167742
Vwp_ih_10_13 wp_ih_10_13 0 0.7526396974147919
Vwn_ih_10_13 wn_ih_10_13 0 0.8473603025852082
Vwp_ih_11_13 wp_ih_11_13 0 0.8475391619473098
Vwn_ih_11_13 wn_ih_11_13 0 0.7524608380526903
Vwp_ih_12_13 wp_ih_12_13 0 0.8097778988314537
Vwn_ih_12_13 wn_ih_12_13 0 0.7902221011685464
Vwp_ih_13_13 wp_ih_13_13 0 0.7873379482460733
Vwn_ih_13_13 wn_ih_13_13 0 0.8126620517539268
Vwp_ih_14_13 wp_ih_14_13 0 0.8222676398408425
Vwn_ih_14_13 wn_ih_14_13 0 0.7777323601591576
Vwp_ih_15_13 wp_ih_15_13 0 0.7082608413211506
Vwn_ih_15_13 wn_ih_15_13 0 0.8917391586788495
Vwp_ho_13_0 wp_ho_13_0 0 0.8893973210371017
Vwn_ho_13_0 wn_ho_13_0 0 0.7106026789628984
Vwp_ho_13_1 wp_ho_13_1 0 0.8559513588077011
Vwn_ho_13_1 wn_ho_13_1 0 0.744048641192299
Vwp_ho_13_2 wp_ho_13_2 0 0.8636816276176984
Vwn_ho_13_2 wn_ho_13_2 0 0.7363183723823017
Vwp_ho_13_3 wp_ho_13_3 0 0.8759301954302898
Vwn_ho_13_3 wn_ho_13_3 0 0.7240698045697103
Vwp_ho_13_4 wp_ho_13_4 0 0.8780147524976503
Vwn_ho_13_4 wn_ho_13_4 0 0.7219852475023498
Vwp_ih_0_14 wp_ih_0_14 0 0.8326905760102117
Vwn_ih_0_14 wn_ih_0_14 0 0.7673094239897884
Vwp_ih_1_14 wp_ih_1_14 0 0.7782180801296893
Vwn_ih_1_14 wn_ih_1_14 0 0.8217819198703108
Vwp_ih_2_14 wp_ih_2_14 0 0.8454210703562173
Vwn_ih_2_14 wn_ih_2_14 0 0.7545789296437828
Vwp_ih_3_14 wp_ih_3_14 0 0.8058418893490168
Vwn_ih_3_14 wn_ih_3_14 0 0.7941581106509833
Vwp_ih_4_14 wp_ih_4_14 0 0.796906695764179
Vwn_ih_4_14 wn_ih_4_14 0 0.803093304235821
Vwp_ih_5_14 wp_ih_5_14 0 0.7682332272604082
Vwn_ih_5_14 wn_ih_5_14 0 0.8317667727395919
Vwp_ih_6_14 wp_ih_6_14 0 0.7964764321324516
Vwn_ih_6_14 wn_ih_6_14 0 0.8035235678675485
Vwp_ih_7_14 wp_ih_7_14 0 0.7909659044089613
Vwn_ih_7_14 wn_ih_7_14 0 0.8090340955910388
Vwp_ih_8_14 wp_ih_8_14 0 0.7631783581414955
Vwn_ih_8_14 wn_ih_8_14 0 0.8368216418585046
Vwp_ih_9_14 wp_ih_9_14 0 0.750191604565905
Vwn_ih_9_14 wn_ih_9_14 0 0.8498083954340951
Vwp_ih_10_14 wp_ih_10_14 0 0.822536191924137
Vwn_ih_10_14 wn_ih_10_14 0 0.7774638080758631
Vwp_ih_11_14 wp_ih_11_14 0 0.8374768488857297
Vwn_ih_11_14 wn_ih_11_14 0 0.7625231511142704
Vwp_ih_12_14 wp_ih_12_14 0 0.8146678695169268
Vwn_ih_12_14 wn_ih_12_14 0 0.7853321304830733
Vwp_ih_13_14 wp_ih_13_14 0 0.7722761153381236
Vwn_ih_13_14 wn_ih_13_14 0 0.8277238846618765
Vwp_ih_14_14 wp_ih_14_14 0 0.8076697829668249
Vwn_ih_14_14 wn_ih_14_14 0 0.7923302170331752
Vwp_ih_15_14 wp_ih_15_14 0 0.7899725132149955
Vwn_ih_15_14 wn_ih_15_14 0 0.8100274867850046
Vwp_ho_14_0 wp_ho_14_0 0 0.7503889496793317
Vwn_ho_14_0 wn_ho_14_0 0 0.8496110503206684
Vwp_ho_14_1 wp_ho_14_1 0 0.8105531968594433
Vwn_ho_14_1 wn_ho_14_1 0 0.7894468031405568
Vwp_ho_14_2 wp_ho_14_2 0 0.7847631285780036
Vwn_ho_14_2 wn_ho_14_2 0 0.8152368714219965
Vwp_ho_14_3 wp_ho_14_3 0 0.7772753001179173
Vwn_ho_14_3 wn_ho_14_3 0 0.8227246998820827
Vwp_ho_14_4 wp_ho_14_4 0 0.7416804451206142
Vwn_ho_14_4 wn_ho_14_4 0 0.8583195548793859
Vwp_ih_0_15 wp_ih_0_15 0 0.7975674273150414
Vwn_ih_0_15 wn_ih_0_15 0 0.8024325726849587
Vwp_ih_1_15 wp_ih_1_15 0 0.8185350431402787
Vwn_ih_1_15 wn_ih_1_15 0 0.7814649568597214
Vwp_ih_2_15 wp_ih_2_15 0 0.8123311739364192
Vwn_ih_2_15 wn_ih_2_15 0 0.7876688260635809
Vwp_ih_3_15 wp_ih_3_15 0 0.7991293644384853
Vwn_ih_3_15 wn_ih_3_15 0 0.8008706355615148
Vwp_ih_4_15 wp_ih_4_15 0 0.8403465066527918
Vwn_ih_4_15 wn_ih_4_15 0 0.7596534933472083
Vwp_ih_5_15 wp_ih_5_15 0 0.781397986658547
Vwn_ih_5_15 wn_ih_5_15 0 0.8186020133414531
Vwp_ih_6_15 wp_ih_6_15 0 0.8237478322798794
Vwn_ih_6_15 wn_ih_6_15 0 0.7762521677201207
Vwp_ih_7_15 wp_ih_7_15 0 0.8029462549959689
Vwn_ih_7_15 wn_ih_7_15 0 0.7970537450040311
Vwp_ih_8_15 wp_ih_8_15 0 0.7891206601151539
Vwn_ih_8_15 wn_ih_8_15 0 0.8108793398848462
Vwp_ih_9_15 wp_ih_9_15 0 0.8364430654546827
Vwn_ih_9_15 wn_ih_9_15 0 0.7635569345453174
Vwp_ih_10_15 wp_ih_10_15 0 0.7660259984999895
Vwn_ih_10_15 wn_ih_10_15 0 0.8339740015000106
Vwp_ih_11_15 wp_ih_11_15 0 0.7662534283280081
Vwn_ih_11_15 wn_ih_11_15 0 0.833746571671992
Vwp_ih_12_15 wp_ih_12_15 0 0.7904631807328875
Vwn_ih_12_15 wn_ih_12_15 0 0.8095368192671126
Vwp_ih_13_15 wp_ih_13_15 0 0.8229636629997761
Vwn_ih_13_15 wn_ih_13_15 0 0.777036337000224
Vwp_ih_14_15 wp_ih_14_15 0 0.8439999261318107
Vwn_ih_14_15 wn_ih_14_15 0 0.7560000738681893
Vwp_ih_15_15 wp_ih_15_15 0 0.8313887516643755
Vwn_ih_15_15 wn_ih_15_15 0 0.7686112483356246
Vwp_ho_15_0 wp_ho_15_0 0 0.8033459268884785
Vwn_ho_15_0 wn_ho_15_0 0 0.7966540731115216
Vwp_ho_15_1 wp_ho_15_1 0 0.8323336838093918
Vwn_ho_15_1 wn_ho_15_1 0 0.7676663161906083
Vwp_ho_15_2 wp_ho_15_2 0 0.8160969990301287
Vwn_ho_15_2 wn_ho_15_2 0 0.7839030009698714
Vwp_ho_15_3 wp_ho_15_3 0 0.7772289286439475
Vwn_ho_15_3 wn_ho_15_3 0 0.8227710713560525
Vwp_ho_15_4 wp_ho_15_4 0 0.7217545940471805
Vwn_ho_15_4 wn_ho_15_4 0 0.8782454059528196
Vwp_ih_0_16 wp_ih_0_16 0 0.8329225725221698
Vwn_ih_0_16 wn_ih_0_16 0 0.7670774274778303
Vwp_ih_1_16 wp_ih_1_16 0 0.7740216273780455
Vwn_ih_1_16 wn_ih_1_16 0 0.8259783726219546
Vwp_ih_2_16 wp_ih_2_16 0 0.8285328538290795
Vwn_ih_2_16 wn_ih_2_16 0 0.7714671461709206
Vwp_ih_3_16 wp_ih_3_16 0 0.8311765480985397
Vwn_ih_3_16 wn_ih_3_16 0 0.7688234519014604
Vwp_ih_4_16 wp_ih_4_16 0 0.8312459318416353
Vwn_ih_4_16 wn_ih_4_16 0 0.7687540681583648
Vwp_ih_5_16 wp_ih_5_16 0 0.7917051191700858
Vwn_ih_5_16 wn_ih_5_16 0 0.8082948808299143
Vwp_ih_6_16 wp_ih_6_16 0 0.8024728288457385
Vwn_ih_6_16 wn_ih_6_16 0 0.7975271711542616
Vwp_ih_7_16 wp_ih_7_16 0 0.8287418244184347
Vwn_ih_7_16 wn_ih_7_16 0 0.7712581755815654
Vwp_ih_8_16 wp_ih_8_16 0 0.8189840438451499
Vwn_ih_8_16 wn_ih_8_16 0 0.7810159561548502
Vwp_ih_9_16 wp_ih_9_16 0 0.7534697592019787
Vwn_ih_9_16 wn_ih_9_16 0 0.8465302407980214
Vwp_ih_10_16 wp_ih_10_16 0 0.7988742877500897
Vwn_ih_10_16 wn_ih_10_16 0 0.8011257122499104
Vwp_ih_11_16 wp_ih_11_16 0 0.8073416157955651
Vwn_ih_11_16 wn_ih_11_16 0 0.792658384204435
Vwp_ih_12_16 wp_ih_12_16 0 0.774779269139951
Vwn_ih_12_16 wn_ih_12_16 0 0.8252207308600491
Vwp_ih_13_16 wp_ih_13_16 0 0.7940108428293506
Vwn_ih_13_16 wn_ih_13_16 0 0.8059891571706495
Vwp_ih_14_16 wp_ih_14_16 0 0.8384112988305792
Vwn_ih_14_16 wn_ih_14_16 0 0.7615887011694209
Vwp_ih_15_16 wp_ih_15_16 0 0.7933724757378012
Vwn_ih_15_16 wn_ih_15_16 0 0.8066275242621989
Vwp_ho_16_0 wp_ho_16_0 0 0.7920441605011723
Vwn_ho_16_0 wn_ho_16_0 0 0.8079558394988278
Vwp_ho_16_1 wp_ho_16_1 0 0.7766421681109713
Vwn_ho_16_1 wn_ho_16_1 0 0.8233578318890288
Vwp_ho_16_2 wp_ho_16_2 0 0.8243342500665565
Vwn_ho_16_2 wn_ho_16_2 0 0.7756657499334436
Vwp_ho_16_3 wp_ho_16_3 0 0.7893109530698832
Vwn_ho_16_3 wn_ho_16_3 0 0.8106890469301169
Vwp_ho_16_4 wp_ho_16_4 0 0.8407476366085213
Vwn_ho_16_4 wn_ho_16_4 0 0.7592523633914788
Vwp_ih_0_17 wp_ih_0_17 0 0.9
Vwn_ih_0_17 wn_ih_0_17 0 0.7000000000000001
Vwp_ih_1_17 wp_ih_1_17 0 0.786870940975017
Vwn_ih_1_17 wn_ih_1_17 0 0.8131290590249831
Vwp_ih_2_17 wp_ih_2_17 0 0.7187135247973684
Vwn_ih_2_17 wn_ih_2_17 0 0.8812864752026317
Vwp_ih_3_17 wp_ih_3_17 0 0.7873399617635787
Vwn_ih_3_17 wn_ih_3_17 0 0.8126600382364214
Vwp_ih_4_17 wp_ih_4_17 0 0.8450370157535688
Vwn_ih_4_17 wn_ih_4_17 0 0.7549629842464313
Vwp_ih_5_17 wp_ih_5_17 0 0.7793569032090648
Vwn_ih_5_17 wn_ih_5_17 0 0.8206430967909353
Vwp_ih_6_17 wp_ih_6_17 0 0.8080187110894828
Vwn_ih_6_17 wn_ih_6_17 0 0.7919812889105173
Vwp_ih_7_17 wp_ih_7_17 0 0.9
Vwn_ih_7_17 wn_ih_7_17 0 0.7000000000000001
Vwp_ih_8_17 wp_ih_8_17 0 0.9
Vwn_ih_8_17 wn_ih_8_17 0 0.7000000000000001
Vwp_ih_9_17 wp_ih_9_17 0 0.7000000000000001
Vwn_ih_9_17 wn_ih_9_17 0 0.9
Vwp_ih_10_17 wp_ih_10_17 0 0.8889272562644531
Vwn_ih_10_17 wn_ih_10_17 0 0.711072743735547
Vwp_ih_11_17 wp_ih_11_17 0 0.8185718990977766
Vwn_ih_11_17 wn_ih_11_17 0 0.7814281009022235
Vwp_ih_12_17 wp_ih_12_17 0 0.8159912216458158
Vwn_ih_12_17 wn_ih_12_17 0 0.7840087783541843
Vwp_ih_13_17 wp_ih_13_17 0 0.73713599308712
Vwn_ih_13_17 wn_ih_13_17 0 0.8628640069128801
Vwp_ih_14_17 wp_ih_14_17 0 0.9
Vwn_ih_14_17 wn_ih_14_17 0 0.7000000000000001
Vwp_ih_15_17 wp_ih_15_17 0 0.8506371847871737
Vwn_ih_15_17 wn_ih_15_17 0 0.7493628152128264
Vwp_ho_17_0 wp_ho_17_0 0 0.7645899265129011
Vwn_ho_17_0 wn_ho_17_0 0 0.835410073487099
Vwp_ho_17_1 wp_ho_17_1 0 0.7886349455478642
Vwn_ho_17_1 wn_ho_17_1 0 0.8113650544521359
Vwp_ho_17_2 wp_ho_17_2 0 0.7349723522478951
Vwn_ho_17_2 wn_ho_17_2 0 0.865027647752105
Vwp_ho_17_3 wp_ho_17_3 0 0.7953935529755733
Vwn_ho_17_3 wn_ho_17_3 0 0.8046064470244267
Vwp_ho_17_4 wp_ho_17_4 0 0.7723577395808863
Vwn_ho_17_4 wn_ho_17_4 0 0.8276422604191138
Vwp_ih_0_18 wp_ih_0_18 0 0.7804643776476273
Vwn_ih_0_18 wn_ih_0_18 0 0.8195356223523728
Vwp_ih_1_18 wp_ih_1_18 0 0.7815909251429218
Vwn_ih_1_18 wn_ih_1_18 0 0.8184090748570783
Vwp_ih_2_18 wp_ih_2_18 0 0.7706800178248724
Vwn_ih_2_18 wn_ih_2_18 0 0.8293199821751277
Vwp_ih_3_18 wp_ih_3_18 0 0.7877713839305277
Vwn_ih_3_18 wn_ih_3_18 0 0.8122286160694724
Vwp_ih_4_18 wp_ih_4_18 0 0.8745955216272128
Vwn_ih_4_18 wn_ih_4_18 0 0.7254044783727873
Vwp_ih_5_18 wp_ih_5_18 0 0.8164982391821692
Vwn_ih_5_18 wn_ih_5_18 0 0.7835017608178309
Vwp_ih_6_18 wp_ih_6_18 0 0.8257610632642003
Vwn_ih_6_18 wn_ih_6_18 0 0.7742389367357998
Vwp_ih_7_18 wp_ih_7_18 0 0.8356725746738034
Vwn_ih_7_18 wn_ih_7_18 0 0.7643274253261967
Vwp_ih_8_18 wp_ih_8_18 0 0.8308240107257542
Vwn_ih_8_18 wn_ih_8_18 0 0.7691759892742459
Vwp_ih_9_18 wp_ih_9_18 0 0.831053359511616
Vwn_ih_9_18 wn_ih_9_18 0 0.7689466404883841
Vwp_ih_10_18 wp_ih_10_18 0 0.7731451414260239
Vwn_ih_10_18 wn_ih_10_18 0 0.8268548585739762
Vwp_ih_11_18 wp_ih_11_18 0 0.7929511423637416
Vwn_ih_11_18 wn_ih_11_18 0 0.8070488576362584
Vwp_ih_12_18 wp_ih_12_18 0 0.8162331123134244
Vwn_ih_12_18 wn_ih_12_18 0 0.7837668876865757
Vwp_ih_13_18 wp_ih_13_18 0 0.8128726892091461
Vwn_ih_13_18 wn_ih_13_18 0 0.787127310790854
Vwp_ih_14_18 wp_ih_14_18 0 0.8384227711174245
Vwn_ih_14_18 wn_ih_14_18 0 0.7615772288825756
Vwp_ih_15_18 wp_ih_15_18 0 0.8288194946038139
Vwn_ih_15_18 wn_ih_15_18 0 0.7711805053961862
Vwp_ho_18_0 wp_ho_18_0 0 0.8465117391812923
Vwn_ho_18_0 wn_ho_18_0 0 0.7534882608187078
Vwp_ho_18_1 wp_ho_18_1 0 0.809595228984796
Vwn_ho_18_1 wn_ho_18_1 0 0.7904047710152041
Vwp_ho_18_2 wp_ho_18_2 0 0.7479652630410066
Vwn_ho_18_2 wn_ho_18_2 0 0.8520347369589935
Vwp_ho_18_3 wp_ho_18_3 0 0.7032741679620433
Vwn_ho_18_3 wn_ho_18_3 0 0.8967258320379567
Vwp_ho_18_4 wp_ho_18_4 0 0.8155320251815752
Vwn_ho_18_4 wn_ho_18_4 0 0.7844679748184249
Vwp_ih_0_19 wp_ih_0_19 0 0.8219060153676534
Vwn_ih_0_19 wn_ih_0_19 0 0.7780939846323467
Vwp_ih_1_19 wp_ih_1_19 0 0.8071769994964848
Vwn_ih_1_19 wn_ih_1_19 0 0.7928230005035153
Vwp_ih_2_19 wp_ih_2_19 0 0.7878635099173623
Vwn_ih_2_19 wn_ih_2_19 0 0.8121364900826378
Vwp_ih_3_19 wp_ih_3_19 0 0.7967485769476712
Vwn_ih_3_19 wn_ih_3_19 0 0.8032514230523289
Vwp_ih_4_19 wp_ih_4_19 0 0.8158459602299244
Vwn_ih_4_19 wn_ih_4_19 0 0.7841540397700757
Vwp_ih_5_19 wp_ih_5_19 0 0.7832169311131234
Vwn_ih_5_19 wn_ih_5_19 0 0.8167830688868767
Vwp_ih_6_19 wp_ih_6_19 0 0.7816655178753826
Vwn_ih_6_19 wn_ih_6_19 0 0.8183344821246175
Vwp_ih_7_19 wp_ih_7_19 0 0.8059202805722936
Vwn_ih_7_19 wn_ih_7_19 0 0.7940797194277065
Vwp_ih_8_19 wp_ih_8_19 0 0.8128282570051091
Vwn_ih_8_19 wn_ih_8_19 0 0.787171742994891
Vwp_ih_9_19 wp_ih_9_19 0 0.7003676449716716
Vwn_ih_9_19 wn_ih_9_19 0 0.8996323550283285
Vwp_ih_10_19 wp_ih_10_19 0 0.8072539869399118
Vwn_ih_10_19 wn_ih_10_19 0 0.7927460130600883
Vwp_ih_11_19 wp_ih_11_19 0 0.7961909207075569
Vwn_ih_11_19 wn_ih_11_19 0 0.8038090792924432
Vwp_ih_12_19 wp_ih_12_19 0 0.7907935814637594
Vwn_ih_12_19 wn_ih_12_19 0 0.8092064185362406
Vwp_ih_13_19 wp_ih_13_19 0 0.8345706723581875
Vwn_ih_13_19 wn_ih_13_19 0 0.7654293276418126
Vwp_ih_14_19 wp_ih_14_19 0 0.8209378532285107
Vwn_ih_14_19 wn_ih_14_19 0 0.7790621467714894
Vwp_ih_15_19 wp_ih_15_19 0 0.8262259423764118
Vwn_ih_15_19 wn_ih_15_19 0 0.7737740576235883
Vwp_ho_19_0 wp_ho_19_0 0 0.7905169545144474
Vwn_ho_19_0 wn_ho_19_0 0 0.8094830454855527
Vwp_ho_19_1 wp_ho_19_1 0 0.815928815362927
Vwn_ho_19_1 wn_ho_19_1 0 0.784071184637073
Vwp_ho_19_2 wp_ho_19_2 0 0.77923228285731
Vwn_ho_19_2 wn_ho_19_2 0 0.82076771714269
Vwp_ho_19_3 wp_ho_19_3 0 0.8146544579762129
Vwn_ho_19_3 wn_ho_19_3 0 0.7853455420237871
Vwp_ho_19_4 wp_ho_19_4 0 0.7130961922891635
Vwn_ho_19_4 wn_ho_19_4 0 0.8869038077108365
Rtp_h0 hcp0 vref 40k
Rtn_h0 hcn0 vref 40k
X_ihx_0_0 a_xp0 a_xn0 wp_ih_0_0 wn_ih_0_0 hcp0 hcn0 xsyn
X_ihx_1_0 a_xp1 a_xn1 wp_ih_1_0 wn_ih_1_0 hcp0 hcn0 xsyn
X_ihx_2_0 a_xp2 a_xn2 wp_ih_2_0 wn_ih_2_0 hcp0 hcn0 xsyn
X_ihx_3_0 a_xp3 a_xn3 wp_ih_3_0 wn_ih_3_0 hcp0 hcn0 xsyn
X_ihx_4_0 a_xp4 a_xn4 wp_ih_4_0 wn_ih_4_0 hcp0 hcn0 xsyn
X_ihx_5_0 a_xp5 a_xn5 wp_ih_5_0 wn_ih_5_0 hcp0 hcn0 xsyn
X_ihx_6_0 a_xp6 a_xn6 wp_ih_6_0 wn_ih_6_0 hcp0 hcn0 xsyn
X_ihx_7_0 a_xp7 a_xn7 wp_ih_7_0 wn_ih_7_0 hcp0 hcn0 xsyn
X_ihx_8_0 a_xp8 a_xn8 wp_ih_8_0 wn_ih_8_0 hcp0 hcn0 xsyn
X_ihx_9_0 a_xp9 a_xn9 wp_ih_9_0 wn_ih_9_0 hcp0 hcn0 xsyn
X_ihx_10_0 a_xp10 a_xn10 wp_ih_10_0 wn_ih_10_0 hcp0 hcn0 xsyn
X_ihx_11_0 a_xp11 a_xn11 wp_ih_11_0 wn_ih_11_0 hcp0 hcn0 xsyn
X_ihx_12_0 a_xp12 a_xn12 wp_ih_12_0 wn_ih_12_0 hcp0 hcn0 xsyn
X_ihx_13_0 a_xp13 a_xn13 wp_ih_13_0 wn_ih_13_0 hcp0 hcn0 xsyn
X_ihx_14_0 a_xp14 a_xn14 wp_ih_14_0 wn_ih_14_0 hcp0 hcn0 xsyn
X_ihx_15_0 a_xp15 a_xn15 wp_ih_15_0 wn_ih_15_0 hcp0 hcn0 xsyn
Xn0 hcp0 hcn0 ahp0 ahn0 vdd vbneu dneuron
Rtp_h1 hcp1 vref 40k
Rtn_h1 hcn1 vref 40k
X_ihx_0_1 a_xp0 a_xn0 wp_ih_0_1 wn_ih_0_1 hcp1 hcn1 xsyn
X_ihx_1_1 a_xp1 a_xn1 wp_ih_1_1 wn_ih_1_1 hcp1 hcn1 xsyn
X_ihx_2_1 a_xp2 a_xn2 wp_ih_2_1 wn_ih_2_1 hcp1 hcn1 xsyn
X_ihx_3_1 a_xp3 a_xn3 wp_ih_3_1 wn_ih_3_1 hcp1 hcn1 xsyn
X_ihx_4_1 a_xp4 a_xn4 wp_ih_4_1 wn_ih_4_1 hcp1 hcn1 xsyn
X_ihx_5_1 a_xp5 a_xn5 wp_ih_5_1 wn_ih_5_1 hcp1 hcn1 xsyn
X_ihx_6_1 a_xp6 a_xn6 wp_ih_6_1 wn_ih_6_1 hcp1 hcn1 xsyn
X_ihx_7_1 a_xp7 a_xn7 wp_ih_7_1 wn_ih_7_1 hcp1 hcn1 xsyn
X_ihx_8_1 a_xp8 a_xn8 wp_ih_8_1 wn_ih_8_1 hcp1 hcn1 xsyn
X_ihx_9_1 a_xp9 a_xn9 wp_ih_9_1 wn_ih_9_1 hcp1 hcn1 xsyn
X_ihx_10_1 a_xp10 a_xn10 wp_ih_10_1 wn_ih_10_1 hcp1 hcn1 xsyn
X_ihx_11_1 a_xp11 a_xn11 wp_ih_11_1 wn_ih_11_1 hcp1 hcn1 xsyn
X_ihx_12_1 a_xp12 a_xn12 wp_ih_12_1 wn_ih_12_1 hcp1 hcn1 xsyn
X_ihx_13_1 a_xp13 a_xn13 wp_ih_13_1 wn_ih_13_1 hcp1 hcn1 xsyn
X_ihx_14_1 a_xp14 a_xn14 wp_ih_14_1 wn_ih_14_1 hcp1 hcn1 xsyn
X_ihx_15_1 a_xp15 a_xn15 wp_ih_15_1 wn_ih_15_1 hcp1 hcn1 xsyn
Xn1 hcp1 hcn1 ahp1 ahn1 vdd vbneu dneuron
Rtp_h2 hcp2 vref 40k
Rtn_h2 hcn2 vref 40k
X_ihx_0_2 a_xp0 a_xn0 wp_ih_0_2 wn_ih_0_2 hcp2 hcn2 xsyn
X_ihx_1_2 a_xp1 a_xn1 wp_ih_1_2 wn_ih_1_2 hcp2 hcn2 xsyn
X_ihx_2_2 a_xp2 a_xn2 wp_ih_2_2 wn_ih_2_2 hcp2 hcn2 xsyn
X_ihx_3_2 a_xp3 a_xn3 wp_ih_3_2 wn_ih_3_2 hcp2 hcn2 xsyn
X_ihx_4_2 a_xp4 a_xn4 wp_ih_4_2 wn_ih_4_2 hcp2 hcn2 xsyn
X_ihx_5_2 a_xp5 a_xn5 wp_ih_5_2 wn_ih_5_2 hcp2 hcn2 xsyn
X_ihx_6_2 a_xp6 a_xn6 wp_ih_6_2 wn_ih_6_2 hcp2 hcn2 xsyn
X_ihx_7_2 a_xp7 a_xn7 wp_ih_7_2 wn_ih_7_2 hcp2 hcn2 xsyn
X_ihx_8_2 a_xp8 a_xn8 wp_ih_8_2 wn_ih_8_2 hcp2 hcn2 xsyn
X_ihx_9_2 a_xp9 a_xn9 wp_ih_9_2 wn_ih_9_2 hcp2 hcn2 xsyn
X_ihx_10_2 a_xp10 a_xn10 wp_ih_10_2 wn_ih_10_2 hcp2 hcn2 xsyn
X_ihx_11_2 a_xp11 a_xn11 wp_ih_11_2 wn_ih_11_2 hcp2 hcn2 xsyn
X_ihx_12_2 a_xp12 a_xn12 wp_ih_12_2 wn_ih_12_2 hcp2 hcn2 xsyn
X_ihx_13_2 a_xp13 a_xn13 wp_ih_13_2 wn_ih_13_2 hcp2 hcn2 xsyn
X_ihx_14_2 a_xp14 a_xn14 wp_ih_14_2 wn_ih_14_2 hcp2 hcn2 xsyn
X_ihx_15_2 a_xp15 a_xn15 wp_ih_15_2 wn_ih_15_2 hcp2 hcn2 xsyn
Xn2 hcp2 hcn2 ahp2 ahn2 vdd vbneu dneuron
Rtp_h3 hcp3 vref 40k
Rtn_h3 hcn3 vref 40k
X_ihx_0_3 a_xp0 a_xn0 wp_ih_0_3 wn_ih_0_3 hcp3 hcn3 xsyn
X_ihx_1_3 a_xp1 a_xn1 wp_ih_1_3 wn_ih_1_3 hcp3 hcn3 xsyn
X_ihx_2_3 a_xp2 a_xn2 wp_ih_2_3 wn_ih_2_3 hcp3 hcn3 xsyn
X_ihx_3_3 a_xp3 a_xn3 wp_ih_3_3 wn_ih_3_3 hcp3 hcn3 xsyn
X_ihx_4_3 a_xp4 a_xn4 wp_ih_4_3 wn_ih_4_3 hcp3 hcn3 xsyn
X_ihx_5_3 a_xp5 a_xn5 wp_ih_5_3 wn_ih_5_3 hcp3 hcn3 xsyn
X_ihx_6_3 a_xp6 a_xn6 wp_ih_6_3 wn_ih_6_3 hcp3 hcn3 xsyn
X_ihx_7_3 a_xp7 a_xn7 wp_ih_7_3 wn_ih_7_3 hcp3 hcn3 xsyn
X_ihx_8_3 a_xp8 a_xn8 wp_ih_8_3 wn_ih_8_3 hcp3 hcn3 xsyn
X_ihx_9_3 a_xp9 a_xn9 wp_ih_9_3 wn_ih_9_3 hcp3 hcn3 xsyn
X_ihx_10_3 a_xp10 a_xn10 wp_ih_10_3 wn_ih_10_3 hcp3 hcn3 xsyn
X_ihx_11_3 a_xp11 a_xn11 wp_ih_11_3 wn_ih_11_3 hcp3 hcn3 xsyn
X_ihx_12_3 a_xp12 a_xn12 wp_ih_12_3 wn_ih_12_3 hcp3 hcn3 xsyn
X_ihx_13_3 a_xp13 a_xn13 wp_ih_13_3 wn_ih_13_3 hcp3 hcn3 xsyn
X_ihx_14_3 a_xp14 a_xn14 wp_ih_14_3 wn_ih_14_3 hcp3 hcn3 xsyn
X_ihx_15_3 a_xp15 a_xn15 wp_ih_15_3 wn_ih_15_3 hcp3 hcn3 xsyn
Xn3 hcp3 hcn3 ahp3 ahn3 vdd vbneu dneuron
Rtp_h4 hcp4 vref 40k
Rtn_h4 hcn4 vref 40k
X_ihx_0_4 a_xp0 a_xn0 wp_ih_0_4 wn_ih_0_4 hcp4 hcn4 xsyn
X_ihx_1_4 a_xp1 a_xn1 wp_ih_1_4 wn_ih_1_4 hcp4 hcn4 xsyn
X_ihx_2_4 a_xp2 a_xn2 wp_ih_2_4 wn_ih_2_4 hcp4 hcn4 xsyn
X_ihx_3_4 a_xp3 a_xn3 wp_ih_3_4 wn_ih_3_4 hcp4 hcn4 xsyn
X_ihx_4_4 a_xp4 a_xn4 wp_ih_4_4 wn_ih_4_4 hcp4 hcn4 xsyn
X_ihx_5_4 a_xp5 a_xn5 wp_ih_5_4 wn_ih_5_4 hcp4 hcn4 xsyn
X_ihx_6_4 a_xp6 a_xn6 wp_ih_6_4 wn_ih_6_4 hcp4 hcn4 xsyn
X_ihx_7_4 a_xp7 a_xn7 wp_ih_7_4 wn_ih_7_4 hcp4 hcn4 xsyn
X_ihx_8_4 a_xp8 a_xn8 wp_ih_8_4 wn_ih_8_4 hcp4 hcn4 xsyn
X_ihx_9_4 a_xp9 a_xn9 wp_ih_9_4 wn_ih_9_4 hcp4 hcn4 xsyn
X_ihx_10_4 a_xp10 a_xn10 wp_ih_10_4 wn_ih_10_4 hcp4 hcn4 xsyn
X_ihx_11_4 a_xp11 a_xn11 wp_ih_11_4 wn_ih_11_4 hcp4 hcn4 xsyn
X_ihx_12_4 a_xp12 a_xn12 wp_ih_12_4 wn_ih_12_4 hcp4 hcn4 xsyn
X_ihx_13_4 a_xp13 a_xn13 wp_ih_13_4 wn_ih_13_4 hcp4 hcn4 xsyn
X_ihx_14_4 a_xp14 a_xn14 wp_ih_14_4 wn_ih_14_4 hcp4 hcn4 xsyn
X_ihx_15_4 a_xp15 a_xn15 wp_ih_15_4 wn_ih_15_4 hcp4 hcn4 xsyn
Xn4 hcp4 hcn4 ahp4 ahn4 vdd vbneu dneuron
Rtp_h5 hcp5 vref 40k
Rtn_h5 hcn5 vref 40k
X_ihx_0_5 a_xp0 a_xn0 wp_ih_0_5 wn_ih_0_5 hcp5 hcn5 xsyn
X_ihx_1_5 a_xp1 a_xn1 wp_ih_1_5 wn_ih_1_5 hcp5 hcn5 xsyn
X_ihx_2_5 a_xp2 a_xn2 wp_ih_2_5 wn_ih_2_5 hcp5 hcn5 xsyn
X_ihx_3_5 a_xp3 a_xn3 wp_ih_3_5 wn_ih_3_5 hcp5 hcn5 xsyn
X_ihx_4_5 a_xp4 a_xn4 wp_ih_4_5 wn_ih_4_5 hcp5 hcn5 xsyn
X_ihx_5_5 a_xp5 a_xn5 wp_ih_5_5 wn_ih_5_5 hcp5 hcn5 xsyn
X_ihx_6_5 a_xp6 a_xn6 wp_ih_6_5 wn_ih_6_5 hcp5 hcn5 xsyn
X_ihx_7_5 a_xp7 a_xn7 wp_ih_7_5 wn_ih_7_5 hcp5 hcn5 xsyn
X_ihx_8_5 a_xp8 a_xn8 wp_ih_8_5 wn_ih_8_5 hcp5 hcn5 xsyn
X_ihx_9_5 a_xp9 a_xn9 wp_ih_9_5 wn_ih_9_5 hcp5 hcn5 xsyn
X_ihx_10_5 a_xp10 a_xn10 wp_ih_10_5 wn_ih_10_5 hcp5 hcn5 xsyn
X_ihx_11_5 a_xp11 a_xn11 wp_ih_11_5 wn_ih_11_5 hcp5 hcn5 xsyn
X_ihx_12_5 a_xp12 a_xn12 wp_ih_12_5 wn_ih_12_5 hcp5 hcn5 xsyn
X_ihx_13_5 a_xp13 a_xn13 wp_ih_13_5 wn_ih_13_5 hcp5 hcn5 xsyn
X_ihx_14_5 a_xp14 a_xn14 wp_ih_14_5 wn_ih_14_5 hcp5 hcn5 xsyn
X_ihx_15_5 a_xp15 a_xn15 wp_ih_15_5 wn_ih_15_5 hcp5 hcn5 xsyn
Xn5 hcp5 hcn5 ahp5 ahn5 vdd vbneu dneuron
Rtp_h6 hcp6 vref 40k
Rtn_h6 hcn6 vref 40k
X_ihx_0_6 a_xp0 a_xn0 wp_ih_0_6 wn_ih_0_6 hcp6 hcn6 xsyn
X_ihx_1_6 a_xp1 a_xn1 wp_ih_1_6 wn_ih_1_6 hcp6 hcn6 xsyn
X_ihx_2_6 a_xp2 a_xn2 wp_ih_2_6 wn_ih_2_6 hcp6 hcn6 xsyn
X_ihx_3_6 a_xp3 a_xn3 wp_ih_3_6 wn_ih_3_6 hcp6 hcn6 xsyn
X_ihx_4_6 a_xp4 a_xn4 wp_ih_4_6 wn_ih_4_6 hcp6 hcn6 xsyn
X_ihx_5_6 a_xp5 a_xn5 wp_ih_5_6 wn_ih_5_6 hcp6 hcn6 xsyn
X_ihx_6_6 a_xp6 a_xn6 wp_ih_6_6 wn_ih_6_6 hcp6 hcn6 xsyn
X_ihx_7_6 a_xp7 a_xn7 wp_ih_7_6 wn_ih_7_6 hcp6 hcn6 xsyn
X_ihx_8_6 a_xp8 a_xn8 wp_ih_8_6 wn_ih_8_6 hcp6 hcn6 xsyn
X_ihx_9_6 a_xp9 a_xn9 wp_ih_9_6 wn_ih_9_6 hcp6 hcn6 xsyn
X_ihx_10_6 a_xp10 a_xn10 wp_ih_10_6 wn_ih_10_6 hcp6 hcn6 xsyn
X_ihx_11_6 a_xp11 a_xn11 wp_ih_11_6 wn_ih_11_6 hcp6 hcn6 xsyn
X_ihx_12_6 a_xp12 a_xn12 wp_ih_12_6 wn_ih_12_6 hcp6 hcn6 xsyn
X_ihx_13_6 a_xp13 a_xn13 wp_ih_13_6 wn_ih_13_6 hcp6 hcn6 xsyn
X_ihx_14_6 a_xp14 a_xn14 wp_ih_14_6 wn_ih_14_6 hcp6 hcn6 xsyn
X_ihx_15_6 a_xp15 a_xn15 wp_ih_15_6 wn_ih_15_6 hcp6 hcn6 xsyn
Xn6 hcp6 hcn6 ahp6 ahn6 vdd vbneu dneuron
Rtp_h7 hcp7 vref 40k
Rtn_h7 hcn7 vref 40k
X_ihx_0_7 a_xp0 a_xn0 wp_ih_0_7 wn_ih_0_7 hcp7 hcn7 xsyn
X_ihx_1_7 a_xp1 a_xn1 wp_ih_1_7 wn_ih_1_7 hcp7 hcn7 xsyn
X_ihx_2_7 a_xp2 a_xn2 wp_ih_2_7 wn_ih_2_7 hcp7 hcn7 xsyn
X_ihx_3_7 a_xp3 a_xn3 wp_ih_3_7 wn_ih_3_7 hcp7 hcn7 xsyn
X_ihx_4_7 a_xp4 a_xn4 wp_ih_4_7 wn_ih_4_7 hcp7 hcn7 xsyn
X_ihx_5_7 a_xp5 a_xn5 wp_ih_5_7 wn_ih_5_7 hcp7 hcn7 xsyn
X_ihx_6_7 a_xp6 a_xn6 wp_ih_6_7 wn_ih_6_7 hcp7 hcn7 xsyn
X_ihx_7_7 a_xp7 a_xn7 wp_ih_7_7 wn_ih_7_7 hcp7 hcn7 xsyn
X_ihx_8_7 a_xp8 a_xn8 wp_ih_8_7 wn_ih_8_7 hcp7 hcn7 xsyn
X_ihx_9_7 a_xp9 a_xn9 wp_ih_9_7 wn_ih_9_7 hcp7 hcn7 xsyn
X_ihx_10_7 a_xp10 a_xn10 wp_ih_10_7 wn_ih_10_7 hcp7 hcn7 xsyn
X_ihx_11_7 a_xp11 a_xn11 wp_ih_11_7 wn_ih_11_7 hcp7 hcn7 xsyn
X_ihx_12_7 a_xp12 a_xn12 wp_ih_12_7 wn_ih_12_7 hcp7 hcn7 xsyn
X_ihx_13_7 a_xp13 a_xn13 wp_ih_13_7 wn_ih_13_7 hcp7 hcn7 xsyn
X_ihx_14_7 a_xp14 a_xn14 wp_ih_14_7 wn_ih_14_7 hcp7 hcn7 xsyn
X_ihx_15_7 a_xp15 a_xn15 wp_ih_15_7 wn_ih_15_7 hcp7 hcn7 xsyn
Xn7 hcp7 hcn7 ahp7 ahn7 vdd vbneu dneuron
Rtp_h8 hcp8 vref 40k
Rtn_h8 hcn8 vref 40k
X_ihx_0_8 a_xp0 a_xn0 wp_ih_0_8 wn_ih_0_8 hcp8 hcn8 xsyn
X_ihx_1_8 a_xp1 a_xn1 wp_ih_1_8 wn_ih_1_8 hcp8 hcn8 xsyn
X_ihx_2_8 a_xp2 a_xn2 wp_ih_2_8 wn_ih_2_8 hcp8 hcn8 xsyn
X_ihx_3_8 a_xp3 a_xn3 wp_ih_3_8 wn_ih_3_8 hcp8 hcn8 xsyn
X_ihx_4_8 a_xp4 a_xn4 wp_ih_4_8 wn_ih_4_8 hcp8 hcn8 xsyn
X_ihx_5_8 a_xp5 a_xn5 wp_ih_5_8 wn_ih_5_8 hcp8 hcn8 xsyn
X_ihx_6_8 a_xp6 a_xn6 wp_ih_6_8 wn_ih_6_8 hcp8 hcn8 xsyn
X_ihx_7_8 a_xp7 a_xn7 wp_ih_7_8 wn_ih_7_8 hcp8 hcn8 xsyn
X_ihx_8_8 a_xp8 a_xn8 wp_ih_8_8 wn_ih_8_8 hcp8 hcn8 xsyn
X_ihx_9_8 a_xp9 a_xn9 wp_ih_9_8 wn_ih_9_8 hcp8 hcn8 xsyn
X_ihx_10_8 a_xp10 a_xn10 wp_ih_10_8 wn_ih_10_8 hcp8 hcn8 xsyn
X_ihx_11_8 a_xp11 a_xn11 wp_ih_11_8 wn_ih_11_8 hcp8 hcn8 xsyn
X_ihx_12_8 a_xp12 a_xn12 wp_ih_12_8 wn_ih_12_8 hcp8 hcn8 xsyn
X_ihx_13_8 a_xp13 a_xn13 wp_ih_13_8 wn_ih_13_8 hcp8 hcn8 xsyn
X_ihx_14_8 a_xp14 a_xn14 wp_ih_14_8 wn_ih_14_8 hcp8 hcn8 xsyn
X_ihx_15_8 a_xp15 a_xn15 wp_ih_15_8 wn_ih_15_8 hcp8 hcn8 xsyn
Xn8 hcp8 hcn8 ahp8 ahn8 vdd vbneu dneuron
Rtp_h9 hcp9 vref 40k
Rtn_h9 hcn9 vref 40k
X_ihx_0_9 a_xp0 a_xn0 wp_ih_0_9 wn_ih_0_9 hcp9 hcn9 xsyn
X_ihx_1_9 a_xp1 a_xn1 wp_ih_1_9 wn_ih_1_9 hcp9 hcn9 xsyn
X_ihx_2_9 a_xp2 a_xn2 wp_ih_2_9 wn_ih_2_9 hcp9 hcn9 xsyn
X_ihx_3_9 a_xp3 a_xn3 wp_ih_3_9 wn_ih_3_9 hcp9 hcn9 xsyn
X_ihx_4_9 a_xp4 a_xn4 wp_ih_4_9 wn_ih_4_9 hcp9 hcn9 xsyn
X_ihx_5_9 a_xp5 a_xn5 wp_ih_5_9 wn_ih_5_9 hcp9 hcn9 xsyn
X_ihx_6_9 a_xp6 a_xn6 wp_ih_6_9 wn_ih_6_9 hcp9 hcn9 xsyn
X_ihx_7_9 a_xp7 a_xn7 wp_ih_7_9 wn_ih_7_9 hcp9 hcn9 xsyn
X_ihx_8_9 a_xp8 a_xn8 wp_ih_8_9 wn_ih_8_9 hcp9 hcn9 xsyn
X_ihx_9_9 a_xp9 a_xn9 wp_ih_9_9 wn_ih_9_9 hcp9 hcn9 xsyn
X_ihx_10_9 a_xp10 a_xn10 wp_ih_10_9 wn_ih_10_9 hcp9 hcn9 xsyn
X_ihx_11_9 a_xp11 a_xn11 wp_ih_11_9 wn_ih_11_9 hcp9 hcn9 xsyn
X_ihx_12_9 a_xp12 a_xn12 wp_ih_12_9 wn_ih_12_9 hcp9 hcn9 xsyn
X_ihx_13_9 a_xp13 a_xn13 wp_ih_13_9 wn_ih_13_9 hcp9 hcn9 xsyn
X_ihx_14_9 a_xp14 a_xn14 wp_ih_14_9 wn_ih_14_9 hcp9 hcn9 xsyn
X_ihx_15_9 a_xp15 a_xn15 wp_ih_15_9 wn_ih_15_9 hcp9 hcn9 xsyn
Xn9 hcp9 hcn9 ahp9 ahn9 vdd vbneu dneuron
Rtp_h10 hcp10 vref 40k
Rtn_h10 hcn10 vref 40k
X_ihx_0_10 a_xp0 a_xn0 wp_ih_0_10 wn_ih_0_10 hcp10 hcn10 xsyn
X_ihx_1_10 a_xp1 a_xn1 wp_ih_1_10 wn_ih_1_10 hcp10 hcn10 xsyn
X_ihx_2_10 a_xp2 a_xn2 wp_ih_2_10 wn_ih_2_10 hcp10 hcn10 xsyn
X_ihx_3_10 a_xp3 a_xn3 wp_ih_3_10 wn_ih_3_10 hcp10 hcn10 xsyn
X_ihx_4_10 a_xp4 a_xn4 wp_ih_4_10 wn_ih_4_10 hcp10 hcn10 xsyn
X_ihx_5_10 a_xp5 a_xn5 wp_ih_5_10 wn_ih_5_10 hcp10 hcn10 xsyn
X_ihx_6_10 a_xp6 a_xn6 wp_ih_6_10 wn_ih_6_10 hcp10 hcn10 xsyn
X_ihx_7_10 a_xp7 a_xn7 wp_ih_7_10 wn_ih_7_10 hcp10 hcn10 xsyn
X_ihx_8_10 a_xp8 a_xn8 wp_ih_8_10 wn_ih_8_10 hcp10 hcn10 xsyn
X_ihx_9_10 a_xp9 a_xn9 wp_ih_9_10 wn_ih_9_10 hcp10 hcn10 xsyn
X_ihx_10_10 a_xp10 a_xn10 wp_ih_10_10 wn_ih_10_10 hcp10 hcn10 xsyn
X_ihx_11_10 a_xp11 a_xn11 wp_ih_11_10 wn_ih_11_10 hcp10 hcn10 xsyn
X_ihx_12_10 a_xp12 a_xn12 wp_ih_12_10 wn_ih_12_10 hcp10 hcn10 xsyn
X_ihx_13_10 a_xp13 a_xn13 wp_ih_13_10 wn_ih_13_10 hcp10 hcn10 xsyn
X_ihx_14_10 a_xp14 a_xn14 wp_ih_14_10 wn_ih_14_10 hcp10 hcn10 xsyn
X_ihx_15_10 a_xp15 a_xn15 wp_ih_15_10 wn_ih_15_10 hcp10 hcn10 xsyn
Xn10 hcp10 hcn10 ahp10 ahn10 vdd vbneu dneuron
Rtp_h11 hcp11 vref 40k
Rtn_h11 hcn11 vref 40k
X_ihx_0_11 a_xp0 a_xn0 wp_ih_0_11 wn_ih_0_11 hcp11 hcn11 xsyn
X_ihx_1_11 a_xp1 a_xn1 wp_ih_1_11 wn_ih_1_11 hcp11 hcn11 xsyn
X_ihx_2_11 a_xp2 a_xn2 wp_ih_2_11 wn_ih_2_11 hcp11 hcn11 xsyn
X_ihx_3_11 a_xp3 a_xn3 wp_ih_3_11 wn_ih_3_11 hcp11 hcn11 xsyn
X_ihx_4_11 a_xp4 a_xn4 wp_ih_4_11 wn_ih_4_11 hcp11 hcn11 xsyn
X_ihx_5_11 a_xp5 a_xn5 wp_ih_5_11 wn_ih_5_11 hcp11 hcn11 xsyn
X_ihx_6_11 a_xp6 a_xn6 wp_ih_6_11 wn_ih_6_11 hcp11 hcn11 xsyn
X_ihx_7_11 a_xp7 a_xn7 wp_ih_7_11 wn_ih_7_11 hcp11 hcn11 xsyn
X_ihx_8_11 a_xp8 a_xn8 wp_ih_8_11 wn_ih_8_11 hcp11 hcn11 xsyn
X_ihx_9_11 a_xp9 a_xn9 wp_ih_9_11 wn_ih_9_11 hcp11 hcn11 xsyn
X_ihx_10_11 a_xp10 a_xn10 wp_ih_10_11 wn_ih_10_11 hcp11 hcn11 xsyn
X_ihx_11_11 a_xp11 a_xn11 wp_ih_11_11 wn_ih_11_11 hcp11 hcn11 xsyn
X_ihx_12_11 a_xp12 a_xn12 wp_ih_12_11 wn_ih_12_11 hcp11 hcn11 xsyn
X_ihx_13_11 a_xp13 a_xn13 wp_ih_13_11 wn_ih_13_11 hcp11 hcn11 xsyn
X_ihx_14_11 a_xp14 a_xn14 wp_ih_14_11 wn_ih_14_11 hcp11 hcn11 xsyn
X_ihx_15_11 a_xp15 a_xn15 wp_ih_15_11 wn_ih_15_11 hcp11 hcn11 xsyn
Xn11 hcp11 hcn11 ahp11 ahn11 vdd vbneu dneuron
Rtp_h12 hcp12 vref 40k
Rtn_h12 hcn12 vref 40k
X_ihx_0_12 a_xp0 a_xn0 wp_ih_0_12 wn_ih_0_12 hcp12 hcn12 xsyn
X_ihx_1_12 a_xp1 a_xn1 wp_ih_1_12 wn_ih_1_12 hcp12 hcn12 xsyn
X_ihx_2_12 a_xp2 a_xn2 wp_ih_2_12 wn_ih_2_12 hcp12 hcn12 xsyn
X_ihx_3_12 a_xp3 a_xn3 wp_ih_3_12 wn_ih_3_12 hcp12 hcn12 xsyn
X_ihx_4_12 a_xp4 a_xn4 wp_ih_4_12 wn_ih_4_12 hcp12 hcn12 xsyn
X_ihx_5_12 a_xp5 a_xn5 wp_ih_5_12 wn_ih_5_12 hcp12 hcn12 xsyn
X_ihx_6_12 a_xp6 a_xn6 wp_ih_6_12 wn_ih_6_12 hcp12 hcn12 xsyn
X_ihx_7_12 a_xp7 a_xn7 wp_ih_7_12 wn_ih_7_12 hcp12 hcn12 xsyn
X_ihx_8_12 a_xp8 a_xn8 wp_ih_8_12 wn_ih_8_12 hcp12 hcn12 xsyn
X_ihx_9_12 a_xp9 a_xn9 wp_ih_9_12 wn_ih_9_12 hcp12 hcn12 xsyn
X_ihx_10_12 a_xp10 a_xn10 wp_ih_10_12 wn_ih_10_12 hcp12 hcn12 xsyn
X_ihx_11_12 a_xp11 a_xn11 wp_ih_11_12 wn_ih_11_12 hcp12 hcn12 xsyn
X_ihx_12_12 a_xp12 a_xn12 wp_ih_12_12 wn_ih_12_12 hcp12 hcn12 xsyn
X_ihx_13_12 a_xp13 a_xn13 wp_ih_13_12 wn_ih_13_12 hcp12 hcn12 xsyn
X_ihx_14_12 a_xp14 a_xn14 wp_ih_14_12 wn_ih_14_12 hcp12 hcn12 xsyn
X_ihx_15_12 a_xp15 a_xn15 wp_ih_15_12 wn_ih_15_12 hcp12 hcn12 xsyn
Xn12 hcp12 hcn12 ahp12 ahn12 vdd vbneu dneuron
Rtp_h13 hcp13 vref 40k
Rtn_h13 hcn13 vref 40k
X_ihx_0_13 a_xp0 a_xn0 wp_ih_0_13 wn_ih_0_13 hcp13 hcn13 xsyn
X_ihx_1_13 a_xp1 a_xn1 wp_ih_1_13 wn_ih_1_13 hcp13 hcn13 xsyn
X_ihx_2_13 a_xp2 a_xn2 wp_ih_2_13 wn_ih_2_13 hcp13 hcn13 xsyn
X_ihx_3_13 a_xp3 a_xn3 wp_ih_3_13 wn_ih_3_13 hcp13 hcn13 xsyn
X_ihx_4_13 a_xp4 a_xn4 wp_ih_4_13 wn_ih_4_13 hcp13 hcn13 xsyn
X_ihx_5_13 a_xp5 a_xn5 wp_ih_5_13 wn_ih_5_13 hcp13 hcn13 xsyn
X_ihx_6_13 a_xp6 a_xn6 wp_ih_6_13 wn_ih_6_13 hcp13 hcn13 xsyn
X_ihx_7_13 a_xp7 a_xn7 wp_ih_7_13 wn_ih_7_13 hcp13 hcn13 xsyn
X_ihx_8_13 a_xp8 a_xn8 wp_ih_8_13 wn_ih_8_13 hcp13 hcn13 xsyn
X_ihx_9_13 a_xp9 a_xn9 wp_ih_9_13 wn_ih_9_13 hcp13 hcn13 xsyn
X_ihx_10_13 a_xp10 a_xn10 wp_ih_10_13 wn_ih_10_13 hcp13 hcn13 xsyn
X_ihx_11_13 a_xp11 a_xn11 wp_ih_11_13 wn_ih_11_13 hcp13 hcn13 xsyn
X_ihx_12_13 a_xp12 a_xn12 wp_ih_12_13 wn_ih_12_13 hcp13 hcn13 xsyn
X_ihx_13_13 a_xp13 a_xn13 wp_ih_13_13 wn_ih_13_13 hcp13 hcn13 xsyn
X_ihx_14_13 a_xp14 a_xn14 wp_ih_14_13 wn_ih_14_13 hcp13 hcn13 xsyn
X_ihx_15_13 a_xp15 a_xn15 wp_ih_15_13 wn_ih_15_13 hcp13 hcn13 xsyn
Xn13 hcp13 hcn13 ahp13 ahn13 vdd vbneu dneuron
Rtp_h14 hcp14 vref 40k
Rtn_h14 hcn14 vref 40k
X_ihx_0_14 a_xp0 a_xn0 wp_ih_0_14 wn_ih_0_14 hcp14 hcn14 xsyn
X_ihx_1_14 a_xp1 a_xn1 wp_ih_1_14 wn_ih_1_14 hcp14 hcn14 xsyn
X_ihx_2_14 a_xp2 a_xn2 wp_ih_2_14 wn_ih_2_14 hcp14 hcn14 xsyn
X_ihx_3_14 a_xp3 a_xn3 wp_ih_3_14 wn_ih_3_14 hcp14 hcn14 xsyn
X_ihx_4_14 a_xp4 a_xn4 wp_ih_4_14 wn_ih_4_14 hcp14 hcn14 xsyn
X_ihx_5_14 a_xp5 a_xn5 wp_ih_5_14 wn_ih_5_14 hcp14 hcn14 xsyn
X_ihx_6_14 a_xp6 a_xn6 wp_ih_6_14 wn_ih_6_14 hcp14 hcn14 xsyn
X_ihx_7_14 a_xp7 a_xn7 wp_ih_7_14 wn_ih_7_14 hcp14 hcn14 xsyn
X_ihx_8_14 a_xp8 a_xn8 wp_ih_8_14 wn_ih_8_14 hcp14 hcn14 xsyn
X_ihx_9_14 a_xp9 a_xn9 wp_ih_9_14 wn_ih_9_14 hcp14 hcn14 xsyn
X_ihx_10_14 a_xp10 a_xn10 wp_ih_10_14 wn_ih_10_14 hcp14 hcn14 xsyn
X_ihx_11_14 a_xp11 a_xn11 wp_ih_11_14 wn_ih_11_14 hcp14 hcn14 xsyn
X_ihx_12_14 a_xp12 a_xn12 wp_ih_12_14 wn_ih_12_14 hcp14 hcn14 xsyn
X_ihx_13_14 a_xp13 a_xn13 wp_ih_13_14 wn_ih_13_14 hcp14 hcn14 xsyn
X_ihx_14_14 a_xp14 a_xn14 wp_ih_14_14 wn_ih_14_14 hcp14 hcn14 xsyn
X_ihx_15_14 a_xp15 a_xn15 wp_ih_15_14 wn_ih_15_14 hcp14 hcn14 xsyn
Xn14 hcp14 hcn14 ahp14 ahn14 vdd vbneu dneuron
Rtp_h15 hcp15 vref 40k
Rtn_h15 hcn15 vref 40k
X_ihx_0_15 a_xp0 a_xn0 wp_ih_0_15 wn_ih_0_15 hcp15 hcn15 xsyn
X_ihx_1_15 a_xp1 a_xn1 wp_ih_1_15 wn_ih_1_15 hcp15 hcn15 xsyn
X_ihx_2_15 a_xp2 a_xn2 wp_ih_2_15 wn_ih_2_15 hcp15 hcn15 xsyn
X_ihx_3_15 a_xp3 a_xn3 wp_ih_3_15 wn_ih_3_15 hcp15 hcn15 xsyn
X_ihx_4_15 a_xp4 a_xn4 wp_ih_4_15 wn_ih_4_15 hcp15 hcn15 xsyn
X_ihx_5_15 a_xp5 a_xn5 wp_ih_5_15 wn_ih_5_15 hcp15 hcn15 xsyn
X_ihx_6_15 a_xp6 a_xn6 wp_ih_6_15 wn_ih_6_15 hcp15 hcn15 xsyn
X_ihx_7_15 a_xp7 a_xn7 wp_ih_7_15 wn_ih_7_15 hcp15 hcn15 xsyn
X_ihx_8_15 a_xp8 a_xn8 wp_ih_8_15 wn_ih_8_15 hcp15 hcn15 xsyn
X_ihx_9_15 a_xp9 a_xn9 wp_ih_9_15 wn_ih_9_15 hcp15 hcn15 xsyn
X_ihx_10_15 a_xp10 a_xn10 wp_ih_10_15 wn_ih_10_15 hcp15 hcn15 xsyn
X_ihx_11_15 a_xp11 a_xn11 wp_ih_11_15 wn_ih_11_15 hcp15 hcn15 xsyn
X_ihx_12_15 a_xp12 a_xn12 wp_ih_12_15 wn_ih_12_15 hcp15 hcn15 xsyn
X_ihx_13_15 a_xp13 a_xn13 wp_ih_13_15 wn_ih_13_15 hcp15 hcn15 xsyn
X_ihx_14_15 a_xp14 a_xn14 wp_ih_14_15 wn_ih_14_15 hcp15 hcn15 xsyn
X_ihx_15_15 a_xp15 a_xn15 wp_ih_15_15 wn_ih_15_15 hcp15 hcn15 xsyn
Xn15 hcp15 hcn15 ahp15 ahn15 vdd vbneu dneuron
Rtp_h16 hcp16 vref 40k
Rtn_h16 hcn16 vref 40k
X_ihx_0_16 a_xp0 a_xn0 wp_ih_0_16 wn_ih_0_16 hcp16 hcn16 xsyn
X_ihx_1_16 a_xp1 a_xn1 wp_ih_1_16 wn_ih_1_16 hcp16 hcn16 xsyn
X_ihx_2_16 a_xp2 a_xn2 wp_ih_2_16 wn_ih_2_16 hcp16 hcn16 xsyn
X_ihx_3_16 a_xp3 a_xn3 wp_ih_3_16 wn_ih_3_16 hcp16 hcn16 xsyn
X_ihx_4_16 a_xp4 a_xn4 wp_ih_4_16 wn_ih_4_16 hcp16 hcn16 xsyn
X_ihx_5_16 a_xp5 a_xn5 wp_ih_5_16 wn_ih_5_16 hcp16 hcn16 xsyn
X_ihx_6_16 a_xp6 a_xn6 wp_ih_6_16 wn_ih_6_16 hcp16 hcn16 xsyn
X_ihx_7_16 a_xp7 a_xn7 wp_ih_7_16 wn_ih_7_16 hcp16 hcn16 xsyn
X_ihx_8_16 a_xp8 a_xn8 wp_ih_8_16 wn_ih_8_16 hcp16 hcn16 xsyn
X_ihx_9_16 a_xp9 a_xn9 wp_ih_9_16 wn_ih_9_16 hcp16 hcn16 xsyn
X_ihx_10_16 a_xp10 a_xn10 wp_ih_10_16 wn_ih_10_16 hcp16 hcn16 xsyn
X_ihx_11_16 a_xp11 a_xn11 wp_ih_11_16 wn_ih_11_16 hcp16 hcn16 xsyn
X_ihx_12_16 a_xp12 a_xn12 wp_ih_12_16 wn_ih_12_16 hcp16 hcn16 xsyn
X_ihx_13_16 a_xp13 a_xn13 wp_ih_13_16 wn_ih_13_16 hcp16 hcn16 xsyn
X_ihx_14_16 a_xp14 a_xn14 wp_ih_14_16 wn_ih_14_16 hcp16 hcn16 xsyn
X_ihx_15_16 a_xp15 a_xn15 wp_ih_15_16 wn_ih_15_16 hcp16 hcn16 xsyn
Xn16 hcp16 hcn16 ahp16 ahn16 vdd vbneu dneuron
Rtp_h17 hcp17 vref 40k
Rtn_h17 hcn17 vref 40k
X_ihx_0_17 a_xp0 a_xn0 wp_ih_0_17 wn_ih_0_17 hcp17 hcn17 xsyn
X_ihx_1_17 a_xp1 a_xn1 wp_ih_1_17 wn_ih_1_17 hcp17 hcn17 xsyn
X_ihx_2_17 a_xp2 a_xn2 wp_ih_2_17 wn_ih_2_17 hcp17 hcn17 xsyn
X_ihx_3_17 a_xp3 a_xn3 wp_ih_3_17 wn_ih_3_17 hcp17 hcn17 xsyn
X_ihx_4_17 a_xp4 a_xn4 wp_ih_4_17 wn_ih_4_17 hcp17 hcn17 xsyn
X_ihx_5_17 a_xp5 a_xn5 wp_ih_5_17 wn_ih_5_17 hcp17 hcn17 xsyn
X_ihx_6_17 a_xp6 a_xn6 wp_ih_6_17 wn_ih_6_17 hcp17 hcn17 xsyn
X_ihx_7_17 a_xp7 a_xn7 wp_ih_7_17 wn_ih_7_17 hcp17 hcn17 xsyn
X_ihx_8_17 a_xp8 a_xn8 wp_ih_8_17 wn_ih_8_17 hcp17 hcn17 xsyn
X_ihx_9_17 a_xp9 a_xn9 wp_ih_9_17 wn_ih_9_17 hcp17 hcn17 xsyn
X_ihx_10_17 a_xp10 a_xn10 wp_ih_10_17 wn_ih_10_17 hcp17 hcn17 xsyn
X_ihx_11_17 a_xp11 a_xn11 wp_ih_11_17 wn_ih_11_17 hcp17 hcn17 xsyn
X_ihx_12_17 a_xp12 a_xn12 wp_ih_12_17 wn_ih_12_17 hcp17 hcn17 xsyn
X_ihx_13_17 a_xp13 a_xn13 wp_ih_13_17 wn_ih_13_17 hcp17 hcn17 xsyn
X_ihx_14_17 a_xp14 a_xn14 wp_ih_14_17 wn_ih_14_17 hcp17 hcn17 xsyn
X_ihx_15_17 a_xp15 a_xn15 wp_ih_15_17 wn_ih_15_17 hcp17 hcn17 xsyn
Xn17 hcp17 hcn17 ahp17 ahn17 vdd vbneu dneuron
Rtp_h18 hcp18 vref 40k
Rtn_h18 hcn18 vref 40k
X_ihx_0_18 a_xp0 a_xn0 wp_ih_0_18 wn_ih_0_18 hcp18 hcn18 xsyn
X_ihx_1_18 a_xp1 a_xn1 wp_ih_1_18 wn_ih_1_18 hcp18 hcn18 xsyn
X_ihx_2_18 a_xp2 a_xn2 wp_ih_2_18 wn_ih_2_18 hcp18 hcn18 xsyn
X_ihx_3_18 a_xp3 a_xn3 wp_ih_3_18 wn_ih_3_18 hcp18 hcn18 xsyn
X_ihx_4_18 a_xp4 a_xn4 wp_ih_4_18 wn_ih_4_18 hcp18 hcn18 xsyn
X_ihx_5_18 a_xp5 a_xn5 wp_ih_5_18 wn_ih_5_18 hcp18 hcn18 xsyn
X_ihx_6_18 a_xp6 a_xn6 wp_ih_6_18 wn_ih_6_18 hcp18 hcn18 xsyn
X_ihx_7_18 a_xp7 a_xn7 wp_ih_7_18 wn_ih_7_18 hcp18 hcn18 xsyn
X_ihx_8_18 a_xp8 a_xn8 wp_ih_8_18 wn_ih_8_18 hcp18 hcn18 xsyn
X_ihx_9_18 a_xp9 a_xn9 wp_ih_9_18 wn_ih_9_18 hcp18 hcn18 xsyn
X_ihx_10_18 a_xp10 a_xn10 wp_ih_10_18 wn_ih_10_18 hcp18 hcn18 xsyn
X_ihx_11_18 a_xp11 a_xn11 wp_ih_11_18 wn_ih_11_18 hcp18 hcn18 xsyn
X_ihx_12_18 a_xp12 a_xn12 wp_ih_12_18 wn_ih_12_18 hcp18 hcn18 xsyn
X_ihx_13_18 a_xp13 a_xn13 wp_ih_13_18 wn_ih_13_18 hcp18 hcn18 xsyn
X_ihx_14_18 a_xp14 a_xn14 wp_ih_14_18 wn_ih_14_18 hcp18 hcn18 xsyn
X_ihx_15_18 a_xp15 a_xn15 wp_ih_15_18 wn_ih_15_18 hcp18 hcn18 xsyn
Xn18 hcp18 hcn18 ahp18 ahn18 vdd vbneu dneuron
Rtp_h19 hcp19 vref 40k
Rtn_h19 hcn19 vref 40k
X_ihx_0_19 a_xp0 a_xn0 wp_ih_0_19 wn_ih_0_19 hcp19 hcn19 xsyn
X_ihx_1_19 a_xp1 a_xn1 wp_ih_1_19 wn_ih_1_19 hcp19 hcn19 xsyn
X_ihx_2_19 a_xp2 a_xn2 wp_ih_2_19 wn_ih_2_19 hcp19 hcn19 xsyn
X_ihx_3_19 a_xp3 a_xn3 wp_ih_3_19 wn_ih_3_19 hcp19 hcn19 xsyn
X_ihx_4_19 a_xp4 a_xn4 wp_ih_4_19 wn_ih_4_19 hcp19 hcn19 xsyn
X_ihx_5_19 a_xp5 a_xn5 wp_ih_5_19 wn_ih_5_19 hcp19 hcn19 xsyn
X_ihx_6_19 a_xp6 a_xn6 wp_ih_6_19 wn_ih_6_19 hcp19 hcn19 xsyn
X_ihx_7_19 a_xp7 a_xn7 wp_ih_7_19 wn_ih_7_19 hcp19 hcn19 xsyn
X_ihx_8_19 a_xp8 a_xn8 wp_ih_8_19 wn_ih_8_19 hcp19 hcn19 xsyn
X_ihx_9_19 a_xp9 a_xn9 wp_ih_9_19 wn_ih_9_19 hcp19 hcn19 xsyn
X_ihx_10_19 a_xp10 a_xn10 wp_ih_10_19 wn_ih_10_19 hcp19 hcn19 xsyn
X_ihx_11_19 a_xp11 a_xn11 wp_ih_11_19 wn_ih_11_19 hcp19 hcn19 xsyn
X_ihx_12_19 a_xp12 a_xn12 wp_ih_12_19 wn_ih_12_19 hcp19 hcn19 xsyn
X_ihx_13_19 a_xp13 a_xn13 wp_ih_13_19 wn_ih_13_19 hcp19 hcn19 xsyn
X_ihx_14_19 a_xp14 a_xn14 wp_ih_14_19 wn_ih_14_19 hcp19 hcn19 xsyn
X_ihx_15_19 a_xp15 a_xn15 wp_ih_15_19 wn_ih_15_19 hcp19 hcn19 xsyn
Xn19 hcp19 hcn19 ahp19 ahn19 vdd vbneu dneuron
Rtp_o0 ocp0 vref 40k
Rtn_o0 ocn0 vref 40k
X_ho_0_0 ahp0 ahn0 wp_ho_0_0 wn_ho_0_0 ocp0 ocn0 xsyn
X_ho_1_0 ahp1 ahn1 wp_ho_1_0 wn_ho_1_0 ocp0 ocn0 xsyn
X_ho_2_0 ahp2 ahn2 wp_ho_2_0 wn_ho_2_0 ocp0 ocn0 xsyn
X_ho_3_0 ahp3 ahn3 wp_ho_3_0 wn_ho_3_0 ocp0 ocn0 xsyn
X_ho_4_0 ahp4 ahn4 wp_ho_4_0 wn_ho_4_0 ocp0 ocn0 xsyn
X_ho_5_0 ahp5 ahn5 wp_ho_5_0 wn_ho_5_0 ocp0 ocn0 xsyn
X_ho_6_0 ahp6 ahn6 wp_ho_6_0 wn_ho_6_0 ocp0 ocn0 xsyn
X_ho_7_0 ahp7 ahn7 wp_ho_7_0 wn_ho_7_0 ocp0 ocn0 xsyn
X_ho_8_0 ahp8 ahn8 wp_ho_8_0 wn_ho_8_0 ocp0 ocn0 xsyn
X_ho_9_0 ahp9 ahn9 wp_ho_9_0 wn_ho_9_0 ocp0 ocn0 xsyn
X_ho_10_0 ahp10 ahn10 wp_ho_10_0 wn_ho_10_0 ocp0 ocn0 xsyn
X_ho_11_0 ahp11 ahn11 wp_ho_11_0 wn_ho_11_0 ocp0 ocn0 xsyn
X_ho_12_0 ahp12 ahn12 wp_ho_12_0 wn_ho_12_0 ocp0 ocn0 xsyn
X_ho_13_0 ahp13 ahn13 wp_ho_13_0 wn_ho_13_0 ocp0 ocn0 xsyn
X_ho_14_0 ahp14 ahn14 wp_ho_14_0 wn_ho_14_0 ocp0 ocn0 xsyn
X_ho_15_0 ahp15 ahn15 wp_ho_15_0 wn_ho_15_0 ocp0 ocn0 xsyn
X_ho_16_0 ahp16 ahn16 wp_ho_16_0 wn_ho_16_0 ocp0 ocn0 xsyn
X_ho_17_0 ahp17 ahn17 wp_ho_17_0 wn_ho_17_0 ocp0 ocn0 xsyn
X_ho_18_0 ahp18 ahn18 wp_ho_18_0 wn_ho_18_0 ocp0 ocn0 xsyn
X_ho_19_0 ahp19 ahn19 wp_ho_19_0 wn_ho_19_0 ocp0 ocn0 xsyn
Rmo0 ocp0 ocn0 20k
Rtp_o1 ocp1 vref 40k
Rtn_o1 ocn1 vref 40k
X_ho_0_1 ahp0 ahn0 wp_ho_0_1 wn_ho_0_1 ocp1 ocn1 xsyn
X_ho_1_1 ahp1 ahn1 wp_ho_1_1 wn_ho_1_1 ocp1 ocn1 xsyn
X_ho_2_1 ahp2 ahn2 wp_ho_2_1 wn_ho_2_1 ocp1 ocn1 xsyn
X_ho_3_1 ahp3 ahn3 wp_ho_3_1 wn_ho_3_1 ocp1 ocn1 xsyn
X_ho_4_1 ahp4 ahn4 wp_ho_4_1 wn_ho_4_1 ocp1 ocn1 xsyn
X_ho_5_1 ahp5 ahn5 wp_ho_5_1 wn_ho_5_1 ocp1 ocn1 xsyn
X_ho_6_1 ahp6 ahn6 wp_ho_6_1 wn_ho_6_1 ocp1 ocn1 xsyn
X_ho_7_1 ahp7 ahn7 wp_ho_7_1 wn_ho_7_1 ocp1 ocn1 xsyn
X_ho_8_1 ahp8 ahn8 wp_ho_8_1 wn_ho_8_1 ocp1 ocn1 xsyn
X_ho_9_1 ahp9 ahn9 wp_ho_9_1 wn_ho_9_1 ocp1 ocn1 xsyn
X_ho_10_1 ahp10 ahn10 wp_ho_10_1 wn_ho_10_1 ocp1 ocn1 xsyn
X_ho_11_1 ahp11 ahn11 wp_ho_11_1 wn_ho_11_1 ocp1 ocn1 xsyn
X_ho_12_1 ahp12 ahn12 wp_ho_12_1 wn_ho_12_1 ocp1 ocn1 xsyn
X_ho_13_1 ahp13 ahn13 wp_ho_13_1 wn_ho_13_1 ocp1 ocn1 xsyn
X_ho_14_1 ahp14 ahn14 wp_ho_14_1 wn_ho_14_1 ocp1 ocn1 xsyn
X_ho_15_1 ahp15 ahn15 wp_ho_15_1 wn_ho_15_1 ocp1 ocn1 xsyn
X_ho_16_1 ahp16 ahn16 wp_ho_16_1 wn_ho_16_1 ocp1 ocn1 xsyn
X_ho_17_1 ahp17 ahn17 wp_ho_17_1 wn_ho_17_1 ocp1 ocn1 xsyn
X_ho_18_1 ahp18 ahn18 wp_ho_18_1 wn_ho_18_1 ocp1 ocn1 xsyn
X_ho_19_1 ahp19 ahn19 wp_ho_19_1 wn_ho_19_1 ocp1 ocn1 xsyn
Rmo1 ocp1 ocn1 20k
Rtp_o2 ocp2 vref 40k
Rtn_o2 ocn2 vref 40k
X_ho_0_2 ahp0 ahn0 wp_ho_0_2 wn_ho_0_2 ocp2 ocn2 xsyn
X_ho_1_2 ahp1 ahn1 wp_ho_1_2 wn_ho_1_2 ocp2 ocn2 xsyn
X_ho_2_2 ahp2 ahn2 wp_ho_2_2 wn_ho_2_2 ocp2 ocn2 xsyn
X_ho_3_2 ahp3 ahn3 wp_ho_3_2 wn_ho_3_2 ocp2 ocn2 xsyn
X_ho_4_2 ahp4 ahn4 wp_ho_4_2 wn_ho_4_2 ocp2 ocn2 xsyn
X_ho_5_2 ahp5 ahn5 wp_ho_5_2 wn_ho_5_2 ocp2 ocn2 xsyn
X_ho_6_2 ahp6 ahn6 wp_ho_6_2 wn_ho_6_2 ocp2 ocn2 xsyn
X_ho_7_2 ahp7 ahn7 wp_ho_7_2 wn_ho_7_2 ocp2 ocn2 xsyn
X_ho_8_2 ahp8 ahn8 wp_ho_8_2 wn_ho_8_2 ocp2 ocn2 xsyn
X_ho_9_2 ahp9 ahn9 wp_ho_9_2 wn_ho_9_2 ocp2 ocn2 xsyn
X_ho_10_2 ahp10 ahn10 wp_ho_10_2 wn_ho_10_2 ocp2 ocn2 xsyn
X_ho_11_2 ahp11 ahn11 wp_ho_11_2 wn_ho_11_2 ocp2 ocn2 xsyn
X_ho_12_2 ahp12 ahn12 wp_ho_12_2 wn_ho_12_2 ocp2 ocn2 xsyn
X_ho_13_2 ahp13 ahn13 wp_ho_13_2 wn_ho_13_2 ocp2 ocn2 xsyn
X_ho_14_2 ahp14 ahn14 wp_ho_14_2 wn_ho_14_2 ocp2 ocn2 xsyn
X_ho_15_2 ahp15 ahn15 wp_ho_15_2 wn_ho_15_2 ocp2 ocn2 xsyn
X_ho_16_2 ahp16 ahn16 wp_ho_16_2 wn_ho_16_2 ocp2 ocn2 xsyn
X_ho_17_2 ahp17 ahn17 wp_ho_17_2 wn_ho_17_2 ocp2 ocn2 xsyn
X_ho_18_2 ahp18 ahn18 wp_ho_18_2 wn_ho_18_2 ocp2 ocn2 xsyn
X_ho_19_2 ahp19 ahn19 wp_ho_19_2 wn_ho_19_2 ocp2 ocn2 xsyn
Rmo2 ocp2 ocn2 20k
Rtp_o3 ocp3 vref 40k
Rtn_o3 ocn3 vref 40k
X_ho_0_3 ahp0 ahn0 wp_ho_0_3 wn_ho_0_3 ocp3 ocn3 xsyn
X_ho_1_3 ahp1 ahn1 wp_ho_1_3 wn_ho_1_3 ocp3 ocn3 xsyn
X_ho_2_3 ahp2 ahn2 wp_ho_2_3 wn_ho_2_3 ocp3 ocn3 xsyn
X_ho_3_3 ahp3 ahn3 wp_ho_3_3 wn_ho_3_3 ocp3 ocn3 xsyn
X_ho_4_3 ahp4 ahn4 wp_ho_4_3 wn_ho_4_3 ocp3 ocn3 xsyn
X_ho_5_3 ahp5 ahn5 wp_ho_5_3 wn_ho_5_3 ocp3 ocn3 xsyn
X_ho_6_3 ahp6 ahn6 wp_ho_6_3 wn_ho_6_3 ocp3 ocn3 xsyn
X_ho_7_3 ahp7 ahn7 wp_ho_7_3 wn_ho_7_3 ocp3 ocn3 xsyn
X_ho_8_3 ahp8 ahn8 wp_ho_8_3 wn_ho_8_3 ocp3 ocn3 xsyn
X_ho_9_3 ahp9 ahn9 wp_ho_9_3 wn_ho_9_3 ocp3 ocn3 xsyn
X_ho_10_3 ahp10 ahn10 wp_ho_10_3 wn_ho_10_3 ocp3 ocn3 xsyn
X_ho_11_3 ahp11 ahn11 wp_ho_11_3 wn_ho_11_3 ocp3 ocn3 xsyn
X_ho_12_3 ahp12 ahn12 wp_ho_12_3 wn_ho_12_3 ocp3 ocn3 xsyn
X_ho_13_3 ahp13 ahn13 wp_ho_13_3 wn_ho_13_3 ocp3 ocn3 xsyn
X_ho_14_3 ahp14 ahn14 wp_ho_14_3 wn_ho_14_3 ocp3 ocn3 xsyn
X_ho_15_3 ahp15 ahn15 wp_ho_15_3 wn_ho_15_3 ocp3 ocn3 xsyn
X_ho_16_3 ahp16 ahn16 wp_ho_16_3 wn_ho_16_3 ocp3 ocn3 xsyn
X_ho_17_3 ahp17 ahn17 wp_ho_17_3 wn_ho_17_3 ocp3 ocn3 xsyn
X_ho_18_3 ahp18 ahn18 wp_ho_18_3 wn_ho_18_3 ocp3 ocn3 xsyn
X_ho_19_3 ahp19 ahn19 wp_ho_19_3 wn_ho_19_3 ocp3 ocn3 xsyn
Rmo3 ocp3 ocn3 20k
Rtp_o4 ocp4 vref 40k
Rtn_o4 ocn4 vref 40k
X_ho_0_4 ahp0 ahn0 wp_ho_0_4 wn_ho_0_4 ocp4 ocn4 xsyn
X_ho_1_4 ahp1 ahn1 wp_ho_1_4 wn_ho_1_4 ocp4 ocn4 xsyn
X_ho_2_4 ahp2 ahn2 wp_ho_2_4 wn_ho_2_4 ocp4 ocn4 xsyn
X_ho_3_4 ahp3 ahn3 wp_ho_3_4 wn_ho_3_4 ocp4 ocn4 xsyn
X_ho_4_4 ahp4 ahn4 wp_ho_4_4 wn_ho_4_4 ocp4 ocn4 xsyn
X_ho_5_4 ahp5 ahn5 wp_ho_5_4 wn_ho_5_4 ocp4 ocn4 xsyn
X_ho_6_4 ahp6 ahn6 wp_ho_6_4 wn_ho_6_4 ocp4 ocn4 xsyn
X_ho_7_4 ahp7 ahn7 wp_ho_7_4 wn_ho_7_4 ocp4 ocn4 xsyn
X_ho_8_4 ahp8 ahn8 wp_ho_8_4 wn_ho_8_4 ocp4 ocn4 xsyn
X_ho_9_4 ahp9 ahn9 wp_ho_9_4 wn_ho_9_4 ocp4 ocn4 xsyn
X_ho_10_4 ahp10 ahn10 wp_ho_10_4 wn_ho_10_4 ocp4 ocn4 xsyn
X_ho_11_4 ahp11 ahn11 wp_ho_11_4 wn_ho_11_4 ocp4 ocn4 xsyn
X_ho_12_4 ahp12 ahn12 wp_ho_12_4 wn_ho_12_4 ocp4 ocn4 xsyn
X_ho_13_4 ahp13 ahn13 wp_ho_13_4 wn_ho_13_4 ocp4 ocn4 xsyn
X_ho_14_4 ahp14 ahn14 wp_ho_14_4 wn_ho_14_4 ocp4 ocn4 xsyn
X_ho_15_4 ahp15 ahn15 wp_ho_15_4 wn_ho_15_4 ocp4 ocn4 xsyn
X_ho_16_4 ahp16 ahn16 wp_ho_16_4 wn_ho_16_4 ocp4 ocn4 xsyn
X_ho_17_4 ahp17 ahn17 wp_ho_17_4 wn_ho_17_4 ocp4 ocn4 xsyn
X_ho_18_4 ahp18 ahn18 wp_ho_18_4 wn_ho_18_4 ocp4 ocn4 xsyn
X_ho_19_4 ahp19 ahn19 wp_ho_19_4 wn_ho_19_4 ocp4 ocn4 xsyn
Rmo4 ocp4 ocn4 20k
.options gmin=1e-10
.end
