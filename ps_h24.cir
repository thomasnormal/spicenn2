fully in-spice PC learner
.model NNR NMOS (LEVEL=1 VTO=0.2 KP=120u LAMBDA=0.02 GAMMA=0 PHI=0.7)
.model PNR PMOS (LEVEL=1 VTO=-0.2 KP=40u LAMBDA=0.02 GAMMA=0 PHI=0.7)
.subckt gsyn inp inn wp wn outp outn vdd vbn
Mtail nt vbn 0 0 NNR W=400u L=100u
M5 na wp s5 0 NNR W=200u L=100u
Rd5 s5 nt 12k
M6 nb wn s6 0 NNR W=200u L=100u
Rd6 s6 nt 12k
M1 outp inp s1 0 NNR W=200u L=100u
Rd1 s1 na 12k
M2 outn inn s2 0 NNR W=200u L=100u
Rd2 s2 na 12k
M3 outn inp s3 0 NNR W=200u L=100u
Rd3 s3 nb 12k
M4 outp inn s4 0 NNR W=200u L=100u
Rd4 s4 nb 12k
.ends
.subckt cmld p n vdd
Rcs1 p cmx 300k
Rcs2 n cmx 300k
MLp p cmx vdd vdd PNR W=6000u L=100u
MLn n cmx vdd vdd PNR W=6000u L=100u
.ends
.subckt dneuron up un ap an vdd vbn
M1 an up tn 0 NNR W=200u L=100u
M2 ap un tn 0 NNR W=200u L=100u
Mt tn vbn 0 0 NNR W=200u L=100u
Xcm ap an vdd cmld
.ends
.subckt esub xp xn mp mn ep en vdd vbn
Mt nt vbn 0 0 NNR W=400u L=100u
M1x ep xn nt 0 NNR W=200u L=100u
M2x en xp nt 0 NNR W=200u L=100u
M1m ep mp nt 0 NNR W=200u L=100u
M2m en mn nt 0 NNR W=200u L=100u
RLp vdd ep 50k
RLn vdd en 50k
.ends
.subckt gprod xp xn yp yn wp wn vdd vbn
Mtail nt vbn 0 0 NNR W=400u L=100u
M5 na yp nt 0 NNR W=200u L=100u
M6 nb yn nt 0 NNR W=200u L=100u
M1 iop xp na 0 NNR W=200u L=100u
M2 ion xn na 0 NNR W=200u L=100u
M3 ion xp nb 0 NNR W=200u L=100u
M4 iop xn nb 0 NNR W=200u L=100u
Mlp iop iop vdd vdd PNR W=200u L=100u
Mln ion ion vdd vdd PNR W=200u L=100u
Mpu_wp wp iop vdd vdd PNR W=200u L=100u
MpRn nrn ion vdd vdd PNR W=200u L=100u
MnRn nrn nrn 0 0 NNR W=200u L=100u
Mpd_wp wp nrn 0 0 NNR W=200u L=100u
Mpu_wn wn ion vdd vdd PNR W=200u L=100u
MpRp nrp iop vdd vdd PNR W=200u L=100u
MnRp nrp nrp 0 0 NNR W=200u L=100u
Mpd_wn wn nrp 0 0 NNR W=200u L=100u
.ends
Vdd vdd 0 1.0
Vbsyn vbsyn 0 0.6
Vbneu vbneu 0 0.35
Vgm gm 0 0.6
Vwcm wcm 0 0.5
Vgbl gbl 0 PWL(0.0n 0.80000 179.9n 0.80000 180.0n 0.80000 359.9n 0.80000 360.0n 0.80000 539.9n 0.80000 540.0n 0.80000 719.9n 0.80000 720.0n 0.80000 899.9n 0.80000 900.0n 0.80000 1079.9n 0.80000 1080.0n 0.80000 1259.9n 0.80000 1260.0n 0.80000 1439.9n 0.80000 1440.0n 0.80000 1619.9n 0.80000 1620.0n 0.80000 1799.9n 0.80000 1800.0n 0.80000 1979.9n 0.80000 1980.0n 0.80000 2159.9n 0.80000 2160.0n 0.80000 2339.9n 0.80000 2340.0n 0.80000 2519.9n 0.80000 2520.0n 0.80000 2699.9n 0.80000 2700.0n 0.80000 2879.9n 0.80000 2880.0n 0.80000 3059.9n 0.80000 3060.0n 0.80000 3239.9n 0.80000 3240.0n 0.80000 3419.9n 0.80000 3420.0n 0.80000 3599.9n 0.80000 3600.0n 0.80000 3779.9n 0.80000 3780.0n 0.80000 3959.9n 0.80000 3960.0n 0.80000 4139.9n 0.80000 4140.0n 0.80000 4319.9n 0.80000 4320.0n 0.80000 4499.9n 0.80000 4500.0n 0.80000 4679.9n 0.80000 4680.0n 0.80000 4859.9n 0.80000 4860.0n 0.80000 5039.9n 0.80000 5040.0n 0.80000 5219.9n 0.80000 5220.0n 0.80000 5399.9n 0.80000 5400.0n 0.80000 5579.9n 0.80000 5580.0n 0.80000 5759.9n 0.80000 5760.0n 0.80000 5939.9n 0.80000 5940.0n 0.80000 6119.9n 0.80000 6120.0n 0.80000 6299.9n 0.80000 6300.0n 0.80000 6479.9n 0.80000 6480.0n 0.80000 6659.9n 0.80000 6660.0n 0.80000 6839.9n 0.80000 6840.0n 0.80000 7019.9n 0.80000 7020.0n 0.80000 7199.9n 0.80000 7200.0n 0.80000 7379.9n 0.80000 7380.0n 0.80000 7559.9n 0.80000 7560.0n 0.80000 7739.9n 0.80000 7740.0n 0.80000 7919.9n 0.80000 7920.0n 0.80000 8099.9n 0.80000 8100.0n 0.80000 8279.9n 0.80000 8280.0n 0.80000 8459.9n 0.80000 8460.0n 0.80000 8639.9n 0.80000 8640.0n 0.80000 8819.9n 0.80000 8820.0n 0.80000 8999.9n 0.80000 9000.0n 0.80000 9179.9n 0.80000 9180.0n 0.80000 9359.9n 0.80000 9360.0n 0.80000 9539.9n 0.80000 9540.0n 0.80000 9719.9n 0.80000 9720.0n 0.80000 9899.9n 0.80000 9900.0n 0.80000 10079.9n 0.80000 10080.0n 0.80000 10259.9n 0.80000 10260.0n 0.80000 10439.9n 0.80000 10440.0n 0.80000 10619.9n 0.80000 10620.0n 0.80000 10799.9n 0.80000 10800.0n 0.80000 10979.9n 0.80000 10980.0n 0.80000 11159.9n 0.80000 11160.0n 0.80000 11339.9n 0.80000 11340.0n 0.80000 11519.9n 0.80000 11520.0n 0.80000 11699.9n 0.80000 11700.0n 0.80000 11879.9n 0.80000 11880.0n 0.80000 12059.9n 0.80000 12060.0n 0.80000 12239.9n 0.80000 12240.0n 0.80000 12419.9n 0.80000 12420.0n 0.80000 12599.9n 0.80000 12600.0n 0.80000 12779.9n 0.80000 12780.0n 0.80000 12959.9n 0.80000 12960.0n 0.80000 13139.9n 0.80000 13140.0n 0.80000 13319.9n 0.80000 13320.0n 0.80000 13499.9n 0.80000 13500.0n 0.80000 13679.9n 0.80000 13680.0n 0.80000 13859.9n 0.80000 13860.0n 0.80000 14039.9n 0.80000 14040.0n 0.80000 14219.9n 0.80000 14220.0n 0.80000 14399.9n 0.80000 14400.0n 0.80000 14579.9n 0.80000 14580.0n 0.80000 14759.9n 0.80000 14760.0n 0.80000 14939.9n 0.80000 14940.0n 0.80000 15119.9n 0.80000 15120.0n 0.80000 15299.9n 0.80000 15300.0n 0.80000 15479.9n 0.80000 15480.0n 0.80000 15659.9n 0.80000 15660.0n 0.80000 15839.9n 0.80000 15840.0n 0.80000 16019.9n 0.80000 16020.0n 0.80000 16199.9n 0.80000 16200.0n 0.80000 16379.9n 0.80000 16380.0n 0.80000 16559.9n 0.80000 16560.0n 0.80000 16739.9n 0.80000 16740.0n 0.80000 16919.9n 0.80000 16920.0n 0.80000 17099.9n 0.80000 17100.0n 0.80000 17279.9n 0.80000 17280.0n 0.80000 17459.9n 0.80000 17460.0n 0.80000 17639.9n 0.80000 17640.0n 0.80000 17819.9n 0.80000 17820.0n 0.80000 17999.9n 0.80000 18000.0n 0.80000 18179.9n 0.80000 18180.0n 0.80000 18359.9n 0.80000 18360.0n 0.80000 18539.9n 0.80000 18540.0n 0.80000 18719.9n 0.80000 18720.0n 0.80000 18899.9n 0.80000 18900.0n 0.80000 19079.9n 0.80000 19080.0n 0.80000 19259.9n 0.80000 19260.0n 0.80000 19439.9n 0.80000 19440.0n 0.80000 19619.9n 0.80000 19620.0n 0.80000 19799.9n 0.80000 19800.0n 0.80000 19979.9n 0.80000 19980.0n 0.80000 20159.9n 0.80000 20160.0n 0.80000 20339.9n 0.80000 20340.0n 0.80000 20519.9n 0.80000 20520.0n 0.80000 20699.9n 0.80000 20700.0n 0.80000 20879.9n 0.80000 20880.0n 0.80000 21059.9n 0.80000 21060.0n 0.80000 21239.9n 0.80000 21240.0n 0.80000 21419.9n 0.80000 21420.0n 0.80000 21599.9n 0.80000 21600.0n 0.80000 21779.9n 0.80000 21780.0n 0.80000 21959.9n 0.80000 21960.0n 0.80000 22139.9n 0.80000 22140.0n 0.80000 22319.9n 0.80000 22320.0n 0.80000 22499.9n 0.80000 22500.0n 0.80000 22679.9n 0.80000 22680.0n 0.80000 22859.9n 0.80000 22860.0n 0.80000 23039.9n 0.80000 23040.0n 0.80000 23219.9n 0.80000 23220.0n 0.80000 23399.9n 0.80000 23400.0n 0.80000 23579.9n 0.80000 23580.0n 0.80000 23759.9n 0.80000 23760.0n 0.80000 23939.9n 0.80000 23940.0n 0.80000 24119.9n 0.80000 24120.0n 0.80000 24299.9n 0.80000 24300.0n 0.80000 24479.9n 0.80000 24480.0n 0.80000 24659.9n 0.80000 24660.0n 0.80000 24839.9n 0.80000 24840.0n 0.80000 25019.9n 0.80000 25020.0n 0.80000 25199.9n 0.80000 25200.0n 0.80000 25379.9n 0.80000 25380.0n 0.80000 25559.9n 0.80000 25560.0n 0.80000 25739.9n 0.80000 25740.0n 0.80000 25919.9n 0.80000 25920.0n 0.80000 26099.9n 0.80000 26100.0n 0.80000 26279.9n 0.80000 26280.0n 0.80000 26459.9n 0.80000 26460.0n 0.80000 26639.9n 0.80000 26640.0n 0.80000 26819.9n 0.80000 26820.0n 0.80000 26999.9n 0.80000 27000.0n 0.80000 27179.9n 0.80000 27180.0n 0.80000 27359.9n 0.80000 27360.0n 0.80000 27539.9n 0.80000 27540.0n 0.80000 27719.9n 0.80000 27720.0n 0.80000 27899.9n 0.80000 27900.0n 0.80000 28079.9n 0.80000 28080.0n 0.80000 28259.9n 0.80000 28260.0n 0.80000 28439.9n 0.80000 28440.0n 0.80000 28619.9n 0.80000 28620.0n 0.80000 28799.9n 0.80000 28800.0n 0.80000 28979.9n 0.80000 28980.0n 0.80000 29159.9n 0.80000 29160.0n 0.80000 29339.9n 0.80000 29340.0n 0.80000 29519.9n 0.80000 29520.0n 0.80000 29699.9n 0.80000 29700.0n 0.80000 29879.9n 0.80000 29880.0n 0.80000 30059.9n 0.80000 30060.0n 0.80000 30239.9n 0.80000 30240.0n 0.80000 30419.9n 0.80000 30420.0n 0.80000 30599.9n 0.80000 30600.0n 0.80000 30779.9n 0.80000 30780.0n 0.80000 30959.9n 0.80000 30960.0n 0.80000 31139.9n 0.80000 31140.0n 0.80000 31319.9n 0.80000 31320.0n 0.80000 31499.9n 0.80000 31500.0n 0.80000 31679.9n 0.80000 31680.0n 0.80000 31859.9n 0.80000 31860.0n 0.80000 32039.9n 0.80000 32040.0n 0.80000 32219.9n 0.80000 32220.0n 0.80000 32399.9n 0.80000 32400.0n 0.80000 32579.9n 0.80000 32580.0n 0.80000 32759.9n 0.80000 32760.0n 0.80000 32939.9n 0.80000 32940.0n 0.80000 33119.9n 0.80000 33120.0n 0.80000 33299.9n 0.80000 33300.0n 0.80000 33479.9n 0.80000 33480.0n 0.80000 33659.9n 0.80000 33660.0n 0.80000 33839.9n 0.80000 33840.0n 0.80000 34019.9n 0.80000 34020.0n 0.80000 34199.9n 0.80000 34200.0n 0.80000 34379.9n 0.80000 34380.0n 0.80000 34559.9n 0.80000 34560.0n 0.80000 34739.9n 0.80000 34740.0n 0.80000 34919.9n 0.80000 34920.0n 0.80000 35099.9n 0.80000 35100.0n 0.80000 35279.9n 0.80000 35280.0n 0.80000 35459.9n 0.80000 35460.0n 0.80000 35639.9n 0.80000 35640.0n 0.80000 35819.9n 0.80000 35820.0n 0.80000 35999.9n 0.80000 36000.0n 0.80000 36179.9n 0.80000 36180.0n 0.80000 36359.9n 0.80000 36360.0n 0.80000 36539.9n 0.80000 36540.0n 0.80000 36719.9n 0.80000 36720.0n 0.80000 36899.9n 0.80000 36900.0n 0.80000 37079.9n 0.80000 37080.0n 0.80000 37259.9n 0.80000 37260.0n 0.80000 37439.9n 0.80000 37440.0n 0.80000 37619.9n 0.80000 37620.0n 0.80000 37799.9n 0.80000 37800.0n 0.80000 37979.9n 0.80000 37980.0n 0.80000 38159.9n 0.80000 38160.0n 0.80000 38339.9n 0.80000 38340.0n 0.80000 38519.9n 0.80000 38520.0n 0.80000 38699.9n 0.80000 38700.0n 0.80000 38879.9n 0.80000 38880.0n 0.80000 39059.9n 0.80000 39060.0n 0.80000 39239.9n 0.80000 39240.0n 0.80000 39419.9n 0.80000 39420.0n 0.80000 39599.9n 0.80000 39600.0n 0.80000 39779.9n 0.80000 39780.0n 0.80000 39959.9n 0.80000 39960.0n 0.80000 40139.9n 0.80000 40140.0n 0.80000 40319.9n 0.80000 40320.0n 0.80000 40499.9n 0.80000 40500.0n 0.80000 40679.9n 0.80000 40680.0n 0.80000 40859.9n 0.80000 40860.0n 0.80000 41039.9n 0.80000 41040.0n 0.80000 41219.9n 0.80000 41220.0n 0.80000 41399.9n 0.80000 41400.0n 0.80000 41579.9n 0.80000 41580.0n 0.80000 41759.9n 0.80000 41760.0n 0.80000 41939.9n 0.80000 41940.0n 0.80000 42119.9n 0.80000 42120.0n 0.80000 42299.9n 0.80000 42300.0n 0.80000 42479.9n 0.80000 42480.0n 0.80000 42659.9n 0.80000 42660.0n 0.80000 42839.9n 0.80000 42840.0n 0.80000 43019.9n 0.80000 43020.0n 0.80000 43199.9n 0.80000 43200.0n 0.80000 43379.9n 0.80000 43380.0n 0.80000 43559.9n 0.80000 43560.0n 0.80000 43739.9n 0.80000 43740.0n 0.80000 43919.9n 0.80000 43920.0n 0.80000 44099.9n 0.80000 44100.0n 0.80000 44279.9n 0.80000 44280.0n 0.80000 44459.9n 0.80000 44460.0n 0.80000 44639.9n 0.80000 44640.0n 0.80000 44819.9n 0.80000 44820.0n 0.80000 44999.9n 0.80000 45000.0n 0.80000 45179.9n 0.80000 45180.0n 0.80000 45359.9n 0.80000 45360.0n 0.80000 45539.9n 0.80000 45540.0n 0.80000 45719.9n 0.80000 45720.0n 0.80000 45899.9n 0.80000 45900.0n 0.80000 46079.9n 0.80000 46080.0n 0.80000 46259.9n 0.80000 46260.0n 0.80000 46439.9n 0.80000 46440.0n 0.80000 46619.9n 0.80000 46620.0n 0.80000 46799.9n 0.80000 46800.0n 0.80000 46979.9n 0.80000 46980.0n 0.80000 47159.9n 0.80000 47160.0n 0.80000 47339.9n 0.80000 47340.0n 0.80000 47519.9n 0.80000 47520.0n 0.80000 47699.9n 0.80000 47700.0n 0.80000 47879.9n 0.80000 47880.0n 0.80000 48059.9n 0.80000 48060.0n 0.80000 48239.9n 0.80000 48240.0n 0.80000 48419.9n 0.80000 48420.0n 0.80000 48599.9n 0.80000 48600.0n 0.80000 48779.9n 0.80000 48780.0n 0.80000 48959.9n 0.80000 48960.0n 0.80000 49139.9n 0.80000 49140.0n 0.80000 49319.9n 0.80000 49320.0n 0.80000 49499.9n 0.80000 49500.0n 0.80000 49679.9n 0.80000 49680.0n 0.80000 49859.9n 0.80000 49860.0n 0.80000 50039.9n 0.80000 50040.0n 0.80000 50219.9n 0.80000 50220.0n 0.80000 50399.9n 0.80000 50400.0n 0.80000 50579.9n 0.80000 50580.0n 0.80000 50759.9n 0.80000 50760.0n 0.80000 50939.9n 0.80000 50940.0n 0.80000 51119.9n 0.80000 51120.0n 0.80000 51299.9n 0.80000 51300.0n 0.80000 51479.9n 0.80000 51480.0n 0.80000 51659.9n 0.80000 51660.0n 0.80000 51839.9n 0.80000 51840.0n 0.80000 52019.9n 0.80000 52020.0n 0.80000 52199.9n 0.80000 52200.0n 0.80000 52379.9n 0.80000 52380.0n 0.80000 52559.9n 0.80000 52560.0n 0.80000 52739.9n 0.80000 52740.0n 0.80000 52919.9n 0.80000 52920.0n 0.80000 53099.9n 0.80000 53100.0n 0.80000 53279.9n 0.80000 53280.0n 0.80000 53459.9n 0.80000 53460.0n 0.80000 53639.9n 0.80000 53640.0n 0.80000 53819.9n 0.80000 53820.0n 0.80000 53999.9n 0.80000 54000.0n 0.80000 54179.9n 0.80000 54180.0n 0.80000 54359.9n 0.80000 54360.0n 0.80000 54539.9n 0.80000 54540.0n 0.80000 54719.9n 0.80000 54720.0n 0.80000 54899.9n 0.80000 54900.0n 0.80000 55079.9n 0.80000 55080.0n 0.80000 55259.9n 0.80000 55260.0n 0.80000 55439.9n 0.80000 55440.0n 0.80000 55619.9n 0.80000 55620.0n 0.80000 55799.9n 0.80000 55800.0n 0.80000 55979.9n 0.80000 55980.0n 0.80000 56159.9n 0.80000 56160.0n 0.80000 56339.9n 0.80000 56340.0n 0.80000 56519.9n 0.80000 56520.0n 0.80000 56699.9n 0.80000 56700.0n 0.80000 56879.9n 0.80000 56880.0n 0.80000 57059.9n 0.80000 57060.0n 0.80000 57239.9n 0.80000 57240.0n 0.80000 57419.9n 0.80000 57420.0n 0.80000 57599.9n 0.80000 57600.0n 0.80000 57779.9n 0.80000 57780.0n 0.80000 57959.9n 0.80000 57960.0n 0.80000 58139.9n 0.80000 58140.0n 0.80000 58319.9n 0.80000 58320.0n 0.80000 58499.9n 0.80000 58500.0n 0.80000 58679.9n 0.80000 58680.0n 0.80000 58859.9n 0.80000 58860.0n 0.80000 59039.9n 0.80000 59040.0n 0.80000 59219.9n 0.80000 59220.0n 0.80000 59399.9n 0.80000 59400.0n 0.80000 59579.9n 0.80000 59580.0n 0.80000 59759.9n 0.80000 59760.0n 0.80000 59939.9n 0.80000 59940.0n 0.80000 60119.9n 0.80000 60120.0n 0.80000 60299.9n 0.80000 60300.0n 0.80000 60479.9n 0.80000 60480.0n 0.80000 60659.9n 0.80000 60660.0n 0.80000 60839.9n 0.80000 60840.0n 0.80000 61019.9n 0.80000 61020.0n 0.80000 61199.9n 0.80000 61200.0n 0.80000 61379.9n 0.80000 61380.0n 0.80000 61559.9n 0.80000 61560.0n 0.80000 61739.9n 0.80000 61740.0n 0.80000 61919.9n 0.80000 61920.0n 0.80000 62099.9n 0.80000 62100.0n 0.80000 62279.9n 0.80000 62280.0n 0.80000 62459.9n 0.80000 62460.0n 0.80000 62639.9n 0.80000 62640.0n 0.80000 62819.9n 0.80000 62820.0n 0.80000 62999.9n 0.80000 63000.0n 0.80000 63179.9n 0.80000 63180.0n 0.80000 63359.9n 0.80000 63360.0n 0.80000 63539.9n 0.80000 63540.0n 0.80000 63719.9n 0.80000 63720.0n 0.80000 63899.9n 0.80000 63900.0n 0.80000 64079.9n 0.80000 64080.0n 0.80000 64259.9n 0.80000 64260.0n 0.80000 64439.9n 0.80000 64440.0n 0.80000 64619.9n 0.80000 64620.0n 0.80000 64799.9n 0.80000 64800.0n 0.80000 64979.9n 0.80000 64980.0n 0.80000 65159.9n 0.80000 65160.0n 0.80000 65339.9n 0.80000 65340.0n 0.80000 65519.9n 0.80000 65520.0n 0.80000 65699.9n 0.80000 65700.0n 0.80000 65879.9n 0.80000 65880.0n 0.80000 66059.9n 0.80000 66060.0n 0.80000 66239.9n 0.80000 66240.0n 0.80000 66419.9n 0.80000 66420.0n 0.80000 66599.9n 0.80000 66600.0n 0.80000 66779.9n 0.80000 66780.0n 0.80000 66959.9n 0.80000 66960.0n 0.80000 67139.9n 0.80000 67140.0n 0.80000 67319.9n 0.80000 67320.0n 0.80000 67499.9n 0.80000 67500.0n 0.80000 67679.9n 0.80000 67680.0n 0.80000 67859.9n 0.80000 67860.0n 0.80000 68039.9n 0.80000 68040.0n 0.80000 68219.9n 0.80000 68220.0n 0.80000 68399.9n 0.80000 68400.0n 0.80000 68579.9n 0.80000 68580.0n 0.80000 68759.9n 0.80000 68760.0n 0.80000 68939.9n 0.80000 68940.0n 0.80000 69119.9n 0.80000 69120.0n 0.80000 69299.9n 0.80000 69300.0n 0.80000 69479.9n 0.80000 69480.0n 0.80000 69659.9n 0.80000 69660.0n 0.80000 69839.9n 0.80000 69840.0n 0.80000 70019.9n 0.80000 70020.0n 0.80000 70199.9n 0.80000 70200.0n 0.80000 70379.9n 0.80000 70380.0n 0.80000 70559.9n 0.80000 70560.0n 0.80000 70739.9n 0.80000 70740.0n 0.80000 70919.9n 0.80000 70920.0n 0.80000 71099.9n 0.80000 71100.0n 0.80000 71279.9n 0.80000 71280.0n 0.80000 71459.9n 0.80000 71460.0n 0.80000 71639.9n 0.80000 71640.0n 0.80000 71819.9n 0.80000 71820.0n 0.80000 71999.9n 0.80000 72000.0n 0.80000 72179.9n 0.80000 72180.0n 0.80000 72359.9n 0.80000 72360.0n 0.80000 72539.9n 0.80000 72540.0n 0.80000 72719.9n 0.80000 72720.0n 0.80000 72899.9n 0.80000 72900.0n 0.80000 73079.9n 0.80000 73080.0n 0.80000 73259.9n 0.80000 73260.0n 0.80000 73439.9n 0.80000 73440.0n 0.80000 73619.9n 0.80000 73620.0n 0.80000 73799.9n 0.80000 73800.0n 0.80000 73979.9n 0.80000 73980.0n 0.80000 74159.9n 0.80000 74160.0n 0.80000 74339.9n 0.80000 74340.0n 0.80000 74519.9n 0.80000 74520.0n 0.80000 74699.9n 0.80000 74700.0n 0.80000 74879.9n 0.80000 74880.0n 0.80000 75059.9n 0.80000 75060.0n 0.80000 75239.9n 0.80000 75240.0n 0.80000 75419.9n 0.80000 75420.0n 0.80000 75599.9n 0.80000 75600.0n 0.80000 75779.9n 0.80000 75780.0n 0.80000 75959.9n 0.80000 75960.0n 0.80000 76139.9n 0.80000 76140.0n 0.80000 76319.9n 0.80000 76320.0n 0.80000 76499.9n 0.80000 76500.0n 0.80000 76679.9n 0.80000 76680.0n 0.80000 76859.9n 0.80000 76860.0n 0.80000 77039.9n 0.80000 77040.0n 0.80000 77219.9n 0.80000 77220.0n 0.80000 77399.9n 0.80000 77400.0n 0.80000 77579.9n 0.80000 77580.0n 0.80000 77759.9n 0.80000 77760.0n 0.80000 77939.9n 0.80000 77940.0n 0.80000 78119.9n 0.80000 78120.0n 0.80000 78299.9n 0.80000 78300.0n 0.80000 78479.9n 0.80000 78480.0n 0.80000 78659.9n 0.80000 78660.0n 0.80000 78839.9n 0.80000 78840.0n 0.80000 79019.9n 0.80000 79020.0n 0.80000 79199.9n 0.80000 79200.0n 0.80000 79379.9n 0.80000 79380.0n 0.80000 79559.9n 0.80000 79560.0n 0.80000 79739.9n 0.80000 79740.0n 0.80000 79919.9n 0.80000 79920.0n 0.80000 80099.9n 0.80000 80100.0n 0.80000 80279.9n 0.80000 80280.0n 0.80000 80459.9n 0.80000 80460.0n 0.80000 80639.9n 0.80000 80640.0n 0.80000 80819.9n 0.80000 80820.0n 0.80000 80999.9n 0.80000 81000.0n 0.80000 81179.9n 0.80000 81180.0n 0.80000 81359.9n 0.80000 81360.0n 0.80000 81539.9n 0.80000 81540.0n 0.80000 81719.9n 0.80000 81720.0n 0.80000 81899.9n 0.80000 81900.0n 0.80000 82079.9n 0.80000 82080.0n 0.80000 82259.9n 0.80000 82260.0n 0.80000 82439.9n 0.80000 82440.0n 0.80000 82619.9n 0.80000 82620.0n 0.80000 82799.9n 0.80000 82800.0n 0.80000 82979.9n 0.80000 82980.0n 0.80000 83159.9n 0.80000 83160.0n 0.80000 83339.9n 0.80000 83340.0n 0.80000 83519.9n 0.80000 83520.0n 0.80000 83699.9n 0.80000 83700.0n 0.80000 83879.9n 0.80000 83880.0n 0.80000 84059.9n 0.80000 84060.0n 0.80000 84239.9n 0.80000 84240.0n 0.80000 84419.9n 0.80000 84420.0n 0.80000 84599.9n 0.80000 84600.0n 0.80000 84779.9n 0.80000 84780.0n 0.80000 84959.9n 0.80000 84960.0n 0.80000 85139.9n 0.80000 85140.0n 0.80000 85319.9n 0.80000 85320.0n 0.80000 85499.9n 0.80000 85500.0n 0.80000 85679.9n 0.80000 85680.0n 0.80000 85859.9n 0.80000 85860.0n 0.80000 86039.9n 0.80000 86040.0n 0.80000 86219.9n 0.80000 86220.0n 0.80000 86399.9n 0.80000 86400.0n 0.80000 86579.9n 0.80000 86580.0n 0.80000 86759.9n 0.80000 86760.0n 0.80000 86939.9n 0.80000 86940.0n 0.80000 87119.9n 0.80000 87120.0n 0.80000 87299.9n 0.80000 87300.0n 0.80000 87479.9n 0.80000 87480.0n 0.80000 87659.9n 0.80000 87660.0n 0.80000 87839.9n 0.80000 87840.0n 0.80000 88019.9n 0.80000 88020.0n 0.80000 88199.9n 0.80000 88200.0n 0.80000 88379.9n 0.80000 88380.0n 0.80000 88559.9n 0.80000 88560.0n 0.80000 88739.9n 0.80000 88740.0n 0.80000 88919.9n 0.80000 88920.0n 0.80000 89099.9n 0.80000 89100.0n 0.80000 89279.9n 0.80000 89280.0n 0.80000 89459.9n 0.80000 89460.0n 0.80000 89639.9n 0.80000 89640.0n 0.80000 89819.9n 0.80000 89820.0n 0.80000 89999.9n 0.80000 90000.0n 0.80000 90179.9n 0.80000 90180.0n 0.80000 90359.9n 0.80000 90360.0n 0.80000 90539.9n 0.80000 90540.0n 0.80000 90719.9n 0.80000 90720.0n 0.80000 90899.9n 0.80000 90900.0n 0.80000 91079.9n 0.80000 91080.0n 0.80000 91259.9n 0.80000 91260.0n 0.80000 91439.9n 0.80000 91440.0n 0.80000 91619.9n 0.80000 91620.0n 0.80000 91799.9n 0.80000 91800.0n 0.80000 91979.9n 0.80000 91980.0n 0.80000 92159.9n 0.80000 92160.0n 0.80000 92339.9n 0.80000 92340.0n 0.80000 92519.9n 0.80000 92520.0n 0.80000 92699.9n 0.80000 92700.0n 0.80000 92879.9n 0.80000 92880.0n 0.80000 93059.9n 0.80000 93060.0n 0.80000 93239.9n 0.80000 93240.0n 0.80000 93419.9n 0.80000 93420.0n 0.80000 93599.9n 0.80000 93600.0n 0.80000 93779.9n 0.80000 93780.0n 0.80000 93959.9n 0.80000 93960.0n 0.80000 94139.9n 0.80000 94140.0n 0.80000 94319.9n 0.80000 94320.0n 0.80000 94499.9n 0.80000 94500.0n 0.80000 94679.9n 0.80000 94680.0n 0.80000 94859.9n 0.80000 94860.0n 0.80000 95039.9n 0.80000 95040.0n 0.80000 95219.9n 0.80000 95220.0n 0.80000 95399.9n 0.80000 95400.0n 0.80000 95579.9n 0.80000 95580.0n 0.80000 95759.9n 0.80000 95760.0n 0.80000 95939.9n 0.80000 95940.0n 0.80000 96119.9n 0.80000 96120.0n 0.80000 96299.9n 0.80000 96300.0n 0.80000 96479.9n 0.80000 96480.0n 0.80000 96659.9n 0.80000 96660.0n 0.80000 96839.9n 0.80000 96840.0n 0.80000 97019.9n 0.80000 97020.0n 0.80000 97199.9n 0.80000 97200.0n 0.80000 97379.9n 0.80000 97380.0n 0.80000 97559.9n 0.80000 97560.0n 0.80000 97739.9n 0.80000 97740.0n 0.80000 97919.9n 0.80000 97920.0n 0.80000 98099.9n 0.80000 98100.0n 0.80000 98279.9n 0.80000 98280.0n 0.80000 98459.9n 0.80000 98460.0n 0.80000 98639.9n 0.80000 98640.0n 0.80000 98819.9n 0.80000 98820.0n 0.80000 98999.9n 0.80000 99000.0n 0.80000 99179.9n 0.80000 99180.0n 0.80000 99359.9n 0.80000 99360.0n 0.80000 99539.9n 0.80000 99540.0n 0.80000 99719.9n 0.80000 99720.0n 0.80000 99899.9n 0.80000 99900.0n 0.80000 100079.9n 0.80000 100080.0n 0.80000 100259.9n 0.80000 100260.0n 0.80000 100439.9n 0.80000 100440.0n 0.80000 100619.9n 0.80000 100620.0n 0.80000 100799.9n 0.80000 100800.0n 0.80000 100979.9n 0.80000 100980.0n 0.80000 101159.9n 0.80000 101160.0n 0.80000 101339.9n 0.80000 101340.0n 0.80000 101519.9n 0.80000 101520.0n 0.80000 101699.9n 0.80000 101700.0n 0.80000 101879.9n 0.80000 101880.0n 0.80000 102059.9n 0.80000 102060.0n 0.80000 102239.9n 0.80000 102240.0n 0.80000 102419.9n 0.80000 102420.0n 0.80000 102599.9n 0.80000 102600.0n 0.80000 102779.9n 0.80000 102780.0n 0.80000 102959.9n 0.80000 102960.0n 0.80000 103139.9n 0.80000 103140.0n 0.80000 103319.9n 0.80000 103320.0n 0.80000 103499.9n 0.80000 103500.0n 0.80000 103679.9n 0.80000 103680.0n 0.80000 103859.9n 0.80000 103860.0n 0.80000 104039.9n 0.80000 104040.0n 0.80000 104219.9n 0.80000 104220.0n 0.80000 104399.9n 0.80000 104400.0n 0.80000 104579.9n 0.80000 104580.0n 0.80000 104759.9n 0.80000 104760.0n 0.80000 104939.9n 0.80000 104940.0n 0.80000 105119.9n 0.80000 105120.0n 0.80000 105299.9n 0.80000 105300.0n 0.80000 105479.9n 0.80000 105480.0n 0.80000 105659.9n 0.80000 105660.0n 0.80000 105839.9n 0.80000 105840.0n 0.80000 106019.9n 0.80000 106020.0n 0.80000 106199.9n 0.80000 106200.0n 0.80000 106379.9n 0.80000 106380.0n 0.80000 106559.9n 0.80000 106560.0n 0.80000 106739.9n 0.80000 106740.0n 0.80000 106919.9n 0.80000 106920.0n 0.80000 107099.9n 0.80000 107100.0n 0.80000 107279.9n 0.80000 107280.0n 0.80000 107459.9n 0.80000 107460.0n 0.80000 107639.9n 0.80000 107640.0n 0.80000 107819.9n 0.80000 107820.0n 0.80000 107999.9n 0.80000 108000.0n 0.80000 108179.9n 0.80000 108180.0n 0.80000 108359.9n 0.80000 108360.0n 0.80000 108539.9n 0.80000 108540.0n 0.80000 108719.9n 0.80000 108720.0n 0.80000 108899.9n 0.80000 108900.0n 0.80000 109079.9n 0.80000 109080.0n 0.80000 109259.9n 0.80000 109260.0n 0.80000 109439.9n 0.80000 109440.0n 0.80000 109619.9n 0.80000 109620.0n 0.80000 109799.9n 0.80000 109800.0n 0.80000 109979.9n 0.80000 109980.0n 0.80000 110159.9n 0.80000 110160.0n 0.80000 110339.9n 0.80000 110340.0n 0.80000 110519.9n 0.80000 110520.0n 0.80000 110699.9n 0.80000 110700.0n 0.80000 110879.9n 0.80000 110880.0n 0.80000 111059.9n 0.80000 111060.0n 0.80000 111239.9n 0.80000 111240.0n 0.80000 111419.9n 0.80000 111420.0n 0.80000 111599.9n 0.80000 111600.0n 0.80000 111779.9n 0.80000 111780.0n 0.80000 111959.9n 0.80000 111960.0n 0.80000 112139.9n 0.80000 112140.0n 0.80000 112319.9n 0.80000 112320.0n 0.80000 112499.9n 0.80000 112500.0n 0.80000 112679.9n 0.80000 112680.0n 0.80000 112859.9n 0.80000 112860.0n 0.80000 113039.9n 0.80000 113040.0n 0.80000 113219.9n 0.80000 113220.0n 0.80000 113399.9n 0.80000 113400.0n 0.80000 113579.9n 0.80000 113580.0n 0.80000 113759.9n 0.80000 113760.0n 0.80000 113939.9n 0.80000 113940.0n 0.80000 114119.9n 0.80000 114120.0n 0.80000 114299.9n 0.80000 114300.0n 0.80000 114479.9n 0.80000 114480.0n 0.80000 114659.9n 0.80000 114660.0n 0.80000 114839.9n 0.80000 114840.0n 0.80000 115019.9n 0.80000 115020.0n 0.80000 115199.9n 0.80000 115200.0n 0.80000 115379.9n 0.80000 115380.0n 0.80000 115559.9n 0.80000 115560.0n 0.80000 115739.9n 0.80000 115740.0n 0.80000 115919.9n 0.80000 115920.0n 0.80000 116099.9n 0.80000 116100.0n 0.80000 116279.9n 0.80000 116280.0n 0.80000 116459.9n 0.80000 116460.0n 0.80000 116639.9n 0.80000 116640.0n 0.80000 116819.9n 0.80000 116820.0n 0.80000 116999.9n 0.80000 117000.0n 0.80000 117179.9n 0.80000 117180.0n 0.80000 117359.9n 0.80000 117360.0n 0.80000 117539.9n 0.80000 117540.0n 0.80000 117719.9n 0.80000 117720.0n 0.80000 117899.9n 0.80000 117900.0n 0.80000 118079.9n 0.80000 118080.0n 0.80000 118259.9n 0.80000 118260.0n 0.80000 118439.9n 0.80000 118440.0n 0.80000 118619.9n 0.80000 118620.0n 0.80000 118799.9n 0.80000 118800.0n 0.80000 118979.9n 0.80000 118980.0n 0.80000 119159.9n 0.80000 119160.0n 0.80000 119339.9n 0.80000 119340.0n 0.80000 119519.9n 0.80000 119520.0n 0.80000 119699.9n 0.80000 119700.0n 0.80000 119879.9n 0.80000 119880.0n 0.80000 120059.9n 0.80000 120060.0n 0.80000 120239.9n 0.80000 120240.0n 0.80000 120419.9n 0.80000 120420.0n 0.80000 120599.9n 0.80000 120600.0n 0.80000 120779.9n 0.80000 120780.0n 0.80000 120959.9n 0.80000 120960.0n 0.80000 121139.9n 0.80000 121140.0n 0.80000 121319.9n 0.80000 121320.0n 0.80000 121499.9n 0.80000 121500.0n 0.80000 121679.9n 0.80000 121680.0n 0.80000 121859.9n 0.80000 121860.0n 0.80000 122039.9n 0.80000 122040.0n 0.80000 122219.9n 0.80000 122220.0n 0.80000 122399.9n 0.80000 122400.0n 0.80000 122579.9n 0.80000 122580.0n 0.80000 122759.9n 0.80000 122760.0n 0.80000 122939.9n 0.80000 122940.0n 0.80000 123119.9n 0.80000 123120.0n 0.80000 123299.9n 0.80000 123300.0n 0.80000 123479.9n 0.80000 123480.0n 0.80000 123659.9n 0.80000 123660.0n 0.80000 123839.9n 0.80000 123840.0n 0.80000 124019.9n 0.80000 124020.0n 0.80000 124199.9n 0.80000 124200.0n 0.80000 124379.9n 0.80000 124380.0n 0.80000 124559.9n 0.80000 124560.0n 0.80000 124739.9n 0.80000 124740.0n 0.80000 124919.9n 0.80000 124920.0n 0.80000 125099.9n 0.80000 125100.0n 0.80000 125279.9n 0.80000 125280.0n 0.80000 125459.9n 0.80000 125460.0n 0.80000 125639.9n 0.80000 125640.0n 0.80000 125819.9n 0.80000 125820.0n 0.80000 125999.9n 0.80000 126000.0n 0.80000 126179.9n 0.80000 126180.0n 0.80000 126359.9n 0.80000 126360.0n 0.80000 126539.9n 0.80000 126540.0n 0.80000 126719.9n 0.80000 126720.0n 0.80000 126899.9n 0.80000 126900.0n 0.80000 127079.9n 0.80000 127080.0n 0.80000 127259.9n 0.80000 127260.0n 0.80000 127439.9n 0.80000 127440.0n 0.80000 127619.9n 0.80000 127620.0n 0.80000 127799.9n 0.80000 127800.0n 0.80000 127979.9n 0.80000 127980.0n 0.80000 128159.9n 0.80000 128160.0n 0.80000 128339.9n 0.80000 128340.0n 0.80000 128519.9n 0.80000 128520.0n 0.80000 128699.9n 0.80000 128700.0n 0.80000 128879.9n 0.80000 128880.0n 0.80000 129059.9n 0.80000 129060.0n 0.80000 129239.9n 0.80000 129240.0n 0.80000 129419.9n 0.80000 129420.0n 0.80000 129599.9n 0.80000 129600.0n 0.80000 129779.9n 0.80000 129780.0n 0.80000 129959.9n 0.80000 129960.0n 0.80000 130139.9n 0.80000 130140.0n 0.80000 130319.9n 0.80000 130320.0n 0.80000 130499.9n 0.80000 130500.0n 0.80000 130679.9n 0.80000 130680.0n 0.80000 130859.9n 0.80000 130860.0n 0.80000 131039.9n 0.80000 131040.0n 0.80000 131219.9n 0.80000 131220.0n 0.80000 131399.9n 0.80000 131400.0n 0.80000 131579.9n 0.80000 131580.0n 0.80000 131759.9n 0.80000 131760.0n 0.80000 131939.9n 0.80000 131940.0n 0.80000 132119.9n 0.80000 132120.0n 0.80000 132299.9n 0.80000 132300.0n 0.80000 132479.9n 0.80000 132480.0n 0.80000 132659.9n 0.80000 132660.0n 0.80000 132839.9n 0.80000 132840.0n 0.80000 133019.9n 0.80000 133020.0n 0.80000 133199.9n 0.80000 133200.0n 0.80000 133379.9n 0.80000 133380.0n 0.80000 133559.9n 0.80000 133560.0n 0.80000 133739.9n 0.80000 133740.0n 0.80000 133919.9n 0.80000 133920.0n 0.80000 134099.9n 0.80000 134100.0n 0.80000 134279.9n 0.80000 134280.0n 0.80000 134459.9n 0.80000 134460.0n 0.80000 134639.9n 0.80000 134640.0n 0.80000 134819.9n 0.80000 134820.0n 0.80000 134999.9n 0.80000 135000.0n 0.80000 135179.9n 0.80000 135180.0n 0.80000 135359.9n 0.80000 135360.0n 0.80000 135539.9n 0.80000 135540.0n 0.80000 135719.9n 0.80000 135720.0n 0.80000 135899.9n 0.80000 135900.0n 0.80000 136079.9n 0.80000 136080.0n 0.80000 136259.9n 0.80000 136260.0n 0.80000 136439.9n 0.80000 136440.0n 0.80000 136619.9n 0.80000 136620.0n 0.80000 136799.9n 0.80000 136800.0n 0.80000 136979.9n 0.80000 136980.0n 0.80000 137159.9n 0.80000 137160.0n 0.80000 137339.9n 0.80000 137340.0n 0.80000 137519.9n 0.80000 137520.0n 0.80000 137699.9n 0.80000 137700.0n 0.80000 137879.9n 0.80000 137880.0n 0.80000 138059.9n 0.80000 138060.0n 0.80000 138239.9n 0.80000 138240.0n 0.80000 138419.9n 0.80000 138420.0n 0.80000 138599.9n 0.80000 138600.0n 0.80000 138779.9n 0.80000 138780.0n 0.80000 138959.9n 0.80000 138960.0n 0.80000 139139.9n 0.80000 139140.0n 0.80000 139319.9n 0.80000 139320.0n 0.80000 139499.9n 0.80000 139500.0n 0.80000 139679.9n 0.80000 139680.0n 0.80000 139859.9n 0.80000 139860.0n 0.80000 140039.9n 0.80000 140040.0n 0.80000 140219.9n 0.80000 140220.0n 0.80000 140399.9n 0.80000 140400.0n 0.80000 140579.9n 0.80000 140580.0n 0.80000 140759.9n 0.80000 140760.0n 0.80000 140939.9n 0.80000 140940.0n 0.80000 141119.9n 0.80000 141120.0n 0.80000 141299.9n 0.80000 141300.0n 0.80000 141479.9n 0.80000 141480.0n 0.80000 141659.9n 0.80000 141660.0n 0.80000 141839.9n 0.80000 141840.0n 0.80000 142019.9n 0.80000 142020.0n 0.80000 142199.9n 0.80000 142200.0n 0.80000 142379.9n 0.80000 142380.0n 0.80000 142559.9n 0.80000 142560.0n 0.80000 142739.9n 0.80000 142740.0n 0.80000 142919.9n 0.80000 142920.0n 0.80000 143099.9n 0.80000 143100.0n 0.80000 143279.9n 0.80000 143280.0n 0.80000 143459.9n 0.80000 143460.0n 0.80000 143639.9n 0.80000 143640.0n 0.80000 143819.9n 0.80000 143820.0n 0.80000 143999.9n 0.80000 144000.0n 0.80000 144179.9n 0.80000 144180.0n 0.80000 144359.9n 0.80000 144360.0n 0.80000 144539.9n 0.80000 144540.0n 0.80000 144719.9n 0.80000 144720.0n 0.80000 144899.9n 0.80000 144900.0n 0.80000 145079.9n 0.80000 145080.0n 0.80000 145259.9n 0.80000 145260.0n 0.80000 145439.9n 0.80000 145440.0n 0.80000 145619.9n 0.80000 145620.0n 0.80000 145799.9n 0.80000 145800.0n 0.80000 145979.9n 0.80000 145980.0n 0.80000 146159.9n 0.80000 146160.0n 0.80000 146339.9n 0.80000 146340.0n 0.80000 146519.9n 0.80000 146520.0n 0.80000 146699.9n 0.80000 146700.0n 0.80000 146879.9n 0.80000 146880.0n 0.80000 147059.9n 0.80000 147060.0n 0.80000 147239.9n 0.80000 147240.0n 0.80000 147419.9n 0.80000 147420.0n 0.80000 147599.9n 0.80000 147600.0n 0.80000 147779.9n 0.80000 147780.0n 0.80000 147959.9n 0.80000 147960.0n 0.80000 148139.9n 0.80000 148140.0n 0.80000 148319.9n 0.80000 148320.0n 0.80000 148499.9n 0.80000 148500.0n 0.80000 148679.9n 0.80000 148680.0n 0.80000 148859.9n 0.80000 148860.0n 0.80000 149039.9n 0.80000 149040.0n 0.80000 149219.9n 0.80000 149220.0n 0.80000 149399.9n 0.80000 149400.0n 0.80000 149579.9n 0.80000 149580.0n 0.80000 149759.9n 0.80000 149760.0n 0.80000 149939.9n 0.80000 149940.0n 0.80000 150119.9n 0.80000 150120.0n 0.80000 150299.9n 0.80000 150300.0n 0.80000 150479.9n 0.80000 150480.0n 0.80000 150659.9n 0.80000 150660.0n 0.80000 150839.9n 0.80000 150840.0n 0.80000 151019.9n 0.80000 151020.0n 0.80000 151199.9n 0.80000 151200.0n 0.80000 151379.9n 0.80000 151380.0n 0.80000 151559.9n 0.80000 151560.0n 0.80000 151739.9n 0.80000 151740.0n 0.80000 151919.9n 0.80000 151920.0n 0.80000 152099.9n 0.80000 152100.0n 0.80000 152279.9n 0.80000 152280.0n 0.80000 152459.9n 0.80000 152460.0n 0.80000 152639.9n 0.80000 152640.0n 0.80000 152819.9n 0.80000 152820.0n 0.80000 152999.9n 0.80000 153000.0n 0.80000 153179.9n 0.80000 153180.0n 0.80000 153359.9n 0.80000 153360.0n 0.80000 153539.9n 0.80000 153540.0n 0.80000 153719.9n 0.80000 153720.0n 0.80000 153899.9n 0.80000 153900.0n 0.80000 154079.9n 0.80000 154080.0n 0.80000 154259.9n 0.80000 154260.0n 0.80000 154439.9n 0.80000 154440.0n 0.80000 154619.9n 0.80000 154620.0n 0.80000 154799.9n 0.80000 154800.0n 0.80000 154979.9n 0.80000 154980.0n 0.80000 155159.9n 0.80000 155160.0n 0.80000 155339.9n 0.80000 155340.0n 0.80000 155519.9n 0.80000 155520.0n 0.80000 155699.9n 0.80000 155700.0n 0.80000 155879.9n 0.80000 155880.0n 0.80000 156059.9n 0.80000 156060.0n 0.80000 156239.9n 0.80000 156240.0n 0.80000 156419.9n 0.80000 156420.0n 0.80000 156599.9n 0.80000 156600.0n 0.80000 156779.9n 0.80000 156780.0n 0.80000 156959.9n 0.80000 156960.0n 0.80000 157139.9n 0.80000 157140.0n 0.80000 157319.9n 0.80000 157320.0n 0.80000 157499.9n 0.80000 157500.0n 0.80000 157679.9n 0.80000 157680.0n 0.80000 157859.9n 0.80000 157860.0n 0.80000 158039.9n 0.80000 158040.0n 0.80000 158219.9n 0.80000 158220.0n 0.80000 158399.9n 0.80000 158400.0n 0.80000 158579.9n 0.80000 158580.0n 0.80000 158759.9n 0.80000 158760.0n 0.80000 158939.9n 0.80000 158940.0n 0.80000 159119.9n 0.80000 159120.0n 0.80000 159299.9n 0.80000 159300.0n 0.80000 159479.9n 0.80000 159480.0n 0.80000 159659.9n 0.80000 159660.0n 0.80000 159839.9n 0.80000 159840.0n 0.80000 160019.9n 0.80000 160020.0n 0.80000 160199.9n 0.80000 160200.0n 0.80000 160379.9n 0.80000 160380.0n 0.80000 160559.9n 0.80000 160560.0n 0.80000 160739.9n 0.80000 160740.0n 0.80000 160919.9n 0.80000 160920.0n 0.80000 161099.9n 0.80000 161100.0n 0.80000 161279.9n 0.80000 161280.0n 0.80000 161459.9n 0.80000 161460.0n 0.80000 161639.9n 0.80000 161640.0n 0.80000 161819.9n 0.80000 161820.0n 0.80000 161999.9n 0.80000 162000.0n 0.80000 162179.9n 0.80000 162180.0n 0.80000 162359.9n 0.80000 162360.0n 0.80000 162539.9n 0.80000 162540.0n 0.80000 162719.9n 0.80000 162720.0n 0.80000 162899.9n 0.80000 162900.0n 0.80000 163079.9n 0.80000 163080.0n 0.80000 163259.9n 0.80000 163260.0n 0.80000 163439.9n 0.80000 163440.0n 0.80000 163619.9n 0.80000 163620.0n 0.80000 163799.9n 0.80000 163800.0n 0.80000 163979.9n 0.80000 163980.0n 0.80000 164159.9n 0.80000 164160.0n 0.80000 164339.9n 0.80000 164340.0n 0.80000 164519.9n 0.80000 164520.0n 0.80000 164699.9n 0.80000 164700.0n 0.80000 164879.9n 0.80000 164880.0n 0.80000 165059.9n 0.80000 165060.0n 0.80000 165239.9n 0.80000 165240.0n 0.80000 165419.9n 0.80000 165420.0n 0.80000 165599.9n 0.80000 165600.0n 0.80000 165779.9n 0.80000 165780.0n 0.80000 165959.9n 0.80000 165960.0n 0.80000 166139.9n 0.80000 166140.0n 0.80000 166319.9n 0.80000 166320.0n 0.80000 166499.9n 0.80000 166500.0n 0.80000 166679.9n 0.80000 166680.0n 0.80000 166859.9n 0.80000 166860.0n 0.80000 167039.9n 0.80000 167040.0n 0.80000 167219.9n 0.80000 167220.0n 0.80000 167399.9n 0.80000 167400.0n 0.80000 167579.9n 0.80000 167580.0n 0.80000 167759.9n 0.80000 167760.0n 0.80000 167939.9n 0.80000 167940.0n 0.80000 168119.9n 0.80000 168120.0n 0.80000 168299.9n 0.80000 168300.0n 0.80000 168479.9n 0.80000 168480.0n 0.80000 168659.9n 0.80000 168660.0n 0.80000 168839.9n 0.80000 168840.0n 0.80000 169019.9n 0.80000 169020.0n 0.80000 169199.9n 0.80000 169200.0n 0.80000 169379.9n 0.80000 169380.0n 0.80000 169559.9n 0.80000 169560.0n 0.80000 169739.9n 0.80000 169740.0n 0.80000 169919.9n 0.80000 169920.0n 0.80000 170099.9n 0.80000 170100.0n 0.80000 170279.9n 0.80000 170280.0n 0.80000 170459.9n 0.80000 170460.0n 0.80000 170639.9n 0.80000 170640.0n 0.80000 170819.9n 0.80000 170820.0n 0.80000 170999.9n 0.80000 171000.0n 0.80000 171179.9n 0.80000 171180.0n 0.80000 171359.9n 0.80000 171360.0n 0.80000 171539.9n 0.80000 171540.0n 0.80000 171719.9n 0.80000 171720.0n 0.80000 171899.9n 0.80000 171900.0n 0.80000 172079.9n 0.80000 172080.0n 0.80000 172259.9n 0.80000 172260.0n 0.80000 172439.9n 0.80000 172440.0n 0.80000 172619.9n 0.80000 172620.0n 0.80000 172799.9n 0.80000 172800.0n 0.00000 172979.9n 0.00000 172980.0n 0.00000 173159.9n 0.00000 173160.0n 0.00000 173339.9n 0.00000 173340.0n 0.00000 173519.9n 0.00000 173520.0n 0.00000 173699.9n 0.00000 173700.0n 0.00000 173879.9n 0.00000 173880.0n 0.00000 174059.9n 0.00000 174060.0n 0.00000 174239.9n 0.00000 174240.0n 0.00000 174419.9n 0.00000 174420.0n 0.00000 174599.9n 0.00000 174600.0n 0.00000 174779.9n 0.00000 174780.0n 0.00000 174959.9n 0.00000 174960.0n 0.00000 175139.9n 0.00000 175140.0n 0.00000 175319.9n 0.00000 175320.0n 0.00000 175499.9n 0.00000 175500.0n 0.00000 175679.9n 0.00000 175680.0n 0.00000 175859.9n 0.00000 175860.0n 0.00000 176039.9n 0.00000 176040.0n 0.00000 176219.9n 0.00000 176220.0n 0.00000 176399.9n 0.00000 176400.0n 0.00000 176579.9n 0.00000 176580.0n 0.00000 176759.9n 0.00000 176760.0n 0.00000 176939.9n 0.00000 176940.0n 0.00000 177119.9n 0.00000 177120.0n 0.00000 177299.9n 0.00000 177300.0n 0.00000 177479.9n 0.00000 177480.0n 0.00000 177659.9n 0.00000 177660.0n 0.00000 177839.9n 0.00000 177840.0n 0.00000 178019.9n 0.00000 178020.0n 0.00000 178199.9n 0.00000 178200.0n 0.00000 178379.9n 0.00000 178380.0n 0.00000 178559.9n 0.00000 178560.0n 0.00000 178739.9n 0.00000 178740.0n 0.00000 178919.9n 0.00000 178920.0n 0.00000 179099.9n 0.00000 179100.0n 0.00000 179279.9n 0.00000 179280.0n 0.00000 179459.9n 0.00000 179460.0n 0.00000 179639.9n 0.00000 179640.0n 0.00000 179819.9n 0.00000 179820.0n 0.00000 179999.9n 0.00000 180000.0n 0.00000 180179.9n 0.00000 180180.0n 0.00000 180359.9n 0.00000 180360.0n 0.00000 180539.9n 0.00000 180540.0n 0.00000 180719.9n 0.00000 180720.0n 0.00000 180899.9n 0.00000 180900.0n 0.00000 181079.9n 0.00000 181080.0n 0.00000 181259.9n 0.00000 181260.0n 0.00000 181439.9n 0.00000 181440.0n 0.00000 181619.9n 0.00000 181620.0n 0.00000 181799.9n 0.00000 181800.0n 0.00000 181979.9n 0.00000 181980.0n 0.00000 182159.9n 0.00000 182160.0n 0.00000 182339.9n 0.00000 182340.0n 0.00000 182519.9n 0.00000 182520.0n 0.00000 182699.9n 0.00000 182700.0n 0.00000 182879.9n 0.00000 182880.0n 0.00000 183059.9n 0.00000 183060.0n 0.00000 183239.9n 0.00000 183240.0n 0.00000 183419.9n 0.00000 183420.0n 0.00000)
Vxp0 a_xp0 0 PWL(0.0n 0.43581 179.9n 0.43581 180.0n 0.27643 359.9n 0.27643 360.0n 0.86030 539.9n 0.86030 540.0n 0.52079 719.9n 0.52079 720.0n 0.69502 899.9n 0.69502 900.0n 0.10559 1079.9n 0.10559 1080.0n 0.47556 1259.9n 0.47556 1260.0n 0.53141 1439.9n 0.53141 1440.0n 0.17082 1619.9n 0.17082 1620.0n 0.69969 1799.9n 0.69969 1800.0n -0.14927 1979.9n -0.14927 1980.0n 0.24079 2159.9n 0.24079 2160.0n 1.36668 2339.9n 1.36668 2340.0n 0.96459 2519.9n 0.96459 2520.0n 0.56449 2699.9n 0.56449 2700.0n 0.73600 2879.9n 0.73600 2880.0n 0.88832 3059.9n 0.88832 3060.0n -0.31038 3239.9n -0.31038 3240.0n 1.07007 3419.9n 1.07007 3420.0n 0.35630 3599.9n 0.35630 3600.0n 0.27076 3779.9n 0.27076 3780.0n 0.55066 3959.9n 0.55066 3960.0n 1.38855 4139.9n 1.38855 4140.0n 0.26419 4319.9n 0.26419 4320.0n 0.31139 4499.9n 0.31139 4500.0n -0.04662 4679.9n -0.04662 4680.0n 0.55006 4859.9n 0.55006 4860.0n 0.48508 5039.9n 0.48508 5040.0n 0.21498 5219.9n 0.21498 5220.0n 0.20119 5399.9n 0.20119 5400.0n 0.70685 5579.9n 0.70685 5580.0n 1.21890 5759.9n 1.21890 5760.0n 0.21498 5939.9n 0.21498 5940.0n 0.27643 6119.9n 0.27643 6120.0n 0.73600 6299.9n 0.73600 6300.0n 0.48508 6479.9n 0.48508 6480.0n -0.04662 6659.9n -0.04662 6660.0n 0.96459 6839.9n 0.96459 6840.0n 0.88832 7019.9n 0.88832 7020.0n 0.26419 7199.9n 0.26419 7200.0n 1.38855 7379.9n 1.38855 7380.0n 0.27076 7559.9n 0.27076 7560.0n -0.14927 7739.9n -0.14927 7740.0n 0.86030 7919.9n 0.86030 7920.0n 0.43581 8099.9n 0.43581 8100.0n 0.55006 8279.9n 0.55006 8280.0n -0.31038 8459.9n -0.31038 8460.0n 0.55066 8639.9n 0.55066 8640.0n 0.52079 8819.9n 0.52079 8820.0n 0.17082 8999.9n 0.17082 9000.0n 0.56449 9179.9n 0.56449 9180.0n 0.20119 9359.9n 0.20119 9360.0n 0.53141 9539.9n 0.53141 9540.0n 0.47556 9719.9n 0.47556 9720.0n 0.69502 9899.9n 0.69502 9900.0n 1.36668 10079.9n 1.36668 10080.0n 0.35630 10259.9n 0.35630 10260.0n 0.10559 10439.9n 0.10559 10440.0n 0.24079 10619.9n 0.24079 10620.0n 0.69969 10799.9n 0.69969 10800.0n 1.07007 10979.9n 1.07007 10980.0n 0.70685 11159.9n 0.70685 11160.0n 1.21890 11339.9n 1.21890 11340.0n 0.31139 11519.9n 0.31139 11520.0n 0.55066 11699.9n 0.55066 11700.0n 0.27076 11879.9n 0.27076 11880.0n 0.35630 12059.9n 0.35630 12060.0n 0.86030 12239.9n 0.86030 12240.0n 0.56449 12419.9n 0.56449 12420.0n 0.20119 12599.9n 0.20119 12600.0n -0.31038 12779.9n -0.31038 12780.0n 1.36668 12959.9n 1.36668 12960.0n 1.07007 13139.9n 1.07007 13140.0n 0.47556 13319.9n 0.47556 13320.0n -0.04662 13499.9n -0.04662 13500.0n 0.26419 13679.9n 0.26419 13680.0n 1.38855 13859.9n 1.38855 13860.0n 0.21498 14039.9n 0.21498 14040.0n 0.31139 14219.9n 0.31139 14220.0n 0.55006 14399.9n 0.55006 14400.0n 0.43581 14579.9n 0.43581 14580.0n 0.69502 14759.9n 0.69502 14760.0n 1.21890 14939.9n 1.21890 14940.0n 0.96459 15119.9n 0.96459 15120.0n 0.70685 15299.9n 0.70685 15300.0n 0.69969 15479.9n 0.69969 15480.0n 0.10559 15659.9n 0.10559 15660.0n 0.73600 15839.9n 0.73600 15840.0n 0.27643 16019.9n 0.27643 16020.0n -0.14927 16199.9n -0.14927 16200.0n 0.24079 16379.9n 0.24079 16380.0n 0.52079 16559.9n 0.52079 16560.0n 0.88832 16739.9n 0.88832 16740.0n 0.48508 16919.9n 0.48508 16920.0n 0.17082 17099.9n 0.17082 17100.0n 0.53141 17279.9n 0.53141 17280.0n 0.70685 17459.9n 0.70685 17460.0n 0.21498 17639.9n 0.21498 17640.0n 1.07007 17819.9n 1.07007 17820.0n 0.48508 17999.9n 0.48508 18000.0n -0.31038 18179.9n -0.31038 18180.0n 1.36668 18359.9n 1.36668 18360.0n 0.73600 18539.9n 0.73600 18540.0n 0.27643 18719.9n 0.27643 18720.0n 0.88832 18899.9n 0.88832 18900.0n 0.26419 19079.9n 0.26419 19080.0n 0.10559 19259.9n 0.10559 19260.0n 0.17082 19439.9n 0.17082 19440.0n 0.69969 19619.9n 0.69969 19620.0n 0.20119 19799.9n 0.20119 19800.0n 0.27076 19979.9n 0.27076 19980.0n 1.38855 20159.9n 1.38855 20160.0n 0.86030 20339.9n 0.86030 20340.0n 0.35630 20519.9n 0.35630 20520.0n 1.21890 20699.9n 1.21890 20700.0n 0.31139 20879.9n 0.31139 20880.0n 0.96459 21059.9n 0.96459 21060.0n 0.56449 21239.9n 0.56449 21240.0n 0.47556 21419.9n 0.47556 21420.0n 0.43581 21599.9n 0.43581 21600.0n 0.55066 21779.9n 0.55066 21780.0n 0.55006 21959.9n 0.55006 21960.0n -0.14927 22139.9n -0.14927 22140.0n 0.24079 22319.9n 0.24079 22320.0n 0.53141 22499.9n 0.53141 22500.0n 0.69502 22679.9n 0.69502 22680.0n 0.52079 22859.9n 0.52079 22860.0n -0.04662 23039.9n -0.04662 23040.0n 0.88832 23219.9n 0.88832 23220.0n 0.69502 23399.9n 0.69502 23400.0n 1.36668 23579.9n 1.36668 23580.0n 0.47556 23759.9n 0.47556 23760.0n 0.20119 23939.9n 0.20119 23940.0n -0.14927 24119.9n -0.14927 24120.0n 1.07007 24299.9n 1.07007 24300.0n 0.52079 24479.9n 0.52079 24480.0n 0.86030 24659.9n 0.86030 24660.0n 0.56449 24839.9n 0.56449 24840.0n 0.96459 25019.9n 0.96459 25020.0n 0.27076 25199.9n 0.27076 25200.0n 0.35630 25379.9n 0.35630 25380.0n 0.48508 25559.9n 0.48508 25560.0n 0.31139 25739.9n 0.31139 25740.0n 1.38855 25919.9n 1.38855 25920.0n 0.21498 26099.9n 0.21498 26100.0n 0.69969 26279.9n 0.69969 26280.0n -0.04662 26459.9n -0.04662 26460.0n 0.55006 26639.9n 0.55006 26640.0n -0.31038 26819.9n -0.31038 26820.0n 0.27643 26999.9n 0.27643 27000.0n 0.55066 27179.9n 0.55066 27180.0n 0.24079 27359.9n 0.24079 27360.0n 0.73600 27539.9n 0.73600 27540.0n 1.21890 27719.9n 1.21890 27720.0n 0.10559 27899.9n 0.10559 27900.0n 0.17082 28079.9n 0.17082 28080.0n 0.53141 28259.9n 0.53141 28260.0n 0.26419 28439.9n 0.26419 28440.0n 0.43581 28619.9n 0.43581 28620.0n 0.70685 28799.9n 0.70685 28800.0n 0.73600 28979.9n 0.73600 28980.0n 0.48508 29159.9n 0.48508 29160.0n 0.10559 29339.9n 0.10559 29340.0n 0.69969 29519.9n 0.69969 29520.0n 0.27076 29699.9n 0.27076 29700.0n 0.52079 29879.9n 0.52079 29880.0n 0.20119 30059.9n 0.20119 30060.0n 0.55066 30239.9n 0.55066 30240.0n 1.38855 30419.9n 1.38855 30420.0n 0.88832 30599.9n 0.88832 30600.0n 0.69502 30779.9n 0.69502 30780.0n 0.70685 30959.9n 0.70685 30960.0n 0.47556 31139.9n 0.47556 31140.0n 0.86030 31319.9n 0.86030 31320.0n 0.26419 31499.9n 0.26419 31500.0n 0.17082 31679.9n 0.17082 31680.0n 0.21498 31859.9n 0.21498 31860.0n 0.31139 32039.9n 0.31139 32040.0n -0.04662 32219.9n -0.04662 32220.0n -0.14927 32399.9n -0.14927 32400.0n 0.24079 32579.9n 0.24079 32580.0n 0.56449 32759.9n 0.56449 32760.0n 1.36668 32939.9n 1.36668 32940.0n 1.21890 33119.9n 1.21890 33120.0n 1.07007 33299.9n 1.07007 33300.0n 0.53141 33479.9n 0.53141 33480.0n 0.35630 33659.9n 0.35630 33660.0n 0.27643 33839.9n 0.27643 33840.0n 0.96459 34019.9n 0.96459 34020.0n -0.31038 34199.9n -0.31038 34200.0n 0.55006 34379.9n 0.55006 34380.0n 0.43581 34559.9n 0.43581 34560.0n 0.73600 34739.9n 0.73600 34740.0n 0.86030 34919.9n 0.86030 34920.0n 0.55006 35099.9n 0.55006 35100.0n 1.36668 35279.9n 1.36668 35280.0n 0.69969 35459.9n 0.69969 35460.0n 0.20119 35639.9n 0.20119 35640.0n 0.88832 35819.9n 0.88832 35820.0n 0.96459 35999.9n 0.96459 36000.0n 0.55066 36179.9n 0.55066 36180.0n 1.38855 36359.9n 1.38855 36360.0n -0.04662 36539.9n -0.04662 36540.0n 1.07007 36719.9n 1.07007 36720.0n 0.70685 36899.9n 0.70685 36900.0n 0.27076 37079.9n 0.27076 37080.0n 0.21498 37259.9n 0.21498 37260.0n 0.47556 37439.9n 0.47556 37440.0n 0.27643 37619.9n 0.27643 37620.0n 0.17082 37799.9n 0.17082 37800.0n 0.35630 37979.9n 0.35630 37980.0n 0.53141 38159.9n 0.53141 38160.0n 0.26419 38339.9n 0.26419 38340.0n 0.31139 38519.9n 0.31139 38520.0n 0.56449 38699.9n 0.56449 38700.0n -0.31038 38879.9n -0.31038 38880.0n 0.69502 39059.9n 0.69502 39060.0n -0.14927 39239.9n -0.14927 39240.0n 0.48508 39419.9n 0.48508 39420.0n 0.43581 39599.9n 0.43581 39600.0n 1.21890 39779.9n 1.21890 39780.0n 0.24079 39959.9n 0.24079 39960.0n 0.52079 40139.9n 0.52079 40140.0n 0.10559 40319.9n 0.10559 40320.0n 0.21498 40499.9n 0.21498 40500.0n 0.10559 40679.9n 0.10559 40680.0n 1.21890 40859.9n 1.21890 40860.0n 0.26419 41039.9n 0.26419 41040.0n 0.27643 41219.9n 0.27643 41220.0n 0.88832 41399.9n 0.88832 41400.0n -0.31038 41579.9n -0.31038 41580.0n -0.04662 41759.9n -0.04662 41760.0n 0.55066 41939.9n 0.55066 41940.0n 0.48508 42119.9n 0.48508 42120.0n 0.27076 42299.9n 0.27076 42300.0n 0.55006 42479.9n 0.55006 42480.0n 0.47556 42659.9n 0.47556 42660.0n 0.70685 42839.9n 0.70685 42840.0n 0.96459 43019.9n 0.96459 43020.0n 0.52079 43199.9n 0.52079 43200.0n 1.07007 43379.9n 1.07007 43380.0n 0.31139 43559.9n 0.31139 43560.0n 0.53141 43739.9n 0.53141 43740.0n 0.73600 43919.9n 0.73600 43920.0n 0.86030 44099.9n 0.86030 44100.0n 0.24079 44279.9n 0.24079 44280.0n 0.56449 44459.9n 0.56449 44460.0n 1.36668 44639.9n 1.36668 44640.0n -0.14927 44819.9n -0.14927 44820.0n 0.69969 44999.9n 0.69969 45000.0n 0.17082 45179.9n 0.17082 45180.0n 1.38855 45359.9n 1.38855 45360.0n 0.69502 45539.9n 0.69502 45540.0n 0.43581 45719.9n 0.43581 45720.0n 0.20119 45899.9n 0.20119 45900.0n 0.35630 46079.9n 0.35630 46080.0n 1.36668 46259.9n 1.36668 46260.0n 0.47556 46439.9n 0.47556 46440.0n 0.35630 46619.9n 0.35630 46620.0n 0.24079 46799.9n 0.24079 46800.0n 0.27643 46979.9n 0.27643 46980.0n 0.10559 47159.9n 0.10559 47160.0n 0.48508 47339.9n 0.48508 47340.0n 0.88832 47519.9n 0.88832 47520.0n 0.20119 47699.9n 0.20119 47700.0n 0.27076 47879.9n 0.27076 47880.0n 0.55066 48059.9n 0.55066 48060.0n 1.07007 48239.9n 1.07007 48240.0n 1.21890 48419.9n 1.21890 48420.0n -0.31038 48599.9n -0.31038 48600.0n -0.14927 48779.9n -0.14927 48780.0n 0.21498 48959.9n 0.21498 48960.0n 0.43581 49139.9n 0.43581 49140.0n 0.69969 49319.9n 0.69969 49320.0n 1.38855 49499.9n 1.38855 49500.0n 0.55006 49679.9n 0.55006 49680.0n 0.96459 49859.9n 0.96459 49860.0n 0.56449 50039.9n 0.56449 50040.0n 0.26419 50219.9n 0.26419 50220.0n 0.73600 50399.9n 0.73600 50400.0n 0.70685 50579.9n 0.70685 50580.0n 0.31139 50759.9n 0.31139 50760.0n 0.86030 50939.9n 0.86030 50940.0n -0.04662 51119.9n -0.04662 51120.0n 0.52079 51299.9n 0.52079 51300.0n 0.69502 51479.9n 0.69502 51480.0n 0.17082 51659.9n 0.17082 51660.0n 0.53141 51839.9n 0.53141 51840.0n 0.56449 52019.9n 0.56449 52020.0n 0.24079 52199.9n 0.24079 52200.0n 0.52079 52379.9n 0.52079 52380.0n 0.70685 52559.9n 0.70685 52560.0n 0.17082 52739.9n 0.17082 52740.0n 0.43581 52919.9n 0.43581 52920.0n 1.36668 53099.9n 1.36668 53100.0n 0.21498 53279.9n 0.21498 53280.0n 0.96459 53459.9n 0.96459 53460.0n 0.27076 53639.9n 0.27076 53640.0n 0.55006 53819.9n 0.55006 53820.0n 0.27643 53999.9n 0.27643 54000.0n 0.55066 54179.9n 0.55066 54180.0n 1.07007 54359.9n 1.07007 54360.0n 1.38855 54539.9n 1.38855 54540.0n -0.31038 54719.9n -0.31038 54720.0n 0.20119 54899.9n 0.20119 54900.0n -0.04662 55079.9n -0.04662 55080.0n 0.47556 55259.9n 0.47556 55260.0n 0.69969 55439.9n 0.69969 55440.0n 0.69502 55619.9n 0.69502 55620.0n -0.14927 55799.9n -0.14927 55800.0n 0.10559 55979.9n 0.10559 55980.0n 0.86030 56159.9n 0.86030 56160.0n 0.53141 56339.9n 0.53141 56340.0n 0.48508 56519.9n 0.48508 56520.0n 0.35630 56699.9n 0.35630 56700.0n 0.88832 56879.9n 0.88832 56880.0n 1.21890 57059.9n 1.21890 57060.0n 0.73600 57239.9n 0.73600 57240.0n 0.31139 57419.9n 0.31139 57420.0n 0.26419 57599.9n 0.26419 57600.0n 1.36668 57779.9n 1.36668 57780.0n 0.69502 57959.9n 0.69502 57960.0n 0.26419 58139.9n 0.26419 58140.0n 1.38855 58319.9n 1.38855 58320.0n 0.52079 58499.9n 0.52079 58500.0n -0.04662 58679.9n -0.04662 58680.0n 0.88832 58859.9n 0.88832 58860.0n 0.55006 59039.9n 0.55006 59040.0n 0.35630 59219.9n 0.35630 59220.0n 0.27076 59399.9n 0.27076 59400.0n 0.17082 59579.9n 0.17082 59580.0n 0.20119 59759.9n 0.20119 59760.0n 0.55066 59939.9n 0.55066 59940.0n 0.86030 60119.9n 0.86030 60120.0n 1.07007 60299.9n 1.07007 60300.0n 0.10559 60479.9n 0.10559 60480.0n 0.53141 60659.9n 0.53141 60660.0n -0.14927 60839.9n -0.14927 60840.0n 0.27643 61019.9n 0.27643 61020.0n 0.69969 61199.9n 0.69969 61200.0n 0.56449 61379.9n 0.56449 61380.0n 0.73600 61559.9n 0.73600 61560.0n 0.43581 61739.9n 0.43581 61740.0n 0.47556 61919.9n 0.47556 61920.0n 0.48508 62099.9n 0.48508 62100.0n -0.31038 62279.9n -0.31038 62280.0n 0.31139 62459.9n 0.31139 62460.0n 0.24079 62639.9n 0.24079 62640.0n 1.21890 62819.9n 1.21890 62820.0n 0.96459 62999.9n 0.96459 63000.0n 0.21498 63179.9n 0.21498 63180.0n 0.70685 63359.9n 0.70685 63360.0n 0.20119 63539.9n 0.20119 63540.0n 0.86030 63719.9n 0.86030 63720.0n 0.31139 63899.9n 0.31139 63900.0n 0.43581 64079.9n 0.43581 64080.0n 0.55066 64259.9n 0.55066 64260.0n -0.14927 64439.9n -0.14927 64440.0n 0.70685 64619.9n 0.70685 64620.0n 0.21498 64799.9n 0.21498 64800.0n 0.27076 64979.9n 0.27076 64980.0n 0.69969 65159.9n 0.69969 65160.0n 0.53141 65339.9n 0.53141 65340.0n 0.17082 65519.9n 0.17082 65520.0n 0.55006 65699.9n 0.55006 65700.0n 0.27643 65879.9n 0.27643 65880.0n 1.38855 66059.9n 1.38855 66060.0n 0.35630 66239.9n 0.35630 66240.0n 0.56449 66419.9n 0.56449 66420.0n 0.88832 66599.9n 0.88832 66600.0n 1.36668 66779.9n 1.36668 66780.0n 0.69502 66959.9n 0.69502 66960.0n 0.24079 67139.9n 0.24079 67140.0n -0.31038 67319.9n -0.31038 67320.0n 0.96459 67499.9n 0.96459 67500.0n 1.21890 67679.9n 1.21890 67680.0n 1.07007 67859.9n 1.07007 67860.0n 0.73600 68039.9n 0.73600 68040.0n 0.47556 68219.9n 0.47556 68220.0n 0.52079 68399.9n 0.52079 68400.0n 0.26419 68579.9n 0.26419 68580.0n 0.10559 68759.9n 0.10559 68760.0n -0.04662 68939.9n -0.04662 68940.0n 0.48508 69119.9n 0.48508 69120.0n 0.86030 69299.9n 0.86030 69300.0n 0.69969 69479.9n 0.69969 69480.0n 0.27076 69659.9n 0.27076 69660.0n 0.47556 69839.9n 0.47556 69840.0n 0.52079 70019.9n 0.52079 70020.0n 0.26419 70199.9n 0.26419 70200.0n 0.55006 70379.9n 0.55006 70380.0n 0.55066 70559.9n 0.55066 70560.0n -0.31038 70739.9n -0.31038 70740.0n 0.20119 70919.9n 0.20119 70920.0n 1.21890 71099.9n 1.21890 71100.0n 0.53141 71279.9n 0.53141 71280.0n 0.17082 71459.9n 0.17082 71460.0n 1.36668 71639.9n 1.36668 71640.0n 1.07007 71819.9n 1.07007 71820.0n 0.73600 71999.9n 0.73600 72000.0n 1.38855 72179.9n 1.38855 72180.0n 0.35630 72359.9n 0.35630 72360.0n 0.56449 72539.9n 0.56449 72540.0n 0.88832 72719.9n 0.88832 72720.0n 0.69502 72899.9n 0.69502 72900.0n -0.14927 73079.9n -0.14927 73080.0n 0.27643 73259.9n 0.27643 73260.0n 0.21498 73439.9n 0.21498 73440.0n 0.10559 73619.9n 0.10559 73620.0n 0.24079 73799.9n 0.24079 73800.0n -0.04662 73979.9n -0.04662 73980.0n 0.43581 74159.9n 0.43581 74160.0n 0.96459 74339.9n 0.96459 74340.0n 0.70685 74519.9n 0.70685 74520.0n 0.48508 74699.9n 0.48508 74700.0n 0.31139 74879.9n 0.31139 74880.0n 0.27076 75059.9n 0.27076 75060.0n 0.27643 75239.9n 0.27643 75240.0n 0.69502 75419.9n 0.69502 75420.0n 0.10559 75599.9n 0.10559 75600.0n 0.53141 75779.9n 0.53141 75780.0n 0.31139 75959.9n 0.31139 75960.0n 0.26419 76139.9n 0.26419 76140.0n 0.48508 76319.9n 0.48508 76320.0n -0.04662 76499.9n -0.04662 76500.0n 0.96459 76679.9n 0.96459 76680.0n 1.38855 76859.9n 1.38855 76860.0n 1.36668 77039.9n 1.36668 77040.0n 0.88832 77219.9n 0.88832 77220.0n -0.14927 77399.9n -0.14927 77400.0n 0.17082 77579.9n 0.17082 77580.0n 0.52079 77759.9n 0.52079 77760.0n 0.35630 77939.9n 0.35630 77940.0n 0.70685 78119.9n 0.70685 78120.0n 0.55006 78299.9n 0.55006 78300.0n 0.86030 78479.9n 0.86030 78480.0n 1.21890 78659.9n 1.21890 78660.0n 0.69969 78839.9n 0.69969 78840.0n 0.24079 79019.9n 0.24079 79020.0n 0.21498 79199.9n 0.21498 79200.0n 0.20119 79379.9n 0.20119 79380.0n 0.43581 79559.9n 0.43581 79560.0n 0.47556 79739.9n 0.47556 79740.0n 0.73600 79919.9n 0.73600 79920.0n 0.55066 80099.9n 0.55066 80100.0n 0.56449 80279.9n 0.56449 80280.0n -0.31038 80459.9n -0.31038 80460.0n 1.07007 80639.9n 1.07007 80640.0n 0.56449 80819.9n 0.56449 80820.0n 0.10559 80999.9n 0.10559 81000.0n 0.24079 81179.9n 0.24079 81180.0n 0.20119 81359.9n 0.20119 81360.0n 0.69502 81539.9n 0.69502 81540.0n 0.31139 81719.9n 0.31139 81720.0n 0.48508 81899.9n 0.48508 81900.0n -0.04662 82079.9n -0.04662 82080.0n 1.38855 82259.9n 1.38855 82260.0n -0.31038 82439.9n -0.31038 82440.0n 0.53141 82619.9n 0.53141 82620.0n 1.21890 82799.9n 1.21890 82800.0n 0.47556 82979.9n 0.47556 82980.0n 0.96459 83159.9n 0.96459 83160.0n 0.70685 83339.9n 0.70685 83340.0n 1.36668 83519.9n 1.36668 83520.0n 0.26419 83699.9n 0.26419 83700.0n 0.17082 83879.9n 0.17082 83880.0n 0.69969 84059.9n 0.69969 84060.0n 0.73600 84239.9n 0.73600 84240.0n 0.27076 84419.9n 0.27076 84420.0n 0.55066 84599.9n 0.55066 84600.0n 0.86030 84779.9n 0.86030 84780.0n 0.52079 84959.9n 0.52079 84960.0n 0.35630 85139.9n 0.35630 85140.0n 0.21498 85319.9n 0.21498 85320.0n -0.14927 85499.9n -0.14927 85500.0n 0.55006 85679.9n 0.55006 85680.0n 1.07007 85859.9n 1.07007 85860.0n 0.88832 86039.9n 0.88832 86040.0n 0.43581 86219.9n 0.43581 86220.0n 0.27643 86399.9n 0.27643 86400.0n 0.24079 86579.9n 0.24079 86580.0n 0.31139 86759.9n 0.31139 86760.0n 0.26419 86939.9n 0.26419 86940.0n 0.48508 87119.9n 0.48508 87120.0n 0.10559 87299.9n 0.10559 87300.0n 0.56449 87479.9n 0.56449 87480.0n -0.14927 87659.9n -0.14927 87660.0n 1.21890 87839.9n 1.21890 87840.0n 0.17082 88019.9n 0.17082 88020.0n 0.96459 88199.9n 0.96459 88200.0n 1.38855 88379.9n 1.38855 88380.0n -0.31038 88559.9n -0.31038 88560.0n 0.55066 88739.9n 0.55066 88740.0n 0.88832 88919.9n 0.88832 88920.0n 0.27643 89099.9n 0.27643 89100.0n 1.36668 89279.9n 1.36668 89280.0n 1.07007 89459.9n 1.07007 89460.0n 0.47556 89639.9n 0.47556 89640.0n 0.73600 89819.9n 0.73600 89820.0n 0.69502 89999.9n 0.69502 90000.0n 0.35630 90179.9n 0.35630 90180.0n 0.21498 90359.9n 0.21498 90360.0n 0.53141 90539.9n 0.53141 90540.0n 0.27076 90719.9n 0.27076 90720.0n 0.20119 90899.9n 0.20119 90900.0n 0.43581 91079.9n 0.43581 91080.0n 0.70685 91259.9n 0.70685 91260.0n -0.04662 91439.9n -0.04662 91440.0n 0.86030 91619.9n 0.86030 91620.0n 0.69969 91799.9n 0.69969 91800.0n 0.52079 91979.9n 0.52079 91980.0n 0.55006 92159.9n 0.55006 92160.0n 0.26419 92339.9n 0.26419 92340.0n 0.55006 92519.9n 0.55006 92520.0n 0.48508 92699.9n 0.48508 92700.0n -0.14927 92879.9n -0.14927 92880.0n -0.04662 93059.9n -0.04662 93060.0n 1.38855 93239.9n 1.38855 93240.0n 0.96459 93419.9n 0.96459 93420.0n 0.31139 93599.9n 0.31139 93600.0n 0.21498 93779.9n 0.21498 93780.0n 1.07007 93959.9n 1.07007 93960.0n 0.20119 94139.9n 0.20119 94140.0n 0.69969 94319.9n 0.69969 94320.0n 0.70685 94499.9n 0.70685 94500.0n 1.36668 94679.9n 1.36668 94680.0n 0.56449 94859.9n 0.56449 94860.0n 0.52079 95039.9n 0.52079 95040.0n 0.35630 95219.9n 0.35630 95220.0n 0.73600 95399.9n 0.73600 95400.0n 1.21890 95579.9n 1.21890 95580.0n 0.27076 95759.9n 0.27076 95760.0n 0.24079 95939.9n 0.24079 95940.0n 0.55066 96119.9n 0.55066 96120.0n -0.31038 96299.9n -0.31038 96300.0n 0.47556 96479.9n 0.47556 96480.0n 0.86030 96659.9n 0.86030 96660.0n 0.17082 96839.9n 0.17082 96840.0n 0.43581 97019.9n 0.43581 97020.0n 0.53141 97199.9n 0.53141 97200.0n 0.88832 97379.9n 0.88832 97380.0n 0.69502 97559.9n 0.69502 97560.0n 0.27643 97739.9n 0.27643 97740.0n 0.10559 97919.9n 0.10559 97920.0n 0.56449 98099.9n 0.56449 98100.0n 1.36668 98279.9n 1.36668 98280.0n 0.27076 98459.9n 0.27076 98460.0n 0.53141 98639.9n 0.53141 98640.0n 0.55066 98819.9n 0.55066 98820.0n 0.55006 98999.9n 0.55006 99000.0n 0.86030 99179.9n 0.86030 99180.0n 0.48508 99359.9n 0.48508 99360.0n 0.26419 99539.9n 0.26419 99540.0n 0.10559 99719.9n 0.10559 99720.0n 0.24079 99899.9n 0.24079 99900.0n 0.20119 100079.9n 0.20119 100080.0n -0.14927 100259.9n -0.14927 100260.0n 0.69969 100439.9n 0.69969 100440.0n 1.38855 100619.9n 1.38855 100620.0n 0.43581 100799.9n 0.43581 100800.0n 0.88832 100979.9n 0.88832 100980.0n 1.07007 101159.9n 1.07007 101160.0n 0.70685 101339.9n 0.70685 101340.0n -0.04662 101519.9n -0.04662 101520.0n 0.96459 101699.9n 0.96459 101700.0n 0.21498 101879.9n 0.21498 101880.0n 0.73600 102059.9n 0.73600 102060.0n 0.17082 102239.9n 0.17082 102240.0n 0.52079 102419.9n 0.52079 102420.0n 0.47556 102599.9n 0.47556 102600.0n 0.27643 102779.9n 0.27643 102780.0n 0.69502 102959.9n 0.69502 102960.0n -0.31038 103139.9n -0.31038 103140.0n 1.21890 103319.9n 1.21890 103320.0n 0.35630 103499.9n 0.35630 103500.0n 0.31139 103679.9n 0.31139 103680.0n 0.96459 103859.9n 0.96459 103860.0n 0.24079 104039.9n 0.24079 104040.0n 0.88832 104219.9n 0.88832 104220.0n 0.53141 104399.9n 0.53141 104400.0n -0.04662 104579.9n -0.04662 104580.0n 1.21890 104759.9n 1.21890 104760.0n 0.35630 104939.9n 0.35630 104940.0n 0.55066 105119.9n 0.55066 105120.0n 0.31139 105299.9n 0.31139 105300.0n 1.36668 105479.9n 1.36668 105480.0n 0.48508 105659.9n 0.48508 105660.0n 0.86030 105839.9n 0.86030 105840.0n 0.56449 106019.9n 0.56449 106020.0n 0.52079 106199.9n 0.52079 106200.0n 0.10559 106379.9n 0.10559 106380.0n 0.47556 106559.9n 0.47556 106560.0n -0.14927 106739.9n -0.14927 106740.0n 1.07007 106919.9n 1.07007 106920.0n 0.55006 107099.9n 0.55006 107100.0n 0.69502 107279.9n 0.69502 107280.0n 0.69969 107459.9n 0.69969 107460.0n 0.27643 107639.9n 0.27643 107640.0n 0.26419 107819.9n 0.26419 107820.0n 0.17082 107999.9n 0.17082 108000.0n -0.31038 108179.9n -0.31038 108180.0n 0.20119 108359.9n 0.20119 108360.0n 0.43581 108539.9n 0.43581 108540.0n 0.70685 108719.9n 0.70685 108720.0n 0.27076 108899.9n 0.27076 108900.0n 0.73600 109079.9n 0.73600 109080.0n 0.21498 109259.9n 0.21498 109260.0n 1.38855 109439.9n 1.38855 109440.0n 0.73600 109619.9n 0.73600 109620.0n 0.96459 109799.9n 0.96459 109800.0n 0.55066 109979.9n 0.55066 109980.0n 0.27643 110159.9n 0.27643 110160.0n -0.14927 110339.9n -0.14927 110340.0n -0.31038 110519.9n -0.31038 110520.0n 0.56449 110699.9n 0.56449 110700.0n 0.27076 110879.9n 0.27076 110880.0n 0.70685 111059.9n 0.70685 111060.0n 0.47556 111239.9n 0.47556 111240.0n 0.35630 111419.9n 0.35630 111420.0n 0.69502 111599.9n 0.69502 111600.0n 1.21890 111779.9n 1.21890 111780.0n 0.69969 111959.9n 0.69969 111960.0n 0.20119 112139.9n 0.20119 112140.0n 0.55006 112319.9n 0.55006 112320.0n 1.07007 112499.9n 1.07007 112500.0n 0.43581 112679.9n 0.43581 112680.0n 0.53141 112859.9n 0.53141 112860.0n 0.26419 113039.9n 0.26419 113040.0n 0.17082 113219.9n 0.17082 113220.0n -0.04662 113399.9n -0.04662 113400.0n 0.10559 113579.9n 0.10559 113580.0n 0.48508 113759.9n 0.48508 113760.0n 0.86030 113939.9n 0.86030 113940.0n 1.36668 114119.9n 1.36668 114120.0n 0.52079 114299.9n 0.52079 114300.0n 0.21498 114479.9n 0.21498 114480.0n 0.24079 114659.9n 0.24079 114660.0n 1.38855 114839.9n 1.38855 114840.0n 0.88832 115019.9n 0.88832 115020.0n 0.31139 115199.9n 0.31139 115200.0n 0.27076 115379.9n 0.27076 115380.0n 0.31139 115559.9n 0.31139 115560.0n 0.52079 115739.9n 0.52079 115740.0n 0.35630 115919.9n 0.35630 115920.0n 0.56449 116099.9n 0.56449 116100.0n 0.20119 116279.9n 0.20119 116280.0n 0.70685 116459.9n 0.70685 116460.0n 0.53141 116639.9n 0.53141 116640.0n 1.07007 116819.9n 1.07007 116820.0n -0.14927 116999.9n -0.14927 117000.0n 0.24079 117179.9n 0.24079 117180.0n 0.43581 117359.9n 0.43581 117360.0n 1.38855 117539.9n 1.38855 117540.0n -0.31038 117719.9n -0.31038 117720.0n 0.55066 117899.9n 0.55066 117900.0n 0.48508 118079.9n 0.48508 118080.0n 0.69969 118259.9n 0.69969 118260.0n 0.26419 118439.9n 0.26419 118440.0n 0.55006 118619.9n 0.55006 118620.0n 0.21498 118799.9n 0.21498 118800.0n 0.88832 118979.9n 0.88832 118980.0n 0.47556 119159.9n 0.47556 119160.0n 1.36668 119339.9n 1.36668 119340.0n 0.10559 119519.9n 0.10559 119520.0n 0.96459 119699.9n 0.96459 119700.0n 0.27643 119879.9n 0.27643 119880.0n 0.17082 120059.9n 0.17082 120060.0n 0.69502 120239.9n 0.69502 120240.0n 1.21890 120419.9n 1.21890 120420.0n 0.86030 120599.9n 0.86030 120600.0n 0.73600 120779.9n 0.73600 120780.0n -0.04662 120959.9n -0.04662 120960.0n 0.47556 121139.9n 0.47556 121140.0n 0.24079 121319.9n 0.24079 121320.0n 0.56449 121499.9n 0.56449 121500.0n 0.86030 121679.9n 0.86030 121680.0n 0.52079 121859.9n 0.52079 121860.0n 0.20119 122039.9n 0.20119 122040.0n 1.38855 122219.9n 1.38855 122220.0n 0.69502 122399.9n 0.69502 122400.0n 0.48508 122579.9n 0.48508 122580.0n 0.17082 122759.9n 0.17082 122760.0n -0.14927 122939.9n -0.14927 122940.0n 0.96459 123119.9n 0.96459 123120.0n 0.88832 123299.9n 0.88832 123300.0n 0.53141 123479.9n 0.53141 123480.0n 0.21498 123659.9n 0.21498 123660.0n 0.31139 123839.9n 0.31139 123840.0n 0.70685 124019.9n 0.70685 124020.0n 1.21890 124199.9n 1.21890 124200.0n 0.55006 124379.9n 0.55006 124380.0n 0.27643 124559.9n 0.27643 124560.0n 0.55066 124739.9n 0.55066 124740.0n -0.31038 124919.9n -0.31038 124920.0n 0.10559 125099.9n 0.10559 125100.0n 0.69969 125279.9n 0.69969 125280.0n 0.26419 125459.9n 0.26419 125460.0n 0.73600 125639.9n 0.73600 125640.0n -0.04662 125819.9n -0.04662 125820.0n 1.36668 125999.9n 1.36668 126000.0n 0.43581 126179.9n 0.43581 126180.0n 0.35630 126359.9n 0.35630 126360.0n 0.27076 126539.9n 0.27076 126540.0n 1.07007 126719.9n 1.07007 126720.0n 0.48508 126899.9n 0.48508 126900.0n 0.26419 127079.9n 0.26419 127080.0n 0.55006 127259.9n 0.55006 127260.0n 0.53141 127439.9n 0.53141 127440.0n 0.52079 127619.9n 0.52079 127620.0n 0.55066 127799.9n 0.55066 127800.0n 0.31139 127979.9n 0.31139 127980.0n 0.17082 128159.9n 0.17082 128160.0n -0.04662 128339.9n -0.04662 128340.0n 0.88832 128519.9n 0.88832 128520.0n 0.21498 128699.9n 0.21498 128700.0n 0.86030 128879.9n 0.86030 128880.0n 0.56449 129059.9n 0.56449 129060.0n 0.35630 129239.9n 0.35630 129240.0n 0.47556 129419.9n 0.47556 129420.0n 1.07007 129599.9n 1.07007 129600.0n 0.24079 129779.9n 0.24079 129780.0n 0.96459 129959.9n 0.96459 129960.0n 0.69502 130139.9n 0.69502 130140.0n 0.69969 130319.9n 0.69969 130320.0n 1.38855 130499.9n 1.38855 130500.0n 1.21890 130679.9n 1.21890 130680.0n 1.36668 130859.9n 1.36668 130860.0n -0.31038 131039.9n -0.31038 131040.0n 0.43581 131219.9n 0.43581 131220.0n 0.20119 131399.9n 0.20119 131400.0n 0.27076 131579.9n 0.27076 131580.0n 0.70685 131759.9n 0.70685 131760.0n 0.73600 131939.9n 0.73600 131940.0n 0.27643 132119.9n 0.27643 132120.0n -0.14927 132299.9n -0.14927 132300.0n 0.10559 132479.9n 0.10559 132480.0n 0.56449 132659.9n 0.56449 132660.0n 0.21498 132839.9n 0.21498 132840.0n 1.36668 133019.9n 1.36668 133020.0n 0.52079 133199.9n 0.52079 133200.0n 0.24079 133379.9n 0.24079 133380.0n 0.69969 133559.9n 0.69969 133560.0n -0.14927 133739.9n -0.14927 133740.0n 1.21890 133919.9n 1.21890 133920.0n 0.53141 134099.9n 0.53141 134100.0n 0.27076 134279.9n 0.27076 134280.0n 0.26419 134459.9n 0.26419 134460.0n 0.88832 134639.9n 0.88832 134640.0n 0.55066 134819.9n 0.55066 134820.0n 0.48508 134999.9n 0.48508 135000.0n 1.07007 135179.9n 1.07007 135180.0n 0.73600 135359.9n 0.73600 135360.0n 0.47556 135539.9n 0.47556 135540.0n -0.31038 135719.9n -0.31038 135720.0n 0.20119 135899.9n 0.20119 135900.0n 0.31139 136079.9n 0.31139 136080.0n -0.04662 136259.9n -0.04662 136260.0n 0.35630 136439.9n 0.35630 136440.0n 1.38855 136619.9n 1.38855 136620.0n 0.55006 136799.9n 0.55006 136800.0n 0.96459 136979.9n 0.96459 136980.0n 0.10559 137159.9n 0.10559 137160.0n 0.17082 137339.9n 0.17082 137340.0n 0.27643 137519.9n 0.27643 137520.0n 0.43581 137699.9n 0.43581 137700.0n 0.86030 137879.9n 0.86030 137880.0n 0.70685 138059.9n 0.70685 138060.0n 0.69502 138239.9n 0.69502 138240.0n 0.48508 138419.9n 0.48508 138420.0n 0.53141 138599.9n 0.53141 138600.0n 0.27076 138779.9n 0.27076 138780.0n 0.17082 138959.9n 0.17082 138960.0n -0.14927 139139.9n -0.14927 139140.0n 0.96459 139319.9n 0.96459 139320.0n 0.55066 139499.9n 0.55066 139500.0n 1.38855 139679.9n 1.38855 139680.0n 0.20119 139859.9n 0.20119 139860.0n 0.43581 140039.9n 0.43581 140040.0n 1.21890 140219.9n 1.21890 140220.0n 0.86030 140399.9n 0.86030 140400.0n 0.73600 140579.9n 0.73600 140580.0n 0.21498 140759.9n 0.21498 140760.0n 0.55006 140939.9n 0.55006 140940.0n 1.07007 141119.9n 1.07007 141120.0n 1.36668 141299.9n 1.36668 141300.0n 0.27643 141479.9n 0.27643 141480.0n 0.52079 141659.9n 0.52079 141660.0n 0.24079 141839.9n 0.24079 141840.0n 0.47556 142019.9n 0.47556 142020.0n 0.69969 142199.9n 0.69969 142200.0n -0.04662 142379.9n -0.04662 142380.0n 0.70685 142559.9n 0.70685 142560.0n 0.26419 142739.9n 0.26419 142740.0n 0.31139 142919.9n 0.31139 142920.0n 0.10559 143099.9n 0.10559 143100.0n 0.56449 143279.9n 0.56449 143280.0n 0.88832 143459.9n 0.88832 143460.0n 0.35630 143639.9n 0.35630 143640.0n -0.31038 143819.9n -0.31038 143820.0n 0.69502 143999.9n 0.69502 144000.0n 0.27643 144179.9n 0.27643 144180.0n 0.26419 144359.9n 0.26419 144360.0n 0.24079 144539.9n 0.24079 144540.0n 1.07007 144719.9n 1.07007 144720.0n 0.70685 144899.9n 0.70685 144900.0n 0.86030 145079.9n 0.86030 145080.0n 1.36668 145259.9n 1.36668 145260.0n 0.88832 145439.9n 0.88832 145440.0n 0.20119 145619.9n 0.20119 145620.0n -0.04662 145799.9n -0.04662 145800.0n 0.52079 145979.9n 0.52079 145980.0n 0.55006 146159.9n 0.55006 146160.0n 0.27076 146339.9n 0.27076 146340.0n 0.21498 146519.9n 0.21498 146520.0n -0.14927 146699.9n -0.14927 146700.0n 0.56449 146879.9n 0.56449 146880.0n 0.47556 147059.9n 0.47556 147060.0n 0.48508 147239.9n 0.48508 147240.0n 1.21890 147419.9n 1.21890 147420.0n 0.69969 147599.9n 0.69969 147600.0n 0.69502 147779.9n 0.69502 147780.0n 0.53141 147959.9n 0.53141 147960.0n 0.31139 148139.9n 0.31139 148140.0n 0.10559 148319.9n 0.10559 148320.0n 0.73600 148499.9n 0.73600 148500.0n -0.31038 148679.9n -0.31038 148680.0n 0.35630 148859.9n 0.35630 148860.0n 0.55066 149039.9n 0.55066 149040.0n 0.96459 149219.9n 0.96459 149220.0n 0.43581 149399.9n 0.43581 149400.0n 0.17082 149579.9n 0.17082 149580.0n 1.38855 149759.9n 1.38855 149760.0n 1.36668 149939.9n 1.36668 149940.0n 0.69502 150119.9n 0.69502 150120.0n 0.96459 150299.9n 0.96459 150300.0n 0.88832 150479.9n 0.88832 150480.0n 0.70685 150659.9n 0.70685 150660.0n 0.20119 150839.9n 0.20119 150840.0n 1.21890 151019.9n 1.21890 151020.0n -0.14927 151199.9n -0.14927 151200.0n 0.31139 151379.9n 0.31139 151380.0n -0.04662 151559.9n -0.04662 151560.0n 0.27643 151739.9n 0.27643 151740.0n -0.31038 151919.9n -0.31038 151920.0n 0.69969 152099.9n 0.69969 152100.0n 0.53141 152279.9n 0.53141 152280.0n 0.48508 152459.9n 0.48508 152460.0n 0.47556 152639.9n 0.47556 152640.0n 0.55006 152819.9n 0.55006 152820.0n 0.73600 152999.9n 0.73600 153000.0n 1.38855 153179.9n 1.38855 153180.0n 0.26419 153359.9n 0.26419 153360.0n 0.56449 153539.9n 0.56449 153540.0n 1.07007 153719.9n 1.07007 153720.0n 0.86030 153899.9n 0.86030 153900.0n 0.21498 154079.9n 0.21498 154080.0n 0.27076 154259.9n 0.27076 154260.0n 0.17082 154439.9n 0.17082 154440.0n 0.43581 154619.9n 0.43581 154620.0n 0.24079 154799.9n 0.24079 154800.0n 0.35630 154979.9n 0.35630 154980.0n 0.10559 155159.9n 0.10559 155160.0n 0.55066 155339.9n 0.55066 155340.0n 0.52079 155519.9n 0.52079 155520.0n 0.96459 155699.9n 0.96459 155700.0n 0.69502 155879.9n 0.69502 155880.0n 0.31139 156059.9n 0.31139 156060.0n 0.17082 156239.9n 0.17082 156240.0n 0.26419 156419.9n 0.26419 156420.0n 1.21890 156599.9n 1.21890 156600.0n 0.27076 156779.9n 0.27076 156780.0n -0.14927 156959.9n -0.14927 156960.0n -0.04662 157139.9n -0.04662 157140.0n 0.88832 157319.9n 0.88832 157320.0n 0.20119 157499.9n 0.20119 157500.0n 0.70685 157679.9n 0.70685 157680.0n 0.27643 157859.9n 0.27643 157860.0n 0.55006 158039.9n 0.55006 158040.0n 0.47556 158219.9n 0.47556 158220.0n 0.21498 158399.9n 0.21498 158400.0n 0.10559 158579.9n 0.10559 158580.0n -0.31038 158759.9n -0.31038 158760.0n 0.48508 158939.9n 0.48508 158940.0n 0.56449 159119.9n 0.56449 159120.0n 0.55066 159299.9n 0.55066 159300.0n 0.86030 159479.9n 0.86030 159480.0n 0.53141 159659.9n 0.53141 159660.0n 0.24079 159839.9n 0.24079 159840.0n 0.73600 160019.9n 0.73600 160020.0n 1.07007 160199.9n 1.07007 160200.0n 0.69969 160379.9n 0.69969 160380.0n 0.35630 160559.9n 0.35630 160560.0n 0.43581 160739.9n 0.43581 160740.0n 0.52079 160919.9n 0.52079 160920.0n 1.36668 161099.9n 1.36668 161100.0n 1.38855 161279.9n 1.38855 161280.0n 0.27643 161459.9n 0.27643 161460.0n 0.73600 161639.9n 0.73600 161640.0n 1.36668 161819.9n 1.36668 161820.0n -0.14927 161999.9n -0.14927 162000.0n 0.26419 162179.9n 0.26419 162180.0n 0.55066 162359.9n 0.55066 162360.0n 0.88832 162539.9n 0.88832 162540.0n -0.31038 162719.9n -0.31038 162720.0n 0.52079 162899.9n 0.52079 162900.0n 1.07007 163079.9n 1.07007 163080.0n 0.21498 163259.9n 0.21498 163260.0n 0.56449 163439.9n 0.56449 163440.0n -0.04662 163619.9n -0.04662 163620.0n 0.86030 163799.9n 0.86030 163800.0n 1.38855 163979.9n 1.38855 163980.0n 0.96459 164159.9n 0.96459 164160.0n 0.69969 164339.9n 0.69969 164340.0n 0.10559 164519.9n 0.10559 164520.0n 0.47556 164699.9n 0.47556 164700.0n 0.55006 164879.9n 0.55006 164880.0n 0.24079 165059.9n 0.24079 165060.0n 0.70685 165239.9n 0.70685 165240.0n 0.35630 165419.9n 0.35630 165420.0n 0.69502 165599.9n 0.69502 165600.0n 0.43581 165779.9n 0.43581 165780.0n 0.20119 165959.9n 0.20119 165960.0n 0.53141 166139.9n 0.53141 166140.0n 0.27076 166319.9n 0.27076 166320.0n 1.21890 166499.9n 1.21890 166500.0n 0.17082 166679.9n 0.17082 166680.0n 0.48508 166859.9n 0.48508 166860.0n 0.31139 167039.9n 0.31139 167040.0n 0.73600 167219.9n 0.73600 167220.0n 0.43581 167399.9n 0.43581 167400.0n 0.69969 167579.9n 0.69969 167580.0n -0.04662 167759.9n -0.04662 167760.0n 0.20119 167939.9n 0.20119 167940.0n 0.52079 168119.9n 0.52079 168120.0n 0.56449 168299.9n 0.56449 168300.0n 0.31139 168479.9n 0.31139 168480.0n 0.53141 168659.9n 0.53141 168660.0n 0.70685 168839.9n 0.70685 168840.0n 0.55066 169019.9n 0.55066 169020.0n 0.88832 169199.9n 0.88832 169200.0n 0.26419 169379.9n 0.26419 169380.0n 0.47556 169559.9n 0.47556 169560.0n -0.31038 169739.9n -0.31038 169740.0n 0.48508 169919.9n 0.48508 169920.0n 0.27076 170099.9n 0.27076 170100.0n 0.24079 170279.9n 0.24079 170280.0n 0.86030 170459.9n 0.86030 170460.0n 1.36668 170639.9n 1.36668 170640.0n 0.96459 170819.9n 0.96459 170820.0n -0.14927 170999.9n -0.14927 171000.0n 0.10559 171179.9n 0.10559 171180.0n 0.55006 171359.9n 0.55006 171360.0n 0.35630 171539.9n 0.35630 171540.0n 0.17082 171719.9n 0.17082 171720.0n 0.21498 171899.9n 0.21498 171900.0n 0.69502 172079.9n 0.69502 172080.0n 1.07007 172259.9n 1.07007 172260.0n 1.38855 172439.9n 1.38855 172440.0n 1.21890 172619.9n 1.21890 172620.0n 0.27643 172799.9n 0.27643 172800.0n 0.57742 172979.9n 0.57742 172980.0n 0.79287 173159.9n 0.79287 173160.0n 0.60090 173339.9n 0.60090 173340.0n 0.23371 173519.9n 0.23371 173520.0n 0.12484 173699.9n 0.12484 173700.0n 0.48351 173879.9n 0.48351 173880.0n 0.52272 174059.9n 0.52272 174060.0n 0.10421 174239.9n 0.10421 174240.0n 0.26187 174419.9n 0.26187 174420.0n 0.26993 174599.9n 0.26993 174600.0n 0.61195 174779.9n 0.61195 174780.0n 0.55435 174959.9n 0.55435 174960.0n 0.15028 175139.9n 0.15028 175140.0n 0.68626 175319.9n 0.68626 175320.0n 0.46500 175499.9n 0.46500 175500.0n 0.34619 175679.9n 0.34619 175680.0n 0.41172 175859.9n 0.41172 175860.0n 0.70707 176039.9n 0.70707 176040.0n 0.65136 176219.9n 0.65136 176220.0n 0.60081 176399.9n 0.60081 176400.0n 0.71496 176579.9n 0.71496 176580.0n 0.09082 176759.9n 0.09082 176760.0n 0.49669 176939.9n 0.49669 176940.0n 0.71193 177119.9n 0.71193 177120.0n 0.76576 177299.9n 0.76576 177300.0n 0.46112 177479.9n 0.46112 177480.0n 0.51272 177659.9n 0.51272 177660.0n 0.49148 177839.9n 0.49148 177840.0n 0.41550 178019.9n 0.41550 178020.0n 0.63432 178199.9n 0.63432 178200.0n 1.28851 178379.9n 1.28851 178380.0n 1.24585 178559.9n 1.24585 178560.0n -0.15208 178739.9n -0.15208 178740.0n 0.58159 178919.9n 0.58159 178920.0n 0.75662 179099.9n 0.75662 179100.0n -0.49277 179279.9n -0.49277 179280.0n -0.19260 179459.9n -0.19260 179460.0n 1.27962 179639.9n 1.27962 179640.0n 0.44267 179819.9n 0.44267 179820.0n 0.04400 179999.9n 0.04400 180000.0n 1.04710 180179.9n 1.04710 180180.0n 0.19758 180359.9n 0.19758 180360.0n 0.60264 180539.9n 0.60264 180540.0n -0.04029 180719.9n -0.04029 180720.0n 0.36851 180899.9n 0.36851 180900.0n 0.18248 181079.9n 0.18248 181080.0n -0.19808 181259.9n -0.19808 181260.0n -0.39872 181439.9n -0.39872 181440.0n 0.71881 181619.9n 0.71881 181620.0n -0.46004 181799.9n -0.46004 181800.0n 1.19303 181979.9n 1.19303 181980.0n 0.06458 182159.9n 0.06458 182160.0n -0.06311 182339.9n -0.06311 182340.0n -0.11193 182519.9n -0.11193 182520.0n -0.17413 182699.9n -0.17413 182700.0n -0.01300 182879.9n -0.01300 182880.0n -0.13586 183059.9n -0.13586 183060.0n -0.03731 183239.9n -0.03731 183240.0n 0.53061 183419.9n 0.53061 183420.0n 0.42812)
Vxn0 a_xn0 0 PWL(0.0n 0.56419 179.9n 0.56419 180.0n 0.72357 359.9n 0.72357 360.0n 0.13970 539.9n 0.13970 540.0n 0.47921 719.9n 0.47921 720.0n 0.30498 899.9n 0.30498 900.0n 0.89441 1079.9n 0.89441 1080.0n 0.52444 1259.9n 0.52444 1260.0n 0.46859 1439.9n 0.46859 1440.0n 0.82918 1619.9n 0.82918 1620.0n 0.30031 1799.9n 0.30031 1800.0n 1.14927 1979.9n 1.14927 1980.0n 0.75921 2159.9n 0.75921 2160.0n -0.36668 2339.9n -0.36668 2340.0n 0.03541 2519.9n 0.03541 2520.0n 0.43551 2699.9n 0.43551 2700.0n 0.26400 2879.9n 0.26400 2880.0n 0.11168 3059.9n 0.11168 3060.0n 1.31038 3239.9n 1.31038 3240.0n -0.07007 3419.9n -0.07007 3420.0n 0.64370 3599.9n 0.64370 3600.0n 0.72924 3779.9n 0.72924 3780.0n 0.44934 3959.9n 0.44934 3960.0n -0.38855 4139.9n -0.38855 4140.0n 0.73581 4319.9n 0.73581 4320.0n 0.68861 4499.9n 0.68861 4500.0n 1.04662 4679.9n 1.04662 4680.0n 0.44994 4859.9n 0.44994 4860.0n 0.51492 5039.9n 0.51492 5040.0n 0.78502 5219.9n 0.78502 5220.0n 0.79881 5399.9n 0.79881 5400.0n 0.29315 5579.9n 0.29315 5580.0n -0.21890 5759.9n -0.21890 5760.0n 0.78502 5939.9n 0.78502 5940.0n 0.72357 6119.9n 0.72357 6120.0n 0.26400 6299.9n 0.26400 6300.0n 0.51492 6479.9n 0.51492 6480.0n 1.04662 6659.9n 1.04662 6660.0n 0.03541 6839.9n 0.03541 6840.0n 0.11168 7019.9n 0.11168 7020.0n 0.73581 7199.9n 0.73581 7200.0n -0.38855 7379.9n -0.38855 7380.0n 0.72924 7559.9n 0.72924 7560.0n 1.14927 7739.9n 1.14927 7740.0n 0.13970 7919.9n 0.13970 7920.0n 0.56419 8099.9n 0.56419 8100.0n 0.44994 8279.9n 0.44994 8280.0n 1.31038 8459.9n 1.31038 8460.0n 0.44934 8639.9n 0.44934 8640.0n 0.47921 8819.9n 0.47921 8820.0n 0.82918 8999.9n 0.82918 9000.0n 0.43551 9179.9n 0.43551 9180.0n 0.79881 9359.9n 0.79881 9360.0n 0.46859 9539.9n 0.46859 9540.0n 0.52444 9719.9n 0.52444 9720.0n 0.30498 9899.9n 0.30498 9900.0n -0.36668 10079.9n -0.36668 10080.0n 0.64370 10259.9n 0.64370 10260.0n 0.89441 10439.9n 0.89441 10440.0n 0.75921 10619.9n 0.75921 10620.0n 0.30031 10799.9n 0.30031 10800.0n -0.07007 10979.9n -0.07007 10980.0n 0.29315 11159.9n 0.29315 11160.0n -0.21890 11339.9n -0.21890 11340.0n 0.68861 11519.9n 0.68861 11520.0n 0.44934 11699.9n 0.44934 11700.0n 0.72924 11879.9n 0.72924 11880.0n 0.64370 12059.9n 0.64370 12060.0n 0.13970 12239.9n 0.13970 12240.0n 0.43551 12419.9n 0.43551 12420.0n 0.79881 12599.9n 0.79881 12600.0n 1.31038 12779.9n 1.31038 12780.0n -0.36668 12959.9n -0.36668 12960.0n -0.07007 13139.9n -0.07007 13140.0n 0.52444 13319.9n 0.52444 13320.0n 1.04662 13499.9n 1.04662 13500.0n 0.73581 13679.9n 0.73581 13680.0n -0.38855 13859.9n -0.38855 13860.0n 0.78502 14039.9n 0.78502 14040.0n 0.68861 14219.9n 0.68861 14220.0n 0.44994 14399.9n 0.44994 14400.0n 0.56419 14579.9n 0.56419 14580.0n 0.30498 14759.9n 0.30498 14760.0n -0.21890 14939.9n -0.21890 14940.0n 0.03541 15119.9n 0.03541 15120.0n 0.29315 15299.9n 0.29315 15300.0n 0.30031 15479.9n 0.30031 15480.0n 0.89441 15659.9n 0.89441 15660.0n 0.26400 15839.9n 0.26400 15840.0n 0.72357 16019.9n 0.72357 16020.0n 1.14927 16199.9n 1.14927 16200.0n 0.75921 16379.9n 0.75921 16380.0n 0.47921 16559.9n 0.47921 16560.0n 0.11168 16739.9n 0.11168 16740.0n 0.51492 16919.9n 0.51492 16920.0n 0.82918 17099.9n 0.82918 17100.0n 0.46859 17279.9n 0.46859 17280.0n 0.29315 17459.9n 0.29315 17460.0n 0.78502 17639.9n 0.78502 17640.0n -0.07007 17819.9n -0.07007 17820.0n 0.51492 17999.9n 0.51492 18000.0n 1.31038 18179.9n 1.31038 18180.0n -0.36668 18359.9n -0.36668 18360.0n 0.26400 18539.9n 0.26400 18540.0n 0.72357 18719.9n 0.72357 18720.0n 0.11168 18899.9n 0.11168 18900.0n 0.73581 19079.9n 0.73581 19080.0n 0.89441 19259.9n 0.89441 19260.0n 0.82918 19439.9n 0.82918 19440.0n 0.30031 19619.9n 0.30031 19620.0n 0.79881 19799.9n 0.79881 19800.0n 0.72924 19979.9n 0.72924 19980.0n -0.38855 20159.9n -0.38855 20160.0n 0.13970 20339.9n 0.13970 20340.0n 0.64370 20519.9n 0.64370 20520.0n -0.21890 20699.9n -0.21890 20700.0n 0.68861 20879.9n 0.68861 20880.0n 0.03541 21059.9n 0.03541 21060.0n 0.43551 21239.9n 0.43551 21240.0n 0.52444 21419.9n 0.52444 21420.0n 0.56419 21599.9n 0.56419 21600.0n 0.44934 21779.9n 0.44934 21780.0n 0.44994 21959.9n 0.44994 21960.0n 1.14927 22139.9n 1.14927 22140.0n 0.75921 22319.9n 0.75921 22320.0n 0.46859 22499.9n 0.46859 22500.0n 0.30498 22679.9n 0.30498 22680.0n 0.47921 22859.9n 0.47921 22860.0n 1.04662 23039.9n 1.04662 23040.0n 0.11168 23219.9n 0.11168 23220.0n 0.30498 23399.9n 0.30498 23400.0n -0.36668 23579.9n -0.36668 23580.0n 0.52444 23759.9n 0.52444 23760.0n 0.79881 23939.9n 0.79881 23940.0n 1.14927 24119.9n 1.14927 24120.0n -0.07007 24299.9n -0.07007 24300.0n 0.47921 24479.9n 0.47921 24480.0n 0.13970 24659.9n 0.13970 24660.0n 0.43551 24839.9n 0.43551 24840.0n 0.03541 25019.9n 0.03541 25020.0n 0.72924 25199.9n 0.72924 25200.0n 0.64370 25379.9n 0.64370 25380.0n 0.51492 25559.9n 0.51492 25560.0n 0.68861 25739.9n 0.68861 25740.0n -0.38855 25919.9n -0.38855 25920.0n 0.78502 26099.9n 0.78502 26100.0n 0.30031 26279.9n 0.30031 26280.0n 1.04662 26459.9n 1.04662 26460.0n 0.44994 26639.9n 0.44994 26640.0n 1.31038 26819.9n 1.31038 26820.0n 0.72357 26999.9n 0.72357 27000.0n 0.44934 27179.9n 0.44934 27180.0n 0.75921 27359.9n 0.75921 27360.0n 0.26400 27539.9n 0.26400 27540.0n -0.21890 27719.9n -0.21890 27720.0n 0.89441 27899.9n 0.89441 27900.0n 0.82918 28079.9n 0.82918 28080.0n 0.46859 28259.9n 0.46859 28260.0n 0.73581 28439.9n 0.73581 28440.0n 0.56419 28619.9n 0.56419 28620.0n 0.29315 28799.9n 0.29315 28800.0n 0.26400 28979.9n 0.26400 28980.0n 0.51492 29159.9n 0.51492 29160.0n 0.89441 29339.9n 0.89441 29340.0n 0.30031 29519.9n 0.30031 29520.0n 0.72924 29699.9n 0.72924 29700.0n 0.47921 29879.9n 0.47921 29880.0n 0.79881 30059.9n 0.79881 30060.0n 0.44934 30239.9n 0.44934 30240.0n -0.38855 30419.9n -0.38855 30420.0n 0.11168 30599.9n 0.11168 30600.0n 0.30498 30779.9n 0.30498 30780.0n 0.29315 30959.9n 0.29315 30960.0n 0.52444 31139.9n 0.52444 31140.0n 0.13970 31319.9n 0.13970 31320.0n 0.73581 31499.9n 0.73581 31500.0n 0.82918 31679.9n 0.82918 31680.0n 0.78502 31859.9n 0.78502 31860.0n 0.68861 32039.9n 0.68861 32040.0n 1.04662 32219.9n 1.04662 32220.0n 1.14927 32399.9n 1.14927 32400.0n 0.75921 32579.9n 0.75921 32580.0n 0.43551 32759.9n 0.43551 32760.0n -0.36668 32939.9n -0.36668 32940.0n -0.21890 33119.9n -0.21890 33120.0n -0.07007 33299.9n -0.07007 33300.0n 0.46859 33479.9n 0.46859 33480.0n 0.64370 33659.9n 0.64370 33660.0n 0.72357 33839.9n 0.72357 33840.0n 0.03541 34019.9n 0.03541 34020.0n 1.31038 34199.9n 1.31038 34200.0n 0.44994 34379.9n 0.44994 34380.0n 0.56419 34559.9n 0.56419 34560.0n 0.26400 34739.9n 0.26400 34740.0n 0.13970 34919.9n 0.13970 34920.0n 0.44994 35099.9n 0.44994 35100.0n -0.36668 35279.9n -0.36668 35280.0n 0.30031 35459.9n 0.30031 35460.0n 0.79881 35639.9n 0.79881 35640.0n 0.11168 35819.9n 0.11168 35820.0n 0.03541 35999.9n 0.03541 36000.0n 0.44934 36179.9n 0.44934 36180.0n -0.38855 36359.9n -0.38855 36360.0n 1.04662 36539.9n 1.04662 36540.0n -0.07007 36719.9n -0.07007 36720.0n 0.29315 36899.9n 0.29315 36900.0n 0.72924 37079.9n 0.72924 37080.0n 0.78502 37259.9n 0.78502 37260.0n 0.52444 37439.9n 0.52444 37440.0n 0.72357 37619.9n 0.72357 37620.0n 0.82918 37799.9n 0.82918 37800.0n 0.64370 37979.9n 0.64370 37980.0n 0.46859 38159.9n 0.46859 38160.0n 0.73581 38339.9n 0.73581 38340.0n 0.68861 38519.9n 0.68861 38520.0n 0.43551 38699.9n 0.43551 38700.0n 1.31038 38879.9n 1.31038 38880.0n 0.30498 39059.9n 0.30498 39060.0n 1.14927 39239.9n 1.14927 39240.0n 0.51492 39419.9n 0.51492 39420.0n 0.56419 39599.9n 0.56419 39600.0n -0.21890 39779.9n -0.21890 39780.0n 0.75921 39959.9n 0.75921 39960.0n 0.47921 40139.9n 0.47921 40140.0n 0.89441 40319.9n 0.89441 40320.0n 0.78502 40499.9n 0.78502 40500.0n 0.89441 40679.9n 0.89441 40680.0n -0.21890 40859.9n -0.21890 40860.0n 0.73581 41039.9n 0.73581 41040.0n 0.72357 41219.9n 0.72357 41220.0n 0.11168 41399.9n 0.11168 41400.0n 1.31038 41579.9n 1.31038 41580.0n 1.04662 41759.9n 1.04662 41760.0n 0.44934 41939.9n 0.44934 41940.0n 0.51492 42119.9n 0.51492 42120.0n 0.72924 42299.9n 0.72924 42300.0n 0.44994 42479.9n 0.44994 42480.0n 0.52444 42659.9n 0.52444 42660.0n 0.29315 42839.9n 0.29315 42840.0n 0.03541 43019.9n 0.03541 43020.0n 0.47921 43199.9n 0.47921 43200.0n -0.07007 43379.9n -0.07007 43380.0n 0.68861 43559.9n 0.68861 43560.0n 0.46859 43739.9n 0.46859 43740.0n 0.26400 43919.9n 0.26400 43920.0n 0.13970 44099.9n 0.13970 44100.0n 0.75921 44279.9n 0.75921 44280.0n 0.43551 44459.9n 0.43551 44460.0n -0.36668 44639.9n -0.36668 44640.0n 1.14927 44819.9n 1.14927 44820.0n 0.30031 44999.9n 0.30031 45000.0n 0.82918 45179.9n 0.82918 45180.0n -0.38855 45359.9n -0.38855 45360.0n 0.30498 45539.9n 0.30498 45540.0n 0.56419 45719.9n 0.56419 45720.0n 0.79881 45899.9n 0.79881 45900.0n 0.64370 46079.9n 0.64370 46080.0n -0.36668 46259.9n -0.36668 46260.0n 0.52444 46439.9n 0.52444 46440.0n 0.64370 46619.9n 0.64370 46620.0n 0.75921 46799.9n 0.75921 46800.0n 0.72357 46979.9n 0.72357 46980.0n 0.89441 47159.9n 0.89441 47160.0n 0.51492 47339.9n 0.51492 47340.0n 0.11168 47519.9n 0.11168 47520.0n 0.79881 47699.9n 0.79881 47700.0n 0.72924 47879.9n 0.72924 47880.0n 0.44934 48059.9n 0.44934 48060.0n -0.07007 48239.9n -0.07007 48240.0n -0.21890 48419.9n -0.21890 48420.0n 1.31038 48599.9n 1.31038 48600.0n 1.14927 48779.9n 1.14927 48780.0n 0.78502 48959.9n 0.78502 48960.0n 0.56419 49139.9n 0.56419 49140.0n 0.30031 49319.9n 0.30031 49320.0n -0.38855 49499.9n -0.38855 49500.0n 0.44994 49679.9n 0.44994 49680.0n 0.03541 49859.9n 0.03541 49860.0n 0.43551 50039.9n 0.43551 50040.0n 0.73581 50219.9n 0.73581 50220.0n 0.26400 50399.9n 0.26400 50400.0n 0.29315 50579.9n 0.29315 50580.0n 0.68861 50759.9n 0.68861 50760.0n 0.13970 50939.9n 0.13970 50940.0n 1.04662 51119.9n 1.04662 51120.0n 0.47921 51299.9n 0.47921 51300.0n 0.30498 51479.9n 0.30498 51480.0n 0.82918 51659.9n 0.82918 51660.0n 0.46859 51839.9n 0.46859 51840.0n 0.43551 52019.9n 0.43551 52020.0n 0.75921 52199.9n 0.75921 52200.0n 0.47921 52379.9n 0.47921 52380.0n 0.29315 52559.9n 0.29315 52560.0n 0.82918 52739.9n 0.82918 52740.0n 0.56419 52919.9n 0.56419 52920.0n -0.36668 53099.9n -0.36668 53100.0n 0.78502 53279.9n 0.78502 53280.0n 0.03541 53459.9n 0.03541 53460.0n 0.72924 53639.9n 0.72924 53640.0n 0.44994 53819.9n 0.44994 53820.0n 0.72357 53999.9n 0.72357 54000.0n 0.44934 54179.9n 0.44934 54180.0n -0.07007 54359.9n -0.07007 54360.0n -0.38855 54539.9n -0.38855 54540.0n 1.31038 54719.9n 1.31038 54720.0n 0.79881 54899.9n 0.79881 54900.0n 1.04662 55079.9n 1.04662 55080.0n 0.52444 55259.9n 0.52444 55260.0n 0.30031 55439.9n 0.30031 55440.0n 0.30498 55619.9n 0.30498 55620.0n 1.14927 55799.9n 1.14927 55800.0n 0.89441 55979.9n 0.89441 55980.0n 0.13970 56159.9n 0.13970 56160.0n 0.46859 56339.9n 0.46859 56340.0n 0.51492 56519.9n 0.51492 56520.0n 0.64370 56699.9n 0.64370 56700.0n 0.11168 56879.9n 0.11168 56880.0n -0.21890 57059.9n -0.21890 57060.0n 0.26400 57239.9n 0.26400 57240.0n 0.68861 57419.9n 0.68861 57420.0n 0.73581 57599.9n 0.73581 57600.0n -0.36668 57779.9n -0.36668 57780.0n 0.30498 57959.9n 0.30498 57960.0n 0.73581 58139.9n 0.73581 58140.0n -0.38855 58319.9n -0.38855 58320.0n 0.47921 58499.9n 0.47921 58500.0n 1.04662 58679.9n 1.04662 58680.0n 0.11168 58859.9n 0.11168 58860.0n 0.44994 59039.9n 0.44994 59040.0n 0.64370 59219.9n 0.64370 59220.0n 0.72924 59399.9n 0.72924 59400.0n 0.82918 59579.9n 0.82918 59580.0n 0.79881 59759.9n 0.79881 59760.0n 0.44934 59939.9n 0.44934 59940.0n 0.13970 60119.9n 0.13970 60120.0n -0.07007 60299.9n -0.07007 60300.0n 0.89441 60479.9n 0.89441 60480.0n 0.46859 60659.9n 0.46859 60660.0n 1.14927 60839.9n 1.14927 60840.0n 0.72357 61019.9n 0.72357 61020.0n 0.30031 61199.9n 0.30031 61200.0n 0.43551 61379.9n 0.43551 61380.0n 0.26400 61559.9n 0.26400 61560.0n 0.56419 61739.9n 0.56419 61740.0n 0.52444 61919.9n 0.52444 61920.0n 0.51492 62099.9n 0.51492 62100.0n 1.31038 62279.9n 1.31038 62280.0n 0.68861 62459.9n 0.68861 62460.0n 0.75921 62639.9n 0.75921 62640.0n -0.21890 62819.9n -0.21890 62820.0n 0.03541 62999.9n 0.03541 63000.0n 0.78502 63179.9n 0.78502 63180.0n 0.29315 63359.9n 0.29315 63360.0n 0.79881 63539.9n 0.79881 63540.0n 0.13970 63719.9n 0.13970 63720.0n 0.68861 63899.9n 0.68861 63900.0n 0.56419 64079.9n 0.56419 64080.0n 0.44934 64259.9n 0.44934 64260.0n 1.14927 64439.9n 1.14927 64440.0n 0.29315 64619.9n 0.29315 64620.0n 0.78502 64799.9n 0.78502 64800.0n 0.72924 64979.9n 0.72924 64980.0n 0.30031 65159.9n 0.30031 65160.0n 0.46859 65339.9n 0.46859 65340.0n 0.82918 65519.9n 0.82918 65520.0n 0.44994 65699.9n 0.44994 65700.0n 0.72357 65879.9n 0.72357 65880.0n -0.38855 66059.9n -0.38855 66060.0n 0.64370 66239.9n 0.64370 66240.0n 0.43551 66419.9n 0.43551 66420.0n 0.11168 66599.9n 0.11168 66600.0n -0.36668 66779.9n -0.36668 66780.0n 0.30498 66959.9n 0.30498 66960.0n 0.75921 67139.9n 0.75921 67140.0n 1.31038 67319.9n 1.31038 67320.0n 0.03541 67499.9n 0.03541 67500.0n -0.21890 67679.9n -0.21890 67680.0n -0.07007 67859.9n -0.07007 67860.0n 0.26400 68039.9n 0.26400 68040.0n 0.52444 68219.9n 0.52444 68220.0n 0.47921 68399.9n 0.47921 68400.0n 0.73581 68579.9n 0.73581 68580.0n 0.89441 68759.9n 0.89441 68760.0n 1.04662 68939.9n 1.04662 68940.0n 0.51492 69119.9n 0.51492 69120.0n 0.13970 69299.9n 0.13970 69300.0n 0.30031 69479.9n 0.30031 69480.0n 0.72924 69659.9n 0.72924 69660.0n 0.52444 69839.9n 0.52444 69840.0n 0.47921 70019.9n 0.47921 70020.0n 0.73581 70199.9n 0.73581 70200.0n 0.44994 70379.9n 0.44994 70380.0n 0.44934 70559.9n 0.44934 70560.0n 1.31038 70739.9n 1.31038 70740.0n 0.79881 70919.9n 0.79881 70920.0n -0.21890 71099.9n -0.21890 71100.0n 0.46859 71279.9n 0.46859 71280.0n 0.82918 71459.9n 0.82918 71460.0n -0.36668 71639.9n -0.36668 71640.0n -0.07007 71819.9n -0.07007 71820.0n 0.26400 71999.9n 0.26400 72000.0n -0.38855 72179.9n -0.38855 72180.0n 0.64370 72359.9n 0.64370 72360.0n 0.43551 72539.9n 0.43551 72540.0n 0.11168 72719.9n 0.11168 72720.0n 0.30498 72899.9n 0.30498 72900.0n 1.14927 73079.9n 1.14927 73080.0n 0.72357 73259.9n 0.72357 73260.0n 0.78502 73439.9n 0.78502 73440.0n 0.89441 73619.9n 0.89441 73620.0n 0.75921 73799.9n 0.75921 73800.0n 1.04662 73979.9n 1.04662 73980.0n 0.56419 74159.9n 0.56419 74160.0n 0.03541 74339.9n 0.03541 74340.0n 0.29315 74519.9n 0.29315 74520.0n 0.51492 74699.9n 0.51492 74700.0n 0.68861 74879.9n 0.68861 74880.0n 0.72924 75059.9n 0.72924 75060.0n 0.72357 75239.9n 0.72357 75240.0n 0.30498 75419.9n 0.30498 75420.0n 0.89441 75599.9n 0.89441 75600.0n 0.46859 75779.9n 0.46859 75780.0n 0.68861 75959.9n 0.68861 75960.0n 0.73581 76139.9n 0.73581 76140.0n 0.51492 76319.9n 0.51492 76320.0n 1.04662 76499.9n 1.04662 76500.0n 0.03541 76679.9n 0.03541 76680.0n -0.38855 76859.9n -0.38855 76860.0n -0.36668 77039.9n -0.36668 77040.0n 0.11168 77219.9n 0.11168 77220.0n 1.14927 77399.9n 1.14927 77400.0n 0.82918 77579.9n 0.82918 77580.0n 0.47921 77759.9n 0.47921 77760.0n 0.64370 77939.9n 0.64370 77940.0n 0.29315 78119.9n 0.29315 78120.0n 0.44994 78299.9n 0.44994 78300.0n 0.13970 78479.9n 0.13970 78480.0n -0.21890 78659.9n -0.21890 78660.0n 0.30031 78839.9n 0.30031 78840.0n 0.75921 79019.9n 0.75921 79020.0n 0.78502 79199.9n 0.78502 79200.0n 0.79881 79379.9n 0.79881 79380.0n 0.56419 79559.9n 0.56419 79560.0n 0.52444 79739.9n 0.52444 79740.0n 0.26400 79919.9n 0.26400 79920.0n 0.44934 80099.9n 0.44934 80100.0n 0.43551 80279.9n 0.43551 80280.0n 1.31038 80459.9n 1.31038 80460.0n -0.07007 80639.9n -0.07007 80640.0n 0.43551 80819.9n 0.43551 80820.0n 0.89441 80999.9n 0.89441 81000.0n 0.75921 81179.9n 0.75921 81180.0n 0.79881 81359.9n 0.79881 81360.0n 0.30498 81539.9n 0.30498 81540.0n 0.68861 81719.9n 0.68861 81720.0n 0.51492 81899.9n 0.51492 81900.0n 1.04662 82079.9n 1.04662 82080.0n -0.38855 82259.9n -0.38855 82260.0n 1.31038 82439.9n 1.31038 82440.0n 0.46859 82619.9n 0.46859 82620.0n -0.21890 82799.9n -0.21890 82800.0n 0.52444 82979.9n 0.52444 82980.0n 0.03541 83159.9n 0.03541 83160.0n 0.29315 83339.9n 0.29315 83340.0n -0.36668 83519.9n -0.36668 83520.0n 0.73581 83699.9n 0.73581 83700.0n 0.82918 83879.9n 0.82918 83880.0n 0.30031 84059.9n 0.30031 84060.0n 0.26400 84239.9n 0.26400 84240.0n 0.72924 84419.9n 0.72924 84420.0n 0.44934 84599.9n 0.44934 84600.0n 0.13970 84779.9n 0.13970 84780.0n 0.47921 84959.9n 0.47921 84960.0n 0.64370 85139.9n 0.64370 85140.0n 0.78502 85319.9n 0.78502 85320.0n 1.14927 85499.9n 1.14927 85500.0n 0.44994 85679.9n 0.44994 85680.0n -0.07007 85859.9n -0.07007 85860.0n 0.11168 86039.9n 0.11168 86040.0n 0.56419 86219.9n 0.56419 86220.0n 0.72357 86399.9n 0.72357 86400.0n 0.75921 86579.9n 0.75921 86580.0n 0.68861 86759.9n 0.68861 86760.0n 0.73581 86939.9n 0.73581 86940.0n 0.51492 87119.9n 0.51492 87120.0n 0.89441 87299.9n 0.89441 87300.0n 0.43551 87479.9n 0.43551 87480.0n 1.14927 87659.9n 1.14927 87660.0n -0.21890 87839.9n -0.21890 87840.0n 0.82918 88019.9n 0.82918 88020.0n 0.03541 88199.9n 0.03541 88200.0n -0.38855 88379.9n -0.38855 88380.0n 1.31038 88559.9n 1.31038 88560.0n 0.44934 88739.9n 0.44934 88740.0n 0.11168 88919.9n 0.11168 88920.0n 0.72357 89099.9n 0.72357 89100.0n -0.36668 89279.9n -0.36668 89280.0n -0.07007 89459.9n -0.07007 89460.0n 0.52444 89639.9n 0.52444 89640.0n 0.26400 89819.9n 0.26400 89820.0n 0.30498 89999.9n 0.30498 90000.0n 0.64370 90179.9n 0.64370 90180.0n 0.78502 90359.9n 0.78502 90360.0n 0.46859 90539.9n 0.46859 90540.0n 0.72924 90719.9n 0.72924 90720.0n 0.79881 90899.9n 0.79881 90900.0n 0.56419 91079.9n 0.56419 91080.0n 0.29315 91259.9n 0.29315 91260.0n 1.04662 91439.9n 1.04662 91440.0n 0.13970 91619.9n 0.13970 91620.0n 0.30031 91799.9n 0.30031 91800.0n 0.47921 91979.9n 0.47921 91980.0n 0.44994 92159.9n 0.44994 92160.0n 0.73581 92339.9n 0.73581 92340.0n 0.44994 92519.9n 0.44994 92520.0n 0.51492 92699.9n 0.51492 92700.0n 1.14927 92879.9n 1.14927 92880.0n 1.04662 93059.9n 1.04662 93060.0n -0.38855 93239.9n -0.38855 93240.0n 0.03541 93419.9n 0.03541 93420.0n 0.68861 93599.9n 0.68861 93600.0n 0.78502 93779.9n 0.78502 93780.0n -0.07007 93959.9n -0.07007 93960.0n 0.79881 94139.9n 0.79881 94140.0n 0.30031 94319.9n 0.30031 94320.0n 0.29315 94499.9n 0.29315 94500.0n -0.36668 94679.9n -0.36668 94680.0n 0.43551 94859.9n 0.43551 94860.0n 0.47921 95039.9n 0.47921 95040.0n 0.64370 95219.9n 0.64370 95220.0n 0.26400 95399.9n 0.26400 95400.0n -0.21890 95579.9n -0.21890 95580.0n 0.72924 95759.9n 0.72924 95760.0n 0.75921 95939.9n 0.75921 95940.0n 0.44934 96119.9n 0.44934 96120.0n 1.31038 96299.9n 1.31038 96300.0n 0.52444 96479.9n 0.52444 96480.0n 0.13970 96659.9n 0.13970 96660.0n 0.82918 96839.9n 0.82918 96840.0n 0.56419 97019.9n 0.56419 97020.0n 0.46859 97199.9n 0.46859 97200.0n 0.11168 97379.9n 0.11168 97380.0n 0.30498 97559.9n 0.30498 97560.0n 0.72357 97739.9n 0.72357 97740.0n 0.89441 97919.9n 0.89441 97920.0n 0.43551 98099.9n 0.43551 98100.0n -0.36668 98279.9n -0.36668 98280.0n 0.72924 98459.9n 0.72924 98460.0n 0.46859 98639.9n 0.46859 98640.0n 0.44934 98819.9n 0.44934 98820.0n 0.44994 98999.9n 0.44994 99000.0n 0.13970 99179.9n 0.13970 99180.0n 0.51492 99359.9n 0.51492 99360.0n 0.73581 99539.9n 0.73581 99540.0n 0.89441 99719.9n 0.89441 99720.0n 0.75921 99899.9n 0.75921 99900.0n 0.79881 100079.9n 0.79881 100080.0n 1.14927 100259.9n 1.14927 100260.0n 0.30031 100439.9n 0.30031 100440.0n -0.38855 100619.9n -0.38855 100620.0n 0.56419 100799.9n 0.56419 100800.0n 0.11168 100979.9n 0.11168 100980.0n -0.07007 101159.9n -0.07007 101160.0n 0.29315 101339.9n 0.29315 101340.0n 1.04662 101519.9n 1.04662 101520.0n 0.03541 101699.9n 0.03541 101700.0n 0.78502 101879.9n 0.78502 101880.0n 0.26400 102059.9n 0.26400 102060.0n 0.82918 102239.9n 0.82918 102240.0n 0.47921 102419.9n 0.47921 102420.0n 0.52444 102599.9n 0.52444 102600.0n 0.72357 102779.9n 0.72357 102780.0n 0.30498 102959.9n 0.30498 102960.0n 1.31038 103139.9n 1.31038 103140.0n -0.21890 103319.9n -0.21890 103320.0n 0.64370 103499.9n 0.64370 103500.0n 0.68861 103679.9n 0.68861 103680.0n 0.03541 103859.9n 0.03541 103860.0n 0.75921 104039.9n 0.75921 104040.0n 0.11168 104219.9n 0.11168 104220.0n 0.46859 104399.9n 0.46859 104400.0n 1.04662 104579.9n 1.04662 104580.0n -0.21890 104759.9n -0.21890 104760.0n 0.64370 104939.9n 0.64370 104940.0n 0.44934 105119.9n 0.44934 105120.0n 0.68861 105299.9n 0.68861 105300.0n -0.36668 105479.9n -0.36668 105480.0n 0.51492 105659.9n 0.51492 105660.0n 0.13970 105839.9n 0.13970 105840.0n 0.43551 106019.9n 0.43551 106020.0n 0.47921 106199.9n 0.47921 106200.0n 0.89441 106379.9n 0.89441 106380.0n 0.52444 106559.9n 0.52444 106560.0n 1.14927 106739.9n 1.14927 106740.0n -0.07007 106919.9n -0.07007 106920.0n 0.44994 107099.9n 0.44994 107100.0n 0.30498 107279.9n 0.30498 107280.0n 0.30031 107459.9n 0.30031 107460.0n 0.72357 107639.9n 0.72357 107640.0n 0.73581 107819.9n 0.73581 107820.0n 0.82918 107999.9n 0.82918 108000.0n 1.31038 108179.9n 1.31038 108180.0n 0.79881 108359.9n 0.79881 108360.0n 0.56419 108539.9n 0.56419 108540.0n 0.29315 108719.9n 0.29315 108720.0n 0.72924 108899.9n 0.72924 108900.0n 0.26400 109079.9n 0.26400 109080.0n 0.78502 109259.9n 0.78502 109260.0n -0.38855 109439.9n -0.38855 109440.0n 0.26400 109619.9n 0.26400 109620.0n 0.03541 109799.9n 0.03541 109800.0n 0.44934 109979.9n 0.44934 109980.0n 0.72357 110159.9n 0.72357 110160.0n 1.14927 110339.9n 1.14927 110340.0n 1.31038 110519.9n 1.31038 110520.0n 0.43551 110699.9n 0.43551 110700.0n 0.72924 110879.9n 0.72924 110880.0n 0.29315 111059.9n 0.29315 111060.0n 0.52444 111239.9n 0.52444 111240.0n 0.64370 111419.9n 0.64370 111420.0n 0.30498 111599.9n 0.30498 111600.0n -0.21890 111779.9n -0.21890 111780.0n 0.30031 111959.9n 0.30031 111960.0n 0.79881 112139.9n 0.79881 112140.0n 0.44994 112319.9n 0.44994 112320.0n -0.07007 112499.9n -0.07007 112500.0n 0.56419 112679.9n 0.56419 112680.0n 0.46859 112859.9n 0.46859 112860.0n 0.73581 113039.9n 0.73581 113040.0n 0.82918 113219.9n 0.82918 113220.0n 1.04662 113399.9n 1.04662 113400.0n 0.89441 113579.9n 0.89441 113580.0n 0.51492 113759.9n 0.51492 113760.0n 0.13970 113939.9n 0.13970 113940.0n -0.36668 114119.9n -0.36668 114120.0n 0.47921 114299.9n 0.47921 114300.0n 0.78502 114479.9n 0.78502 114480.0n 0.75921 114659.9n 0.75921 114660.0n -0.38855 114839.9n -0.38855 114840.0n 0.11168 115019.9n 0.11168 115020.0n 0.68861 115199.9n 0.68861 115200.0n 0.72924 115379.9n 0.72924 115380.0n 0.68861 115559.9n 0.68861 115560.0n 0.47921 115739.9n 0.47921 115740.0n 0.64370 115919.9n 0.64370 115920.0n 0.43551 116099.9n 0.43551 116100.0n 0.79881 116279.9n 0.79881 116280.0n 0.29315 116459.9n 0.29315 116460.0n 0.46859 116639.9n 0.46859 116640.0n -0.07007 116819.9n -0.07007 116820.0n 1.14927 116999.9n 1.14927 117000.0n 0.75921 117179.9n 0.75921 117180.0n 0.56419 117359.9n 0.56419 117360.0n -0.38855 117539.9n -0.38855 117540.0n 1.31038 117719.9n 1.31038 117720.0n 0.44934 117899.9n 0.44934 117900.0n 0.51492 118079.9n 0.51492 118080.0n 0.30031 118259.9n 0.30031 118260.0n 0.73581 118439.9n 0.73581 118440.0n 0.44994 118619.9n 0.44994 118620.0n 0.78502 118799.9n 0.78502 118800.0n 0.11168 118979.9n 0.11168 118980.0n 0.52444 119159.9n 0.52444 119160.0n -0.36668 119339.9n -0.36668 119340.0n 0.89441 119519.9n 0.89441 119520.0n 0.03541 119699.9n 0.03541 119700.0n 0.72357 119879.9n 0.72357 119880.0n 0.82918 120059.9n 0.82918 120060.0n 0.30498 120239.9n 0.30498 120240.0n -0.21890 120419.9n -0.21890 120420.0n 0.13970 120599.9n 0.13970 120600.0n 0.26400 120779.9n 0.26400 120780.0n 1.04662 120959.9n 1.04662 120960.0n 0.52444 121139.9n 0.52444 121140.0n 0.75921 121319.9n 0.75921 121320.0n 0.43551 121499.9n 0.43551 121500.0n 0.13970 121679.9n 0.13970 121680.0n 0.47921 121859.9n 0.47921 121860.0n 0.79881 122039.9n 0.79881 122040.0n -0.38855 122219.9n -0.38855 122220.0n 0.30498 122399.9n 0.30498 122400.0n 0.51492 122579.9n 0.51492 122580.0n 0.82918 122759.9n 0.82918 122760.0n 1.14927 122939.9n 1.14927 122940.0n 0.03541 123119.9n 0.03541 123120.0n 0.11168 123299.9n 0.11168 123300.0n 0.46859 123479.9n 0.46859 123480.0n 0.78502 123659.9n 0.78502 123660.0n 0.68861 123839.9n 0.68861 123840.0n 0.29315 124019.9n 0.29315 124020.0n -0.21890 124199.9n -0.21890 124200.0n 0.44994 124379.9n 0.44994 124380.0n 0.72357 124559.9n 0.72357 124560.0n 0.44934 124739.9n 0.44934 124740.0n 1.31038 124919.9n 1.31038 124920.0n 0.89441 125099.9n 0.89441 125100.0n 0.30031 125279.9n 0.30031 125280.0n 0.73581 125459.9n 0.73581 125460.0n 0.26400 125639.9n 0.26400 125640.0n 1.04662 125819.9n 1.04662 125820.0n -0.36668 125999.9n -0.36668 126000.0n 0.56419 126179.9n 0.56419 126180.0n 0.64370 126359.9n 0.64370 126360.0n 0.72924 126539.9n 0.72924 126540.0n -0.07007 126719.9n -0.07007 126720.0n 0.51492 126899.9n 0.51492 126900.0n 0.73581 127079.9n 0.73581 127080.0n 0.44994 127259.9n 0.44994 127260.0n 0.46859 127439.9n 0.46859 127440.0n 0.47921 127619.9n 0.47921 127620.0n 0.44934 127799.9n 0.44934 127800.0n 0.68861 127979.9n 0.68861 127980.0n 0.82918 128159.9n 0.82918 128160.0n 1.04662 128339.9n 1.04662 128340.0n 0.11168 128519.9n 0.11168 128520.0n 0.78502 128699.9n 0.78502 128700.0n 0.13970 128879.9n 0.13970 128880.0n 0.43551 129059.9n 0.43551 129060.0n 0.64370 129239.9n 0.64370 129240.0n 0.52444 129419.9n 0.52444 129420.0n -0.07007 129599.9n -0.07007 129600.0n 0.75921 129779.9n 0.75921 129780.0n 0.03541 129959.9n 0.03541 129960.0n 0.30498 130139.9n 0.30498 130140.0n 0.30031 130319.9n 0.30031 130320.0n -0.38855 130499.9n -0.38855 130500.0n -0.21890 130679.9n -0.21890 130680.0n -0.36668 130859.9n -0.36668 130860.0n 1.31038 131039.9n 1.31038 131040.0n 0.56419 131219.9n 0.56419 131220.0n 0.79881 131399.9n 0.79881 131400.0n 0.72924 131579.9n 0.72924 131580.0n 0.29315 131759.9n 0.29315 131760.0n 0.26400 131939.9n 0.26400 131940.0n 0.72357 132119.9n 0.72357 132120.0n 1.14927 132299.9n 1.14927 132300.0n 0.89441 132479.9n 0.89441 132480.0n 0.43551 132659.9n 0.43551 132660.0n 0.78502 132839.9n 0.78502 132840.0n -0.36668 133019.9n -0.36668 133020.0n 0.47921 133199.9n 0.47921 133200.0n 0.75921 133379.9n 0.75921 133380.0n 0.30031 133559.9n 0.30031 133560.0n 1.14927 133739.9n 1.14927 133740.0n -0.21890 133919.9n -0.21890 133920.0n 0.46859 134099.9n 0.46859 134100.0n 0.72924 134279.9n 0.72924 134280.0n 0.73581 134459.9n 0.73581 134460.0n 0.11168 134639.9n 0.11168 134640.0n 0.44934 134819.9n 0.44934 134820.0n 0.51492 134999.9n 0.51492 135000.0n -0.07007 135179.9n -0.07007 135180.0n 0.26400 135359.9n 0.26400 135360.0n 0.52444 135539.9n 0.52444 135540.0n 1.31038 135719.9n 1.31038 135720.0n 0.79881 135899.9n 0.79881 135900.0n 0.68861 136079.9n 0.68861 136080.0n 1.04662 136259.9n 1.04662 136260.0n 0.64370 136439.9n 0.64370 136440.0n -0.38855 136619.9n -0.38855 136620.0n 0.44994 136799.9n 0.44994 136800.0n 0.03541 136979.9n 0.03541 136980.0n 0.89441 137159.9n 0.89441 137160.0n 0.82918 137339.9n 0.82918 137340.0n 0.72357 137519.9n 0.72357 137520.0n 0.56419 137699.9n 0.56419 137700.0n 0.13970 137879.9n 0.13970 137880.0n 0.29315 138059.9n 0.29315 138060.0n 0.30498 138239.9n 0.30498 138240.0n 0.51492 138419.9n 0.51492 138420.0n 0.46859 138599.9n 0.46859 138600.0n 0.72924 138779.9n 0.72924 138780.0n 0.82918 138959.9n 0.82918 138960.0n 1.14927 139139.9n 1.14927 139140.0n 0.03541 139319.9n 0.03541 139320.0n 0.44934 139499.9n 0.44934 139500.0n -0.38855 139679.9n -0.38855 139680.0n 0.79881 139859.9n 0.79881 139860.0n 0.56419 140039.9n 0.56419 140040.0n -0.21890 140219.9n -0.21890 140220.0n 0.13970 140399.9n 0.13970 140400.0n 0.26400 140579.9n 0.26400 140580.0n 0.78502 140759.9n 0.78502 140760.0n 0.44994 140939.9n 0.44994 140940.0n -0.07007 141119.9n -0.07007 141120.0n -0.36668 141299.9n -0.36668 141300.0n 0.72357 141479.9n 0.72357 141480.0n 0.47921 141659.9n 0.47921 141660.0n 0.75921 141839.9n 0.75921 141840.0n 0.52444 142019.9n 0.52444 142020.0n 0.30031 142199.9n 0.30031 142200.0n 1.04662 142379.9n 1.04662 142380.0n 0.29315 142559.9n 0.29315 142560.0n 0.73581 142739.9n 0.73581 142740.0n 0.68861 142919.9n 0.68861 142920.0n 0.89441 143099.9n 0.89441 143100.0n 0.43551 143279.9n 0.43551 143280.0n 0.11168 143459.9n 0.11168 143460.0n 0.64370 143639.9n 0.64370 143640.0n 1.31038 143819.9n 1.31038 143820.0n 0.30498 143999.9n 0.30498 144000.0n 0.72357 144179.9n 0.72357 144180.0n 0.73581 144359.9n 0.73581 144360.0n 0.75921 144539.9n 0.75921 144540.0n -0.07007 144719.9n -0.07007 144720.0n 0.29315 144899.9n 0.29315 144900.0n 0.13970 145079.9n 0.13970 145080.0n -0.36668 145259.9n -0.36668 145260.0n 0.11168 145439.9n 0.11168 145440.0n 0.79881 145619.9n 0.79881 145620.0n 1.04662 145799.9n 1.04662 145800.0n 0.47921 145979.9n 0.47921 145980.0n 0.44994 146159.9n 0.44994 146160.0n 0.72924 146339.9n 0.72924 146340.0n 0.78502 146519.9n 0.78502 146520.0n 1.14927 146699.9n 1.14927 146700.0n 0.43551 146879.9n 0.43551 146880.0n 0.52444 147059.9n 0.52444 147060.0n 0.51492 147239.9n 0.51492 147240.0n -0.21890 147419.9n -0.21890 147420.0n 0.30031 147599.9n 0.30031 147600.0n 0.30498 147779.9n 0.30498 147780.0n 0.46859 147959.9n 0.46859 147960.0n 0.68861 148139.9n 0.68861 148140.0n 0.89441 148319.9n 0.89441 148320.0n 0.26400 148499.9n 0.26400 148500.0n 1.31038 148679.9n 1.31038 148680.0n 0.64370 148859.9n 0.64370 148860.0n 0.44934 149039.9n 0.44934 149040.0n 0.03541 149219.9n 0.03541 149220.0n 0.56419 149399.9n 0.56419 149400.0n 0.82918 149579.9n 0.82918 149580.0n -0.38855 149759.9n -0.38855 149760.0n -0.36668 149939.9n -0.36668 149940.0n 0.30498 150119.9n 0.30498 150120.0n 0.03541 150299.9n 0.03541 150300.0n 0.11168 150479.9n 0.11168 150480.0n 0.29315 150659.9n 0.29315 150660.0n 0.79881 150839.9n 0.79881 150840.0n -0.21890 151019.9n -0.21890 151020.0n 1.14927 151199.9n 1.14927 151200.0n 0.68861 151379.9n 0.68861 151380.0n 1.04662 151559.9n 1.04662 151560.0n 0.72357 151739.9n 0.72357 151740.0n 1.31038 151919.9n 1.31038 151920.0n 0.30031 152099.9n 0.30031 152100.0n 0.46859 152279.9n 0.46859 152280.0n 0.51492 152459.9n 0.51492 152460.0n 0.52444 152639.9n 0.52444 152640.0n 0.44994 152819.9n 0.44994 152820.0n 0.26400 152999.9n 0.26400 153000.0n -0.38855 153179.9n -0.38855 153180.0n 0.73581 153359.9n 0.73581 153360.0n 0.43551 153539.9n 0.43551 153540.0n -0.07007 153719.9n -0.07007 153720.0n 0.13970 153899.9n 0.13970 153900.0n 0.78502 154079.9n 0.78502 154080.0n 0.72924 154259.9n 0.72924 154260.0n 0.82918 154439.9n 0.82918 154440.0n 0.56419 154619.9n 0.56419 154620.0n 0.75921 154799.9n 0.75921 154800.0n 0.64370 154979.9n 0.64370 154980.0n 0.89441 155159.9n 0.89441 155160.0n 0.44934 155339.9n 0.44934 155340.0n 0.47921 155519.9n 0.47921 155520.0n 0.03541 155699.9n 0.03541 155700.0n 0.30498 155879.9n 0.30498 155880.0n 0.68861 156059.9n 0.68861 156060.0n 0.82918 156239.9n 0.82918 156240.0n 0.73581 156419.9n 0.73581 156420.0n -0.21890 156599.9n -0.21890 156600.0n 0.72924 156779.9n 0.72924 156780.0n 1.14927 156959.9n 1.14927 156960.0n 1.04662 157139.9n 1.04662 157140.0n 0.11168 157319.9n 0.11168 157320.0n 0.79881 157499.9n 0.79881 157500.0n 0.29315 157679.9n 0.29315 157680.0n 0.72357 157859.9n 0.72357 157860.0n 0.44994 158039.9n 0.44994 158040.0n 0.52444 158219.9n 0.52444 158220.0n 0.78502 158399.9n 0.78502 158400.0n 0.89441 158579.9n 0.89441 158580.0n 1.31038 158759.9n 1.31038 158760.0n 0.51492 158939.9n 0.51492 158940.0n 0.43551 159119.9n 0.43551 159120.0n 0.44934 159299.9n 0.44934 159300.0n 0.13970 159479.9n 0.13970 159480.0n 0.46859 159659.9n 0.46859 159660.0n 0.75921 159839.9n 0.75921 159840.0n 0.26400 160019.9n 0.26400 160020.0n -0.07007 160199.9n -0.07007 160200.0n 0.30031 160379.9n 0.30031 160380.0n 0.64370 160559.9n 0.64370 160560.0n 0.56419 160739.9n 0.56419 160740.0n 0.47921 160919.9n 0.47921 160920.0n -0.36668 161099.9n -0.36668 161100.0n -0.38855 161279.9n -0.38855 161280.0n 0.72357 161459.9n 0.72357 161460.0n 0.26400 161639.9n 0.26400 161640.0n -0.36668 161819.9n -0.36668 161820.0n 1.14927 161999.9n 1.14927 162000.0n 0.73581 162179.9n 0.73581 162180.0n 0.44934 162359.9n 0.44934 162360.0n 0.11168 162539.9n 0.11168 162540.0n 1.31038 162719.9n 1.31038 162720.0n 0.47921 162899.9n 0.47921 162900.0n -0.07007 163079.9n -0.07007 163080.0n 0.78502 163259.9n 0.78502 163260.0n 0.43551 163439.9n 0.43551 163440.0n 1.04662 163619.9n 1.04662 163620.0n 0.13970 163799.9n 0.13970 163800.0n -0.38855 163979.9n -0.38855 163980.0n 0.03541 164159.9n 0.03541 164160.0n 0.30031 164339.9n 0.30031 164340.0n 0.89441 164519.9n 0.89441 164520.0n 0.52444 164699.9n 0.52444 164700.0n 0.44994 164879.9n 0.44994 164880.0n 0.75921 165059.9n 0.75921 165060.0n 0.29315 165239.9n 0.29315 165240.0n 0.64370 165419.9n 0.64370 165420.0n 0.30498 165599.9n 0.30498 165600.0n 0.56419 165779.9n 0.56419 165780.0n 0.79881 165959.9n 0.79881 165960.0n 0.46859 166139.9n 0.46859 166140.0n 0.72924 166319.9n 0.72924 166320.0n -0.21890 166499.9n -0.21890 166500.0n 0.82918 166679.9n 0.82918 166680.0n 0.51492 166859.9n 0.51492 166860.0n 0.68861 167039.9n 0.68861 167040.0n 0.26400 167219.9n 0.26400 167220.0n 0.56419 167399.9n 0.56419 167400.0n 0.30031 167579.9n 0.30031 167580.0n 1.04662 167759.9n 1.04662 167760.0n 0.79881 167939.9n 0.79881 167940.0n 0.47921 168119.9n 0.47921 168120.0n 0.43551 168299.9n 0.43551 168300.0n 0.68861 168479.9n 0.68861 168480.0n 0.46859 168659.9n 0.46859 168660.0n 0.29315 168839.9n 0.29315 168840.0n 0.44934 169019.9n 0.44934 169020.0n 0.11168 169199.9n 0.11168 169200.0n 0.73581 169379.9n 0.73581 169380.0n 0.52444 169559.9n 0.52444 169560.0n 1.31038 169739.9n 1.31038 169740.0n 0.51492 169919.9n 0.51492 169920.0n 0.72924 170099.9n 0.72924 170100.0n 0.75921 170279.9n 0.75921 170280.0n 0.13970 170459.9n 0.13970 170460.0n -0.36668 170639.9n -0.36668 170640.0n 0.03541 170819.9n 0.03541 170820.0n 1.14927 170999.9n 1.14927 171000.0n 0.89441 171179.9n 0.89441 171180.0n 0.44994 171359.9n 0.44994 171360.0n 0.64370 171539.9n 0.64370 171540.0n 0.82918 171719.9n 0.82918 171720.0n 0.78502 171899.9n 0.78502 171900.0n 0.30498 172079.9n 0.30498 172080.0n -0.07007 172259.9n -0.07007 172260.0n -0.38855 172439.9n -0.38855 172440.0n -0.21890 172619.9n -0.21890 172620.0n 0.72357 172799.9n 0.72357 172800.0n 0.42258 172979.9n 0.42258 172980.0n 0.20713 173159.9n 0.20713 173160.0n 0.39910 173339.9n 0.39910 173340.0n 0.76629 173519.9n 0.76629 173520.0n 0.87516 173699.9n 0.87516 173700.0n 0.51649 173879.9n 0.51649 173880.0n 0.47728 174059.9n 0.47728 174060.0n 0.89579 174239.9n 0.89579 174240.0n 0.73813 174419.9n 0.73813 174420.0n 0.73007 174599.9n 0.73007 174600.0n 0.38805 174779.9n 0.38805 174780.0n 0.44565 174959.9n 0.44565 174960.0n 0.84972 175139.9n 0.84972 175140.0n 0.31374 175319.9n 0.31374 175320.0n 0.53500 175499.9n 0.53500 175500.0n 0.65381 175679.9n 0.65381 175680.0n 0.58828 175859.9n 0.58828 175860.0n 0.29293 176039.9n 0.29293 176040.0n 0.34864 176219.9n 0.34864 176220.0n 0.39919 176399.9n 0.39919 176400.0n 0.28504 176579.9n 0.28504 176580.0n 0.90918 176759.9n 0.90918 176760.0n 0.50331 176939.9n 0.50331 176940.0n 0.28807 177119.9n 0.28807 177120.0n 0.23424 177299.9n 0.23424 177300.0n 0.53888 177479.9n 0.53888 177480.0n 0.48728 177659.9n 0.48728 177660.0n 0.50852 177839.9n 0.50852 177840.0n 0.58450 178019.9n 0.58450 178020.0n 0.36568 178199.9n 0.36568 178200.0n -0.28851 178379.9n -0.28851 178380.0n -0.24585 178559.9n -0.24585 178560.0n 1.15208 178739.9n 1.15208 178740.0n 0.41841 178919.9n 0.41841 178920.0n 0.24338 179099.9n 0.24338 179100.0n 1.49277 179279.9n 1.49277 179280.0n 1.19260 179459.9n 1.19260 179460.0n -0.27962 179639.9n -0.27962 179640.0n 0.55733 179819.9n 0.55733 179820.0n 0.95600 179999.9n 0.95600 180000.0n -0.04710 180179.9n -0.04710 180180.0n 0.80242 180359.9n 0.80242 180360.0n 0.39736 180539.9n 0.39736 180540.0n 1.04029 180719.9n 1.04029 180720.0n 0.63149 180899.9n 0.63149 180900.0n 0.81752 181079.9n 0.81752 181080.0n 1.19808 181259.9n 1.19808 181260.0n 1.39872 181439.9n 1.39872 181440.0n 0.28119 181619.9n 0.28119 181620.0n 1.46004 181799.9n 1.46004 181800.0n -0.19303 181979.9n -0.19303 181980.0n 0.93542 182159.9n 0.93542 182160.0n 1.06311 182339.9n 1.06311 182340.0n 1.11193 182519.9n 1.11193 182520.0n 1.17413 182699.9n 1.17413 182700.0n 1.01300 182879.9n 1.01300 182880.0n 1.13586 183059.9n 1.13586 183060.0n 1.03731 183239.9n 1.03731 183240.0n 0.46939 183419.9n 0.46939 183420.0n 0.57188)
Vxp1 a_xp1 0 PWL(0.0n 0.67130 179.9n 0.67130 180.0n -0.23386 359.9n -0.23386 360.0n 0.40313 539.9n 0.40313 540.0n 0.34013 719.9n 0.34013 720.0n 0.48458 899.9n 0.48458 900.0n 1.11225 1079.9n 1.11225 1080.0n -0.37792 1259.9n -0.37792 1260.0n -0.21828 1439.9n -0.21828 1440.0n 0.66096 1619.9n 0.66096 1620.0n 1.23180 1799.9n 1.23180 1800.0n 1.17517 1979.9n 1.17517 1980.0n 0.56595 2159.9n 0.56595 2160.0n 0.13226 2339.9n 0.13226 2340.0n -0.33158 2519.9n -0.33158 2520.0n 0.28189 2699.9n 0.28189 2700.0n 0.23835 2879.9n 0.23835 2880.0n -0.08309 3059.9n -0.08309 3060.0n 0.28700 3239.9n 0.28700 3240.0n 1.28574 3419.9n 1.28574 3420.0n 0.42554 3599.9n 0.42554 3600.0n 1.27694 3779.9n 1.27694 3780.0n 0.76415 3959.9n 0.76415 3960.0n 0.59247 4139.9n 0.59247 4140.0n -0.15161 4319.9n -0.15161 4320.0n 0.70122 4499.9n 0.70122 4500.0n 1.18224 4679.9n 1.18224 4680.0n 0.63482 4859.9n 0.63482 4860.0n 0.29915 5039.9n 0.29915 5040.0n 0.65842 5219.9n 0.65842 5220.0n 0.25911 5399.9n 0.25911 5400.0n 0.33171 5579.9n 0.33171 5580.0n 1.20712 5759.9n 1.20712 5760.0n 0.65842 5939.9n 0.65842 5940.0n -0.23386 6119.9n -0.23386 6120.0n 0.23835 6299.9n 0.23835 6300.0n 0.29915 6479.9n 0.29915 6480.0n 1.18224 6659.9n 1.18224 6660.0n -0.33158 6839.9n -0.33158 6840.0n -0.08309 7019.9n -0.08309 7020.0n -0.15161 7199.9n -0.15161 7200.0n 0.59247 7379.9n 0.59247 7380.0n 1.27694 7559.9n 1.27694 7560.0n 1.17517 7739.9n 1.17517 7740.0n 0.40313 7919.9n 0.40313 7920.0n 0.67130 8099.9n 0.67130 8100.0n 0.63482 8279.9n 0.63482 8280.0n 0.28700 8459.9n 0.28700 8460.0n 0.76415 8639.9n 0.76415 8640.0n 0.34013 8819.9n 0.34013 8820.0n 0.66096 8999.9n 0.66096 9000.0n 0.28189 9179.9n 0.28189 9180.0n 0.25911 9359.9n 0.25911 9360.0n -0.21828 9539.9n -0.21828 9540.0n -0.37792 9719.9n -0.37792 9720.0n 0.48458 9899.9n 0.48458 9900.0n 0.13226 10079.9n 0.13226 10080.0n 0.42554 10259.9n 0.42554 10260.0n 1.11225 10439.9n 1.11225 10440.0n 0.56595 10619.9n 0.56595 10620.0n 1.23180 10799.9n 1.23180 10800.0n 1.28574 10979.9n 1.28574 10980.0n 0.33171 11159.9n 0.33171 11160.0n 1.20712 11339.9n 1.20712 11340.0n 0.70122 11519.9n 0.70122 11520.0n 0.76415 11699.9n 0.76415 11700.0n 1.27694 11879.9n 1.27694 11880.0n 0.42554 12059.9n 0.42554 12060.0n 0.40313 12239.9n 0.40313 12240.0n 0.28189 12419.9n 0.28189 12420.0n 0.25911 12599.9n 0.25911 12600.0n 0.28700 12779.9n 0.28700 12780.0n 0.13226 12959.9n 0.13226 12960.0n 1.28574 13139.9n 1.28574 13140.0n -0.37792 13319.9n -0.37792 13320.0n 1.18224 13499.9n 1.18224 13500.0n -0.15161 13679.9n -0.15161 13680.0n 0.59247 13859.9n 0.59247 13860.0n 0.65842 14039.9n 0.65842 14040.0n 0.70122 14219.9n 0.70122 14220.0n 0.63482 14399.9n 0.63482 14400.0n 0.67130 14579.9n 0.67130 14580.0n 0.48458 14759.9n 0.48458 14760.0n 1.20712 14939.9n 1.20712 14940.0n -0.33158 15119.9n -0.33158 15120.0n 0.33171 15299.9n 0.33171 15300.0n 1.23180 15479.9n 1.23180 15480.0n 1.11225 15659.9n 1.11225 15660.0n 0.23835 15839.9n 0.23835 15840.0n -0.23386 16019.9n -0.23386 16020.0n 1.17517 16199.9n 1.17517 16200.0n 0.56595 16379.9n 0.56595 16380.0n 0.34013 16559.9n 0.34013 16560.0n -0.08309 16739.9n -0.08309 16740.0n 0.29915 16919.9n 0.29915 16920.0n 0.66096 17099.9n 0.66096 17100.0n -0.21828 17279.9n -0.21828 17280.0n 0.33171 17459.9n 0.33171 17460.0n 0.65842 17639.9n 0.65842 17640.0n 1.28574 17819.9n 1.28574 17820.0n 0.29915 17999.9n 0.29915 18000.0n 0.28700 18179.9n 0.28700 18180.0n 0.13226 18359.9n 0.13226 18360.0n 0.23835 18539.9n 0.23835 18540.0n -0.23386 18719.9n -0.23386 18720.0n -0.08309 18899.9n -0.08309 18900.0n -0.15161 19079.9n -0.15161 19080.0n 1.11225 19259.9n 1.11225 19260.0n 0.66096 19439.9n 0.66096 19440.0n 1.23180 19619.9n 1.23180 19620.0n 0.25911 19799.9n 0.25911 19800.0n 1.27694 19979.9n 1.27694 19980.0n 0.59247 20159.9n 0.59247 20160.0n 0.40313 20339.9n 0.40313 20340.0n 0.42554 20519.9n 0.42554 20520.0n 1.20712 20699.9n 1.20712 20700.0n 0.70122 20879.9n 0.70122 20880.0n -0.33158 21059.9n -0.33158 21060.0n 0.28189 21239.9n 0.28189 21240.0n -0.37792 21419.9n -0.37792 21420.0n 0.67130 21599.9n 0.67130 21600.0n 0.76415 21779.9n 0.76415 21780.0n 0.63482 21959.9n 0.63482 21960.0n 1.17517 22139.9n 1.17517 22140.0n 0.56595 22319.9n 0.56595 22320.0n -0.21828 22499.9n -0.21828 22500.0n 0.48458 22679.9n 0.48458 22680.0n 0.34013 22859.9n 0.34013 22860.0n 1.18224 23039.9n 1.18224 23040.0n -0.08309 23219.9n -0.08309 23220.0n 0.48458 23399.9n 0.48458 23400.0n 0.13226 23579.9n 0.13226 23580.0n -0.37792 23759.9n -0.37792 23760.0n 0.25911 23939.9n 0.25911 23940.0n 1.17517 24119.9n 1.17517 24120.0n 1.28574 24299.9n 1.28574 24300.0n 0.34013 24479.9n 0.34013 24480.0n 0.40313 24659.9n 0.40313 24660.0n 0.28189 24839.9n 0.28189 24840.0n -0.33158 25019.9n -0.33158 25020.0n 1.27694 25199.9n 1.27694 25200.0n 0.42554 25379.9n 0.42554 25380.0n 0.29915 25559.9n 0.29915 25560.0n 0.70122 25739.9n 0.70122 25740.0n 0.59247 25919.9n 0.59247 25920.0n 0.65842 26099.9n 0.65842 26100.0n 1.23180 26279.9n 1.23180 26280.0n 1.18224 26459.9n 1.18224 26460.0n 0.63482 26639.9n 0.63482 26640.0n 0.28700 26819.9n 0.28700 26820.0n -0.23386 26999.9n -0.23386 27000.0n 0.76415 27179.9n 0.76415 27180.0n 0.56595 27359.9n 0.56595 27360.0n 0.23835 27539.9n 0.23835 27540.0n 1.20712 27719.9n 1.20712 27720.0n 1.11225 27899.9n 1.11225 27900.0n 0.66096 28079.9n 0.66096 28080.0n -0.21828 28259.9n -0.21828 28260.0n -0.15161 28439.9n -0.15161 28440.0n 0.67130 28619.9n 0.67130 28620.0n 0.33171 28799.9n 0.33171 28800.0n 0.23835 28979.9n 0.23835 28980.0n 0.29915 29159.9n 0.29915 29160.0n 1.11225 29339.9n 1.11225 29340.0n 1.23180 29519.9n 1.23180 29520.0n 1.27694 29699.9n 1.27694 29700.0n 0.34013 29879.9n 0.34013 29880.0n 0.25911 30059.9n 0.25911 30060.0n 0.76415 30239.9n 0.76415 30240.0n 0.59247 30419.9n 0.59247 30420.0n -0.08309 30599.9n -0.08309 30600.0n 0.48458 30779.9n 0.48458 30780.0n 0.33171 30959.9n 0.33171 30960.0n -0.37792 31139.9n -0.37792 31140.0n 0.40313 31319.9n 0.40313 31320.0n -0.15161 31499.9n -0.15161 31500.0n 0.66096 31679.9n 0.66096 31680.0n 0.65842 31859.9n 0.65842 31860.0n 0.70122 32039.9n 0.70122 32040.0n 1.18224 32219.9n 1.18224 32220.0n 1.17517 32399.9n 1.17517 32400.0n 0.56595 32579.9n 0.56595 32580.0n 0.28189 32759.9n 0.28189 32760.0n 0.13226 32939.9n 0.13226 32940.0n 1.20712 33119.9n 1.20712 33120.0n 1.28574 33299.9n 1.28574 33300.0n -0.21828 33479.9n -0.21828 33480.0n 0.42554 33659.9n 0.42554 33660.0n -0.23386 33839.9n -0.23386 33840.0n -0.33158 34019.9n -0.33158 34020.0n 0.28700 34199.9n 0.28700 34200.0n 0.63482 34379.9n 0.63482 34380.0n 0.67130 34559.9n 0.67130 34560.0n 0.23835 34739.9n 0.23835 34740.0n 0.40313 34919.9n 0.40313 34920.0n 0.63482 35099.9n 0.63482 35100.0n 0.13226 35279.9n 0.13226 35280.0n 1.23180 35459.9n 1.23180 35460.0n 0.25911 35639.9n 0.25911 35640.0n -0.08309 35819.9n -0.08309 35820.0n -0.33158 35999.9n -0.33158 36000.0n 0.76415 36179.9n 0.76415 36180.0n 0.59247 36359.9n 0.59247 36360.0n 1.18224 36539.9n 1.18224 36540.0n 1.28574 36719.9n 1.28574 36720.0n 0.33171 36899.9n 0.33171 36900.0n 1.27694 37079.9n 1.27694 37080.0n 0.65842 37259.9n 0.65842 37260.0n -0.37792 37439.9n -0.37792 37440.0n -0.23386 37619.9n -0.23386 37620.0n 0.66096 37799.9n 0.66096 37800.0n 0.42554 37979.9n 0.42554 37980.0n -0.21828 38159.9n -0.21828 38160.0n -0.15161 38339.9n -0.15161 38340.0n 0.70122 38519.9n 0.70122 38520.0n 0.28189 38699.9n 0.28189 38700.0n 0.28700 38879.9n 0.28700 38880.0n 0.48458 39059.9n 0.48458 39060.0n 1.17517 39239.9n 1.17517 39240.0n 0.29915 39419.9n 0.29915 39420.0n 0.67130 39599.9n 0.67130 39600.0n 1.20712 39779.9n 1.20712 39780.0n 0.56595 39959.9n 0.56595 39960.0n 0.34013 40139.9n 0.34013 40140.0n 1.11225 40319.9n 1.11225 40320.0n 0.65842 40499.9n 0.65842 40500.0n 1.11225 40679.9n 1.11225 40680.0n 1.20712 40859.9n 1.20712 40860.0n -0.15161 41039.9n -0.15161 41040.0n -0.23386 41219.9n -0.23386 41220.0n -0.08309 41399.9n -0.08309 41400.0n 0.28700 41579.9n 0.28700 41580.0n 1.18224 41759.9n 1.18224 41760.0n 0.76415 41939.9n 0.76415 41940.0n 0.29915 42119.9n 0.29915 42120.0n 1.27694 42299.9n 1.27694 42300.0n 0.63482 42479.9n 0.63482 42480.0n -0.37792 42659.9n -0.37792 42660.0n 0.33171 42839.9n 0.33171 42840.0n -0.33158 43019.9n -0.33158 43020.0n 0.34013 43199.9n 0.34013 43200.0n 1.28574 43379.9n 1.28574 43380.0n 0.70122 43559.9n 0.70122 43560.0n -0.21828 43739.9n -0.21828 43740.0n 0.23835 43919.9n 0.23835 43920.0n 0.40313 44099.9n 0.40313 44100.0n 0.56595 44279.9n 0.56595 44280.0n 0.28189 44459.9n 0.28189 44460.0n 0.13226 44639.9n 0.13226 44640.0n 1.17517 44819.9n 1.17517 44820.0n 1.23180 44999.9n 1.23180 45000.0n 0.66096 45179.9n 0.66096 45180.0n 0.59247 45359.9n 0.59247 45360.0n 0.48458 45539.9n 0.48458 45540.0n 0.67130 45719.9n 0.67130 45720.0n 0.25911 45899.9n 0.25911 45900.0n 0.42554 46079.9n 0.42554 46080.0n 0.13226 46259.9n 0.13226 46260.0n -0.37792 46439.9n -0.37792 46440.0n 0.42554 46619.9n 0.42554 46620.0n 0.56595 46799.9n 0.56595 46800.0n -0.23386 46979.9n -0.23386 46980.0n 1.11225 47159.9n 1.11225 47160.0n 0.29915 47339.9n 0.29915 47340.0n -0.08309 47519.9n -0.08309 47520.0n 0.25911 47699.9n 0.25911 47700.0n 1.27694 47879.9n 1.27694 47880.0n 0.76415 48059.9n 0.76415 48060.0n 1.28574 48239.9n 1.28574 48240.0n 1.20712 48419.9n 1.20712 48420.0n 0.28700 48599.9n 0.28700 48600.0n 1.17517 48779.9n 1.17517 48780.0n 0.65842 48959.9n 0.65842 48960.0n 0.67130 49139.9n 0.67130 49140.0n 1.23180 49319.9n 1.23180 49320.0n 0.59247 49499.9n 0.59247 49500.0n 0.63482 49679.9n 0.63482 49680.0n -0.33158 49859.9n -0.33158 49860.0n 0.28189 50039.9n 0.28189 50040.0n -0.15161 50219.9n -0.15161 50220.0n 0.23835 50399.9n 0.23835 50400.0n 0.33171 50579.9n 0.33171 50580.0n 0.70122 50759.9n 0.70122 50760.0n 0.40313 50939.9n 0.40313 50940.0n 1.18224 51119.9n 1.18224 51120.0n 0.34013 51299.9n 0.34013 51300.0n 0.48458 51479.9n 0.48458 51480.0n 0.66096 51659.9n 0.66096 51660.0n -0.21828 51839.9n -0.21828 51840.0n 0.28189 52019.9n 0.28189 52020.0n 0.56595 52199.9n 0.56595 52200.0n 0.34013 52379.9n 0.34013 52380.0n 0.33171 52559.9n 0.33171 52560.0n 0.66096 52739.9n 0.66096 52740.0n 0.67130 52919.9n 0.67130 52920.0n 0.13226 53099.9n 0.13226 53100.0n 0.65842 53279.9n 0.65842 53280.0n -0.33158 53459.9n -0.33158 53460.0n 1.27694 53639.9n 1.27694 53640.0n 0.63482 53819.9n 0.63482 53820.0n -0.23386 53999.9n -0.23386 54000.0n 0.76415 54179.9n 0.76415 54180.0n 1.28574 54359.9n 1.28574 54360.0n 0.59247 54539.9n 0.59247 54540.0n 0.28700 54719.9n 0.28700 54720.0n 0.25911 54899.9n 0.25911 54900.0n 1.18224 55079.9n 1.18224 55080.0n -0.37792 55259.9n -0.37792 55260.0n 1.23180 55439.9n 1.23180 55440.0n 0.48458 55619.9n 0.48458 55620.0n 1.17517 55799.9n 1.17517 55800.0n 1.11225 55979.9n 1.11225 55980.0n 0.40313 56159.9n 0.40313 56160.0n -0.21828 56339.9n -0.21828 56340.0n 0.29915 56519.9n 0.29915 56520.0n 0.42554 56699.9n 0.42554 56700.0n -0.08309 56879.9n -0.08309 56880.0n 1.20712 57059.9n 1.20712 57060.0n 0.23835 57239.9n 0.23835 57240.0n 0.70122 57419.9n 0.70122 57420.0n -0.15161 57599.9n -0.15161 57600.0n 0.13226 57779.9n 0.13226 57780.0n 0.48458 57959.9n 0.48458 57960.0n -0.15161 58139.9n -0.15161 58140.0n 0.59247 58319.9n 0.59247 58320.0n 0.34013 58499.9n 0.34013 58500.0n 1.18224 58679.9n 1.18224 58680.0n -0.08309 58859.9n -0.08309 58860.0n 0.63482 59039.9n 0.63482 59040.0n 0.42554 59219.9n 0.42554 59220.0n 1.27694 59399.9n 1.27694 59400.0n 0.66096 59579.9n 0.66096 59580.0n 0.25911 59759.9n 0.25911 59760.0n 0.76415 59939.9n 0.76415 59940.0n 0.40313 60119.9n 0.40313 60120.0n 1.28574 60299.9n 1.28574 60300.0n 1.11225 60479.9n 1.11225 60480.0n -0.21828 60659.9n -0.21828 60660.0n 1.17517 60839.9n 1.17517 60840.0n -0.23386 61019.9n -0.23386 61020.0n 1.23180 61199.9n 1.23180 61200.0n 0.28189 61379.9n 0.28189 61380.0n 0.23835 61559.9n 0.23835 61560.0n 0.67130 61739.9n 0.67130 61740.0n -0.37792 61919.9n -0.37792 61920.0n 0.29915 62099.9n 0.29915 62100.0n 0.28700 62279.9n 0.28700 62280.0n 0.70122 62459.9n 0.70122 62460.0n 0.56595 62639.9n 0.56595 62640.0n 1.20712 62819.9n 1.20712 62820.0n -0.33158 62999.9n -0.33158 63000.0n 0.65842 63179.9n 0.65842 63180.0n 0.33171 63359.9n 0.33171 63360.0n 0.25911 63539.9n 0.25911 63540.0n 0.40313 63719.9n 0.40313 63720.0n 0.70122 63899.9n 0.70122 63900.0n 0.67130 64079.9n 0.67130 64080.0n 0.76415 64259.9n 0.76415 64260.0n 1.17517 64439.9n 1.17517 64440.0n 0.33171 64619.9n 0.33171 64620.0n 0.65842 64799.9n 0.65842 64800.0n 1.27694 64979.9n 1.27694 64980.0n 1.23180 65159.9n 1.23180 65160.0n -0.21828 65339.9n -0.21828 65340.0n 0.66096 65519.9n 0.66096 65520.0n 0.63482 65699.9n 0.63482 65700.0n -0.23386 65879.9n -0.23386 65880.0n 0.59247 66059.9n 0.59247 66060.0n 0.42554 66239.9n 0.42554 66240.0n 0.28189 66419.9n 0.28189 66420.0n -0.08309 66599.9n -0.08309 66600.0n 0.13226 66779.9n 0.13226 66780.0n 0.48458 66959.9n 0.48458 66960.0n 0.56595 67139.9n 0.56595 67140.0n 0.28700 67319.9n 0.28700 67320.0n -0.33158 67499.9n -0.33158 67500.0n 1.20712 67679.9n 1.20712 67680.0n 1.28574 67859.9n 1.28574 67860.0n 0.23835 68039.9n 0.23835 68040.0n -0.37792 68219.9n -0.37792 68220.0n 0.34013 68399.9n 0.34013 68400.0n -0.15161 68579.9n -0.15161 68580.0n 1.11225 68759.9n 1.11225 68760.0n 1.18224 68939.9n 1.18224 68940.0n 0.29915 69119.9n 0.29915 69120.0n 0.40313 69299.9n 0.40313 69300.0n 1.23180 69479.9n 1.23180 69480.0n 1.27694 69659.9n 1.27694 69660.0n -0.37792 69839.9n -0.37792 69840.0n 0.34013 70019.9n 0.34013 70020.0n -0.15161 70199.9n -0.15161 70200.0n 0.63482 70379.9n 0.63482 70380.0n 0.76415 70559.9n 0.76415 70560.0n 0.28700 70739.9n 0.28700 70740.0n 0.25911 70919.9n 0.25911 70920.0n 1.20712 71099.9n 1.20712 71100.0n -0.21828 71279.9n -0.21828 71280.0n 0.66096 71459.9n 0.66096 71460.0n 0.13226 71639.9n 0.13226 71640.0n 1.28574 71819.9n 1.28574 71820.0n 0.23835 71999.9n 0.23835 72000.0n 0.59247 72179.9n 0.59247 72180.0n 0.42554 72359.9n 0.42554 72360.0n 0.28189 72539.9n 0.28189 72540.0n -0.08309 72719.9n -0.08309 72720.0n 0.48458 72899.9n 0.48458 72900.0n 1.17517 73079.9n 1.17517 73080.0n -0.23386 73259.9n -0.23386 73260.0n 0.65842 73439.9n 0.65842 73440.0n 1.11225 73619.9n 1.11225 73620.0n 0.56595 73799.9n 0.56595 73800.0n 1.18224 73979.9n 1.18224 73980.0n 0.67130 74159.9n 0.67130 74160.0n -0.33158 74339.9n -0.33158 74340.0n 0.33171 74519.9n 0.33171 74520.0n 0.29915 74699.9n 0.29915 74700.0n 0.70122 74879.9n 0.70122 74880.0n 1.27694 75059.9n 1.27694 75060.0n -0.23386 75239.9n -0.23386 75240.0n 0.48458 75419.9n 0.48458 75420.0n 1.11225 75599.9n 1.11225 75600.0n -0.21828 75779.9n -0.21828 75780.0n 0.70122 75959.9n 0.70122 75960.0n -0.15161 76139.9n -0.15161 76140.0n 0.29915 76319.9n 0.29915 76320.0n 1.18224 76499.9n 1.18224 76500.0n -0.33158 76679.9n -0.33158 76680.0n 0.59247 76859.9n 0.59247 76860.0n 0.13226 77039.9n 0.13226 77040.0n -0.08309 77219.9n -0.08309 77220.0n 1.17517 77399.9n 1.17517 77400.0n 0.66096 77579.9n 0.66096 77580.0n 0.34013 77759.9n 0.34013 77760.0n 0.42554 77939.9n 0.42554 77940.0n 0.33171 78119.9n 0.33171 78120.0n 0.63482 78299.9n 0.63482 78300.0n 0.40313 78479.9n 0.40313 78480.0n 1.20712 78659.9n 1.20712 78660.0n 1.23180 78839.9n 1.23180 78840.0n 0.56595 79019.9n 0.56595 79020.0n 0.65842 79199.9n 0.65842 79200.0n 0.25911 79379.9n 0.25911 79380.0n 0.67130 79559.9n 0.67130 79560.0n -0.37792 79739.9n -0.37792 79740.0n 0.23835 79919.9n 0.23835 79920.0n 0.76415 80099.9n 0.76415 80100.0n 0.28189 80279.9n 0.28189 80280.0n 0.28700 80459.9n 0.28700 80460.0n 1.28574 80639.9n 1.28574 80640.0n 0.28189 80819.9n 0.28189 80820.0n 1.11225 80999.9n 1.11225 81000.0n 0.56595 81179.9n 0.56595 81180.0n 0.25911 81359.9n 0.25911 81360.0n 0.48458 81539.9n 0.48458 81540.0n 0.70122 81719.9n 0.70122 81720.0n 0.29915 81899.9n 0.29915 81900.0n 1.18224 82079.9n 1.18224 82080.0n 0.59247 82259.9n 0.59247 82260.0n 0.28700 82439.9n 0.28700 82440.0n -0.21828 82619.9n -0.21828 82620.0n 1.20712 82799.9n 1.20712 82800.0n -0.37792 82979.9n -0.37792 82980.0n -0.33158 83159.9n -0.33158 83160.0n 0.33171 83339.9n 0.33171 83340.0n 0.13226 83519.9n 0.13226 83520.0n -0.15161 83699.9n -0.15161 83700.0n 0.66096 83879.9n 0.66096 83880.0n 1.23180 84059.9n 1.23180 84060.0n 0.23835 84239.9n 0.23835 84240.0n 1.27694 84419.9n 1.27694 84420.0n 0.76415 84599.9n 0.76415 84600.0n 0.40313 84779.9n 0.40313 84780.0n 0.34013 84959.9n 0.34013 84960.0n 0.42554 85139.9n 0.42554 85140.0n 0.65842 85319.9n 0.65842 85320.0n 1.17517 85499.9n 1.17517 85500.0n 0.63482 85679.9n 0.63482 85680.0n 1.28574 85859.9n 1.28574 85860.0n -0.08309 86039.9n -0.08309 86040.0n 0.67130 86219.9n 0.67130 86220.0n -0.23386 86399.9n -0.23386 86400.0n 0.56595 86579.9n 0.56595 86580.0n 0.70122 86759.9n 0.70122 86760.0n -0.15161 86939.9n -0.15161 86940.0n 0.29915 87119.9n 0.29915 87120.0n 1.11225 87299.9n 1.11225 87300.0n 0.28189 87479.9n 0.28189 87480.0n 1.17517 87659.9n 1.17517 87660.0n 1.20712 87839.9n 1.20712 87840.0n 0.66096 88019.9n 0.66096 88020.0n -0.33158 88199.9n -0.33158 88200.0n 0.59247 88379.9n 0.59247 88380.0n 0.28700 88559.9n 0.28700 88560.0n 0.76415 88739.9n 0.76415 88740.0n -0.08309 88919.9n -0.08309 88920.0n -0.23386 89099.9n -0.23386 89100.0n 0.13226 89279.9n 0.13226 89280.0n 1.28574 89459.9n 1.28574 89460.0n -0.37792 89639.9n -0.37792 89640.0n 0.23835 89819.9n 0.23835 89820.0n 0.48458 89999.9n 0.48458 90000.0n 0.42554 90179.9n 0.42554 90180.0n 0.65842 90359.9n 0.65842 90360.0n -0.21828 90539.9n -0.21828 90540.0n 1.27694 90719.9n 1.27694 90720.0n 0.25911 90899.9n 0.25911 90900.0n 0.67130 91079.9n 0.67130 91080.0n 0.33171 91259.9n 0.33171 91260.0n 1.18224 91439.9n 1.18224 91440.0n 0.40313 91619.9n 0.40313 91620.0n 1.23180 91799.9n 1.23180 91800.0n 0.34013 91979.9n 0.34013 91980.0n 0.63482 92159.9n 0.63482 92160.0n -0.15161 92339.9n -0.15161 92340.0n 0.63482 92519.9n 0.63482 92520.0n 0.29915 92699.9n 0.29915 92700.0n 1.17517 92879.9n 1.17517 92880.0n 1.18224 93059.9n 1.18224 93060.0n 0.59247 93239.9n 0.59247 93240.0n -0.33158 93419.9n -0.33158 93420.0n 0.70122 93599.9n 0.70122 93600.0n 0.65842 93779.9n 0.65842 93780.0n 1.28574 93959.9n 1.28574 93960.0n 0.25911 94139.9n 0.25911 94140.0n 1.23180 94319.9n 1.23180 94320.0n 0.33171 94499.9n 0.33171 94500.0n 0.13226 94679.9n 0.13226 94680.0n 0.28189 94859.9n 0.28189 94860.0n 0.34013 95039.9n 0.34013 95040.0n 0.42554 95219.9n 0.42554 95220.0n 0.23835 95399.9n 0.23835 95400.0n 1.20712 95579.9n 1.20712 95580.0n 1.27694 95759.9n 1.27694 95760.0n 0.56595 95939.9n 0.56595 95940.0n 0.76415 96119.9n 0.76415 96120.0n 0.28700 96299.9n 0.28700 96300.0n -0.37792 96479.9n -0.37792 96480.0n 0.40313 96659.9n 0.40313 96660.0n 0.66096 96839.9n 0.66096 96840.0n 0.67130 97019.9n 0.67130 97020.0n -0.21828 97199.9n -0.21828 97200.0n -0.08309 97379.9n -0.08309 97380.0n 0.48458 97559.9n 0.48458 97560.0n -0.23386 97739.9n -0.23386 97740.0n 1.11225 97919.9n 1.11225 97920.0n 0.28189 98099.9n 0.28189 98100.0n 0.13226 98279.9n 0.13226 98280.0n 1.27694 98459.9n 1.27694 98460.0n -0.21828 98639.9n -0.21828 98640.0n 0.76415 98819.9n 0.76415 98820.0n 0.63482 98999.9n 0.63482 99000.0n 0.40313 99179.9n 0.40313 99180.0n 0.29915 99359.9n 0.29915 99360.0n -0.15161 99539.9n -0.15161 99540.0n 1.11225 99719.9n 1.11225 99720.0n 0.56595 99899.9n 0.56595 99900.0n 0.25911 100079.9n 0.25911 100080.0n 1.17517 100259.9n 1.17517 100260.0n 1.23180 100439.9n 1.23180 100440.0n 0.59247 100619.9n 0.59247 100620.0n 0.67130 100799.9n 0.67130 100800.0n -0.08309 100979.9n -0.08309 100980.0n 1.28574 101159.9n 1.28574 101160.0n 0.33171 101339.9n 0.33171 101340.0n 1.18224 101519.9n 1.18224 101520.0n -0.33158 101699.9n -0.33158 101700.0n 0.65842 101879.9n 0.65842 101880.0n 0.23835 102059.9n 0.23835 102060.0n 0.66096 102239.9n 0.66096 102240.0n 0.34013 102419.9n 0.34013 102420.0n -0.37792 102599.9n -0.37792 102600.0n -0.23386 102779.9n -0.23386 102780.0n 0.48458 102959.9n 0.48458 102960.0n 0.28700 103139.9n 0.28700 103140.0n 1.20712 103319.9n 1.20712 103320.0n 0.42554 103499.9n 0.42554 103500.0n 0.70122 103679.9n 0.70122 103680.0n -0.33158 103859.9n -0.33158 103860.0n 0.56595 104039.9n 0.56595 104040.0n -0.08309 104219.9n -0.08309 104220.0n -0.21828 104399.9n -0.21828 104400.0n 1.18224 104579.9n 1.18224 104580.0n 1.20712 104759.9n 1.20712 104760.0n 0.42554 104939.9n 0.42554 104940.0n 0.76415 105119.9n 0.76415 105120.0n 0.70122 105299.9n 0.70122 105300.0n 0.13226 105479.9n 0.13226 105480.0n 0.29915 105659.9n 0.29915 105660.0n 0.40313 105839.9n 0.40313 105840.0n 0.28189 106019.9n 0.28189 106020.0n 0.34013 106199.9n 0.34013 106200.0n 1.11225 106379.9n 1.11225 106380.0n -0.37792 106559.9n -0.37792 106560.0n 1.17517 106739.9n 1.17517 106740.0n 1.28574 106919.9n 1.28574 106920.0n 0.63482 107099.9n 0.63482 107100.0n 0.48458 107279.9n 0.48458 107280.0n 1.23180 107459.9n 1.23180 107460.0n -0.23386 107639.9n -0.23386 107640.0n -0.15161 107819.9n -0.15161 107820.0n 0.66096 107999.9n 0.66096 108000.0n 0.28700 108179.9n 0.28700 108180.0n 0.25911 108359.9n 0.25911 108360.0n 0.67130 108539.9n 0.67130 108540.0n 0.33171 108719.9n 0.33171 108720.0n 1.27694 108899.9n 1.27694 108900.0n 0.23835 109079.9n 0.23835 109080.0n 0.65842 109259.9n 0.65842 109260.0n 0.59247 109439.9n 0.59247 109440.0n 0.23835 109619.9n 0.23835 109620.0n -0.33158 109799.9n -0.33158 109800.0n 0.76415 109979.9n 0.76415 109980.0n -0.23386 110159.9n -0.23386 110160.0n 1.17517 110339.9n 1.17517 110340.0n 0.28700 110519.9n 0.28700 110520.0n 0.28189 110699.9n 0.28189 110700.0n 1.27694 110879.9n 1.27694 110880.0n 0.33171 111059.9n 0.33171 111060.0n -0.37792 111239.9n -0.37792 111240.0n 0.42554 111419.9n 0.42554 111420.0n 0.48458 111599.9n 0.48458 111600.0n 1.20712 111779.9n 1.20712 111780.0n 1.23180 111959.9n 1.23180 111960.0n 0.25911 112139.9n 0.25911 112140.0n 0.63482 112319.9n 0.63482 112320.0n 1.28574 112499.9n 1.28574 112500.0n 0.67130 112679.9n 0.67130 112680.0n -0.21828 112859.9n -0.21828 112860.0n -0.15161 113039.9n -0.15161 113040.0n 0.66096 113219.9n 0.66096 113220.0n 1.18224 113399.9n 1.18224 113400.0n 1.11225 113579.9n 1.11225 113580.0n 0.29915 113759.9n 0.29915 113760.0n 0.40313 113939.9n 0.40313 113940.0n 0.13226 114119.9n 0.13226 114120.0n 0.34013 114299.9n 0.34013 114300.0n 0.65842 114479.9n 0.65842 114480.0n 0.56595 114659.9n 0.56595 114660.0n 0.59247 114839.9n 0.59247 114840.0n -0.08309 115019.9n -0.08309 115020.0n 0.70122 115199.9n 0.70122 115200.0n 1.27694 115379.9n 1.27694 115380.0n 0.70122 115559.9n 0.70122 115560.0n 0.34013 115739.9n 0.34013 115740.0n 0.42554 115919.9n 0.42554 115920.0n 0.28189 116099.9n 0.28189 116100.0n 0.25911 116279.9n 0.25911 116280.0n 0.33171 116459.9n 0.33171 116460.0n -0.21828 116639.9n -0.21828 116640.0n 1.28574 116819.9n 1.28574 116820.0n 1.17517 116999.9n 1.17517 117000.0n 0.56595 117179.9n 0.56595 117180.0n 0.67130 117359.9n 0.67130 117360.0n 0.59247 117539.9n 0.59247 117540.0n 0.28700 117719.9n 0.28700 117720.0n 0.76415 117899.9n 0.76415 117900.0n 0.29915 118079.9n 0.29915 118080.0n 1.23180 118259.9n 1.23180 118260.0n -0.15161 118439.9n -0.15161 118440.0n 0.63482 118619.9n 0.63482 118620.0n 0.65842 118799.9n 0.65842 118800.0n -0.08309 118979.9n -0.08309 118980.0n -0.37792 119159.9n -0.37792 119160.0n 0.13226 119339.9n 0.13226 119340.0n 1.11225 119519.9n 1.11225 119520.0n -0.33158 119699.9n -0.33158 119700.0n -0.23386 119879.9n -0.23386 119880.0n 0.66096 120059.9n 0.66096 120060.0n 0.48458 120239.9n 0.48458 120240.0n 1.20712 120419.9n 1.20712 120420.0n 0.40313 120599.9n 0.40313 120600.0n 0.23835 120779.9n 0.23835 120780.0n 1.18224 120959.9n 1.18224 120960.0n -0.37792 121139.9n -0.37792 121140.0n 0.56595 121319.9n 0.56595 121320.0n 0.28189 121499.9n 0.28189 121500.0n 0.40313 121679.9n 0.40313 121680.0n 0.34013 121859.9n 0.34013 121860.0n 0.25911 122039.9n 0.25911 122040.0n 0.59247 122219.9n 0.59247 122220.0n 0.48458 122399.9n 0.48458 122400.0n 0.29915 122579.9n 0.29915 122580.0n 0.66096 122759.9n 0.66096 122760.0n 1.17517 122939.9n 1.17517 122940.0n -0.33158 123119.9n -0.33158 123120.0n -0.08309 123299.9n -0.08309 123300.0n -0.21828 123479.9n -0.21828 123480.0n 0.65842 123659.9n 0.65842 123660.0n 0.70122 123839.9n 0.70122 123840.0n 0.33171 124019.9n 0.33171 124020.0n 1.20712 124199.9n 1.20712 124200.0n 0.63482 124379.9n 0.63482 124380.0n -0.23386 124559.9n -0.23386 124560.0n 0.76415 124739.9n 0.76415 124740.0n 0.28700 124919.9n 0.28700 124920.0n 1.11225 125099.9n 1.11225 125100.0n 1.23180 125279.9n 1.23180 125280.0n -0.15161 125459.9n -0.15161 125460.0n 0.23835 125639.9n 0.23835 125640.0n 1.18224 125819.9n 1.18224 125820.0n 0.13226 125999.9n 0.13226 126000.0n 0.67130 126179.9n 0.67130 126180.0n 0.42554 126359.9n 0.42554 126360.0n 1.27694 126539.9n 1.27694 126540.0n 1.28574 126719.9n 1.28574 126720.0n 0.29915 126899.9n 0.29915 126900.0n -0.15161 127079.9n -0.15161 127080.0n 0.63482 127259.9n 0.63482 127260.0n -0.21828 127439.9n -0.21828 127440.0n 0.34013 127619.9n 0.34013 127620.0n 0.76415 127799.9n 0.76415 127800.0n 0.70122 127979.9n 0.70122 127980.0n 0.66096 128159.9n 0.66096 128160.0n 1.18224 128339.9n 1.18224 128340.0n -0.08309 128519.9n -0.08309 128520.0n 0.65842 128699.9n 0.65842 128700.0n 0.40313 128879.9n 0.40313 128880.0n 0.28189 129059.9n 0.28189 129060.0n 0.42554 129239.9n 0.42554 129240.0n -0.37792 129419.9n -0.37792 129420.0n 1.28574 129599.9n 1.28574 129600.0n 0.56595 129779.9n 0.56595 129780.0n -0.33158 129959.9n -0.33158 129960.0n 0.48458 130139.9n 0.48458 130140.0n 1.23180 130319.9n 1.23180 130320.0n 0.59247 130499.9n 0.59247 130500.0n 1.20712 130679.9n 1.20712 130680.0n 0.13226 130859.9n 0.13226 130860.0n 0.28700 131039.9n 0.28700 131040.0n 0.67130 131219.9n 0.67130 131220.0n 0.25911 131399.9n 0.25911 131400.0n 1.27694 131579.9n 1.27694 131580.0n 0.33171 131759.9n 0.33171 131760.0n 0.23835 131939.9n 0.23835 131940.0n -0.23386 132119.9n -0.23386 132120.0n 1.17517 132299.9n 1.17517 132300.0n 1.11225 132479.9n 1.11225 132480.0n 0.28189 132659.9n 0.28189 132660.0n 0.65842 132839.9n 0.65842 132840.0n 0.13226 133019.9n 0.13226 133020.0n 0.34013 133199.9n 0.34013 133200.0n 0.56595 133379.9n 0.56595 133380.0n 1.23180 133559.9n 1.23180 133560.0n 1.17517 133739.9n 1.17517 133740.0n 1.20712 133919.9n 1.20712 133920.0n -0.21828 134099.9n -0.21828 134100.0n 1.27694 134279.9n 1.27694 134280.0n -0.15161 134459.9n -0.15161 134460.0n -0.08309 134639.9n -0.08309 134640.0n 0.76415 134819.9n 0.76415 134820.0n 0.29915 134999.9n 0.29915 135000.0n 1.28574 135179.9n 1.28574 135180.0n 0.23835 135359.9n 0.23835 135360.0n -0.37792 135539.9n -0.37792 135540.0n 0.28700 135719.9n 0.28700 135720.0n 0.25911 135899.9n 0.25911 135900.0n 0.70122 136079.9n 0.70122 136080.0n 1.18224 136259.9n 1.18224 136260.0n 0.42554 136439.9n 0.42554 136440.0n 0.59247 136619.9n 0.59247 136620.0n 0.63482 136799.9n 0.63482 136800.0n -0.33158 136979.9n -0.33158 136980.0n 1.11225 137159.9n 1.11225 137160.0n 0.66096 137339.9n 0.66096 137340.0n -0.23386 137519.9n -0.23386 137520.0n 0.67130 137699.9n 0.67130 137700.0n 0.40313 137879.9n 0.40313 137880.0n 0.33171 138059.9n 0.33171 138060.0n 0.48458 138239.9n 0.48458 138240.0n 0.29915 138419.9n 0.29915 138420.0n -0.21828 138599.9n -0.21828 138600.0n 1.27694 138779.9n 1.27694 138780.0n 0.66096 138959.9n 0.66096 138960.0n 1.17517 139139.9n 1.17517 139140.0n -0.33158 139319.9n -0.33158 139320.0n 0.76415 139499.9n 0.76415 139500.0n 0.59247 139679.9n 0.59247 139680.0n 0.25911 139859.9n 0.25911 139860.0n 0.67130 140039.9n 0.67130 140040.0n 1.20712 140219.9n 1.20712 140220.0n 0.40313 140399.9n 0.40313 140400.0n 0.23835 140579.9n 0.23835 140580.0n 0.65842 140759.9n 0.65842 140760.0n 0.63482 140939.9n 0.63482 140940.0n 1.28574 141119.9n 1.28574 141120.0n 0.13226 141299.9n 0.13226 141300.0n -0.23386 141479.9n -0.23386 141480.0n 0.34013 141659.9n 0.34013 141660.0n 0.56595 141839.9n 0.56595 141840.0n -0.37792 142019.9n -0.37792 142020.0n 1.23180 142199.9n 1.23180 142200.0n 1.18224 142379.9n 1.18224 142380.0n 0.33171 142559.9n 0.33171 142560.0n -0.15161 142739.9n -0.15161 142740.0n 0.70122 142919.9n 0.70122 142920.0n 1.11225 143099.9n 1.11225 143100.0n 0.28189 143279.9n 0.28189 143280.0n -0.08309 143459.9n -0.08309 143460.0n 0.42554 143639.9n 0.42554 143640.0n 0.28700 143819.9n 0.28700 143820.0n 0.48458 143999.9n 0.48458 144000.0n -0.23386 144179.9n -0.23386 144180.0n -0.15161 144359.9n -0.15161 144360.0n 0.56595 144539.9n 0.56595 144540.0n 1.28574 144719.9n 1.28574 144720.0n 0.33171 144899.9n 0.33171 144900.0n 0.40313 145079.9n 0.40313 145080.0n 0.13226 145259.9n 0.13226 145260.0n -0.08309 145439.9n -0.08309 145440.0n 0.25911 145619.9n 0.25911 145620.0n 1.18224 145799.9n 1.18224 145800.0n 0.34013 145979.9n 0.34013 145980.0n 0.63482 146159.9n 0.63482 146160.0n 1.27694 146339.9n 1.27694 146340.0n 0.65842 146519.9n 0.65842 146520.0n 1.17517 146699.9n 1.17517 146700.0n 0.28189 146879.9n 0.28189 146880.0n -0.37792 147059.9n -0.37792 147060.0n 0.29915 147239.9n 0.29915 147240.0n 1.20712 147419.9n 1.20712 147420.0n 1.23180 147599.9n 1.23180 147600.0n 0.48458 147779.9n 0.48458 147780.0n -0.21828 147959.9n -0.21828 147960.0n 0.70122 148139.9n 0.70122 148140.0n 1.11225 148319.9n 1.11225 148320.0n 0.23835 148499.9n 0.23835 148500.0n 0.28700 148679.9n 0.28700 148680.0n 0.42554 148859.9n 0.42554 148860.0n 0.76415 149039.9n 0.76415 149040.0n -0.33158 149219.9n -0.33158 149220.0n 0.67130 149399.9n 0.67130 149400.0n 0.66096 149579.9n 0.66096 149580.0n 0.59247 149759.9n 0.59247 149760.0n 0.13226 149939.9n 0.13226 149940.0n 0.48458 150119.9n 0.48458 150120.0n -0.33158 150299.9n -0.33158 150300.0n -0.08309 150479.9n -0.08309 150480.0n 0.33171 150659.9n 0.33171 150660.0n 0.25911 150839.9n 0.25911 150840.0n 1.20712 151019.9n 1.20712 151020.0n 1.17517 151199.9n 1.17517 151200.0n 0.70122 151379.9n 0.70122 151380.0n 1.18224 151559.9n 1.18224 151560.0n -0.23386 151739.9n -0.23386 151740.0n 0.28700 151919.9n 0.28700 151920.0n 1.23180 152099.9n 1.23180 152100.0n -0.21828 152279.9n -0.21828 152280.0n 0.29915 152459.9n 0.29915 152460.0n -0.37792 152639.9n -0.37792 152640.0n 0.63482 152819.9n 0.63482 152820.0n 0.23835 152999.9n 0.23835 153000.0n 0.59247 153179.9n 0.59247 153180.0n -0.15161 153359.9n -0.15161 153360.0n 0.28189 153539.9n 0.28189 153540.0n 1.28574 153719.9n 1.28574 153720.0n 0.40313 153899.9n 0.40313 153900.0n 0.65842 154079.9n 0.65842 154080.0n 1.27694 154259.9n 1.27694 154260.0n 0.66096 154439.9n 0.66096 154440.0n 0.67130 154619.9n 0.67130 154620.0n 0.56595 154799.9n 0.56595 154800.0n 0.42554 154979.9n 0.42554 154980.0n 1.11225 155159.9n 1.11225 155160.0n 0.76415 155339.9n 0.76415 155340.0n 0.34013 155519.9n 0.34013 155520.0n -0.33158 155699.9n -0.33158 155700.0n 0.48458 155879.9n 0.48458 155880.0n 0.70122 156059.9n 0.70122 156060.0n 0.66096 156239.9n 0.66096 156240.0n -0.15161 156419.9n -0.15161 156420.0n 1.20712 156599.9n 1.20712 156600.0n 1.27694 156779.9n 1.27694 156780.0n 1.17517 156959.9n 1.17517 156960.0n 1.18224 157139.9n 1.18224 157140.0n -0.08309 157319.9n -0.08309 157320.0n 0.25911 157499.9n 0.25911 157500.0n 0.33171 157679.9n 0.33171 157680.0n -0.23386 157859.9n -0.23386 157860.0n 0.63482 158039.9n 0.63482 158040.0n -0.37792 158219.9n -0.37792 158220.0n 0.65842 158399.9n 0.65842 158400.0n 1.11225 158579.9n 1.11225 158580.0n 0.28700 158759.9n 0.28700 158760.0n 0.29915 158939.9n 0.29915 158940.0n 0.28189 159119.9n 0.28189 159120.0n 0.76415 159299.9n 0.76415 159300.0n 0.40313 159479.9n 0.40313 159480.0n -0.21828 159659.9n -0.21828 159660.0n 0.56595 159839.9n 0.56595 159840.0n 0.23835 160019.9n 0.23835 160020.0n 1.28574 160199.9n 1.28574 160200.0n 1.23180 160379.9n 1.23180 160380.0n 0.42554 160559.9n 0.42554 160560.0n 0.67130 160739.9n 0.67130 160740.0n 0.34013 160919.9n 0.34013 160920.0n 0.13226 161099.9n 0.13226 161100.0n 0.59247 161279.9n 0.59247 161280.0n -0.23386 161459.9n -0.23386 161460.0n 0.23835 161639.9n 0.23835 161640.0n 0.13226 161819.9n 0.13226 161820.0n 1.17517 161999.9n 1.17517 162000.0n -0.15161 162179.9n -0.15161 162180.0n 0.76415 162359.9n 0.76415 162360.0n -0.08309 162539.9n -0.08309 162540.0n 0.28700 162719.9n 0.28700 162720.0n 0.34013 162899.9n 0.34013 162900.0n 1.28574 163079.9n 1.28574 163080.0n 0.65842 163259.9n 0.65842 163260.0n 0.28189 163439.9n 0.28189 163440.0n 1.18224 163619.9n 1.18224 163620.0n 0.40313 163799.9n 0.40313 163800.0n 0.59247 163979.9n 0.59247 163980.0n -0.33158 164159.9n -0.33158 164160.0n 1.23180 164339.9n 1.23180 164340.0n 1.11225 164519.9n 1.11225 164520.0n -0.37792 164699.9n -0.37792 164700.0n 0.63482 164879.9n 0.63482 164880.0n 0.56595 165059.9n 0.56595 165060.0n 0.33171 165239.9n 0.33171 165240.0n 0.42554 165419.9n 0.42554 165420.0n 0.48458 165599.9n 0.48458 165600.0n 0.67130 165779.9n 0.67130 165780.0n 0.25911 165959.9n 0.25911 165960.0n -0.21828 166139.9n -0.21828 166140.0n 1.27694 166319.9n 1.27694 166320.0n 1.20712 166499.9n 1.20712 166500.0n 0.66096 166679.9n 0.66096 166680.0n 0.29915 166859.9n 0.29915 166860.0n 0.70122 167039.9n 0.70122 167040.0n 0.23835 167219.9n 0.23835 167220.0n 0.67130 167399.9n 0.67130 167400.0n 1.23180 167579.9n 1.23180 167580.0n 1.18224 167759.9n 1.18224 167760.0n 0.25911 167939.9n 0.25911 167940.0n 0.34013 168119.9n 0.34013 168120.0n 0.28189 168299.9n 0.28189 168300.0n 0.70122 168479.9n 0.70122 168480.0n -0.21828 168659.9n -0.21828 168660.0n 0.33171 168839.9n 0.33171 168840.0n 0.76415 169019.9n 0.76415 169020.0n -0.08309 169199.9n -0.08309 169200.0n -0.15161 169379.9n -0.15161 169380.0n -0.37792 169559.9n -0.37792 169560.0n 0.28700 169739.9n 0.28700 169740.0n 0.29915 169919.9n 0.29915 169920.0n 1.27694 170099.9n 1.27694 170100.0n 0.56595 170279.9n 0.56595 170280.0n 0.40313 170459.9n 0.40313 170460.0n 0.13226 170639.9n 0.13226 170640.0n -0.33158 170819.9n -0.33158 170820.0n 1.17517 170999.9n 1.17517 171000.0n 1.11225 171179.9n 1.11225 171180.0n 0.63482 171359.9n 0.63482 171360.0n 0.42554 171539.9n 0.42554 171540.0n 0.66096 171719.9n 0.66096 171720.0n 0.65842 171899.9n 0.65842 171900.0n 0.48458 172079.9n 0.48458 172080.0n 1.28574 172259.9n 1.28574 172260.0n 0.59247 172439.9n 0.59247 172440.0n 1.20712 172619.9n 1.20712 172620.0n -0.23386 172799.9n -0.23386 172800.0n 0.36576 172979.9n 0.36576 172980.0n 0.33730 173159.9n 0.33730 173160.0n 0.38385 173339.9n 0.38385 173340.0n 0.59706 173519.9n 0.59706 173520.0n 0.62307 173699.9n 0.62307 173700.0n 0.67018 173879.9n 0.67018 173880.0n 0.70540 174059.9n 0.70540 174060.0n 0.53582 174239.9n 0.53582 174240.0n 0.33357 174419.9n 0.33357 174420.0n 0.52885 174599.9n 0.52885 174600.0n 0.74383 174779.9n 0.74383 174780.0n 0.78409 174959.9n 0.78409 174960.0n 0.51936 175139.9n 0.51936 175140.0n 0.50532 175319.9n 0.50532 175320.0n 0.68189 175499.9n 0.68189 175500.0n 0.79862 175679.9n 0.79862 175680.0n 0.35050 175859.9n 0.35050 175860.0n 0.16858 176039.9n 0.16858 176040.0n 0.55253 176219.9n 0.55253 176220.0n 0.60823 176399.9n 0.60823 176400.0n 0.63611 176579.9n 0.63611 176580.0n 0.41197 176759.9n 0.41197 176760.0n 0.69413 176939.9n 0.69413 176940.0n 0.58457 177119.9n 0.58457 177120.0n 0.33751 177299.9n 0.33751 177300.0n 0.71381 177479.9n 0.71381 177480.0n 0.64266 177659.9n 0.64266 177660.0n 0.16018 177839.9n 0.16018 177840.0n 0.78157 178019.9n 0.78157 178020.0n 0.22203 178199.9n 0.22203 178200.0n 0.87402 178379.9n 0.87402 178380.0n -0.10545 178559.9n -0.10545 178560.0n -0.25282 178739.9n -0.25282 178740.0n -0.37666 178919.9n -0.37666 178920.0n 1.43391 179099.9n 1.43391 179100.0n 0.37511 179279.9n 0.37511 179280.0n 0.35780 179459.9n 0.35780 179460.0n 1.04281 179639.9n 1.04281 179640.0n 1.30757 179819.9n 1.30757 179820.0n -0.27950 179999.9n -0.27950 180000.0n 0.10137 180179.9n 0.10137 180180.0n 1.20727 180359.9n 1.20727 180360.0n 1.40210 180539.9n 1.40210 180540.0n 1.03003 180719.9n 1.03003 180720.0n -0.27250 180899.9n -0.27250 180900.0n -0.24444 181079.9n -0.24444 181080.0n 0.81835 181259.9n 0.81835 181260.0n 0.11792 181439.9n 0.11792 181440.0n -0.41822 181619.9n -0.41822 181620.0n 0.75242 181799.9n 0.75242 181800.0n 0.57354 181979.9n 0.57354 181980.0n 1.22124 182159.9n 1.22124 182160.0n 1.07258 182339.9n 1.07258 182340.0n 1.14286 182519.9n 1.14286 182520.0n -0.14226 182699.9n -0.14226 182700.0n 1.32817 182879.9n 1.32817 182880.0n 1.08864 183059.9n 1.08864 183060.0n 1.09055 183239.9n 1.09055 183240.0n 1.50665 183419.9n 1.50665 183420.0n -0.21520)
Vxn1 a_xn1 0 PWL(0.0n 0.32870 179.9n 0.32870 180.0n 1.23386 359.9n 1.23386 360.0n 0.59687 539.9n 0.59687 540.0n 0.65987 719.9n 0.65987 720.0n 0.51542 899.9n 0.51542 900.0n -0.11225 1079.9n -0.11225 1080.0n 1.37792 1259.9n 1.37792 1260.0n 1.21828 1439.9n 1.21828 1440.0n 0.33904 1619.9n 0.33904 1620.0n -0.23180 1799.9n -0.23180 1800.0n -0.17517 1979.9n -0.17517 1980.0n 0.43405 2159.9n 0.43405 2160.0n 0.86774 2339.9n 0.86774 2340.0n 1.33158 2519.9n 1.33158 2520.0n 0.71811 2699.9n 0.71811 2700.0n 0.76165 2879.9n 0.76165 2880.0n 1.08309 3059.9n 1.08309 3060.0n 0.71300 3239.9n 0.71300 3240.0n -0.28574 3419.9n -0.28574 3420.0n 0.57446 3599.9n 0.57446 3600.0n -0.27694 3779.9n -0.27694 3780.0n 0.23585 3959.9n 0.23585 3960.0n 0.40753 4139.9n 0.40753 4140.0n 1.15161 4319.9n 1.15161 4320.0n 0.29878 4499.9n 0.29878 4500.0n -0.18224 4679.9n -0.18224 4680.0n 0.36518 4859.9n 0.36518 4860.0n 0.70085 5039.9n 0.70085 5040.0n 0.34158 5219.9n 0.34158 5220.0n 0.74089 5399.9n 0.74089 5400.0n 0.66829 5579.9n 0.66829 5580.0n -0.20712 5759.9n -0.20712 5760.0n 0.34158 5939.9n 0.34158 5940.0n 1.23386 6119.9n 1.23386 6120.0n 0.76165 6299.9n 0.76165 6300.0n 0.70085 6479.9n 0.70085 6480.0n -0.18224 6659.9n -0.18224 6660.0n 1.33158 6839.9n 1.33158 6840.0n 1.08309 7019.9n 1.08309 7020.0n 1.15161 7199.9n 1.15161 7200.0n 0.40753 7379.9n 0.40753 7380.0n -0.27694 7559.9n -0.27694 7560.0n -0.17517 7739.9n -0.17517 7740.0n 0.59687 7919.9n 0.59687 7920.0n 0.32870 8099.9n 0.32870 8100.0n 0.36518 8279.9n 0.36518 8280.0n 0.71300 8459.9n 0.71300 8460.0n 0.23585 8639.9n 0.23585 8640.0n 0.65987 8819.9n 0.65987 8820.0n 0.33904 8999.9n 0.33904 9000.0n 0.71811 9179.9n 0.71811 9180.0n 0.74089 9359.9n 0.74089 9360.0n 1.21828 9539.9n 1.21828 9540.0n 1.37792 9719.9n 1.37792 9720.0n 0.51542 9899.9n 0.51542 9900.0n 0.86774 10079.9n 0.86774 10080.0n 0.57446 10259.9n 0.57446 10260.0n -0.11225 10439.9n -0.11225 10440.0n 0.43405 10619.9n 0.43405 10620.0n -0.23180 10799.9n -0.23180 10800.0n -0.28574 10979.9n -0.28574 10980.0n 0.66829 11159.9n 0.66829 11160.0n -0.20712 11339.9n -0.20712 11340.0n 0.29878 11519.9n 0.29878 11520.0n 0.23585 11699.9n 0.23585 11700.0n -0.27694 11879.9n -0.27694 11880.0n 0.57446 12059.9n 0.57446 12060.0n 0.59687 12239.9n 0.59687 12240.0n 0.71811 12419.9n 0.71811 12420.0n 0.74089 12599.9n 0.74089 12600.0n 0.71300 12779.9n 0.71300 12780.0n 0.86774 12959.9n 0.86774 12960.0n -0.28574 13139.9n -0.28574 13140.0n 1.37792 13319.9n 1.37792 13320.0n -0.18224 13499.9n -0.18224 13500.0n 1.15161 13679.9n 1.15161 13680.0n 0.40753 13859.9n 0.40753 13860.0n 0.34158 14039.9n 0.34158 14040.0n 0.29878 14219.9n 0.29878 14220.0n 0.36518 14399.9n 0.36518 14400.0n 0.32870 14579.9n 0.32870 14580.0n 0.51542 14759.9n 0.51542 14760.0n -0.20712 14939.9n -0.20712 14940.0n 1.33158 15119.9n 1.33158 15120.0n 0.66829 15299.9n 0.66829 15300.0n -0.23180 15479.9n -0.23180 15480.0n -0.11225 15659.9n -0.11225 15660.0n 0.76165 15839.9n 0.76165 15840.0n 1.23386 16019.9n 1.23386 16020.0n -0.17517 16199.9n -0.17517 16200.0n 0.43405 16379.9n 0.43405 16380.0n 0.65987 16559.9n 0.65987 16560.0n 1.08309 16739.9n 1.08309 16740.0n 0.70085 16919.9n 0.70085 16920.0n 0.33904 17099.9n 0.33904 17100.0n 1.21828 17279.9n 1.21828 17280.0n 0.66829 17459.9n 0.66829 17460.0n 0.34158 17639.9n 0.34158 17640.0n -0.28574 17819.9n -0.28574 17820.0n 0.70085 17999.9n 0.70085 18000.0n 0.71300 18179.9n 0.71300 18180.0n 0.86774 18359.9n 0.86774 18360.0n 0.76165 18539.9n 0.76165 18540.0n 1.23386 18719.9n 1.23386 18720.0n 1.08309 18899.9n 1.08309 18900.0n 1.15161 19079.9n 1.15161 19080.0n -0.11225 19259.9n -0.11225 19260.0n 0.33904 19439.9n 0.33904 19440.0n -0.23180 19619.9n -0.23180 19620.0n 0.74089 19799.9n 0.74089 19800.0n -0.27694 19979.9n -0.27694 19980.0n 0.40753 20159.9n 0.40753 20160.0n 0.59687 20339.9n 0.59687 20340.0n 0.57446 20519.9n 0.57446 20520.0n -0.20712 20699.9n -0.20712 20700.0n 0.29878 20879.9n 0.29878 20880.0n 1.33158 21059.9n 1.33158 21060.0n 0.71811 21239.9n 0.71811 21240.0n 1.37792 21419.9n 1.37792 21420.0n 0.32870 21599.9n 0.32870 21600.0n 0.23585 21779.9n 0.23585 21780.0n 0.36518 21959.9n 0.36518 21960.0n -0.17517 22139.9n -0.17517 22140.0n 0.43405 22319.9n 0.43405 22320.0n 1.21828 22499.9n 1.21828 22500.0n 0.51542 22679.9n 0.51542 22680.0n 0.65987 22859.9n 0.65987 22860.0n -0.18224 23039.9n -0.18224 23040.0n 1.08309 23219.9n 1.08309 23220.0n 0.51542 23399.9n 0.51542 23400.0n 0.86774 23579.9n 0.86774 23580.0n 1.37792 23759.9n 1.37792 23760.0n 0.74089 23939.9n 0.74089 23940.0n -0.17517 24119.9n -0.17517 24120.0n -0.28574 24299.9n -0.28574 24300.0n 0.65987 24479.9n 0.65987 24480.0n 0.59687 24659.9n 0.59687 24660.0n 0.71811 24839.9n 0.71811 24840.0n 1.33158 25019.9n 1.33158 25020.0n -0.27694 25199.9n -0.27694 25200.0n 0.57446 25379.9n 0.57446 25380.0n 0.70085 25559.9n 0.70085 25560.0n 0.29878 25739.9n 0.29878 25740.0n 0.40753 25919.9n 0.40753 25920.0n 0.34158 26099.9n 0.34158 26100.0n -0.23180 26279.9n -0.23180 26280.0n -0.18224 26459.9n -0.18224 26460.0n 0.36518 26639.9n 0.36518 26640.0n 0.71300 26819.9n 0.71300 26820.0n 1.23386 26999.9n 1.23386 27000.0n 0.23585 27179.9n 0.23585 27180.0n 0.43405 27359.9n 0.43405 27360.0n 0.76165 27539.9n 0.76165 27540.0n -0.20712 27719.9n -0.20712 27720.0n -0.11225 27899.9n -0.11225 27900.0n 0.33904 28079.9n 0.33904 28080.0n 1.21828 28259.9n 1.21828 28260.0n 1.15161 28439.9n 1.15161 28440.0n 0.32870 28619.9n 0.32870 28620.0n 0.66829 28799.9n 0.66829 28800.0n 0.76165 28979.9n 0.76165 28980.0n 0.70085 29159.9n 0.70085 29160.0n -0.11225 29339.9n -0.11225 29340.0n -0.23180 29519.9n -0.23180 29520.0n -0.27694 29699.9n -0.27694 29700.0n 0.65987 29879.9n 0.65987 29880.0n 0.74089 30059.9n 0.74089 30060.0n 0.23585 30239.9n 0.23585 30240.0n 0.40753 30419.9n 0.40753 30420.0n 1.08309 30599.9n 1.08309 30600.0n 0.51542 30779.9n 0.51542 30780.0n 0.66829 30959.9n 0.66829 30960.0n 1.37792 31139.9n 1.37792 31140.0n 0.59687 31319.9n 0.59687 31320.0n 1.15161 31499.9n 1.15161 31500.0n 0.33904 31679.9n 0.33904 31680.0n 0.34158 31859.9n 0.34158 31860.0n 0.29878 32039.9n 0.29878 32040.0n -0.18224 32219.9n -0.18224 32220.0n -0.17517 32399.9n -0.17517 32400.0n 0.43405 32579.9n 0.43405 32580.0n 0.71811 32759.9n 0.71811 32760.0n 0.86774 32939.9n 0.86774 32940.0n -0.20712 33119.9n -0.20712 33120.0n -0.28574 33299.9n -0.28574 33300.0n 1.21828 33479.9n 1.21828 33480.0n 0.57446 33659.9n 0.57446 33660.0n 1.23386 33839.9n 1.23386 33840.0n 1.33158 34019.9n 1.33158 34020.0n 0.71300 34199.9n 0.71300 34200.0n 0.36518 34379.9n 0.36518 34380.0n 0.32870 34559.9n 0.32870 34560.0n 0.76165 34739.9n 0.76165 34740.0n 0.59687 34919.9n 0.59687 34920.0n 0.36518 35099.9n 0.36518 35100.0n 0.86774 35279.9n 0.86774 35280.0n -0.23180 35459.9n -0.23180 35460.0n 0.74089 35639.9n 0.74089 35640.0n 1.08309 35819.9n 1.08309 35820.0n 1.33158 35999.9n 1.33158 36000.0n 0.23585 36179.9n 0.23585 36180.0n 0.40753 36359.9n 0.40753 36360.0n -0.18224 36539.9n -0.18224 36540.0n -0.28574 36719.9n -0.28574 36720.0n 0.66829 36899.9n 0.66829 36900.0n -0.27694 37079.9n -0.27694 37080.0n 0.34158 37259.9n 0.34158 37260.0n 1.37792 37439.9n 1.37792 37440.0n 1.23386 37619.9n 1.23386 37620.0n 0.33904 37799.9n 0.33904 37800.0n 0.57446 37979.9n 0.57446 37980.0n 1.21828 38159.9n 1.21828 38160.0n 1.15161 38339.9n 1.15161 38340.0n 0.29878 38519.9n 0.29878 38520.0n 0.71811 38699.9n 0.71811 38700.0n 0.71300 38879.9n 0.71300 38880.0n 0.51542 39059.9n 0.51542 39060.0n -0.17517 39239.9n -0.17517 39240.0n 0.70085 39419.9n 0.70085 39420.0n 0.32870 39599.9n 0.32870 39600.0n -0.20712 39779.9n -0.20712 39780.0n 0.43405 39959.9n 0.43405 39960.0n 0.65987 40139.9n 0.65987 40140.0n -0.11225 40319.9n -0.11225 40320.0n 0.34158 40499.9n 0.34158 40500.0n -0.11225 40679.9n -0.11225 40680.0n -0.20712 40859.9n -0.20712 40860.0n 1.15161 41039.9n 1.15161 41040.0n 1.23386 41219.9n 1.23386 41220.0n 1.08309 41399.9n 1.08309 41400.0n 0.71300 41579.9n 0.71300 41580.0n -0.18224 41759.9n -0.18224 41760.0n 0.23585 41939.9n 0.23585 41940.0n 0.70085 42119.9n 0.70085 42120.0n -0.27694 42299.9n -0.27694 42300.0n 0.36518 42479.9n 0.36518 42480.0n 1.37792 42659.9n 1.37792 42660.0n 0.66829 42839.9n 0.66829 42840.0n 1.33158 43019.9n 1.33158 43020.0n 0.65987 43199.9n 0.65987 43200.0n -0.28574 43379.9n -0.28574 43380.0n 0.29878 43559.9n 0.29878 43560.0n 1.21828 43739.9n 1.21828 43740.0n 0.76165 43919.9n 0.76165 43920.0n 0.59687 44099.9n 0.59687 44100.0n 0.43405 44279.9n 0.43405 44280.0n 0.71811 44459.9n 0.71811 44460.0n 0.86774 44639.9n 0.86774 44640.0n -0.17517 44819.9n -0.17517 44820.0n -0.23180 44999.9n -0.23180 45000.0n 0.33904 45179.9n 0.33904 45180.0n 0.40753 45359.9n 0.40753 45360.0n 0.51542 45539.9n 0.51542 45540.0n 0.32870 45719.9n 0.32870 45720.0n 0.74089 45899.9n 0.74089 45900.0n 0.57446 46079.9n 0.57446 46080.0n 0.86774 46259.9n 0.86774 46260.0n 1.37792 46439.9n 1.37792 46440.0n 0.57446 46619.9n 0.57446 46620.0n 0.43405 46799.9n 0.43405 46800.0n 1.23386 46979.9n 1.23386 46980.0n -0.11225 47159.9n -0.11225 47160.0n 0.70085 47339.9n 0.70085 47340.0n 1.08309 47519.9n 1.08309 47520.0n 0.74089 47699.9n 0.74089 47700.0n -0.27694 47879.9n -0.27694 47880.0n 0.23585 48059.9n 0.23585 48060.0n -0.28574 48239.9n -0.28574 48240.0n -0.20712 48419.9n -0.20712 48420.0n 0.71300 48599.9n 0.71300 48600.0n -0.17517 48779.9n -0.17517 48780.0n 0.34158 48959.9n 0.34158 48960.0n 0.32870 49139.9n 0.32870 49140.0n -0.23180 49319.9n -0.23180 49320.0n 0.40753 49499.9n 0.40753 49500.0n 0.36518 49679.9n 0.36518 49680.0n 1.33158 49859.9n 1.33158 49860.0n 0.71811 50039.9n 0.71811 50040.0n 1.15161 50219.9n 1.15161 50220.0n 0.76165 50399.9n 0.76165 50400.0n 0.66829 50579.9n 0.66829 50580.0n 0.29878 50759.9n 0.29878 50760.0n 0.59687 50939.9n 0.59687 50940.0n -0.18224 51119.9n -0.18224 51120.0n 0.65987 51299.9n 0.65987 51300.0n 0.51542 51479.9n 0.51542 51480.0n 0.33904 51659.9n 0.33904 51660.0n 1.21828 51839.9n 1.21828 51840.0n 0.71811 52019.9n 0.71811 52020.0n 0.43405 52199.9n 0.43405 52200.0n 0.65987 52379.9n 0.65987 52380.0n 0.66829 52559.9n 0.66829 52560.0n 0.33904 52739.9n 0.33904 52740.0n 0.32870 52919.9n 0.32870 52920.0n 0.86774 53099.9n 0.86774 53100.0n 0.34158 53279.9n 0.34158 53280.0n 1.33158 53459.9n 1.33158 53460.0n -0.27694 53639.9n -0.27694 53640.0n 0.36518 53819.9n 0.36518 53820.0n 1.23386 53999.9n 1.23386 54000.0n 0.23585 54179.9n 0.23585 54180.0n -0.28574 54359.9n -0.28574 54360.0n 0.40753 54539.9n 0.40753 54540.0n 0.71300 54719.9n 0.71300 54720.0n 0.74089 54899.9n 0.74089 54900.0n -0.18224 55079.9n -0.18224 55080.0n 1.37792 55259.9n 1.37792 55260.0n -0.23180 55439.9n -0.23180 55440.0n 0.51542 55619.9n 0.51542 55620.0n -0.17517 55799.9n -0.17517 55800.0n -0.11225 55979.9n -0.11225 55980.0n 0.59687 56159.9n 0.59687 56160.0n 1.21828 56339.9n 1.21828 56340.0n 0.70085 56519.9n 0.70085 56520.0n 0.57446 56699.9n 0.57446 56700.0n 1.08309 56879.9n 1.08309 56880.0n -0.20712 57059.9n -0.20712 57060.0n 0.76165 57239.9n 0.76165 57240.0n 0.29878 57419.9n 0.29878 57420.0n 1.15161 57599.9n 1.15161 57600.0n 0.86774 57779.9n 0.86774 57780.0n 0.51542 57959.9n 0.51542 57960.0n 1.15161 58139.9n 1.15161 58140.0n 0.40753 58319.9n 0.40753 58320.0n 0.65987 58499.9n 0.65987 58500.0n -0.18224 58679.9n -0.18224 58680.0n 1.08309 58859.9n 1.08309 58860.0n 0.36518 59039.9n 0.36518 59040.0n 0.57446 59219.9n 0.57446 59220.0n -0.27694 59399.9n -0.27694 59400.0n 0.33904 59579.9n 0.33904 59580.0n 0.74089 59759.9n 0.74089 59760.0n 0.23585 59939.9n 0.23585 59940.0n 0.59687 60119.9n 0.59687 60120.0n -0.28574 60299.9n -0.28574 60300.0n -0.11225 60479.9n -0.11225 60480.0n 1.21828 60659.9n 1.21828 60660.0n -0.17517 60839.9n -0.17517 60840.0n 1.23386 61019.9n 1.23386 61020.0n -0.23180 61199.9n -0.23180 61200.0n 0.71811 61379.9n 0.71811 61380.0n 0.76165 61559.9n 0.76165 61560.0n 0.32870 61739.9n 0.32870 61740.0n 1.37792 61919.9n 1.37792 61920.0n 0.70085 62099.9n 0.70085 62100.0n 0.71300 62279.9n 0.71300 62280.0n 0.29878 62459.9n 0.29878 62460.0n 0.43405 62639.9n 0.43405 62640.0n -0.20712 62819.9n -0.20712 62820.0n 1.33158 62999.9n 1.33158 63000.0n 0.34158 63179.9n 0.34158 63180.0n 0.66829 63359.9n 0.66829 63360.0n 0.74089 63539.9n 0.74089 63540.0n 0.59687 63719.9n 0.59687 63720.0n 0.29878 63899.9n 0.29878 63900.0n 0.32870 64079.9n 0.32870 64080.0n 0.23585 64259.9n 0.23585 64260.0n -0.17517 64439.9n -0.17517 64440.0n 0.66829 64619.9n 0.66829 64620.0n 0.34158 64799.9n 0.34158 64800.0n -0.27694 64979.9n -0.27694 64980.0n -0.23180 65159.9n -0.23180 65160.0n 1.21828 65339.9n 1.21828 65340.0n 0.33904 65519.9n 0.33904 65520.0n 0.36518 65699.9n 0.36518 65700.0n 1.23386 65879.9n 1.23386 65880.0n 0.40753 66059.9n 0.40753 66060.0n 0.57446 66239.9n 0.57446 66240.0n 0.71811 66419.9n 0.71811 66420.0n 1.08309 66599.9n 1.08309 66600.0n 0.86774 66779.9n 0.86774 66780.0n 0.51542 66959.9n 0.51542 66960.0n 0.43405 67139.9n 0.43405 67140.0n 0.71300 67319.9n 0.71300 67320.0n 1.33158 67499.9n 1.33158 67500.0n -0.20712 67679.9n -0.20712 67680.0n -0.28574 67859.9n -0.28574 67860.0n 0.76165 68039.9n 0.76165 68040.0n 1.37792 68219.9n 1.37792 68220.0n 0.65987 68399.9n 0.65987 68400.0n 1.15161 68579.9n 1.15161 68580.0n -0.11225 68759.9n -0.11225 68760.0n -0.18224 68939.9n -0.18224 68940.0n 0.70085 69119.9n 0.70085 69120.0n 0.59687 69299.9n 0.59687 69300.0n -0.23180 69479.9n -0.23180 69480.0n -0.27694 69659.9n -0.27694 69660.0n 1.37792 69839.9n 1.37792 69840.0n 0.65987 70019.9n 0.65987 70020.0n 1.15161 70199.9n 1.15161 70200.0n 0.36518 70379.9n 0.36518 70380.0n 0.23585 70559.9n 0.23585 70560.0n 0.71300 70739.9n 0.71300 70740.0n 0.74089 70919.9n 0.74089 70920.0n -0.20712 71099.9n -0.20712 71100.0n 1.21828 71279.9n 1.21828 71280.0n 0.33904 71459.9n 0.33904 71460.0n 0.86774 71639.9n 0.86774 71640.0n -0.28574 71819.9n -0.28574 71820.0n 0.76165 71999.9n 0.76165 72000.0n 0.40753 72179.9n 0.40753 72180.0n 0.57446 72359.9n 0.57446 72360.0n 0.71811 72539.9n 0.71811 72540.0n 1.08309 72719.9n 1.08309 72720.0n 0.51542 72899.9n 0.51542 72900.0n -0.17517 73079.9n -0.17517 73080.0n 1.23386 73259.9n 1.23386 73260.0n 0.34158 73439.9n 0.34158 73440.0n -0.11225 73619.9n -0.11225 73620.0n 0.43405 73799.9n 0.43405 73800.0n -0.18224 73979.9n -0.18224 73980.0n 0.32870 74159.9n 0.32870 74160.0n 1.33158 74339.9n 1.33158 74340.0n 0.66829 74519.9n 0.66829 74520.0n 0.70085 74699.9n 0.70085 74700.0n 0.29878 74879.9n 0.29878 74880.0n -0.27694 75059.9n -0.27694 75060.0n 1.23386 75239.9n 1.23386 75240.0n 0.51542 75419.9n 0.51542 75420.0n -0.11225 75599.9n -0.11225 75600.0n 1.21828 75779.9n 1.21828 75780.0n 0.29878 75959.9n 0.29878 75960.0n 1.15161 76139.9n 1.15161 76140.0n 0.70085 76319.9n 0.70085 76320.0n -0.18224 76499.9n -0.18224 76500.0n 1.33158 76679.9n 1.33158 76680.0n 0.40753 76859.9n 0.40753 76860.0n 0.86774 77039.9n 0.86774 77040.0n 1.08309 77219.9n 1.08309 77220.0n -0.17517 77399.9n -0.17517 77400.0n 0.33904 77579.9n 0.33904 77580.0n 0.65987 77759.9n 0.65987 77760.0n 0.57446 77939.9n 0.57446 77940.0n 0.66829 78119.9n 0.66829 78120.0n 0.36518 78299.9n 0.36518 78300.0n 0.59687 78479.9n 0.59687 78480.0n -0.20712 78659.9n -0.20712 78660.0n -0.23180 78839.9n -0.23180 78840.0n 0.43405 79019.9n 0.43405 79020.0n 0.34158 79199.9n 0.34158 79200.0n 0.74089 79379.9n 0.74089 79380.0n 0.32870 79559.9n 0.32870 79560.0n 1.37792 79739.9n 1.37792 79740.0n 0.76165 79919.9n 0.76165 79920.0n 0.23585 80099.9n 0.23585 80100.0n 0.71811 80279.9n 0.71811 80280.0n 0.71300 80459.9n 0.71300 80460.0n -0.28574 80639.9n -0.28574 80640.0n 0.71811 80819.9n 0.71811 80820.0n -0.11225 80999.9n -0.11225 81000.0n 0.43405 81179.9n 0.43405 81180.0n 0.74089 81359.9n 0.74089 81360.0n 0.51542 81539.9n 0.51542 81540.0n 0.29878 81719.9n 0.29878 81720.0n 0.70085 81899.9n 0.70085 81900.0n -0.18224 82079.9n -0.18224 82080.0n 0.40753 82259.9n 0.40753 82260.0n 0.71300 82439.9n 0.71300 82440.0n 1.21828 82619.9n 1.21828 82620.0n -0.20712 82799.9n -0.20712 82800.0n 1.37792 82979.9n 1.37792 82980.0n 1.33158 83159.9n 1.33158 83160.0n 0.66829 83339.9n 0.66829 83340.0n 0.86774 83519.9n 0.86774 83520.0n 1.15161 83699.9n 1.15161 83700.0n 0.33904 83879.9n 0.33904 83880.0n -0.23180 84059.9n -0.23180 84060.0n 0.76165 84239.9n 0.76165 84240.0n -0.27694 84419.9n -0.27694 84420.0n 0.23585 84599.9n 0.23585 84600.0n 0.59687 84779.9n 0.59687 84780.0n 0.65987 84959.9n 0.65987 84960.0n 0.57446 85139.9n 0.57446 85140.0n 0.34158 85319.9n 0.34158 85320.0n -0.17517 85499.9n -0.17517 85500.0n 0.36518 85679.9n 0.36518 85680.0n -0.28574 85859.9n -0.28574 85860.0n 1.08309 86039.9n 1.08309 86040.0n 0.32870 86219.9n 0.32870 86220.0n 1.23386 86399.9n 1.23386 86400.0n 0.43405 86579.9n 0.43405 86580.0n 0.29878 86759.9n 0.29878 86760.0n 1.15161 86939.9n 1.15161 86940.0n 0.70085 87119.9n 0.70085 87120.0n -0.11225 87299.9n -0.11225 87300.0n 0.71811 87479.9n 0.71811 87480.0n -0.17517 87659.9n -0.17517 87660.0n -0.20712 87839.9n -0.20712 87840.0n 0.33904 88019.9n 0.33904 88020.0n 1.33158 88199.9n 1.33158 88200.0n 0.40753 88379.9n 0.40753 88380.0n 0.71300 88559.9n 0.71300 88560.0n 0.23585 88739.9n 0.23585 88740.0n 1.08309 88919.9n 1.08309 88920.0n 1.23386 89099.9n 1.23386 89100.0n 0.86774 89279.9n 0.86774 89280.0n -0.28574 89459.9n -0.28574 89460.0n 1.37792 89639.9n 1.37792 89640.0n 0.76165 89819.9n 0.76165 89820.0n 0.51542 89999.9n 0.51542 90000.0n 0.57446 90179.9n 0.57446 90180.0n 0.34158 90359.9n 0.34158 90360.0n 1.21828 90539.9n 1.21828 90540.0n -0.27694 90719.9n -0.27694 90720.0n 0.74089 90899.9n 0.74089 90900.0n 0.32870 91079.9n 0.32870 91080.0n 0.66829 91259.9n 0.66829 91260.0n -0.18224 91439.9n -0.18224 91440.0n 0.59687 91619.9n 0.59687 91620.0n -0.23180 91799.9n -0.23180 91800.0n 0.65987 91979.9n 0.65987 91980.0n 0.36518 92159.9n 0.36518 92160.0n 1.15161 92339.9n 1.15161 92340.0n 0.36518 92519.9n 0.36518 92520.0n 0.70085 92699.9n 0.70085 92700.0n -0.17517 92879.9n -0.17517 92880.0n -0.18224 93059.9n -0.18224 93060.0n 0.40753 93239.9n 0.40753 93240.0n 1.33158 93419.9n 1.33158 93420.0n 0.29878 93599.9n 0.29878 93600.0n 0.34158 93779.9n 0.34158 93780.0n -0.28574 93959.9n -0.28574 93960.0n 0.74089 94139.9n 0.74089 94140.0n -0.23180 94319.9n -0.23180 94320.0n 0.66829 94499.9n 0.66829 94500.0n 0.86774 94679.9n 0.86774 94680.0n 0.71811 94859.9n 0.71811 94860.0n 0.65987 95039.9n 0.65987 95040.0n 0.57446 95219.9n 0.57446 95220.0n 0.76165 95399.9n 0.76165 95400.0n -0.20712 95579.9n -0.20712 95580.0n -0.27694 95759.9n -0.27694 95760.0n 0.43405 95939.9n 0.43405 95940.0n 0.23585 96119.9n 0.23585 96120.0n 0.71300 96299.9n 0.71300 96300.0n 1.37792 96479.9n 1.37792 96480.0n 0.59687 96659.9n 0.59687 96660.0n 0.33904 96839.9n 0.33904 96840.0n 0.32870 97019.9n 0.32870 97020.0n 1.21828 97199.9n 1.21828 97200.0n 1.08309 97379.9n 1.08309 97380.0n 0.51542 97559.9n 0.51542 97560.0n 1.23386 97739.9n 1.23386 97740.0n -0.11225 97919.9n -0.11225 97920.0n 0.71811 98099.9n 0.71811 98100.0n 0.86774 98279.9n 0.86774 98280.0n -0.27694 98459.9n -0.27694 98460.0n 1.21828 98639.9n 1.21828 98640.0n 0.23585 98819.9n 0.23585 98820.0n 0.36518 98999.9n 0.36518 99000.0n 0.59687 99179.9n 0.59687 99180.0n 0.70085 99359.9n 0.70085 99360.0n 1.15161 99539.9n 1.15161 99540.0n -0.11225 99719.9n -0.11225 99720.0n 0.43405 99899.9n 0.43405 99900.0n 0.74089 100079.9n 0.74089 100080.0n -0.17517 100259.9n -0.17517 100260.0n -0.23180 100439.9n -0.23180 100440.0n 0.40753 100619.9n 0.40753 100620.0n 0.32870 100799.9n 0.32870 100800.0n 1.08309 100979.9n 1.08309 100980.0n -0.28574 101159.9n -0.28574 101160.0n 0.66829 101339.9n 0.66829 101340.0n -0.18224 101519.9n -0.18224 101520.0n 1.33158 101699.9n 1.33158 101700.0n 0.34158 101879.9n 0.34158 101880.0n 0.76165 102059.9n 0.76165 102060.0n 0.33904 102239.9n 0.33904 102240.0n 0.65987 102419.9n 0.65987 102420.0n 1.37792 102599.9n 1.37792 102600.0n 1.23386 102779.9n 1.23386 102780.0n 0.51542 102959.9n 0.51542 102960.0n 0.71300 103139.9n 0.71300 103140.0n -0.20712 103319.9n -0.20712 103320.0n 0.57446 103499.9n 0.57446 103500.0n 0.29878 103679.9n 0.29878 103680.0n 1.33158 103859.9n 1.33158 103860.0n 0.43405 104039.9n 0.43405 104040.0n 1.08309 104219.9n 1.08309 104220.0n 1.21828 104399.9n 1.21828 104400.0n -0.18224 104579.9n -0.18224 104580.0n -0.20712 104759.9n -0.20712 104760.0n 0.57446 104939.9n 0.57446 104940.0n 0.23585 105119.9n 0.23585 105120.0n 0.29878 105299.9n 0.29878 105300.0n 0.86774 105479.9n 0.86774 105480.0n 0.70085 105659.9n 0.70085 105660.0n 0.59687 105839.9n 0.59687 105840.0n 0.71811 106019.9n 0.71811 106020.0n 0.65987 106199.9n 0.65987 106200.0n -0.11225 106379.9n -0.11225 106380.0n 1.37792 106559.9n 1.37792 106560.0n -0.17517 106739.9n -0.17517 106740.0n -0.28574 106919.9n -0.28574 106920.0n 0.36518 107099.9n 0.36518 107100.0n 0.51542 107279.9n 0.51542 107280.0n -0.23180 107459.9n -0.23180 107460.0n 1.23386 107639.9n 1.23386 107640.0n 1.15161 107819.9n 1.15161 107820.0n 0.33904 107999.9n 0.33904 108000.0n 0.71300 108179.9n 0.71300 108180.0n 0.74089 108359.9n 0.74089 108360.0n 0.32870 108539.9n 0.32870 108540.0n 0.66829 108719.9n 0.66829 108720.0n -0.27694 108899.9n -0.27694 108900.0n 0.76165 109079.9n 0.76165 109080.0n 0.34158 109259.9n 0.34158 109260.0n 0.40753 109439.9n 0.40753 109440.0n 0.76165 109619.9n 0.76165 109620.0n 1.33158 109799.9n 1.33158 109800.0n 0.23585 109979.9n 0.23585 109980.0n 1.23386 110159.9n 1.23386 110160.0n -0.17517 110339.9n -0.17517 110340.0n 0.71300 110519.9n 0.71300 110520.0n 0.71811 110699.9n 0.71811 110700.0n -0.27694 110879.9n -0.27694 110880.0n 0.66829 111059.9n 0.66829 111060.0n 1.37792 111239.9n 1.37792 111240.0n 0.57446 111419.9n 0.57446 111420.0n 0.51542 111599.9n 0.51542 111600.0n -0.20712 111779.9n -0.20712 111780.0n -0.23180 111959.9n -0.23180 111960.0n 0.74089 112139.9n 0.74089 112140.0n 0.36518 112319.9n 0.36518 112320.0n -0.28574 112499.9n -0.28574 112500.0n 0.32870 112679.9n 0.32870 112680.0n 1.21828 112859.9n 1.21828 112860.0n 1.15161 113039.9n 1.15161 113040.0n 0.33904 113219.9n 0.33904 113220.0n -0.18224 113399.9n -0.18224 113400.0n -0.11225 113579.9n -0.11225 113580.0n 0.70085 113759.9n 0.70085 113760.0n 0.59687 113939.9n 0.59687 113940.0n 0.86774 114119.9n 0.86774 114120.0n 0.65987 114299.9n 0.65987 114300.0n 0.34158 114479.9n 0.34158 114480.0n 0.43405 114659.9n 0.43405 114660.0n 0.40753 114839.9n 0.40753 114840.0n 1.08309 115019.9n 1.08309 115020.0n 0.29878 115199.9n 0.29878 115200.0n -0.27694 115379.9n -0.27694 115380.0n 0.29878 115559.9n 0.29878 115560.0n 0.65987 115739.9n 0.65987 115740.0n 0.57446 115919.9n 0.57446 115920.0n 0.71811 116099.9n 0.71811 116100.0n 0.74089 116279.9n 0.74089 116280.0n 0.66829 116459.9n 0.66829 116460.0n 1.21828 116639.9n 1.21828 116640.0n -0.28574 116819.9n -0.28574 116820.0n -0.17517 116999.9n -0.17517 117000.0n 0.43405 117179.9n 0.43405 117180.0n 0.32870 117359.9n 0.32870 117360.0n 0.40753 117539.9n 0.40753 117540.0n 0.71300 117719.9n 0.71300 117720.0n 0.23585 117899.9n 0.23585 117900.0n 0.70085 118079.9n 0.70085 118080.0n -0.23180 118259.9n -0.23180 118260.0n 1.15161 118439.9n 1.15161 118440.0n 0.36518 118619.9n 0.36518 118620.0n 0.34158 118799.9n 0.34158 118800.0n 1.08309 118979.9n 1.08309 118980.0n 1.37792 119159.9n 1.37792 119160.0n 0.86774 119339.9n 0.86774 119340.0n -0.11225 119519.9n -0.11225 119520.0n 1.33158 119699.9n 1.33158 119700.0n 1.23386 119879.9n 1.23386 119880.0n 0.33904 120059.9n 0.33904 120060.0n 0.51542 120239.9n 0.51542 120240.0n -0.20712 120419.9n -0.20712 120420.0n 0.59687 120599.9n 0.59687 120600.0n 0.76165 120779.9n 0.76165 120780.0n -0.18224 120959.9n -0.18224 120960.0n 1.37792 121139.9n 1.37792 121140.0n 0.43405 121319.9n 0.43405 121320.0n 0.71811 121499.9n 0.71811 121500.0n 0.59687 121679.9n 0.59687 121680.0n 0.65987 121859.9n 0.65987 121860.0n 0.74089 122039.9n 0.74089 122040.0n 0.40753 122219.9n 0.40753 122220.0n 0.51542 122399.9n 0.51542 122400.0n 0.70085 122579.9n 0.70085 122580.0n 0.33904 122759.9n 0.33904 122760.0n -0.17517 122939.9n -0.17517 122940.0n 1.33158 123119.9n 1.33158 123120.0n 1.08309 123299.9n 1.08309 123300.0n 1.21828 123479.9n 1.21828 123480.0n 0.34158 123659.9n 0.34158 123660.0n 0.29878 123839.9n 0.29878 123840.0n 0.66829 124019.9n 0.66829 124020.0n -0.20712 124199.9n -0.20712 124200.0n 0.36518 124379.9n 0.36518 124380.0n 1.23386 124559.9n 1.23386 124560.0n 0.23585 124739.9n 0.23585 124740.0n 0.71300 124919.9n 0.71300 124920.0n -0.11225 125099.9n -0.11225 125100.0n -0.23180 125279.9n -0.23180 125280.0n 1.15161 125459.9n 1.15161 125460.0n 0.76165 125639.9n 0.76165 125640.0n -0.18224 125819.9n -0.18224 125820.0n 0.86774 125999.9n 0.86774 126000.0n 0.32870 126179.9n 0.32870 126180.0n 0.57446 126359.9n 0.57446 126360.0n -0.27694 126539.9n -0.27694 126540.0n -0.28574 126719.9n -0.28574 126720.0n 0.70085 126899.9n 0.70085 126900.0n 1.15161 127079.9n 1.15161 127080.0n 0.36518 127259.9n 0.36518 127260.0n 1.21828 127439.9n 1.21828 127440.0n 0.65987 127619.9n 0.65987 127620.0n 0.23585 127799.9n 0.23585 127800.0n 0.29878 127979.9n 0.29878 127980.0n 0.33904 128159.9n 0.33904 128160.0n -0.18224 128339.9n -0.18224 128340.0n 1.08309 128519.9n 1.08309 128520.0n 0.34158 128699.9n 0.34158 128700.0n 0.59687 128879.9n 0.59687 128880.0n 0.71811 129059.9n 0.71811 129060.0n 0.57446 129239.9n 0.57446 129240.0n 1.37792 129419.9n 1.37792 129420.0n -0.28574 129599.9n -0.28574 129600.0n 0.43405 129779.9n 0.43405 129780.0n 1.33158 129959.9n 1.33158 129960.0n 0.51542 130139.9n 0.51542 130140.0n -0.23180 130319.9n -0.23180 130320.0n 0.40753 130499.9n 0.40753 130500.0n -0.20712 130679.9n -0.20712 130680.0n 0.86774 130859.9n 0.86774 130860.0n 0.71300 131039.9n 0.71300 131040.0n 0.32870 131219.9n 0.32870 131220.0n 0.74089 131399.9n 0.74089 131400.0n -0.27694 131579.9n -0.27694 131580.0n 0.66829 131759.9n 0.66829 131760.0n 0.76165 131939.9n 0.76165 131940.0n 1.23386 132119.9n 1.23386 132120.0n -0.17517 132299.9n -0.17517 132300.0n -0.11225 132479.9n -0.11225 132480.0n 0.71811 132659.9n 0.71811 132660.0n 0.34158 132839.9n 0.34158 132840.0n 0.86774 133019.9n 0.86774 133020.0n 0.65987 133199.9n 0.65987 133200.0n 0.43405 133379.9n 0.43405 133380.0n -0.23180 133559.9n -0.23180 133560.0n -0.17517 133739.9n -0.17517 133740.0n -0.20712 133919.9n -0.20712 133920.0n 1.21828 134099.9n 1.21828 134100.0n -0.27694 134279.9n -0.27694 134280.0n 1.15161 134459.9n 1.15161 134460.0n 1.08309 134639.9n 1.08309 134640.0n 0.23585 134819.9n 0.23585 134820.0n 0.70085 134999.9n 0.70085 135000.0n -0.28574 135179.9n -0.28574 135180.0n 0.76165 135359.9n 0.76165 135360.0n 1.37792 135539.9n 1.37792 135540.0n 0.71300 135719.9n 0.71300 135720.0n 0.74089 135899.9n 0.74089 135900.0n 0.29878 136079.9n 0.29878 136080.0n -0.18224 136259.9n -0.18224 136260.0n 0.57446 136439.9n 0.57446 136440.0n 0.40753 136619.9n 0.40753 136620.0n 0.36518 136799.9n 0.36518 136800.0n 1.33158 136979.9n 1.33158 136980.0n -0.11225 137159.9n -0.11225 137160.0n 0.33904 137339.9n 0.33904 137340.0n 1.23386 137519.9n 1.23386 137520.0n 0.32870 137699.9n 0.32870 137700.0n 0.59687 137879.9n 0.59687 137880.0n 0.66829 138059.9n 0.66829 138060.0n 0.51542 138239.9n 0.51542 138240.0n 0.70085 138419.9n 0.70085 138420.0n 1.21828 138599.9n 1.21828 138600.0n -0.27694 138779.9n -0.27694 138780.0n 0.33904 138959.9n 0.33904 138960.0n -0.17517 139139.9n -0.17517 139140.0n 1.33158 139319.9n 1.33158 139320.0n 0.23585 139499.9n 0.23585 139500.0n 0.40753 139679.9n 0.40753 139680.0n 0.74089 139859.9n 0.74089 139860.0n 0.32870 140039.9n 0.32870 140040.0n -0.20712 140219.9n -0.20712 140220.0n 0.59687 140399.9n 0.59687 140400.0n 0.76165 140579.9n 0.76165 140580.0n 0.34158 140759.9n 0.34158 140760.0n 0.36518 140939.9n 0.36518 140940.0n -0.28574 141119.9n -0.28574 141120.0n 0.86774 141299.9n 0.86774 141300.0n 1.23386 141479.9n 1.23386 141480.0n 0.65987 141659.9n 0.65987 141660.0n 0.43405 141839.9n 0.43405 141840.0n 1.37792 142019.9n 1.37792 142020.0n -0.23180 142199.9n -0.23180 142200.0n -0.18224 142379.9n -0.18224 142380.0n 0.66829 142559.9n 0.66829 142560.0n 1.15161 142739.9n 1.15161 142740.0n 0.29878 142919.9n 0.29878 142920.0n -0.11225 143099.9n -0.11225 143100.0n 0.71811 143279.9n 0.71811 143280.0n 1.08309 143459.9n 1.08309 143460.0n 0.57446 143639.9n 0.57446 143640.0n 0.71300 143819.9n 0.71300 143820.0n 0.51542 143999.9n 0.51542 144000.0n 1.23386 144179.9n 1.23386 144180.0n 1.15161 144359.9n 1.15161 144360.0n 0.43405 144539.9n 0.43405 144540.0n -0.28574 144719.9n -0.28574 144720.0n 0.66829 144899.9n 0.66829 144900.0n 0.59687 145079.9n 0.59687 145080.0n 0.86774 145259.9n 0.86774 145260.0n 1.08309 145439.9n 1.08309 145440.0n 0.74089 145619.9n 0.74089 145620.0n -0.18224 145799.9n -0.18224 145800.0n 0.65987 145979.9n 0.65987 145980.0n 0.36518 146159.9n 0.36518 146160.0n -0.27694 146339.9n -0.27694 146340.0n 0.34158 146519.9n 0.34158 146520.0n -0.17517 146699.9n -0.17517 146700.0n 0.71811 146879.9n 0.71811 146880.0n 1.37792 147059.9n 1.37792 147060.0n 0.70085 147239.9n 0.70085 147240.0n -0.20712 147419.9n -0.20712 147420.0n -0.23180 147599.9n -0.23180 147600.0n 0.51542 147779.9n 0.51542 147780.0n 1.21828 147959.9n 1.21828 147960.0n 0.29878 148139.9n 0.29878 148140.0n -0.11225 148319.9n -0.11225 148320.0n 0.76165 148499.9n 0.76165 148500.0n 0.71300 148679.9n 0.71300 148680.0n 0.57446 148859.9n 0.57446 148860.0n 0.23585 149039.9n 0.23585 149040.0n 1.33158 149219.9n 1.33158 149220.0n 0.32870 149399.9n 0.32870 149400.0n 0.33904 149579.9n 0.33904 149580.0n 0.40753 149759.9n 0.40753 149760.0n 0.86774 149939.9n 0.86774 149940.0n 0.51542 150119.9n 0.51542 150120.0n 1.33158 150299.9n 1.33158 150300.0n 1.08309 150479.9n 1.08309 150480.0n 0.66829 150659.9n 0.66829 150660.0n 0.74089 150839.9n 0.74089 150840.0n -0.20712 151019.9n -0.20712 151020.0n -0.17517 151199.9n -0.17517 151200.0n 0.29878 151379.9n 0.29878 151380.0n -0.18224 151559.9n -0.18224 151560.0n 1.23386 151739.9n 1.23386 151740.0n 0.71300 151919.9n 0.71300 151920.0n -0.23180 152099.9n -0.23180 152100.0n 1.21828 152279.9n 1.21828 152280.0n 0.70085 152459.9n 0.70085 152460.0n 1.37792 152639.9n 1.37792 152640.0n 0.36518 152819.9n 0.36518 152820.0n 0.76165 152999.9n 0.76165 153000.0n 0.40753 153179.9n 0.40753 153180.0n 1.15161 153359.9n 1.15161 153360.0n 0.71811 153539.9n 0.71811 153540.0n -0.28574 153719.9n -0.28574 153720.0n 0.59687 153899.9n 0.59687 153900.0n 0.34158 154079.9n 0.34158 154080.0n -0.27694 154259.9n -0.27694 154260.0n 0.33904 154439.9n 0.33904 154440.0n 0.32870 154619.9n 0.32870 154620.0n 0.43405 154799.9n 0.43405 154800.0n 0.57446 154979.9n 0.57446 154980.0n -0.11225 155159.9n -0.11225 155160.0n 0.23585 155339.9n 0.23585 155340.0n 0.65987 155519.9n 0.65987 155520.0n 1.33158 155699.9n 1.33158 155700.0n 0.51542 155879.9n 0.51542 155880.0n 0.29878 156059.9n 0.29878 156060.0n 0.33904 156239.9n 0.33904 156240.0n 1.15161 156419.9n 1.15161 156420.0n -0.20712 156599.9n -0.20712 156600.0n -0.27694 156779.9n -0.27694 156780.0n -0.17517 156959.9n -0.17517 156960.0n -0.18224 157139.9n -0.18224 157140.0n 1.08309 157319.9n 1.08309 157320.0n 0.74089 157499.9n 0.74089 157500.0n 0.66829 157679.9n 0.66829 157680.0n 1.23386 157859.9n 1.23386 157860.0n 0.36518 158039.9n 0.36518 158040.0n 1.37792 158219.9n 1.37792 158220.0n 0.34158 158399.9n 0.34158 158400.0n -0.11225 158579.9n -0.11225 158580.0n 0.71300 158759.9n 0.71300 158760.0n 0.70085 158939.9n 0.70085 158940.0n 0.71811 159119.9n 0.71811 159120.0n 0.23585 159299.9n 0.23585 159300.0n 0.59687 159479.9n 0.59687 159480.0n 1.21828 159659.9n 1.21828 159660.0n 0.43405 159839.9n 0.43405 159840.0n 0.76165 160019.9n 0.76165 160020.0n -0.28574 160199.9n -0.28574 160200.0n -0.23180 160379.9n -0.23180 160380.0n 0.57446 160559.9n 0.57446 160560.0n 0.32870 160739.9n 0.32870 160740.0n 0.65987 160919.9n 0.65987 160920.0n 0.86774 161099.9n 0.86774 161100.0n 0.40753 161279.9n 0.40753 161280.0n 1.23386 161459.9n 1.23386 161460.0n 0.76165 161639.9n 0.76165 161640.0n 0.86774 161819.9n 0.86774 161820.0n -0.17517 161999.9n -0.17517 162000.0n 1.15161 162179.9n 1.15161 162180.0n 0.23585 162359.9n 0.23585 162360.0n 1.08309 162539.9n 1.08309 162540.0n 0.71300 162719.9n 0.71300 162720.0n 0.65987 162899.9n 0.65987 162900.0n -0.28574 163079.9n -0.28574 163080.0n 0.34158 163259.9n 0.34158 163260.0n 0.71811 163439.9n 0.71811 163440.0n -0.18224 163619.9n -0.18224 163620.0n 0.59687 163799.9n 0.59687 163800.0n 0.40753 163979.9n 0.40753 163980.0n 1.33158 164159.9n 1.33158 164160.0n -0.23180 164339.9n -0.23180 164340.0n -0.11225 164519.9n -0.11225 164520.0n 1.37792 164699.9n 1.37792 164700.0n 0.36518 164879.9n 0.36518 164880.0n 0.43405 165059.9n 0.43405 165060.0n 0.66829 165239.9n 0.66829 165240.0n 0.57446 165419.9n 0.57446 165420.0n 0.51542 165599.9n 0.51542 165600.0n 0.32870 165779.9n 0.32870 165780.0n 0.74089 165959.9n 0.74089 165960.0n 1.21828 166139.9n 1.21828 166140.0n -0.27694 166319.9n -0.27694 166320.0n -0.20712 166499.9n -0.20712 166500.0n 0.33904 166679.9n 0.33904 166680.0n 0.70085 166859.9n 0.70085 166860.0n 0.29878 167039.9n 0.29878 167040.0n 0.76165 167219.9n 0.76165 167220.0n 0.32870 167399.9n 0.32870 167400.0n -0.23180 167579.9n -0.23180 167580.0n -0.18224 167759.9n -0.18224 167760.0n 0.74089 167939.9n 0.74089 167940.0n 0.65987 168119.9n 0.65987 168120.0n 0.71811 168299.9n 0.71811 168300.0n 0.29878 168479.9n 0.29878 168480.0n 1.21828 168659.9n 1.21828 168660.0n 0.66829 168839.9n 0.66829 168840.0n 0.23585 169019.9n 0.23585 169020.0n 1.08309 169199.9n 1.08309 169200.0n 1.15161 169379.9n 1.15161 169380.0n 1.37792 169559.9n 1.37792 169560.0n 0.71300 169739.9n 0.71300 169740.0n 0.70085 169919.9n 0.70085 169920.0n -0.27694 170099.9n -0.27694 170100.0n 0.43405 170279.9n 0.43405 170280.0n 0.59687 170459.9n 0.59687 170460.0n 0.86774 170639.9n 0.86774 170640.0n 1.33158 170819.9n 1.33158 170820.0n -0.17517 170999.9n -0.17517 171000.0n -0.11225 171179.9n -0.11225 171180.0n 0.36518 171359.9n 0.36518 171360.0n 0.57446 171539.9n 0.57446 171540.0n 0.33904 171719.9n 0.33904 171720.0n 0.34158 171899.9n 0.34158 171900.0n 0.51542 172079.9n 0.51542 172080.0n -0.28574 172259.9n -0.28574 172260.0n 0.40753 172439.9n 0.40753 172440.0n -0.20712 172619.9n -0.20712 172620.0n 1.23386 172799.9n 1.23386 172800.0n 0.63424 172979.9n 0.63424 172980.0n 0.66270 173159.9n 0.66270 173160.0n 0.61615 173339.9n 0.61615 173340.0n 0.40294 173519.9n 0.40294 173520.0n 0.37693 173699.9n 0.37693 173700.0n 0.32982 173879.9n 0.32982 173880.0n 0.29460 174059.9n 0.29460 174060.0n 0.46418 174239.9n 0.46418 174240.0n 0.66643 174419.9n 0.66643 174420.0n 0.47115 174599.9n 0.47115 174600.0n 0.25617 174779.9n 0.25617 174780.0n 0.21591 174959.9n 0.21591 174960.0n 0.48064 175139.9n 0.48064 175140.0n 0.49468 175319.9n 0.49468 175320.0n 0.31811 175499.9n 0.31811 175500.0n 0.20138 175679.9n 0.20138 175680.0n 0.64950 175859.9n 0.64950 175860.0n 0.83142 176039.9n 0.83142 176040.0n 0.44747 176219.9n 0.44747 176220.0n 0.39177 176399.9n 0.39177 176400.0n 0.36389 176579.9n 0.36389 176580.0n 0.58803 176759.9n 0.58803 176760.0n 0.30587 176939.9n 0.30587 176940.0n 0.41543 177119.9n 0.41543 177120.0n 0.66249 177299.9n 0.66249 177300.0n 0.28619 177479.9n 0.28619 177480.0n 0.35734 177659.9n 0.35734 177660.0n 0.83982 177839.9n 0.83982 177840.0n 0.21843 178019.9n 0.21843 178020.0n 0.77797 178199.9n 0.77797 178200.0n 0.12598 178379.9n 0.12598 178380.0n 1.10545 178559.9n 1.10545 178560.0n 1.25282 178739.9n 1.25282 178740.0n 1.37666 178919.9n 1.37666 178920.0n -0.43391 179099.9n -0.43391 179100.0n 0.62489 179279.9n 0.62489 179280.0n 0.64220 179459.9n 0.64220 179460.0n -0.04281 179639.9n -0.04281 179640.0n -0.30757 179819.9n -0.30757 179820.0n 1.27950 179999.9n 1.27950 180000.0n 0.89863 180179.9n 0.89863 180180.0n -0.20727 180359.9n -0.20727 180360.0n -0.40210 180539.9n -0.40210 180540.0n -0.03003 180719.9n -0.03003 180720.0n 1.27250 180899.9n 1.27250 180900.0n 1.24444 181079.9n 1.24444 181080.0n 0.18165 181259.9n 0.18165 181260.0n 0.88208 181439.9n 0.88208 181440.0n 1.41822 181619.9n 1.41822 181620.0n 0.24758 181799.9n 0.24758 181800.0n 0.42646 181979.9n 0.42646 181980.0n -0.22124 182159.9n -0.22124 182160.0n -0.07258 182339.9n -0.07258 182340.0n -0.14286 182519.9n -0.14286 182520.0n 1.14226 182699.9n 1.14226 182700.0n -0.32817 182879.9n -0.32817 182880.0n -0.08864 183059.9n -0.08864 183060.0n -0.09055 183239.9n -0.09055 183240.0n -0.50665 183419.9n -0.50665 183420.0n 1.21520)
Vxp2 a_xp2 0 PWL(0.0n 0.80000 179.9n 0.80000 180.0n 0.80000 359.9n 0.80000 360.0n 0.80000 539.9n 0.80000 540.0n 0.80000 719.9n 0.80000 720.0n 0.80000 899.9n 0.80000 900.0n 0.80000 1079.9n 0.80000 1080.0n 0.80000 1259.9n 0.80000 1260.0n 0.80000 1439.9n 0.80000 1440.0n 0.80000 1619.9n 0.80000 1620.0n 0.80000 1799.9n 0.80000 1800.0n 0.80000 1979.9n 0.80000 1980.0n 0.80000 2159.9n 0.80000 2160.0n 0.80000 2339.9n 0.80000 2340.0n 0.80000 2519.9n 0.80000 2520.0n 0.80000 2699.9n 0.80000 2700.0n 0.80000 2879.9n 0.80000 2880.0n 0.80000 3059.9n 0.80000 3060.0n 0.80000 3239.9n 0.80000 3240.0n 0.80000 3419.9n 0.80000 3420.0n 0.80000 3599.9n 0.80000 3600.0n 0.80000 3779.9n 0.80000 3780.0n 0.80000 3959.9n 0.80000 3960.0n 0.80000 4139.9n 0.80000 4140.0n 0.80000 4319.9n 0.80000 4320.0n 0.80000 4499.9n 0.80000 4500.0n 0.80000 4679.9n 0.80000 4680.0n 0.80000 4859.9n 0.80000 4860.0n 0.80000 5039.9n 0.80000 5040.0n 0.80000 5219.9n 0.80000 5220.0n 0.80000 5399.9n 0.80000 5400.0n 0.80000 5579.9n 0.80000 5580.0n 0.80000 5759.9n 0.80000 5760.0n 0.80000 5939.9n 0.80000 5940.0n 0.80000 6119.9n 0.80000 6120.0n 0.80000 6299.9n 0.80000 6300.0n 0.80000 6479.9n 0.80000 6480.0n 0.80000 6659.9n 0.80000 6660.0n 0.80000 6839.9n 0.80000 6840.0n 0.80000 7019.9n 0.80000 7020.0n 0.80000 7199.9n 0.80000 7200.0n 0.80000 7379.9n 0.80000 7380.0n 0.80000 7559.9n 0.80000 7560.0n 0.80000 7739.9n 0.80000 7740.0n 0.80000 7919.9n 0.80000 7920.0n 0.80000 8099.9n 0.80000 8100.0n 0.80000 8279.9n 0.80000 8280.0n 0.80000 8459.9n 0.80000 8460.0n 0.80000 8639.9n 0.80000 8640.0n 0.80000 8819.9n 0.80000 8820.0n 0.80000 8999.9n 0.80000 9000.0n 0.80000 9179.9n 0.80000 9180.0n 0.80000 9359.9n 0.80000 9360.0n 0.80000 9539.9n 0.80000 9540.0n 0.80000 9719.9n 0.80000 9720.0n 0.80000 9899.9n 0.80000 9900.0n 0.80000 10079.9n 0.80000 10080.0n 0.80000 10259.9n 0.80000 10260.0n 0.80000 10439.9n 0.80000 10440.0n 0.80000 10619.9n 0.80000 10620.0n 0.80000 10799.9n 0.80000 10800.0n 0.80000 10979.9n 0.80000 10980.0n 0.80000 11159.9n 0.80000 11160.0n 0.80000 11339.9n 0.80000 11340.0n 0.80000 11519.9n 0.80000 11520.0n 0.80000 11699.9n 0.80000 11700.0n 0.80000 11879.9n 0.80000 11880.0n 0.80000 12059.9n 0.80000 12060.0n 0.80000 12239.9n 0.80000 12240.0n 0.80000 12419.9n 0.80000 12420.0n 0.80000 12599.9n 0.80000 12600.0n 0.80000 12779.9n 0.80000 12780.0n 0.80000 12959.9n 0.80000 12960.0n 0.80000 13139.9n 0.80000 13140.0n 0.80000 13319.9n 0.80000 13320.0n 0.80000 13499.9n 0.80000 13500.0n 0.80000 13679.9n 0.80000 13680.0n 0.80000 13859.9n 0.80000 13860.0n 0.80000 14039.9n 0.80000 14040.0n 0.80000 14219.9n 0.80000 14220.0n 0.80000 14399.9n 0.80000 14400.0n 0.80000 14579.9n 0.80000 14580.0n 0.80000 14759.9n 0.80000 14760.0n 0.80000 14939.9n 0.80000 14940.0n 0.80000 15119.9n 0.80000 15120.0n 0.80000 15299.9n 0.80000 15300.0n 0.80000 15479.9n 0.80000 15480.0n 0.80000 15659.9n 0.80000 15660.0n 0.80000 15839.9n 0.80000 15840.0n 0.80000 16019.9n 0.80000 16020.0n 0.80000 16199.9n 0.80000 16200.0n 0.80000 16379.9n 0.80000 16380.0n 0.80000 16559.9n 0.80000 16560.0n 0.80000 16739.9n 0.80000 16740.0n 0.80000 16919.9n 0.80000 16920.0n 0.80000 17099.9n 0.80000 17100.0n 0.80000 17279.9n 0.80000 17280.0n 0.80000 17459.9n 0.80000 17460.0n 0.80000 17639.9n 0.80000 17640.0n 0.80000 17819.9n 0.80000 17820.0n 0.80000 17999.9n 0.80000 18000.0n 0.80000 18179.9n 0.80000 18180.0n 0.80000 18359.9n 0.80000 18360.0n 0.80000 18539.9n 0.80000 18540.0n 0.80000 18719.9n 0.80000 18720.0n 0.80000 18899.9n 0.80000 18900.0n 0.80000 19079.9n 0.80000 19080.0n 0.80000 19259.9n 0.80000 19260.0n 0.80000 19439.9n 0.80000 19440.0n 0.80000 19619.9n 0.80000 19620.0n 0.80000 19799.9n 0.80000 19800.0n 0.80000 19979.9n 0.80000 19980.0n 0.80000 20159.9n 0.80000 20160.0n 0.80000 20339.9n 0.80000 20340.0n 0.80000 20519.9n 0.80000 20520.0n 0.80000 20699.9n 0.80000 20700.0n 0.80000 20879.9n 0.80000 20880.0n 0.80000 21059.9n 0.80000 21060.0n 0.80000 21239.9n 0.80000 21240.0n 0.80000 21419.9n 0.80000 21420.0n 0.80000 21599.9n 0.80000 21600.0n 0.80000 21779.9n 0.80000 21780.0n 0.80000 21959.9n 0.80000 21960.0n 0.80000 22139.9n 0.80000 22140.0n 0.80000 22319.9n 0.80000 22320.0n 0.80000 22499.9n 0.80000 22500.0n 0.80000 22679.9n 0.80000 22680.0n 0.80000 22859.9n 0.80000 22860.0n 0.80000 23039.9n 0.80000 23040.0n 0.80000 23219.9n 0.80000 23220.0n 0.80000 23399.9n 0.80000 23400.0n 0.80000 23579.9n 0.80000 23580.0n 0.80000 23759.9n 0.80000 23760.0n 0.80000 23939.9n 0.80000 23940.0n 0.80000 24119.9n 0.80000 24120.0n 0.80000 24299.9n 0.80000 24300.0n 0.80000 24479.9n 0.80000 24480.0n 0.80000 24659.9n 0.80000 24660.0n 0.80000 24839.9n 0.80000 24840.0n 0.80000 25019.9n 0.80000 25020.0n 0.80000 25199.9n 0.80000 25200.0n 0.80000 25379.9n 0.80000 25380.0n 0.80000 25559.9n 0.80000 25560.0n 0.80000 25739.9n 0.80000 25740.0n 0.80000 25919.9n 0.80000 25920.0n 0.80000 26099.9n 0.80000 26100.0n 0.80000 26279.9n 0.80000 26280.0n 0.80000 26459.9n 0.80000 26460.0n 0.80000 26639.9n 0.80000 26640.0n 0.80000 26819.9n 0.80000 26820.0n 0.80000 26999.9n 0.80000 27000.0n 0.80000 27179.9n 0.80000 27180.0n 0.80000 27359.9n 0.80000 27360.0n 0.80000 27539.9n 0.80000 27540.0n 0.80000 27719.9n 0.80000 27720.0n 0.80000 27899.9n 0.80000 27900.0n 0.80000 28079.9n 0.80000 28080.0n 0.80000 28259.9n 0.80000 28260.0n 0.80000 28439.9n 0.80000 28440.0n 0.80000 28619.9n 0.80000 28620.0n 0.80000 28799.9n 0.80000 28800.0n 0.80000 28979.9n 0.80000 28980.0n 0.80000 29159.9n 0.80000 29160.0n 0.80000 29339.9n 0.80000 29340.0n 0.80000 29519.9n 0.80000 29520.0n 0.80000 29699.9n 0.80000 29700.0n 0.80000 29879.9n 0.80000 29880.0n 0.80000 30059.9n 0.80000 30060.0n 0.80000 30239.9n 0.80000 30240.0n 0.80000 30419.9n 0.80000 30420.0n 0.80000 30599.9n 0.80000 30600.0n 0.80000 30779.9n 0.80000 30780.0n 0.80000 30959.9n 0.80000 30960.0n 0.80000 31139.9n 0.80000 31140.0n 0.80000 31319.9n 0.80000 31320.0n 0.80000 31499.9n 0.80000 31500.0n 0.80000 31679.9n 0.80000 31680.0n 0.80000 31859.9n 0.80000 31860.0n 0.80000 32039.9n 0.80000 32040.0n 0.80000 32219.9n 0.80000 32220.0n 0.80000 32399.9n 0.80000 32400.0n 0.80000 32579.9n 0.80000 32580.0n 0.80000 32759.9n 0.80000 32760.0n 0.80000 32939.9n 0.80000 32940.0n 0.80000 33119.9n 0.80000 33120.0n 0.80000 33299.9n 0.80000 33300.0n 0.80000 33479.9n 0.80000 33480.0n 0.80000 33659.9n 0.80000 33660.0n 0.80000 33839.9n 0.80000 33840.0n 0.80000 34019.9n 0.80000 34020.0n 0.80000 34199.9n 0.80000 34200.0n 0.80000 34379.9n 0.80000 34380.0n 0.80000 34559.9n 0.80000 34560.0n 0.80000 34739.9n 0.80000 34740.0n 0.80000 34919.9n 0.80000 34920.0n 0.80000 35099.9n 0.80000 35100.0n 0.80000 35279.9n 0.80000 35280.0n 0.80000 35459.9n 0.80000 35460.0n 0.80000 35639.9n 0.80000 35640.0n 0.80000 35819.9n 0.80000 35820.0n 0.80000 35999.9n 0.80000 36000.0n 0.80000 36179.9n 0.80000 36180.0n 0.80000 36359.9n 0.80000 36360.0n 0.80000 36539.9n 0.80000 36540.0n 0.80000 36719.9n 0.80000 36720.0n 0.80000 36899.9n 0.80000 36900.0n 0.80000 37079.9n 0.80000 37080.0n 0.80000 37259.9n 0.80000 37260.0n 0.80000 37439.9n 0.80000 37440.0n 0.80000 37619.9n 0.80000 37620.0n 0.80000 37799.9n 0.80000 37800.0n 0.80000 37979.9n 0.80000 37980.0n 0.80000 38159.9n 0.80000 38160.0n 0.80000 38339.9n 0.80000 38340.0n 0.80000 38519.9n 0.80000 38520.0n 0.80000 38699.9n 0.80000 38700.0n 0.80000 38879.9n 0.80000 38880.0n 0.80000 39059.9n 0.80000 39060.0n 0.80000 39239.9n 0.80000 39240.0n 0.80000 39419.9n 0.80000 39420.0n 0.80000 39599.9n 0.80000 39600.0n 0.80000 39779.9n 0.80000 39780.0n 0.80000 39959.9n 0.80000 39960.0n 0.80000 40139.9n 0.80000 40140.0n 0.80000 40319.9n 0.80000 40320.0n 0.80000 40499.9n 0.80000 40500.0n 0.80000 40679.9n 0.80000 40680.0n 0.80000 40859.9n 0.80000 40860.0n 0.80000 41039.9n 0.80000 41040.0n 0.80000 41219.9n 0.80000 41220.0n 0.80000 41399.9n 0.80000 41400.0n 0.80000 41579.9n 0.80000 41580.0n 0.80000 41759.9n 0.80000 41760.0n 0.80000 41939.9n 0.80000 41940.0n 0.80000 42119.9n 0.80000 42120.0n 0.80000 42299.9n 0.80000 42300.0n 0.80000 42479.9n 0.80000 42480.0n 0.80000 42659.9n 0.80000 42660.0n 0.80000 42839.9n 0.80000 42840.0n 0.80000 43019.9n 0.80000 43020.0n 0.80000 43199.9n 0.80000 43200.0n 0.80000 43379.9n 0.80000 43380.0n 0.80000 43559.9n 0.80000 43560.0n 0.80000 43739.9n 0.80000 43740.0n 0.80000 43919.9n 0.80000 43920.0n 0.80000 44099.9n 0.80000 44100.0n 0.80000 44279.9n 0.80000 44280.0n 0.80000 44459.9n 0.80000 44460.0n 0.80000 44639.9n 0.80000 44640.0n 0.80000 44819.9n 0.80000 44820.0n 0.80000 44999.9n 0.80000 45000.0n 0.80000 45179.9n 0.80000 45180.0n 0.80000 45359.9n 0.80000 45360.0n 0.80000 45539.9n 0.80000 45540.0n 0.80000 45719.9n 0.80000 45720.0n 0.80000 45899.9n 0.80000 45900.0n 0.80000 46079.9n 0.80000 46080.0n 0.80000 46259.9n 0.80000 46260.0n 0.80000 46439.9n 0.80000 46440.0n 0.80000 46619.9n 0.80000 46620.0n 0.80000 46799.9n 0.80000 46800.0n 0.80000 46979.9n 0.80000 46980.0n 0.80000 47159.9n 0.80000 47160.0n 0.80000 47339.9n 0.80000 47340.0n 0.80000 47519.9n 0.80000 47520.0n 0.80000 47699.9n 0.80000 47700.0n 0.80000 47879.9n 0.80000 47880.0n 0.80000 48059.9n 0.80000 48060.0n 0.80000 48239.9n 0.80000 48240.0n 0.80000 48419.9n 0.80000 48420.0n 0.80000 48599.9n 0.80000 48600.0n 0.80000 48779.9n 0.80000 48780.0n 0.80000 48959.9n 0.80000 48960.0n 0.80000 49139.9n 0.80000 49140.0n 0.80000 49319.9n 0.80000 49320.0n 0.80000 49499.9n 0.80000 49500.0n 0.80000 49679.9n 0.80000 49680.0n 0.80000 49859.9n 0.80000 49860.0n 0.80000 50039.9n 0.80000 50040.0n 0.80000 50219.9n 0.80000 50220.0n 0.80000 50399.9n 0.80000 50400.0n 0.80000 50579.9n 0.80000 50580.0n 0.80000 50759.9n 0.80000 50760.0n 0.80000 50939.9n 0.80000 50940.0n 0.80000 51119.9n 0.80000 51120.0n 0.80000 51299.9n 0.80000 51300.0n 0.80000 51479.9n 0.80000 51480.0n 0.80000 51659.9n 0.80000 51660.0n 0.80000 51839.9n 0.80000 51840.0n 0.80000 52019.9n 0.80000 52020.0n 0.80000 52199.9n 0.80000 52200.0n 0.80000 52379.9n 0.80000 52380.0n 0.80000 52559.9n 0.80000 52560.0n 0.80000 52739.9n 0.80000 52740.0n 0.80000 52919.9n 0.80000 52920.0n 0.80000 53099.9n 0.80000 53100.0n 0.80000 53279.9n 0.80000 53280.0n 0.80000 53459.9n 0.80000 53460.0n 0.80000 53639.9n 0.80000 53640.0n 0.80000 53819.9n 0.80000 53820.0n 0.80000 53999.9n 0.80000 54000.0n 0.80000 54179.9n 0.80000 54180.0n 0.80000 54359.9n 0.80000 54360.0n 0.80000 54539.9n 0.80000 54540.0n 0.80000 54719.9n 0.80000 54720.0n 0.80000 54899.9n 0.80000 54900.0n 0.80000 55079.9n 0.80000 55080.0n 0.80000 55259.9n 0.80000 55260.0n 0.80000 55439.9n 0.80000 55440.0n 0.80000 55619.9n 0.80000 55620.0n 0.80000 55799.9n 0.80000 55800.0n 0.80000 55979.9n 0.80000 55980.0n 0.80000 56159.9n 0.80000 56160.0n 0.80000 56339.9n 0.80000 56340.0n 0.80000 56519.9n 0.80000 56520.0n 0.80000 56699.9n 0.80000 56700.0n 0.80000 56879.9n 0.80000 56880.0n 0.80000 57059.9n 0.80000 57060.0n 0.80000 57239.9n 0.80000 57240.0n 0.80000 57419.9n 0.80000 57420.0n 0.80000 57599.9n 0.80000 57600.0n 0.80000 57779.9n 0.80000 57780.0n 0.80000 57959.9n 0.80000 57960.0n 0.80000 58139.9n 0.80000 58140.0n 0.80000 58319.9n 0.80000 58320.0n 0.80000 58499.9n 0.80000 58500.0n 0.80000 58679.9n 0.80000 58680.0n 0.80000 58859.9n 0.80000 58860.0n 0.80000 59039.9n 0.80000 59040.0n 0.80000 59219.9n 0.80000 59220.0n 0.80000 59399.9n 0.80000 59400.0n 0.80000 59579.9n 0.80000 59580.0n 0.80000 59759.9n 0.80000 59760.0n 0.80000 59939.9n 0.80000 59940.0n 0.80000 60119.9n 0.80000 60120.0n 0.80000 60299.9n 0.80000 60300.0n 0.80000 60479.9n 0.80000 60480.0n 0.80000 60659.9n 0.80000 60660.0n 0.80000 60839.9n 0.80000 60840.0n 0.80000 61019.9n 0.80000 61020.0n 0.80000 61199.9n 0.80000 61200.0n 0.80000 61379.9n 0.80000 61380.0n 0.80000 61559.9n 0.80000 61560.0n 0.80000 61739.9n 0.80000 61740.0n 0.80000 61919.9n 0.80000 61920.0n 0.80000 62099.9n 0.80000 62100.0n 0.80000 62279.9n 0.80000 62280.0n 0.80000 62459.9n 0.80000 62460.0n 0.80000 62639.9n 0.80000 62640.0n 0.80000 62819.9n 0.80000 62820.0n 0.80000 62999.9n 0.80000 63000.0n 0.80000 63179.9n 0.80000 63180.0n 0.80000 63359.9n 0.80000 63360.0n 0.80000 63539.9n 0.80000 63540.0n 0.80000 63719.9n 0.80000 63720.0n 0.80000 63899.9n 0.80000 63900.0n 0.80000 64079.9n 0.80000 64080.0n 0.80000 64259.9n 0.80000 64260.0n 0.80000 64439.9n 0.80000 64440.0n 0.80000 64619.9n 0.80000 64620.0n 0.80000 64799.9n 0.80000 64800.0n 0.80000 64979.9n 0.80000 64980.0n 0.80000 65159.9n 0.80000 65160.0n 0.80000 65339.9n 0.80000 65340.0n 0.80000 65519.9n 0.80000 65520.0n 0.80000 65699.9n 0.80000 65700.0n 0.80000 65879.9n 0.80000 65880.0n 0.80000 66059.9n 0.80000 66060.0n 0.80000 66239.9n 0.80000 66240.0n 0.80000 66419.9n 0.80000 66420.0n 0.80000 66599.9n 0.80000 66600.0n 0.80000 66779.9n 0.80000 66780.0n 0.80000 66959.9n 0.80000 66960.0n 0.80000 67139.9n 0.80000 67140.0n 0.80000 67319.9n 0.80000 67320.0n 0.80000 67499.9n 0.80000 67500.0n 0.80000 67679.9n 0.80000 67680.0n 0.80000 67859.9n 0.80000 67860.0n 0.80000 68039.9n 0.80000 68040.0n 0.80000 68219.9n 0.80000 68220.0n 0.80000 68399.9n 0.80000 68400.0n 0.80000 68579.9n 0.80000 68580.0n 0.80000 68759.9n 0.80000 68760.0n 0.80000 68939.9n 0.80000 68940.0n 0.80000 69119.9n 0.80000 69120.0n 0.80000 69299.9n 0.80000 69300.0n 0.80000 69479.9n 0.80000 69480.0n 0.80000 69659.9n 0.80000 69660.0n 0.80000 69839.9n 0.80000 69840.0n 0.80000 70019.9n 0.80000 70020.0n 0.80000 70199.9n 0.80000 70200.0n 0.80000 70379.9n 0.80000 70380.0n 0.80000 70559.9n 0.80000 70560.0n 0.80000 70739.9n 0.80000 70740.0n 0.80000 70919.9n 0.80000 70920.0n 0.80000 71099.9n 0.80000 71100.0n 0.80000 71279.9n 0.80000 71280.0n 0.80000 71459.9n 0.80000 71460.0n 0.80000 71639.9n 0.80000 71640.0n 0.80000 71819.9n 0.80000 71820.0n 0.80000 71999.9n 0.80000 72000.0n 0.80000 72179.9n 0.80000 72180.0n 0.80000 72359.9n 0.80000 72360.0n 0.80000 72539.9n 0.80000 72540.0n 0.80000 72719.9n 0.80000 72720.0n 0.80000 72899.9n 0.80000 72900.0n 0.80000 73079.9n 0.80000 73080.0n 0.80000 73259.9n 0.80000 73260.0n 0.80000 73439.9n 0.80000 73440.0n 0.80000 73619.9n 0.80000 73620.0n 0.80000 73799.9n 0.80000 73800.0n 0.80000 73979.9n 0.80000 73980.0n 0.80000 74159.9n 0.80000 74160.0n 0.80000 74339.9n 0.80000 74340.0n 0.80000 74519.9n 0.80000 74520.0n 0.80000 74699.9n 0.80000 74700.0n 0.80000 74879.9n 0.80000 74880.0n 0.80000 75059.9n 0.80000 75060.0n 0.80000 75239.9n 0.80000 75240.0n 0.80000 75419.9n 0.80000 75420.0n 0.80000 75599.9n 0.80000 75600.0n 0.80000 75779.9n 0.80000 75780.0n 0.80000 75959.9n 0.80000 75960.0n 0.80000 76139.9n 0.80000 76140.0n 0.80000 76319.9n 0.80000 76320.0n 0.80000 76499.9n 0.80000 76500.0n 0.80000 76679.9n 0.80000 76680.0n 0.80000 76859.9n 0.80000 76860.0n 0.80000 77039.9n 0.80000 77040.0n 0.80000 77219.9n 0.80000 77220.0n 0.80000 77399.9n 0.80000 77400.0n 0.80000 77579.9n 0.80000 77580.0n 0.80000 77759.9n 0.80000 77760.0n 0.80000 77939.9n 0.80000 77940.0n 0.80000 78119.9n 0.80000 78120.0n 0.80000 78299.9n 0.80000 78300.0n 0.80000 78479.9n 0.80000 78480.0n 0.80000 78659.9n 0.80000 78660.0n 0.80000 78839.9n 0.80000 78840.0n 0.80000 79019.9n 0.80000 79020.0n 0.80000 79199.9n 0.80000 79200.0n 0.80000 79379.9n 0.80000 79380.0n 0.80000 79559.9n 0.80000 79560.0n 0.80000 79739.9n 0.80000 79740.0n 0.80000 79919.9n 0.80000 79920.0n 0.80000 80099.9n 0.80000 80100.0n 0.80000 80279.9n 0.80000 80280.0n 0.80000 80459.9n 0.80000 80460.0n 0.80000 80639.9n 0.80000 80640.0n 0.80000 80819.9n 0.80000 80820.0n 0.80000 80999.9n 0.80000 81000.0n 0.80000 81179.9n 0.80000 81180.0n 0.80000 81359.9n 0.80000 81360.0n 0.80000 81539.9n 0.80000 81540.0n 0.80000 81719.9n 0.80000 81720.0n 0.80000 81899.9n 0.80000 81900.0n 0.80000 82079.9n 0.80000 82080.0n 0.80000 82259.9n 0.80000 82260.0n 0.80000 82439.9n 0.80000 82440.0n 0.80000 82619.9n 0.80000 82620.0n 0.80000 82799.9n 0.80000 82800.0n 0.80000 82979.9n 0.80000 82980.0n 0.80000 83159.9n 0.80000 83160.0n 0.80000 83339.9n 0.80000 83340.0n 0.80000 83519.9n 0.80000 83520.0n 0.80000 83699.9n 0.80000 83700.0n 0.80000 83879.9n 0.80000 83880.0n 0.80000 84059.9n 0.80000 84060.0n 0.80000 84239.9n 0.80000 84240.0n 0.80000 84419.9n 0.80000 84420.0n 0.80000 84599.9n 0.80000 84600.0n 0.80000 84779.9n 0.80000 84780.0n 0.80000 84959.9n 0.80000 84960.0n 0.80000 85139.9n 0.80000 85140.0n 0.80000 85319.9n 0.80000 85320.0n 0.80000 85499.9n 0.80000 85500.0n 0.80000 85679.9n 0.80000 85680.0n 0.80000 85859.9n 0.80000 85860.0n 0.80000 86039.9n 0.80000 86040.0n 0.80000 86219.9n 0.80000 86220.0n 0.80000 86399.9n 0.80000 86400.0n 0.80000 86579.9n 0.80000 86580.0n 0.80000 86759.9n 0.80000 86760.0n 0.80000 86939.9n 0.80000 86940.0n 0.80000 87119.9n 0.80000 87120.0n 0.80000 87299.9n 0.80000 87300.0n 0.80000 87479.9n 0.80000 87480.0n 0.80000 87659.9n 0.80000 87660.0n 0.80000 87839.9n 0.80000 87840.0n 0.80000 88019.9n 0.80000 88020.0n 0.80000 88199.9n 0.80000 88200.0n 0.80000 88379.9n 0.80000 88380.0n 0.80000 88559.9n 0.80000 88560.0n 0.80000 88739.9n 0.80000 88740.0n 0.80000 88919.9n 0.80000 88920.0n 0.80000 89099.9n 0.80000 89100.0n 0.80000 89279.9n 0.80000 89280.0n 0.80000 89459.9n 0.80000 89460.0n 0.80000 89639.9n 0.80000 89640.0n 0.80000 89819.9n 0.80000 89820.0n 0.80000 89999.9n 0.80000 90000.0n 0.80000 90179.9n 0.80000 90180.0n 0.80000 90359.9n 0.80000 90360.0n 0.80000 90539.9n 0.80000 90540.0n 0.80000 90719.9n 0.80000 90720.0n 0.80000 90899.9n 0.80000 90900.0n 0.80000 91079.9n 0.80000 91080.0n 0.80000 91259.9n 0.80000 91260.0n 0.80000 91439.9n 0.80000 91440.0n 0.80000 91619.9n 0.80000 91620.0n 0.80000 91799.9n 0.80000 91800.0n 0.80000 91979.9n 0.80000 91980.0n 0.80000 92159.9n 0.80000 92160.0n 0.80000 92339.9n 0.80000 92340.0n 0.80000 92519.9n 0.80000 92520.0n 0.80000 92699.9n 0.80000 92700.0n 0.80000 92879.9n 0.80000 92880.0n 0.80000 93059.9n 0.80000 93060.0n 0.80000 93239.9n 0.80000 93240.0n 0.80000 93419.9n 0.80000 93420.0n 0.80000 93599.9n 0.80000 93600.0n 0.80000 93779.9n 0.80000 93780.0n 0.80000 93959.9n 0.80000 93960.0n 0.80000 94139.9n 0.80000 94140.0n 0.80000 94319.9n 0.80000 94320.0n 0.80000 94499.9n 0.80000 94500.0n 0.80000 94679.9n 0.80000 94680.0n 0.80000 94859.9n 0.80000 94860.0n 0.80000 95039.9n 0.80000 95040.0n 0.80000 95219.9n 0.80000 95220.0n 0.80000 95399.9n 0.80000 95400.0n 0.80000 95579.9n 0.80000 95580.0n 0.80000 95759.9n 0.80000 95760.0n 0.80000 95939.9n 0.80000 95940.0n 0.80000 96119.9n 0.80000 96120.0n 0.80000 96299.9n 0.80000 96300.0n 0.80000 96479.9n 0.80000 96480.0n 0.80000 96659.9n 0.80000 96660.0n 0.80000 96839.9n 0.80000 96840.0n 0.80000 97019.9n 0.80000 97020.0n 0.80000 97199.9n 0.80000 97200.0n 0.80000 97379.9n 0.80000 97380.0n 0.80000 97559.9n 0.80000 97560.0n 0.80000 97739.9n 0.80000 97740.0n 0.80000 97919.9n 0.80000 97920.0n 0.80000 98099.9n 0.80000 98100.0n 0.80000 98279.9n 0.80000 98280.0n 0.80000 98459.9n 0.80000 98460.0n 0.80000 98639.9n 0.80000 98640.0n 0.80000 98819.9n 0.80000 98820.0n 0.80000 98999.9n 0.80000 99000.0n 0.80000 99179.9n 0.80000 99180.0n 0.80000 99359.9n 0.80000 99360.0n 0.80000 99539.9n 0.80000 99540.0n 0.80000 99719.9n 0.80000 99720.0n 0.80000 99899.9n 0.80000 99900.0n 0.80000 100079.9n 0.80000 100080.0n 0.80000 100259.9n 0.80000 100260.0n 0.80000 100439.9n 0.80000 100440.0n 0.80000 100619.9n 0.80000 100620.0n 0.80000 100799.9n 0.80000 100800.0n 0.80000 100979.9n 0.80000 100980.0n 0.80000 101159.9n 0.80000 101160.0n 0.80000 101339.9n 0.80000 101340.0n 0.80000 101519.9n 0.80000 101520.0n 0.80000 101699.9n 0.80000 101700.0n 0.80000 101879.9n 0.80000 101880.0n 0.80000 102059.9n 0.80000 102060.0n 0.80000 102239.9n 0.80000 102240.0n 0.80000 102419.9n 0.80000 102420.0n 0.80000 102599.9n 0.80000 102600.0n 0.80000 102779.9n 0.80000 102780.0n 0.80000 102959.9n 0.80000 102960.0n 0.80000 103139.9n 0.80000 103140.0n 0.80000 103319.9n 0.80000 103320.0n 0.80000 103499.9n 0.80000 103500.0n 0.80000 103679.9n 0.80000 103680.0n 0.80000 103859.9n 0.80000 103860.0n 0.80000 104039.9n 0.80000 104040.0n 0.80000 104219.9n 0.80000 104220.0n 0.80000 104399.9n 0.80000 104400.0n 0.80000 104579.9n 0.80000 104580.0n 0.80000 104759.9n 0.80000 104760.0n 0.80000 104939.9n 0.80000 104940.0n 0.80000 105119.9n 0.80000 105120.0n 0.80000 105299.9n 0.80000 105300.0n 0.80000 105479.9n 0.80000 105480.0n 0.80000 105659.9n 0.80000 105660.0n 0.80000 105839.9n 0.80000 105840.0n 0.80000 106019.9n 0.80000 106020.0n 0.80000 106199.9n 0.80000 106200.0n 0.80000 106379.9n 0.80000 106380.0n 0.80000 106559.9n 0.80000 106560.0n 0.80000 106739.9n 0.80000 106740.0n 0.80000 106919.9n 0.80000 106920.0n 0.80000 107099.9n 0.80000 107100.0n 0.80000 107279.9n 0.80000 107280.0n 0.80000 107459.9n 0.80000 107460.0n 0.80000 107639.9n 0.80000 107640.0n 0.80000 107819.9n 0.80000 107820.0n 0.80000 107999.9n 0.80000 108000.0n 0.80000 108179.9n 0.80000 108180.0n 0.80000 108359.9n 0.80000 108360.0n 0.80000 108539.9n 0.80000 108540.0n 0.80000 108719.9n 0.80000 108720.0n 0.80000 108899.9n 0.80000 108900.0n 0.80000 109079.9n 0.80000 109080.0n 0.80000 109259.9n 0.80000 109260.0n 0.80000 109439.9n 0.80000 109440.0n 0.80000 109619.9n 0.80000 109620.0n 0.80000 109799.9n 0.80000 109800.0n 0.80000 109979.9n 0.80000 109980.0n 0.80000 110159.9n 0.80000 110160.0n 0.80000 110339.9n 0.80000 110340.0n 0.80000 110519.9n 0.80000 110520.0n 0.80000 110699.9n 0.80000 110700.0n 0.80000 110879.9n 0.80000 110880.0n 0.80000 111059.9n 0.80000 111060.0n 0.80000 111239.9n 0.80000 111240.0n 0.80000 111419.9n 0.80000 111420.0n 0.80000 111599.9n 0.80000 111600.0n 0.80000 111779.9n 0.80000 111780.0n 0.80000 111959.9n 0.80000 111960.0n 0.80000 112139.9n 0.80000 112140.0n 0.80000 112319.9n 0.80000 112320.0n 0.80000 112499.9n 0.80000 112500.0n 0.80000 112679.9n 0.80000 112680.0n 0.80000 112859.9n 0.80000 112860.0n 0.80000 113039.9n 0.80000 113040.0n 0.80000 113219.9n 0.80000 113220.0n 0.80000 113399.9n 0.80000 113400.0n 0.80000 113579.9n 0.80000 113580.0n 0.80000 113759.9n 0.80000 113760.0n 0.80000 113939.9n 0.80000 113940.0n 0.80000 114119.9n 0.80000 114120.0n 0.80000 114299.9n 0.80000 114300.0n 0.80000 114479.9n 0.80000 114480.0n 0.80000 114659.9n 0.80000 114660.0n 0.80000 114839.9n 0.80000 114840.0n 0.80000 115019.9n 0.80000 115020.0n 0.80000 115199.9n 0.80000 115200.0n 0.80000 115379.9n 0.80000 115380.0n 0.80000 115559.9n 0.80000 115560.0n 0.80000 115739.9n 0.80000 115740.0n 0.80000 115919.9n 0.80000 115920.0n 0.80000 116099.9n 0.80000 116100.0n 0.80000 116279.9n 0.80000 116280.0n 0.80000 116459.9n 0.80000 116460.0n 0.80000 116639.9n 0.80000 116640.0n 0.80000 116819.9n 0.80000 116820.0n 0.80000 116999.9n 0.80000 117000.0n 0.80000 117179.9n 0.80000 117180.0n 0.80000 117359.9n 0.80000 117360.0n 0.80000 117539.9n 0.80000 117540.0n 0.80000 117719.9n 0.80000 117720.0n 0.80000 117899.9n 0.80000 117900.0n 0.80000 118079.9n 0.80000 118080.0n 0.80000 118259.9n 0.80000 118260.0n 0.80000 118439.9n 0.80000 118440.0n 0.80000 118619.9n 0.80000 118620.0n 0.80000 118799.9n 0.80000 118800.0n 0.80000 118979.9n 0.80000 118980.0n 0.80000 119159.9n 0.80000 119160.0n 0.80000 119339.9n 0.80000 119340.0n 0.80000 119519.9n 0.80000 119520.0n 0.80000 119699.9n 0.80000 119700.0n 0.80000 119879.9n 0.80000 119880.0n 0.80000 120059.9n 0.80000 120060.0n 0.80000 120239.9n 0.80000 120240.0n 0.80000 120419.9n 0.80000 120420.0n 0.80000 120599.9n 0.80000 120600.0n 0.80000 120779.9n 0.80000 120780.0n 0.80000 120959.9n 0.80000 120960.0n 0.80000 121139.9n 0.80000 121140.0n 0.80000 121319.9n 0.80000 121320.0n 0.80000 121499.9n 0.80000 121500.0n 0.80000 121679.9n 0.80000 121680.0n 0.80000 121859.9n 0.80000 121860.0n 0.80000 122039.9n 0.80000 122040.0n 0.80000 122219.9n 0.80000 122220.0n 0.80000 122399.9n 0.80000 122400.0n 0.80000 122579.9n 0.80000 122580.0n 0.80000 122759.9n 0.80000 122760.0n 0.80000 122939.9n 0.80000 122940.0n 0.80000 123119.9n 0.80000 123120.0n 0.80000 123299.9n 0.80000 123300.0n 0.80000 123479.9n 0.80000 123480.0n 0.80000 123659.9n 0.80000 123660.0n 0.80000 123839.9n 0.80000 123840.0n 0.80000 124019.9n 0.80000 124020.0n 0.80000 124199.9n 0.80000 124200.0n 0.80000 124379.9n 0.80000 124380.0n 0.80000 124559.9n 0.80000 124560.0n 0.80000 124739.9n 0.80000 124740.0n 0.80000 124919.9n 0.80000 124920.0n 0.80000 125099.9n 0.80000 125100.0n 0.80000 125279.9n 0.80000 125280.0n 0.80000 125459.9n 0.80000 125460.0n 0.80000 125639.9n 0.80000 125640.0n 0.80000 125819.9n 0.80000 125820.0n 0.80000 125999.9n 0.80000 126000.0n 0.80000 126179.9n 0.80000 126180.0n 0.80000 126359.9n 0.80000 126360.0n 0.80000 126539.9n 0.80000 126540.0n 0.80000 126719.9n 0.80000 126720.0n 0.80000 126899.9n 0.80000 126900.0n 0.80000 127079.9n 0.80000 127080.0n 0.80000 127259.9n 0.80000 127260.0n 0.80000 127439.9n 0.80000 127440.0n 0.80000 127619.9n 0.80000 127620.0n 0.80000 127799.9n 0.80000 127800.0n 0.80000 127979.9n 0.80000 127980.0n 0.80000 128159.9n 0.80000 128160.0n 0.80000 128339.9n 0.80000 128340.0n 0.80000 128519.9n 0.80000 128520.0n 0.80000 128699.9n 0.80000 128700.0n 0.80000 128879.9n 0.80000 128880.0n 0.80000 129059.9n 0.80000 129060.0n 0.80000 129239.9n 0.80000 129240.0n 0.80000 129419.9n 0.80000 129420.0n 0.80000 129599.9n 0.80000 129600.0n 0.80000 129779.9n 0.80000 129780.0n 0.80000 129959.9n 0.80000 129960.0n 0.80000 130139.9n 0.80000 130140.0n 0.80000 130319.9n 0.80000 130320.0n 0.80000 130499.9n 0.80000 130500.0n 0.80000 130679.9n 0.80000 130680.0n 0.80000 130859.9n 0.80000 130860.0n 0.80000 131039.9n 0.80000 131040.0n 0.80000 131219.9n 0.80000 131220.0n 0.80000 131399.9n 0.80000 131400.0n 0.80000 131579.9n 0.80000 131580.0n 0.80000 131759.9n 0.80000 131760.0n 0.80000 131939.9n 0.80000 131940.0n 0.80000 132119.9n 0.80000 132120.0n 0.80000 132299.9n 0.80000 132300.0n 0.80000 132479.9n 0.80000 132480.0n 0.80000 132659.9n 0.80000 132660.0n 0.80000 132839.9n 0.80000 132840.0n 0.80000 133019.9n 0.80000 133020.0n 0.80000 133199.9n 0.80000 133200.0n 0.80000 133379.9n 0.80000 133380.0n 0.80000 133559.9n 0.80000 133560.0n 0.80000 133739.9n 0.80000 133740.0n 0.80000 133919.9n 0.80000 133920.0n 0.80000 134099.9n 0.80000 134100.0n 0.80000 134279.9n 0.80000 134280.0n 0.80000 134459.9n 0.80000 134460.0n 0.80000 134639.9n 0.80000 134640.0n 0.80000 134819.9n 0.80000 134820.0n 0.80000 134999.9n 0.80000 135000.0n 0.80000 135179.9n 0.80000 135180.0n 0.80000 135359.9n 0.80000 135360.0n 0.80000 135539.9n 0.80000 135540.0n 0.80000 135719.9n 0.80000 135720.0n 0.80000 135899.9n 0.80000 135900.0n 0.80000 136079.9n 0.80000 136080.0n 0.80000 136259.9n 0.80000 136260.0n 0.80000 136439.9n 0.80000 136440.0n 0.80000 136619.9n 0.80000 136620.0n 0.80000 136799.9n 0.80000 136800.0n 0.80000 136979.9n 0.80000 136980.0n 0.80000 137159.9n 0.80000 137160.0n 0.80000 137339.9n 0.80000 137340.0n 0.80000 137519.9n 0.80000 137520.0n 0.80000 137699.9n 0.80000 137700.0n 0.80000 137879.9n 0.80000 137880.0n 0.80000 138059.9n 0.80000 138060.0n 0.80000 138239.9n 0.80000 138240.0n 0.80000 138419.9n 0.80000 138420.0n 0.80000 138599.9n 0.80000 138600.0n 0.80000 138779.9n 0.80000 138780.0n 0.80000 138959.9n 0.80000 138960.0n 0.80000 139139.9n 0.80000 139140.0n 0.80000 139319.9n 0.80000 139320.0n 0.80000 139499.9n 0.80000 139500.0n 0.80000 139679.9n 0.80000 139680.0n 0.80000 139859.9n 0.80000 139860.0n 0.80000 140039.9n 0.80000 140040.0n 0.80000 140219.9n 0.80000 140220.0n 0.80000 140399.9n 0.80000 140400.0n 0.80000 140579.9n 0.80000 140580.0n 0.80000 140759.9n 0.80000 140760.0n 0.80000 140939.9n 0.80000 140940.0n 0.80000 141119.9n 0.80000 141120.0n 0.80000 141299.9n 0.80000 141300.0n 0.80000 141479.9n 0.80000 141480.0n 0.80000 141659.9n 0.80000 141660.0n 0.80000 141839.9n 0.80000 141840.0n 0.80000 142019.9n 0.80000 142020.0n 0.80000 142199.9n 0.80000 142200.0n 0.80000 142379.9n 0.80000 142380.0n 0.80000 142559.9n 0.80000 142560.0n 0.80000 142739.9n 0.80000 142740.0n 0.80000 142919.9n 0.80000 142920.0n 0.80000 143099.9n 0.80000 143100.0n 0.80000 143279.9n 0.80000 143280.0n 0.80000 143459.9n 0.80000 143460.0n 0.80000 143639.9n 0.80000 143640.0n 0.80000 143819.9n 0.80000 143820.0n 0.80000 143999.9n 0.80000 144000.0n 0.80000 144179.9n 0.80000 144180.0n 0.80000 144359.9n 0.80000 144360.0n 0.80000 144539.9n 0.80000 144540.0n 0.80000 144719.9n 0.80000 144720.0n 0.80000 144899.9n 0.80000 144900.0n 0.80000 145079.9n 0.80000 145080.0n 0.80000 145259.9n 0.80000 145260.0n 0.80000 145439.9n 0.80000 145440.0n 0.80000 145619.9n 0.80000 145620.0n 0.80000 145799.9n 0.80000 145800.0n 0.80000 145979.9n 0.80000 145980.0n 0.80000 146159.9n 0.80000 146160.0n 0.80000 146339.9n 0.80000 146340.0n 0.80000 146519.9n 0.80000 146520.0n 0.80000 146699.9n 0.80000 146700.0n 0.80000 146879.9n 0.80000 146880.0n 0.80000 147059.9n 0.80000 147060.0n 0.80000 147239.9n 0.80000 147240.0n 0.80000 147419.9n 0.80000 147420.0n 0.80000 147599.9n 0.80000 147600.0n 0.80000 147779.9n 0.80000 147780.0n 0.80000 147959.9n 0.80000 147960.0n 0.80000 148139.9n 0.80000 148140.0n 0.80000 148319.9n 0.80000 148320.0n 0.80000 148499.9n 0.80000 148500.0n 0.80000 148679.9n 0.80000 148680.0n 0.80000 148859.9n 0.80000 148860.0n 0.80000 149039.9n 0.80000 149040.0n 0.80000 149219.9n 0.80000 149220.0n 0.80000 149399.9n 0.80000 149400.0n 0.80000 149579.9n 0.80000 149580.0n 0.80000 149759.9n 0.80000 149760.0n 0.80000 149939.9n 0.80000 149940.0n 0.80000 150119.9n 0.80000 150120.0n 0.80000 150299.9n 0.80000 150300.0n 0.80000 150479.9n 0.80000 150480.0n 0.80000 150659.9n 0.80000 150660.0n 0.80000 150839.9n 0.80000 150840.0n 0.80000 151019.9n 0.80000 151020.0n 0.80000 151199.9n 0.80000 151200.0n 0.80000 151379.9n 0.80000 151380.0n 0.80000 151559.9n 0.80000 151560.0n 0.80000 151739.9n 0.80000 151740.0n 0.80000 151919.9n 0.80000 151920.0n 0.80000 152099.9n 0.80000 152100.0n 0.80000 152279.9n 0.80000 152280.0n 0.80000 152459.9n 0.80000 152460.0n 0.80000 152639.9n 0.80000 152640.0n 0.80000 152819.9n 0.80000 152820.0n 0.80000 152999.9n 0.80000 153000.0n 0.80000 153179.9n 0.80000 153180.0n 0.80000 153359.9n 0.80000 153360.0n 0.80000 153539.9n 0.80000 153540.0n 0.80000 153719.9n 0.80000 153720.0n 0.80000 153899.9n 0.80000 153900.0n 0.80000 154079.9n 0.80000 154080.0n 0.80000 154259.9n 0.80000 154260.0n 0.80000 154439.9n 0.80000 154440.0n 0.80000 154619.9n 0.80000 154620.0n 0.80000 154799.9n 0.80000 154800.0n 0.80000 154979.9n 0.80000 154980.0n 0.80000 155159.9n 0.80000 155160.0n 0.80000 155339.9n 0.80000 155340.0n 0.80000 155519.9n 0.80000 155520.0n 0.80000 155699.9n 0.80000 155700.0n 0.80000 155879.9n 0.80000 155880.0n 0.80000 156059.9n 0.80000 156060.0n 0.80000 156239.9n 0.80000 156240.0n 0.80000 156419.9n 0.80000 156420.0n 0.80000 156599.9n 0.80000 156600.0n 0.80000 156779.9n 0.80000 156780.0n 0.80000 156959.9n 0.80000 156960.0n 0.80000 157139.9n 0.80000 157140.0n 0.80000 157319.9n 0.80000 157320.0n 0.80000 157499.9n 0.80000 157500.0n 0.80000 157679.9n 0.80000 157680.0n 0.80000 157859.9n 0.80000 157860.0n 0.80000 158039.9n 0.80000 158040.0n 0.80000 158219.9n 0.80000 158220.0n 0.80000 158399.9n 0.80000 158400.0n 0.80000 158579.9n 0.80000 158580.0n 0.80000 158759.9n 0.80000 158760.0n 0.80000 158939.9n 0.80000 158940.0n 0.80000 159119.9n 0.80000 159120.0n 0.80000 159299.9n 0.80000 159300.0n 0.80000 159479.9n 0.80000 159480.0n 0.80000 159659.9n 0.80000 159660.0n 0.80000 159839.9n 0.80000 159840.0n 0.80000 160019.9n 0.80000 160020.0n 0.80000 160199.9n 0.80000 160200.0n 0.80000 160379.9n 0.80000 160380.0n 0.80000 160559.9n 0.80000 160560.0n 0.80000 160739.9n 0.80000 160740.0n 0.80000 160919.9n 0.80000 160920.0n 0.80000 161099.9n 0.80000 161100.0n 0.80000 161279.9n 0.80000 161280.0n 0.80000 161459.9n 0.80000 161460.0n 0.80000 161639.9n 0.80000 161640.0n 0.80000 161819.9n 0.80000 161820.0n 0.80000 161999.9n 0.80000 162000.0n 0.80000 162179.9n 0.80000 162180.0n 0.80000 162359.9n 0.80000 162360.0n 0.80000 162539.9n 0.80000 162540.0n 0.80000 162719.9n 0.80000 162720.0n 0.80000 162899.9n 0.80000 162900.0n 0.80000 163079.9n 0.80000 163080.0n 0.80000 163259.9n 0.80000 163260.0n 0.80000 163439.9n 0.80000 163440.0n 0.80000 163619.9n 0.80000 163620.0n 0.80000 163799.9n 0.80000 163800.0n 0.80000 163979.9n 0.80000 163980.0n 0.80000 164159.9n 0.80000 164160.0n 0.80000 164339.9n 0.80000 164340.0n 0.80000 164519.9n 0.80000 164520.0n 0.80000 164699.9n 0.80000 164700.0n 0.80000 164879.9n 0.80000 164880.0n 0.80000 165059.9n 0.80000 165060.0n 0.80000 165239.9n 0.80000 165240.0n 0.80000 165419.9n 0.80000 165420.0n 0.80000 165599.9n 0.80000 165600.0n 0.80000 165779.9n 0.80000 165780.0n 0.80000 165959.9n 0.80000 165960.0n 0.80000 166139.9n 0.80000 166140.0n 0.80000 166319.9n 0.80000 166320.0n 0.80000 166499.9n 0.80000 166500.0n 0.80000 166679.9n 0.80000 166680.0n 0.80000 166859.9n 0.80000 166860.0n 0.80000 167039.9n 0.80000 167040.0n 0.80000 167219.9n 0.80000 167220.0n 0.80000 167399.9n 0.80000 167400.0n 0.80000 167579.9n 0.80000 167580.0n 0.80000 167759.9n 0.80000 167760.0n 0.80000 167939.9n 0.80000 167940.0n 0.80000 168119.9n 0.80000 168120.0n 0.80000 168299.9n 0.80000 168300.0n 0.80000 168479.9n 0.80000 168480.0n 0.80000 168659.9n 0.80000 168660.0n 0.80000 168839.9n 0.80000 168840.0n 0.80000 169019.9n 0.80000 169020.0n 0.80000 169199.9n 0.80000 169200.0n 0.80000 169379.9n 0.80000 169380.0n 0.80000 169559.9n 0.80000 169560.0n 0.80000 169739.9n 0.80000 169740.0n 0.80000 169919.9n 0.80000 169920.0n 0.80000 170099.9n 0.80000 170100.0n 0.80000 170279.9n 0.80000 170280.0n 0.80000 170459.9n 0.80000 170460.0n 0.80000 170639.9n 0.80000 170640.0n 0.80000 170819.9n 0.80000 170820.0n 0.80000 170999.9n 0.80000 171000.0n 0.80000 171179.9n 0.80000 171180.0n 0.80000 171359.9n 0.80000 171360.0n 0.80000 171539.9n 0.80000 171540.0n 0.80000 171719.9n 0.80000 171720.0n 0.80000 171899.9n 0.80000 171900.0n 0.80000 172079.9n 0.80000 172080.0n 0.80000 172259.9n 0.80000 172260.0n 0.80000 172439.9n 0.80000 172440.0n 0.80000 172619.9n 0.80000 172620.0n 0.80000 172799.9n 0.80000 172800.0n 0.80000 172979.9n 0.80000 172980.0n 0.80000 173159.9n 0.80000 173160.0n 0.80000 173339.9n 0.80000 173340.0n 0.80000 173519.9n 0.80000 173520.0n 0.80000 173699.9n 0.80000 173700.0n 0.80000 173879.9n 0.80000 173880.0n 0.80000 174059.9n 0.80000 174060.0n 0.80000 174239.9n 0.80000 174240.0n 0.80000 174419.9n 0.80000 174420.0n 0.80000 174599.9n 0.80000 174600.0n 0.80000 174779.9n 0.80000 174780.0n 0.80000 174959.9n 0.80000 174960.0n 0.80000 175139.9n 0.80000 175140.0n 0.80000 175319.9n 0.80000 175320.0n 0.80000 175499.9n 0.80000 175500.0n 0.80000 175679.9n 0.80000 175680.0n 0.80000 175859.9n 0.80000 175860.0n 0.80000 176039.9n 0.80000 176040.0n 0.80000 176219.9n 0.80000 176220.0n 0.80000 176399.9n 0.80000 176400.0n 0.80000 176579.9n 0.80000 176580.0n 0.80000 176759.9n 0.80000 176760.0n 0.80000 176939.9n 0.80000 176940.0n 0.80000 177119.9n 0.80000 177120.0n 0.80000 177299.9n 0.80000 177300.0n 0.80000 177479.9n 0.80000 177480.0n 0.80000 177659.9n 0.80000 177660.0n 0.80000 177839.9n 0.80000 177840.0n 0.80000 178019.9n 0.80000 178020.0n 0.80000 178199.9n 0.80000 178200.0n 0.80000 178379.9n 0.80000 178380.0n 0.80000 178559.9n 0.80000 178560.0n 0.80000 178739.9n 0.80000 178740.0n 0.80000 178919.9n 0.80000 178920.0n 0.80000 179099.9n 0.80000 179100.0n 0.80000 179279.9n 0.80000 179280.0n 0.80000 179459.9n 0.80000 179460.0n 0.80000 179639.9n 0.80000 179640.0n 0.80000 179819.9n 0.80000 179820.0n 0.80000 179999.9n 0.80000 180000.0n 0.80000 180179.9n 0.80000 180180.0n 0.80000 180359.9n 0.80000 180360.0n 0.80000 180539.9n 0.80000 180540.0n 0.80000 180719.9n 0.80000 180720.0n 0.80000 180899.9n 0.80000 180900.0n 0.80000 181079.9n 0.80000 181080.0n 0.80000 181259.9n 0.80000 181260.0n 0.80000 181439.9n 0.80000 181440.0n 0.80000 181619.9n 0.80000 181620.0n 0.80000 181799.9n 0.80000 181800.0n 0.80000 181979.9n 0.80000 181980.0n 0.80000 182159.9n 0.80000 182160.0n 0.80000 182339.9n 0.80000 182340.0n 0.80000 182519.9n 0.80000 182520.0n 0.80000 182699.9n 0.80000 182700.0n 0.80000 182879.9n 0.80000 182880.0n 0.80000 183059.9n 0.80000 183060.0n 0.80000 183239.9n 0.80000 183240.0n 0.80000 183419.9n 0.80000 183420.0n 0.80000)
Vxn2 a_xn2 0 PWL(0.0n 0.20000 179.9n 0.20000 180.0n 0.20000 359.9n 0.20000 360.0n 0.20000 539.9n 0.20000 540.0n 0.20000 719.9n 0.20000 720.0n 0.20000 899.9n 0.20000 900.0n 0.20000 1079.9n 0.20000 1080.0n 0.20000 1259.9n 0.20000 1260.0n 0.20000 1439.9n 0.20000 1440.0n 0.20000 1619.9n 0.20000 1620.0n 0.20000 1799.9n 0.20000 1800.0n 0.20000 1979.9n 0.20000 1980.0n 0.20000 2159.9n 0.20000 2160.0n 0.20000 2339.9n 0.20000 2340.0n 0.20000 2519.9n 0.20000 2520.0n 0.20000 2699.9n 0.20000 2700.0n 0.20000 2879.9n 0.20000 2880.0n 0.20000 3059.9n 0.20000 3060.0n 0.20000 3239.9n 0.20000 3240.0n 0.20000 3419.9n 0.20000 3420.0n 0.20000 3599.9n 0.20000 3600.0n 0.20000 3779.9n 0.20000 3780.0n 0.20000 3959.9n 0.20000 3960.0n 0.20000 4139.9n 0.20000 4140.0n 0.20000 4319.9n 0.20000 4320.0n 0.20000 4499.9n 0.20000 4500.0n 0.20000 4679.9n 0.20000 4680.0n 0.20000 4859.9n 0.20000 4860.0n 0.20000 5039.9n 0.20000 5040.0n 0.20000 5219.9n 0.20000 5220.0n 0.20000 5399.9n 0.20000 5400.0n 0.20000 5579.9n 0.20000 5580.0n 0.20000 5759.9n 0.20000 5760.0n 0.20000 5939.9n 0.20000 5940.0n 0.20000 6119.9n 0.20000 6120.0n 0.20000 6299.9n 0.20000 6300.0n 0.20000 6479.9n 0.20000 6480.0n 0.20000 6659.9n 0.20000 6660.0n 0.20000 6839.9n 0.20000 6840.0n 0.20000 7019.9n 0.20000 7020.0n 0.20000 7199.9n 0.20000 7200.0n 0.20000 7379.9n 0.20000 7380.0n 0.20000 7559.9n 0.20000 7560.0n 0.20000 7739.9n 0.20000 7740.0n 0.20000 7919.9n 0.20000 7920.0n 0.20000 8099.9n 0.20000 8100.0n 0.20000 8279.9n 0.20000 8280.0n 0.20000 8459.9n 0.20000 8460.0n 0.20000 8639.9n 0.20000 8640.0n 0.20000 8819.9n 0.20000 8820.0n 0.20000 8999.9n 0.20000 9000.0n 0.20000 9179.9n 0.20000 9180.0n 0.20000 9359.9n 0.20000 9360.0n 0.20000 9539.9n 0.20000 9540.0n 0.20000 9719.9n 0.20000 9720.0n 0.20000 9899.9n 0.20000 9900.0n 0.20000 10079.9n 0.20000 10080.0n 0.20000 10259.9n 0.20000 10260.0n 0.20000 10439.9n 0.20000 10440.0n 0.20000 10619.9n 0.20000 10620.0n 0.20000 10799.9n 0.20000 10800.0n 0.20000 10979.9n 0.20000 10980.0n 0.20000 11159.9n 0.20000 11160.0n 0.20000 11339.9n 0.20000 11340.0n 0.20000 11519.9n 0.20000 11520.0n 0.20000 11699.9n 0.20000 11700.0n 0.20000 11879.9n 0.20000 11880.0n 0.20000 12059.9n 0.20000 12060.0n 0.20000 12239.9n 0.20000 12240.0n 0.20000 12419.9n 0.20000 12420.0n 0.20000 12599.9n 0.20000 12600.0n 0.20000 12779.9n 0.20000 12780.0n 0.20000 12959.9n 0.20000 12960.0n 0.20000 13139.9n 0.20000 13140.0n 0.20000 13319.9n 0.20000 13320.0n 0.20000 13499.9n 0.20000 13500.0n 0.20000 13679.9n 0.20000 13680.0n 0.20000 13859.9n 0.20000 13860.0n 0.20000 14039.9n 0.20000 14040.0n 0.20000 14219.9n 0.20000 14220.0n 0.20000 14399.9n 0.20000 14400.0n 0.20000 14579.9n 0.20000 14580.0n 0.20000 14759.9n 0.20000 14760.0n 0.20000 14939.9n 0.20000 14940.0n 0.20000 15119.9n 0.20000 15120.0n 0.20000 15299.9n 0.20000 15300.0n 0.20000 15479.9n 0.20000 15480.0n 0.20000 15659.9n 0.20000 15660.0n 0.20000 15839.9n 0.20000 15840.0n 0.20000 16019.9n 0.20000 16020.0n 0.20000 16199.9n 0.20000 16200.0n 0.20000 16379.9n 0.20000 16380.0n 0.20000 16559.9n 0.20000 16560.0n 0.20000 16739.9n 0.20000 16740.0n 0.20000 16919.9n 0.20000 16920.0n 0.20000 17099.9n 0.20000 17100.0n 0.20000 17279.9n 0.20000 17280.0n 0.20000 17459.9n 0.20000 17460.0n 0.20000 17639.9n 0.20000 17640.0n 0.20000 17819.9n 0.20000 17820.0n 0.20000 17999.9n 0.20000 18000.0n 0.20000 18179.9n 0.20000 18180.0n 0.20000 18359.9n 0.20000 18360.0n 0.20000 18539.9n 0.20000 18540.0n 0.20000 18719.9n 0.20000 18720.0n 0.20000 18899.9n 0.20000 18900.0n 0.20000 19079.9n 0.20000 19080.0n 0.20000 19259.9n 0.20000 19260.0n 0.20000 19439.9n 0.20000 19440.0n 0.20000 19619.9n 0.20000 19620.0n 0.20000 19799.9n 0.20000 19800.0n 0.20000 19979.9n 0.20000 19980.0n 0.20000 20159.9n 0.20000 20160.0n 0.20000 20339.9n 0.20000 20340.0n 0.20000 20519.9n 0.20000 20520.0n 0.20000 20699.9n 0.20000 20700.0n 0.20000 20879.9n 0.20000 20880.0n 0.20000 21059.9n 0.20000 21060.0n 0.20000 21239.9n 0.20000 21240.0n 0.20000 21419.9n 0.20000 21420.0n 0.20000 21599.9n 0.20000 21600.0n 0.20000 21779.9n 0.20000 21780.0n 0.20000 21959.9n 0.20000 21960.0n 0.20000 22139.9n 0.20000 22140.0n 0.20000 22319.9n 0.20000 22320.0n 0.20000 22499.9n 0.20000 22500.0n 0.20000 22679.9n 0.20000 22680.0n 0.20000 22859.9n 0.20000 22860.0n 0.20000 23039.9n 0.20000 23040.0n 0.20000 23219.9n 0.20000 23220.0n 0.20000 23399.9n 0.20000 23400.0n 0.20000 23579.9n 0.20000 23580.0n 0.20000 23759.9n 0.20000 23760.0n 0.20000 23939.9n 0.20000 23940.0n 0.20000 24119.9n 0.20000 24120.0n 0.20000 24299.9n 0.20000 24300.0n 0.20000 24479.9n 0.20000 24480.0n 0.20000 24659.9n 0.20000 24660.0n 0.20000 24839.9n 0.20000 24840.0n 0.20000 25019.9n 0.20000 25020.0n 0.20000 25199.9n 0.20000 25200.0n 0.20000 25379.9n 0.20000 25380.0n 0.20000 25559.9n 0.20000 25560.0n 0.20000 25739.9n 0.20000 25740.0n 0.20000 25919.9n 0.20000 25920.0n 0.20000 26099.9n 0.20000 26100.0n 0.20000 26279.9n 0.20000 26280.0n 0.20000 26459.9n 0.20000 26460.0n 0.20000 26639.9n 0.20000 26640.0n 0.20000 26819.9n 0.20000 26820.0n 0.20000 26999.9n 0.20000 27000.0n 0.20000 27179.9n 0.20000 27180.0n 0.20000 27359.9n 0.20000 27360.0n 0.20000 27539.9n 0.20000 27540.0n 0.20000 27719.9n 0.20000 27720.0n 0.20000 27899.9n 0.20000 27900.0n 0.20000 28079.9n 0.20000 28080.0n 0.20000 28259.9n 0.20000 28260.0n 0.20000 28439.9n 0.20000 28440.0n 0.20000 28619.9n 0.20000 28620.0n 0.20000 28799.9n 0.20000 28800.0n 0.20000 28979.9n 0.20000 28980.0n 0.20000 29159.9n 0.20000 29160.0n 0.20000 29339.9n 0.20000 29340.0n 0.20000 29519.9n 0.20000 29520.0n 0.20000 29699.9n 0.20000 29700.0n 0.20000 29879.9n 0.20000 29880.0n 0.20000 30059.9n 0.20000 30060.0n 0.20000 30239.9n 0.20000 30240.0n 0.20000 30419.9n 0.20000 30420.0n 0.20000 30599.9n 0.20000 30600.0n 0.20000 30779.9n 0.20000 30780.0n 0.20000 30959.9n 0.20000 30960.0n 0.20000 31139.9n 0.20000 31140.0n 0.20000 31319.9n 0.20000 31320.0n 0.20000 31499.9n 0.20000 31500.0n 0.20000 31679.9n 0.20000 31680.0n 0.20000 31859.9n 0.20000 31860.0n 0.20000 32039.9n 0.20000 32040.0n 0.20000 32219.9n 0.20000 32220.0n 0.20000 32399.9n 0.20000 32400.0n 0.20000 32579.9n 0.20000 32580.0n 0.20000 32759.9n 0.20000 32760.0n 0.20000 32939.9n 0.20000 32940.0n 0.20000 33119.9n 0.20000 33120.0n 0.20000 33299.9n 0.20000 33300.0n 0.20000 33479.9n 0.20000 33480.0n 0.20000 33659.9n 0.20000 33660.0n 0.20000 33839.9n 0.20000 33840.0n 0.20000 34019.9n 0.20000 34020.0n 0.20000 34199.9n 0.20000 34200.0n 0.20000 34379.9n 0.20000 34380.0n 0.20000 34559.9n 0.20000 34560.0n 0.20000 34739.9n 0.20000 34740.0n 0.20000 34919.9n 0.20000 34920.0n 0.20000 35099.9n 0.20000 35100.0n 0.20000 35279.9n 0.20000 35280.0n 0.20000 35459.9n 0.20000 35460.0n 0.20000 35639.9n 0.20000 35640.0n 0.20000 35819.9n 0.20000 35820.0n 0.20000 35999.9n 0.20000 36000.0n 0.20000 36179.9n 0.20000 36180.0n 0.20000 36359.9n 0.20000 36360.0n 0.20000 36539.9n 0.20000 36540.0n 0.20000 36719.9n 0.20000 36720.0n 0.20000 36899.9n 0.20000 36900.0n 0.20000 37079.9n 0.20000 37080.0n 0.20000 37259.9n 0.20000 37260.0n 0.20000 37439.9n 0.20000 37440.0n 0.20000 37619.9n 0.20000 37620.0n 0.20000 37799.9n 0.20000 37800.0n 0.20000 37979.9n 0.20000 37980.0n 0.20000 38159.9n 0.20000 38160.0n 0.20000 38339.9n 0.20000 38340.0n 0.20000 38519.9n 0.20000 38520.0n 0.20000 38699.9n 0.20000 38700.0n 0.20000 38879.9n 0.20000 38880.0n 0.20000 39059.9n 0.20000 39060.0n 0.20000 39239.9n 0.20000 39240.0n 0.20000 39419.9n 0.20000 39420.0n 0.20000 39599.9n 0.20000 39600.0n 0.20000 39779.9n 0.20000 39780.0n 0.20000 39959.9n 0.20000 39960.0n 0.20000 40139.9n 0.20000 40140.0n 0.20000 40319.9n 0.20000 40320.0n 0.20000 40499.9n 0.20000 40500.0n 0.20000 40679.9n 0.20000 40680.0n 0.20000 40859.9n 0.20000 40860.0n 0.20000 41039.9n 0.20000 41040.0n 0.20000 41219.9n 0.20000 41220.0n 0.20000 41399.9n 0.20000 41400.0n 0.20000 41579.9n 0.20000 41580.0n 0.20000 41759.9n 0.20000 41760.0n 0.20000 41939.9n 0.20000 41940.0n 0.20000 42119.9n 0.20000 42120.0n 0.20000 42299.9n 0.20000 42300.0n 0.20000 42479.9n 0.20000 42480.0n 0.20000 42659.9n 0.20000 42660.0n 0.20000 42839.9n 0.20000 42840.0n 0.20000 43019.9n 0.20000 43020.0n 0.20000 43199.9n 0.20000 43200.0n 0.20000 43379.9n 0.20000 43380.0n 0.20000 43559.9n 0.20000 43560.0n 0.20000 43739.9n 0.20000 43740.0n 0.20000 43919.9n 0.20000 43920.0n 0.20000 44099.9n 0.20000 44100.0n 0.20000 44279.9n 0.20000 44280.0n 0.20000 44459.9n 0.20000 44460.0n 0.20000 44639.9n 0.20000 44640.0n 0.20000 44819.9n 0.20000 44820.0n 0.20000 44999.9n 0.20000 45000.0n 0.20000 45179.9n 0.20000 45180.0n 0.20000 45359.9n 0.20000 45360.0n 0.20000 45539.9n 0.20000 45540.0n 0.20000 45719.9n 0.20000 45720.0n 0.20000 45899.9n 0.20000 45900.0n 0.20000 46079.9n 0.20000 46080.0n 0.20000 46259.9n 0.20000 46260.0n 0.20000 46439.9n 0.20000 46440.0n 0.20000 46619.9n 0.20000 46620.0n 0.20000 46799.9n 0.20000 46800.0n 0.20000 46979.9n 0.20000 46980.0n 0.20000 47159.9n 0.20000 47160.0n 0.20000 47339.9n 0.20000 47340.0n 0.20000 47519.9n 0.20000 47520.0n 0.20000 47699.9n 0.20000 47700.0n 0.20000 47879.9n 0.20000 47880.0n 0.20000 48059.9n 0.20000 48060.0n 0.20000 48239.9n 0.20000 48240.0n 0.20000 48419.9n 0.20000 48420.0n 0.20000 48599.9n 0.20000 48600.0n 0.20000 48779.9n 0.20000 48780.0n 0.20000 48959.9n 0.20000 48960.0n 0.20000 49139.9n 0.20000 49140.0n 0.20000 49319.9n 0.20000 49320.0n 0.20000 49499.9n 0.20000 49500.0n 0.20000 49679.9n 0.20000 49680.0n 0.20000 49859.9n 0.20000 49860.0n 0.20000 50039.9n 0.20000 50040.0n 0.20000 50219.9n 0.20000 50220.0n 0.20000 50399.9n 0.20000 50400.0n 0.20000 50579.9n 0.20000 50580.0n 0.20000 50759.9n 0.20000 50760.0n 0.20000 50939.9n 0.20000 50940.0n 0.20000 51119.9n 0.20000 51120.0n 0.20000 51299.9n 0.20000 51300.0n 0.20000 51479.9n 0.20000 51480.0n 0.20000 51659.9n 0.20000 51660.0n 0.20000 51839.9n 0.20000 51840.0n 0.20000 52019.9n 0.20000 52020.0n 0.20000 52199.9n 0.20000 52200.0n 0.20000 52379.9n 0.20000 52380.0n 0.20000 52559.9n 0.20000 52560.0n 0.20000 52739.9n 0.20000 52740.0n 0.20000 52919.9n 0.20000 52920.0n 0.20000 53099.9n 0.20000 53100.0n 0.20000 53279.9n 0.20000 53280.0n 0.20000 53459.9n 0.20000 53460.0n 0.20000 53639.9n 0.20000 53640.0n 0.20000 53819.9n 0.20000 53820.0n 0.20000 53999.9n 0.20000 54000.0n 0.20000 54179.9n 0.20000 54180.0n 0.20000 54359.9n 0.20000 54360.0n 0.20000 54539.9n 0.20000 54540.0n 0.20000 54719.9n 0.20000 54720.0n 0.20000 54899.9n 0.20000 54900.0n 0.20000 55079.9n 0.20000 55080.0n 0.20000 55259.9n 0.20000 55260.0n 0.20000 55439.9n 0.20000 55440.0n 0.20000 55619.9n 0.20000 55620.0n 0.20000 55799.9n 0.20000 55800.0n 0.20000 55979.9n 0.20000 55980.0n 0.20000 56159.9n 0.20000 56160.0n 0.20000 56339.9n 0.20000 56340.0n 0.20000 56519.9n 0.20000 56520.0n 0.20000 56699.9n 0.20000 56700.0n 0.20000 56879.9n 0.20000 56880.0n 0.20000 57059.9n 0.20000 57060.0n 0.20000 57239.9n 0.20000 57240.0n 0.20000 57419.9n 0.20000 57420.0n 0.20000 57599.9n 0.20000 57600.0n 0.20000 57779.9n 0.20000 57780.0n 0.20000 57959.9n 0.20000 57960.0n 0.20000 58139.9n 0.20000 58140.0n 0.20000 58319.9n 0.20000 58320.0n 0.20000 58499.9n 0.20000 58500.0n 0.20000 58679.9n 0.20000 58680.0n 0.20000 58859.9n 0.20000 58860.0n 0.20000 59039.9n 0.20000 59040.0n 0.20000 59219.9n 0.20000 59220.0n 0.20000 59399.9n 0.20000 59400.0n 0.20000 59579.9n 0.20000 59580.0n 0.20000 59759.9n 0.20000 59760.0n 0.20000 59939.9n 0.20000 59940.0n 0.20000 60119.9n 0.20000 60120.0n 0.20000 60299.9n 0.20000 60300.0n 0.20000 60479.9n 0.20000 60480.0n 0.20000 60659.9n 0.20000 60660.0n 0.20000 60839.9n 0.20000 60840.0n 0.20000 61019.9n 0.20000 61020.0n 0.20000 61199.9n 0.20000 61200.0n 0.20000 61379.9n 0.20000 61380.0n 0.20000 61559.9n 0.20000 61560.0n 0.20000 61739.9n 0.20000 61740.0n 0.20000 61919.9n 0.20000 61920.0n 0.20000 62099.9n 0.20000 62100.0n 0.20000 62279.9n 0.20000 62280.0n 0.20000 62459.9n 0.20000 62460.0n 0.20000 62639.9n 0.20000 62640.0n 0.20000 62819.9n 0.20000 62820.0n 0.20000 62999.9n 0.20000 63000.0n 0.20000 63179.9n 0.20000 63180.0n 0.20000 63359.9n 0.20000 63360.0n 0.20000 63539.9n 0.20000 63540.0n 0.20000 63719.9n 0.20000 63720.0n 0.20000 63899.9n 0.20000 63900.0n 0.20000 64079.9n 0.20000 64080.0n 0.20000 64259.9n 0.20000 64260.0n 0.20000 64439.9n 0.20000 64440.0n 0.20000 64619.9n 0.20000 64620.0n 0.20000 64799.9n 0.20000 64800.0n 0.20000 64979.9n 0.20000 64980.0n 0.20000 65159.9n 0.20000 65160.0n 0.20000 65339.9n 0.20000 65340.0n 0.20000 65519.9n 0.20000 65520.0n 0.20000 65699.9n 0.20000 65700.0n 0.20000 65879.9n 0.20000 65880.0n 0.20000 66059.9n 0.20000 66060.0n 0.20000 66239.9n 0.20000 66240.0n 0.20000 66419.9n 0.20000 66420.0n 0.20000 66599.9n 0.20000 66600.0n 0.20000 66779.9n 0.20000 66780.0n 0.20000 66959.9n 0.20000 66960.0n 0.20000 67139.9n 0.20000 67140.0n 0.20000 67319.9n 0.20000 67320.0n 0.20000 67499.9n 0.20000 67500.0n 0.20000 67679.9n 0.20000 67680.0n 0.20000 67859.9n 0.20000 67860.0n 0.20000 68039.9n 0.20000 68040.0n 0.20000 68219.9n 0.20000 68220.0n 0.20000 68399.9n 0.20000 68400.0n 0.20000 68579.9n 0.20000 68580.0n 0.20000 68759.9n 0.20000 68760.0n 0.20000 68939.9n 0.20000 68940.0n 0.20000 69119.9n 0.20000 69120.0n 0.20000 69299.9n 0.20000 69300.0n 0.20000 69479.9n 0.20000 69480.0n 0.20000 69659.9n 0.20000 69660.0n 0.20000 69839.9n 0.20000 69840.0n 0.20000 70019.9n 0.20000 70020.0n 0.20000 70199.9n 0.20000 70200.0n 0.20000 70379.9n 0.20000 70380.0n 0.20000 70559.9n 0.20000 70560.0n 0.20000 70739.9n 0.20000 70740.0n 0.20000 70919.9n 0.20000 70920.0n 0.20000 71099.9n 0.20000 71100.0n 0.20000 71279.9n 0.20000 71280.0n 0.20000 71459.9n 0.20000 71460.0n 0.20000 71639.9n 0.20000 71640.0n 0.20000 71819.9n 0.20000 71820.0n 0.20000 71999.9n 0.20000 72000.0n 0.20000 72179.9n 0.20000 72180.0n 0.20000 72359.9n 0.20000 72360.0n 0.20000 72539.9n 0.20000 72540.0n 0.20000 72719.9n 0.20000 72720.0n 0.20000 72899.9n 0.20000 72900.0n 0.20000 73079.9n 0.20000 73080.0n 0.20000 73259.9n 0.20000 73260.0n 0.20000 73439.9n 0.20000 73440.0n 0.20000 73619.9n 0.20000 73620.0n 0.20000 73799.9n 0.20000 73800.0n 0.20000 73979.9n 0.20000 73980.0n 0.20000 74159.9n 0.20000 74160.0n 0.20000 74339.9n 0.20000 74340.0n 0.20000 74519.9n 0.20000 74520.0n 0.20000 74699.9n 0.20000 74700.0n 0.20000 74879.9n 0.20000 74880.0n 0.20000 75059.9n 0.20000 75060.0n 0.20000 75239.9n 0.20000 75240.0n 0.20000 75419.9n 0.20000 75420.0n 0.20000 75599.9n 0.20000 75600.0n 0.20000 75779.9n 0.20000 75780.0n 0.20000 75959.9n 0.20000 75960.0n 0.20000 76139.9n 0.20000 76140.0n 0.20000 76319.9n 0.20000 76320.0n 0.20000 76499.9n 0.20000 76500.0n 0.20000 76679.9n 0.20000 76680.0n 0.20000 76859.9n 0.20000 76860.0n 0.20000 77039.9n 0.20000 77040.0n 0.20000 77219.9n 0.20000 77220.0n 0.20000 77399.9n 0.20000 77400.0n 0.20000 77579.9n 0.20000 77580.0n 0.20000 77759.9n 0.20000 77760.0n 0.20000 77939.9n 0.20000 77940.0n 0.20000 78119.9n 0.20000 78120.0n 0.20000 78299.9n 0.20000 78300.0n 0.20000 78479.9n 0.20000 78480.0n 0.20000 78659.9n 0.20000 78660.0n 0.20000 78839.9n 0.20000 78840.0n 0.20000 79019.9n 0.20000 79020.0n 0.20000 79199.9n 0.20000 79200.0n 0.20000 79379.9n 0.20000 79380.0n 0.20000 79559.9n 0.20000 79560.0n 0.20000 79739.9n 0.20000 79740.0n 0.20000 79919.9n 0.20000 79920.0n 0.20000 80099.9n 0.20000 80100.0n 0.20000 80279.9n 0.20000 80280.0n 0.20000 80459.9n 0.20000 80460.0n 0.20000 80639.9n 0.20000 80640.0n 0.20000 80819.9n 0.20000 80820.0n 0.20000 80999.9n 0.20000 81000.0n 0.20000 81179.9n 0.20000 81180.0n 0.20000 81359.9n 0.20000 81360.0n 0.20000 81539.9n 0.20000 81540.0n 0.20000 81719.9n 0.20000 81720.0n 0.20000 81899.9n 0.20000 81900.0n 0.20000 82079.9n 0.20000 82080.0n 0.20000 82259.9n 0.20000 82260.0n 0.20000 82439.9n 0.20000 82440.0n 0.20000 82619.9n 0.20000 82620.0n 0.20000 82799.9n 0.20000 82800.0n 0.20000 82979.9n 0.20000 82980.0n 0.20000 83159.9n 0.20000 83160.0n 0.20000 83339.9n 0.20000 83340.0n 0.20000 83519.9n 0.20000 83520.0n 0.20000 83699.9n 0.20000 83700.0n 0.20000 83879.9n 0.20000 83880.0n 0.20000 84059.9n 0.20000 84060.0n 0.20000 84239.9n 0.20000 84240.0n 0.20000 84419.9n 0.20000 84420.0n 0.20000 84599.9n 0.20000 84600.0n 0.20000 84779.9n 0.20000 84780.0n 0.20000 84959.9n 0.20000 84960.0n 0.20000 85139.9n 0.20000 85140.0n 0.20000 85319.9n 0.20000 85320.0n 0.20000 85499.9n 0.20000 85500.0n 0.20000 85679.9n 0.20000 85680.0n 0.20000 85859.9n 0.20000 85860.0n 0.20000 86039.9n 0.20000 86040.0n 0.20000 86219.9n 0.20000 86220.0n 0.20000 86399.9n 0.20000 86400.0n 0.20000 86579.9n 0.20000 86580.0n 0.20000 86759.9n 0.20000 86760.0n 0.20000 86939.9n 0.20000 86940.0n 0.20000 87119.9n 0.20000 87120.0n 0.20000 87299.9n 0.20000 87300.0n 0.20000 87479.9n 0.20000 87480.0n 0.20000 87659.9n 0.20000 87660.0n 0.20000 87839.9n 0.20000 87840.0n 0.20000 88019.9n 0.20000 88020.0n 0.20000 88199.9n 0.20000 88200.0n 0.20000 88379.9n 0.20000 88380.0n 0.20000 88559.9n 0.20000 88560.0n 0.20000 88739.9n 0.20000 88740.0n 0.20000 88919.9n 0.20000 88920.0n 0.20000 89099.9n 0.20000 89100.0n 0.20000 89279.9n 0.20000 89280.0n 0.20000 89459.9n 0.20000 89460.0n 0.20000 89639.9n 0.20000 89640.0n 0.20000 89819.9n 0.20000 89820.0n 0.20000 89999.9n 0.20000 90000.0n 0.20000 90179.9n 0.20000 90180.0n 0.20000 90359.9n 0.20000 90360.0n 0.20000 90539.9n 0.20000 90540.0n 0.20000 90719.9n 0.20000 90720.0n 0.20000 90899.9n 0.20000 90900.0n 0.20000 91079.9n 0.20000 91080.0n 0.20000 91259.9n 0.20000 91260.0n 0.20000 91439.9n 0.20000 91440.0n 0.20000 91619.9n 0.20000 91620.0n 0.20000 91799.9n 0.20000 91800.0n 0.20000 91979.9n 0.20000 91980.0n 0.20000 92159.9n 0.20000 92160.0n 0.20000 92339.9n 0.20000 92340.0n 0.20000 92519.9n 0.20000 92520.0n 0.20000 92699.9n 0.20000 92700.0n 0.20000 92879.9n 0.20000 92880.0n 0.20000 93059.9n 0.20000 93060.0n 0.20000 93239.9n 0.20000 93240.0n 0.20000 93419.9n 0.20000 93420.0n 0.20000 93599.9n 0.20000 93600.0n 0.20000 93779.9n 0.20000 93780.0n 0.20000 93959.9n 0.20000 93960.0n 0.20000 94139.9n 0.20000 94140.0n 0.20000 94319.9n 0.20000 94320.0n 0.20000 94499.9n 0.20000 94500.0n 0.20000 94679.9n 0.20000 94680.0n 0.20000 94859.9n 0.20000 94860.0n 0.20000 95039.9n 0.20000 95040.0n 0.20000 95219.9n 0.20000 95220.0n 0.20000 95399.9n 0.20000 95400.0n 0.20000 95579.9n 0.20000 95580.0n 0.20000 95759.9n 0.20000 95760.0n 0.20000 95939.9n 0.20000 95940.0n 0.20000 96119.9n 0.20000 96120.0n 0.20000 96299.9n 0.20000 96300.0n 0.20000 96479.9n 0.20000 96480.0n 0.20000 96659.9n 0.20000 96660.0n 0.20000 96839.9n 0.20000 96840.0n 0.20000 97019.9n 0.20000 97020.0n 0.20000 97199.9n 0.20000 97200.0n 0.20000 97379.9n 0.20000 97380.0n 0.20000 97559.9n 0.20000 97560.0n 0.20000 97739.9n 0.20000 97740.0n 0.20000 97919.9n 0.20000 97920.0n 0.20000 98099.9n 0.20000 98100.0n 0.20000 98279.9n 0.20000 98280.0n 0.20000 98459.9n 0.20000 98460.0n 0.20000 98639.9n 0.20000 98640.0n 0.20000 98819.9n 0.20000 98820.0n 0.20000 98999.9n 0.20000 99000.0n 0.20000 99179.9n 0.20000 99180.0n 0.20000 99359.9n 0.20000 99360.0n 0.20000 99539.9n 0.20000 99540.0n 0.20000 99719.9n 0.20000 99720.0n 0.20000 99899.9n 0.20000 99900.0n 0.20000 100079.9n 0.20000 100080.0n 0.20000 100259.9n 0.20000 100260.0n 0.20000 100439.9n 0.20000 100440.0n 0.20000 100619.9n 0.20000 100620.0n 0.20000 100799.9n 0.20000 100800.0n 0.20000 100979.9n 0.20000 100980.0n 0.20000 101159.9n 0.20000 101160.0n 0.20000 101339.9n 0.20000 101340.0n 0.20000 101519.9n 0.20000 101520.0n 0.20000 101699.9n 0.20000 101700.0n 0.20000 101879.9n 0.20000 101880.0n 0.20000 102059.9n 0.20000 102060.0n 0.20000 102239.9n 0.20000 102240.0n 0.20000 102419.9n 0.20000 102420.0n 0.20000 102599.9n 0.20000 102600.0n 0.20000 102779.9n 0.20000 102780.0n 0.20000 102959.9n 0.20000 102960.0n 0.20000 103139.9n 0.20000 103140.0n 0.20000 103319.9n 0.20000 103320.0n 0.20000 103499.9n 0.20000 103500.0n 0.20000 103679.9n 0.20000 103680.0n 0.20000 103859.9n 0.20000 103860.0n 0.20000 104039.9n 0.20000 104040.0n 0.20000 104219.9n 0.20000 104220.0n 0.20000 104399.9n 0.20000 104400.0n 0.20000 104579.9n 0.20000 104580.0n 0.20000 104759.9n 0.20000 104760.0n 0.20000 104939.9n 0.20000 104940.0n 0.20000 105119.9n 0.20000 105120.0n 0.20000 105299.9n 0.20000 105300.0n 0.20000 105479.9n 0.20000 105480.0n 0.20000 105659.9n 0.20000 105660.0n 0.20000 105839.9n 0.20000 105840.0n 0.20000 106019.9n 0.20000 106020.0n 0.20000 106199.9n 0.20000 106200.0n 0.20000 106379.9n 0.20000 106380.0n 0.20000 106559.9n 0.20000 106560.0n 0.20000 106739.9n 0.20000 106740.0n 0.20000 106919.9n 0.20000 106920.0n 0.20000 107099.9n 0.20000 107100.0n 0.20000 107279.9n 0.20000 107280.0n 0.20000 107459.9n 0.20000 107460.0n 0.20000 107639.9n 0.20000 107640.0n 0.20000 107819.9n 0.20000 107820.0n 0.20000 107999.9n 0.20000 108000.0n 0.20000 108179.9n 0.20000 108180.0n 0.20000 108359.9n 0.20000 108360.0n 0.20000 108539.9n 0.20000 108540.0n 0.20000 108719.9n 0.20000 108720.0n 0.20000 108899.9n 0.20000 108900.0n 0.20000 109079.9n 0.20000 109080.0n 0.20000 109259.9n 0.20000 109260.0n 0.20000 109439.9n 0.20000 109440.0n 0.20000 109619.9n 0.20000 109620.0n 0.20000 109799.9n 0.20000 109800.0n 0.20000 109979.9n 0.20000 109980.0n 0.20000 110159.9n 0.20000 110160.0n 0.20000 110339.9n 0.20000 110340.0n 0.20000 110519.9n 0.20000 110520.0n 0.20000 110699.9n 0.20000 110700.0n 0.20000 110879.9n 0.20000 110880.0n 0.20000 111059.9n 0.20000 111060.0n 0.20000 111239.9n 0.20000 111240.0n 0.20000 111419.9n 0.20000 111420.0n 0.20000 111599.9n 0.20000 111600.0n 0.20000 111779.9n 0.20000 111780.0n 0.20000 111959.9n 0.20000 111960.0n 0.20000 112139.9n 0.20000 112140.0n 0.20000 112319.9n 0.20000 112320.0n 0.20000 112499.9n 0.20000 112500.0n 0.20000 112679.9n 0.20000 112680.0n 0.20000 112859.9n 0.20000 112860.0n 0.20000 113039.9n 0.20000 113040.0n 0.20000 113219.9n 0.20000 113220.0n 0.20000 113399.9n 0.20000 113400.0n 0.20000 113579.9n 0.20000 113580.0n 0.20000 113759.9n 0.20000 113760.0n 0.20000 113939.9n 0.20000 113940.0n 0.20000 114119.9n 0.20000 114120.0n 0.20000 114299.9n 0.20000 114300.0n 0.20000 114479.9n 0.20000 114480.0n 0.20000 114659.9n 0.20000 114660.0n 0.20000 114839.9n 0.20000 114840.0n 0.20000 115019.9n 0.20000 115020.0n 0.20000 115199.9n 0.20000 115200.0n 0.20000 115379.9n 0.20000 115380.0n 0.20000 115559.9n 0.20000 115560.0n 0.20000 115739.9n 0.20000 115740.0n 0.20000 115919.9n 0.20000 115920.0n 0.20000 116099.9n 0.20000 116100.0n 0.20000 116279.9n 0.20000 116280.0n 0.20000 116459.9n 0.20000 116460.0n 0.20000 116639.9n 0.20000 116640.0n 0.20000 116819.9n 0.20000 116820.0n 0.20000 116999.9n 0.20000 117000.0n 0.20000 117179.9n 0.20000 117180.0n 0.20000 117359.9n 0.20000 117360.0n 0.20000 117539.9n 0.20000 117540.0n 0.20000 117719.9n 0.20000 117720.0n 0.20000 117899.9n 0.20000 117900.0n 0.20000 118079.9n 0.20000 118080.0n 0.20000 118259.9n 0.20000 118260.0n 0.20000 118439.9n 0.20000 118440.0n 0.20000 118619.9n 0.20000 118620.0n 0.20000 118799.9n 0.20000 118800.0n 0.20000 118979.9n 0.20000 118980.0n 0.20000 119159.9n 0.20000 119160.0n 0.20000 119339.9n 0.20000 119340.0n 0.20000 119519.9n 0.20000 119520.0n 0.20000 119699.9n 0.20000 119700.0n 0.20000 119879.9n 0.20000 119880.0n 0.20000 120059.9n 0.20000 120060.0n 0.20000 120239.9n 0.20000 120240.0n 0.20000 120419.9n 0.20000 120420.0n 0.20000 120599.9n 0.20000 120600.0n 0.20000 120779.9n 0.20000 120780.0n 0.20000 120959.9n 0.20000 120960.0n 0.20000 121139.9n 0.20000 121140.0n 0.20000 121319.9n 0.20000 121320.0n 0.20000 121499.9n 0.20000 121500.0n 0.20000 121679.9n 0.20000 121680.0n 0.20000 121859.9n 0.20000 121860.0n 0.20000 122039.9n 0.20000 122040.0n 0.20000 122219.9n 0.20000 122220.0n 0.20000 122399.9n 0.20000 122400.0n 0.20000 122579.9n 0.20000 122580.0n 0.20000 122759.9n 0.20000 122760.0n 0.20000 122939.9n 0.20000 122940.0n 0.20000 123119.9n 0.20000 123120.0n 0.20000 123299.9n 0.20000 123300.0n 0.20000 123479.9n 0.20000 123480.0n 0.20000 123659.9n 0.20000 123660.0n 0.20000 123839.9n 0.20000 123840.0n 0.20000 124019.9n 0.20000 124020.0n 0.20000 124199.9n 0.20000 124200.0n 0.20000 124379.9n 0.20000 124380.0n 0.20000 124559.9n 0.20000 124560.0n 0.20000 124739.9n 0.20000 124740.0n 0.20000 124919.9n 0.20000 124920.0n 0.20000 125099.9n 0.20000 125100.0n 0.20000 125279.9n 0.20000 125280.0n 0.20000 125459.9n 0.20000 125460.0n 0.20000 125639.9n 0.20000 125640.0n 0.20000 125819.9n 0.20000 125820.0n 0.20000 125999.9n 0.20000 126000.0n 0.20000 126179.9n 0.20000 126180.0n 0.20000 126359.9n 0.20000 126360.0n 0.20000 126539.9n 0.20000 126540.0n 0.20000 126719.9n 0.20000 126720.0n 0.20000 126899.9n 0.20000 126900.0n 0.20000 127079.9n 0.20000 127080.0n 0.20000 127259.9n 0.20000 127260.0n 0.20000 127439.9n 0.20000 127440.0n 0.20000 127619.9n 0.20000 127620.0n 0.20000 127799.9n 0.20000 127800.0n 0.20000 127979.9n 0.20000 127980.0n 0.20000 128159.9n 0.20000 128160.0n 0.20000 128339.9n 0.20000 128340.0n 0.20000 128519.9n 0.20000 128520.0n 0.20000 128699.9n 0.20000 128700.0n 0.20000 128879.9n 0.20000 128880.0n 0.20000 129059.9n 0.20000 129060.0n 0.20000 129239.9n 0.20000 129240.0n 0.20000 129419.9n 0.20000 129420.0n 0.20000 129599.9n 0.20000 129600.0n 0.20000 129779.9n 0.20000 129780.0n 0.20000 129959.9n 0.20000 129960.0n 0.20000 130139.9n 0.20000 130140.0n 0.20000 130319.9n 0.20000 130320.0n 0.20000 130499.9n 0.20000 130500.0n 0.20000 130679.9n 0.20000 130680.0n 0.20000 130859.9n 0.20000 130860.0n 0.20000 131039.9n 0.20000 131040.0n 0.20000 131219.9n 0.20000 131220.0n 0.20000 131399.9n 0.20000 131400.0n 0.20000 131579.9n 0.20000 131580.0n 0.20000 131759.9n 0.20000 131760.0n 0.20000 131939.9n 0.20000 131940.0n 0.20000 132119.9n 0.20000 132120.0n 0.20000 132299.9n 0.20000 132300.0n 0.20000 132479.9n 0.20000 132480.0n 0.20000 132659.9n 0.20000 132660.0n 0.20000 132839.9n 0.20000 132840.0n 0.20000 133019.9n 0.20000 133020.0n 0.20000 133199.9n 0.20000 133200.0n 0.20000 133379.9n 0.20000 133380.0n 0.20000 133559.9n 0.20000 133560.0n 0.20000 133739.9n 0.20000 133740.0n 0.20000 133919.9n 0.20000 133920.0n 0.20000 134099.9n 0.20000 134100.0n 0.20000 134279.9n 0.20000 134280.0n 0.20000 134459.9n 0.20000 134460.0n 0.20000 134639.9n 0.20000 134640.0n 0.20000 134819.9n 0.20000 134820.0n 0.20000 134999.9n 0.20000 135000.0n 0.20000 135179.9n 0.20000 135180.0n 0.20000 135359.9n 0.20000 135360.0n 0.20000 135539.9n 0.20000 135540.0n 0.20000 135719.9n 0.20000 135720.0n 0.20000 135899.9n 0.20000 135900.0n 0.20000 136079.9n 0.20000 136080.0n 0.20000 136259.9n 0.20000 136260.0n 0.20000 136439.9n 0.20000 136440.0n 0.20000 136619.9n 0.20000 136620.0n 0.20000 136799.9n 0.20000 136800.0n 0.20000 136979.9n 0.20000 136980.0n 0.20000 137159.9n 0.20000 137160.0n 0.20000 137339.9n 0.20000 137340.0n 0.20000 137519.9n 0.20000 137520.0n 0.20000 137699.9n 0.20000 137700.0n 0.20000 137879.9n 0.20000 137880.0n 0.20000 138059.9n 0.20000 138060.0n 0.20000 138239.9n 0.20000 138240.0n 0.20000 138419.9n 0.20000 138420.0n 0.20000 138599.9n 0.20000 138600.0n 0.20000 138779.9n 0.20000 138780.0n 0.20000 138959.9n 0.20000 138960.0n 0.20000 139139.9n 0.20000 139140.0n 0.20000 139319.9n 0.20000 139320.0n 0.20000 139499.9n 0.20000 139500.0n 0.20000 139679.9n 0.20000 139680.0n 0.20000 139859.9n 0.20000 139860.0n 0.20000 140039.9n 0.20000 140040.0n 0.20000 140219.9n 0.20000 140220.0n 0.20000 140399.9n 0.20000 140400.0n 0.20000 140579.9n 0.20000 140580.0n 0.20000 140759.9n 0.20000 140760.0n 0.20000 140939.9n 0.20000 140940.0n 0.20000 141119.9n 0.20000 141120.0n 0.20000 141299.9n 0.20000 141300.0n 0.20000 141479.9n 0.20000 141480.0n 0.20000 141659.9n 0.20000 141660.0n 0.20000 141839.9n 0.20000 141840.0n 0.20000 142019.9n 0.20000 142020.0n 0.20000 142199.9n 0.20000 142200.0n 0.20000 142379.9n 0.20000 142380.0n 0.20000 142559.9n 0.20000 142560.0n 0.20000 142739.9n 0.20000 142740.0n 0.20000 142919.9n 0.20000 142920.0n 0.20000 143099.9n 0.20000 143100.0n 0.20000 143279.9n 0.20000 143280.0n 0.20000 143459.9n 0.20000 143460.0n 0.20000 143639.9n 0.20000 143640.0n 0.20000 143819.9n 0.20000 143820.0n 0.20000 143999.9n 0.20000 144000.0n 0.20000 144179.9n 0.20000 144180.0n 0.20000 144359.9n 0.20000 144360.0n 0.20000 144539.9n 0.20000 144540.0n 0.20000 144719.9n 0.20000 144720.0n 0.20000 144899.9n 0.20000 144900.0n 0.20000 145079.9n 0.20000 145080.0n 0.20000 145259.9n 0.20000 145260.0n 0.20000 145439.9n 0.20000 145440.0n 0.20000 145619.9n 0.20000 145620.0n 0.20000 145799.9n 0.20000 145800.0n 0.20000 145979.9n 0.20000 145980.0n 0.20000 146159.9n 0.20000 146160.0n 0.20000 146339.9n 0.20000 146340.0n 0.20000 146519.9n 0.20000 146520.0n 0.20000 146699.9n 0.20000 146700.0n 0.20000 146879.9n 0.20000 146880.0n 0.20000 147059.9n 0.20000 147060.0n 0.20000 147239.9n 0.20000 147240.0n 0.20000 147419.9n 0.20000 147420.0n 0.20000 147599.9n 0.20000 147600.0n 0.20000 147779.9n 0.20000 147780.0n 0.20000 147959.9n 0.20000 147960.0n 0.20000 148139.9n 0.20000 148140.0n 0.20000 148319.9n 0.20000 148320.0n 0.20000 148499.9n 0.20000 148500.0n 0.20000 148679.9n 0.20000 148680.0n 0.20000 148859.9n 0.20000 148860.0n 0.20000 149039.9n 0.20000 149040.0n 0.20000 149219.9n 0.20000 149220.0n 0.20000 149399.9n 0.20000 149400.0n 0.20000 149579.9n 0.20000 149580.0n 0.20000 149759.9n 0.20000 149760.0n 0.20000 149939.9n 0.20000 149940.0n 0.20000 150119.9n 0.20000 150120.0n 0.20000 150299.9n 0.20000 150300.0n 0.20000 150479.9n 0.20000 150480.0n 0.20000 150659.9n 0.20000 150660.0n 0.20000 150839.9n 0.20000 150840.0n 0.20000 151019.9n 0.20000 151020.0n 0.20000 151199.9n 0.20000 151200.0n 0.20000 151379.9n 0.20000 151380.0n 0.20000 151559.9n 0.20000 151560.0n 0.20000 151739.9n 0.20000 151740.0n 0.20000 151919.9n 0.20000 151920.0n 0.20000 152099.9n 0.20000 152100.0n 0.20000 152279.9n 0.20000 152280.0n 0.20000 152459.9n 0.20000 152460.0n 0.20000 152639.9n 0.20000 152640.0n 0.20000 152819.9n 0.20000 152820.0n 0.20000 152999.9n 0.20000 153000.0n 0.20000 153179.9n 0.20000 153180.0n 0.20000 153359.9n 0.20000 153360.0n 0.20000 153539.9n 0.20000 153540.0n 0.20000 153719.9n 0.20000 153720.0n 0.20000 153899.9n 0.20000 153900.0n 0.20000 154079.9n 0.20000 154080.0n 0.20000 154259.9n 0.20000 154260.0n 0.20000 154439.9n 0.20000 154440.0n 0.20000 154619.9n 0.20000 154620.0n 0.20000 154799.9n 0.20000 154800.0n 0.20000 154979.9n 0.20000 154980.0n 0.20000 155159.9n 0.20000 155160.0n 0.20000 155339.9n 0.20000 155340.0n 0.20000 155519.9n 0.20000 155520.0n 0.20000 155699.9n 0.20000 155700.0n 0.20000 155879.9n 0.20000 155880.0n 0.20000 156059.9n 0.20000 156060.0n 0.20000 156239.9n 0.20000 156240.0n 0.20000 156419.9n 0.20000 156420.0n 0.20000 156599.9n 0.20000 156600.0n 0.20000 156779.9n 0.20000 156780.0n 0.20000 156959.9n 0.20000 156960.0n 0.20000 157139.9n 0.20000 157140.0n 0.20000 157319.9n 0.20000 157320.0n 0.20000 157499.9n 0.20000 157500.0n 0.20000 157679.9n 0.20000 157680.0n 0.20000 157859.9n 0.20000 157860.0n 0.20000 158039.9n 0.20000 158040.0n 0.20000 158219.9n 0.20000 158220.0n 0.20000 158399.9n 0.20000 158400.0n 0.20000 158579.9n 0.20000 158580.0n 0.20000 158759.9n 0.20000 158760.0n 0.20000 158939.9n 0.20000 158940.0n 0.20000 159119.9n 0.20000 159120.0n 0.20000 159299.9n 0.20000 159300.0n 0.20000 159479.9n 0.20000 159480.0n 0.20000 159659.9n 0.20000 159660.0n 0.20000 159839.9n 0.20000 159840.0n 0.20000 160019.9n 0.20000 160020.0n 0.20000 160199.9n 0.20000 160200.0n 0.20000 160379.9n 0.20000 160380.0n 0.20000 160559.9n 0.20000 160560.0n 0.20000 160739.9n 0.20000 160740.0n 0.20000 160919.9n 0.20000 160920.0n 0.20000 161099.9n 0.20000 161100.0n 0.20000 161279.9n 0.20000 161280.0n 0.20000 161459.9n 0.20000 161460.0n 0.20000 161639.9n 0.20000 161640.0n 0.20000 161819.9n 0.20000 161820.0n 0.20000 161999.9n 0.20000 162000.0n 0.20000 162179.9n 0.20000 162180.0n 0.20000 162359.9n 0.20000 162360.0n 0.20000 162539.9n 0.20000 162540.0n 0.20000 162719.9n 0.20000 162720.0n 0.20000 162899.9n 0.20000 162900.0n 0.20000 163079.9n 0.20000 163080.0n 0.20000 163259.9n 0.20000 163260.0n 0.20000 163439.9n 0.20000 163440.0n 0.20000 163619.9n 0.20000 163620.0n 0.20000 163799.9n 0.20000 163800.0n 0.20000 163979.9n 0.20000 163980.0n 0.20000 164159.9n 0.20000 164160.0n 0.20000 164339.9n 0.20000 164340.0n 0.20000 164519.9n 0.20000 164520.0n 0.20000 164699.9n 0.20000 164700.0n 0.20000 164879.9n 0.20000 164880.0n 0.20000 165059.9n 0.20000 165060.0n 0.20000 165239.9n 0.20000 165240.0n 0.20000 165419.9n 0.20000 165420.0n 0.20000 165599.9n 0.20000 165600.0n 0.20000 165779.9n 0.20000 165780.0n 0.20000 165959.9n 0.20000 165960.0n 0.20000 166139.9n 0.20000 166140.0n 0.20000 166319.9n 0.20000 166320.0n 0.20000 166499.9n 0.20000 166500.0n 0.20000 166679.9n 0.20000 166680.0n 0.20000 166859.9n 0.20000 166860.0n 0.20000 167039.9n 0.20000 167040.0n 0.20000 167219.9n 0.20000 167220.0n 0.20000 167399.9n 0.20000 167400.0n 0.20000 167579.9n 0.20000 167580.0n 0.20000 167759.9n 0.20000 167760.0n 0.20000 167939.9n 0.20000 167940.0n 0.20000 168119.9n 0.20000 168120.0n 0.20000 168299.9n 0.20000 168300.0n 0.20000 168479.9n 0.20000 168480.0n 0.20000 168659.9n 0.20000 168660.0n 0.20000 168839.9n 0.20000 168840.0n 0.20000 169019.9n 0.20000 169020.0n 0.20000 169199.9n 0.20000 169200.0n 0.20000 169379.9n 0.20000 169380.0n 0.20000 169559.9n 0.20000 169560.0n 0.20000 169739.9n 0.20000 169740.0n 0.20000 169919.9n 0.20000 169920.0n 0.20000 170099.9n 0.20000 170100.0n 0.20000 170279.9n 0.20000 170280.0n 0.20000 170459.9n 0.20000 170460.0n 0.20000 170639.9n 0.20000 170640.0n 0.20000 170819.9n 0.20000 170820.0n 0.20000 170999.9n 0.20000 171000.0n 0.20000 171179.9n 0.20000 171180.0n 0.20000 171359.9n 0.20000 171360.0n 0.20000 171539.9n 0.20000 171540.0n 0.20000 171719.9n 0.20000 171720.0n 0.20000 171899.9n 0.20000 171900.0n 0.20000 172079.9n 0.20000 172080.0n 0.20000 172259.9n 0.20000 172260.0n 0.20000 172439.9n 0.20000 172440.0n 0.20000 172619.9n 0.20000 172620.0n 0.20000 172799.9n 0.20000 172800.0n 0.20000 172979.9n 0.20000 172980.0n 0.20000 173159.9n 0.20000 173160.0n 0.20000 173339.9n 0.20000 173340.0n 0.20000 173519.9n 0.20000 173520.0n 0.20000 173699.9n 0.20000 173700.0n 0.20000 173879.9n 0.20000 173880.0n 0.20000 174059.9n 0.20000 174060.0n 0.20000 174239.9n 0.20000 174240.0n 0.20000 174419.9n 0.20000 174420.0n 0.20000 174599.9n 0.20000 174600.0n 0.20000 174779.9n 0.20000 174780.0n 0.20000 174959.9n 0.20000 174960.0n 0.20000 175139.9n 0.20000 175140.0n 0.20000 175319.9n 0.20000 175320.0n 0.20000 175499.9n 0.20000 175500.0n 0.20000 175679.9n 0.20000 175680.0n 0.20000 175859.9n 0.20000 175860.0n 0.20000 176039.9n 0.20000 176040.0n 0.20000 176219.9n 0.20000 176220.0n 0.20000 176399.9n 0.20000 176400.0n 0.20000 176579.9n 0.20000 176580.0n 0.20000 176759.9n 0.20000 176760.0n 0.20000 176939.9n 0.20000 176940.0n 0.20000 177119.9n 0.20000 177120.0n 0.20000 177299.9n 0.20000 177300.0n 0.20000 177479.9n 0.20000 177480.0n 0.20000 177659.9n 0.20000 177660.0n 0.20000 177839.9n 0.20000 177840.0n 0.20000 178019.9n 0.20000 178020.0n 0.20000 178199.9n 0.20000 178200.0n 0.20000 178379.9n 0.20000 178380.0n 0.20000 178559.9n 0.20000 178560.0n 0.20000 178739.9n 0.20000 178740.0n 0.20000 178919.9n 0.20000 178920.0n 0.20000 179099.9n 0.20000 179100.0n 0.20000 179279.9n 0.20000 179280.0n 0.20000 179459.9n 0.20000 179460.0n 0.20000 179639.9n 0.20000 179640.0n 0.20000 179819.9n 0.20000 179820.0n 0.20000 179999.9n 0.20000 180000.0n 0.20000 180179.9n 0.20000 180180.0n 0.20000 180359.9n 0.20000 180360.0n 0.20000 180539.9n 0.20000 180540.0n 0.20000 180719.9n 0.20000 180720.0n 0.20000 180899.9n 0.20000 180900.0n 0.20000 181079.9n 0.20000 181080.0n 0.20000 181259.9n 0.20000 181260.0n 0.20000 181439.9n 0.20000 181440.0n 0.20000 181619.9n 0.20000 181620.0n 0.20000 181799.9n 0.20000 181800.0n 0.20000 181979.9n 0.20000 181980.0n 0.20000 182159.9n 0.20000 182160.0n 0.20000 182339.9n 0.20000 182340.0n 0.20000 182519.9n 0.20000 182520.0n 0.20000 182699.9n 0.20000 182700.0n 0.20000 182879.9n 0.20000 182880.0n 0.20000 183059.9n 0.20000 183060.0n 0.20000 183239.9n 0.20000 183240.0n 0.20000 183419.9n 0.20000 183420.0n 0.20000)
Vxop0 xop0 0 PWL(0.0n 0.70000 179.9n 0.70000 180.0n 0.30000 359.9n 0.30000 360.0n 0.70000 539.9n 0.70000 540.0n 0.70000 719.9n 0.70000 720.0n 0.70000 899.9n 0.70000 900.0n 0.30000 1079.9n 0.30000 1080.0n 0.30000 1259.9n 0.30000 1260.0n 0.30000 1439.9n 0.30000 1440.0n 0.70000 1619.9n 0.70000 1620.0n 0.30000 1799.9n 0.30000 1800.0n 0.30000 1979.9n 0.30000 1980.0n 0.70000 2159.9n 0.70000 2160.0n 0.30000 2339.9n 0.30000 2340.0n 0.30000 2519.9n 0.30000 2520.0n 0.70000 2699.9n 0.70000 2700.0n 0.70000 2879.9n 0.70000 2880.0n 0.30000 3059.9n 0.30000 3060.0n 0.30000 3239.9n 0.30000 3240.0n 0.30000 3419.9n 0.30000 3420.0n 0.70000 3599.9n 0.70000 3600.0n 0.30000 3779.9n 0.30000 3780.0n 0.70000 3959.9n 0.70000 3960.0n 0.30000 4139.9n 0.30000 4140.0n 0.30000 4319.9n 0.30000 4320.0n 0.70000 4499.9n 0.70000 4500.0n 0.30000 4679.9n 0.30000 4680.0n 0.70000 4859.9n 0.70000 4860.0n 0.70000 5039.9n 0.70000 5040.0n 0.70000 5219.9n 0.70000 5220.0n 0.70000 5399.9n 0.70000 5400.0n 0.70000 5579.9n 0.70000 5580.0n 0.30000 5759.9n 0.30000 5760.0n 0.70000 5939.9n 0.70000 5940.0n 0.30000 6119.9n 0.30000 6120.0n 0.70000 6299.9n 0.70000 6300.0n 0.70000 6479.9n 0.70000 6480.0n 0.30000 6659.9n 0.30000 6660.0n 0.30000 6839.9n 0.30000 6840.0n 0.30000 7019.9n 0.30000 7020.0n 0.30000 7199.9n 0.30000 7200.0n 0.30000 7379.9n 0.30000 7380.0n 0.30000 7559.9n 0.30000 7560.0n 0.30000 7739.9n 0.30000 7740.0n 0.70000 7919.9n 0.70000 7920.0n 0.70000 8099.9n 0.70000 8100.0n 0.70000 8279.9n 0.70000 8280.0n 0.30000 8459.9n 0.30000 8460.0n 0.70000 8639.9n 0.70000 8640.0n 0.70000 8819.9n 0.70000 8820.0n 0.70000 8999.9n 0.70000 9000.0n 0.70000 9179.9n 0.70000 9180.0n 0.70000 9359.9n 0.70000 9360.0n 0.30000 9539.9n 0.30000 9540.0n 0.30000 9719.9n 0.30000 9720.0n 0.70000 9899.9n 0.70000 9900.0n 0.30000 10079.9n 0.30000 10080.0n 0.70000 10259.9n 0.70000 10260.0n 0.30000 10439.9n 0.30000 10440.0n 0.70000 10619.9n 0.70000 10620.0n 0.30000 10799.9n 0.30000 10800.0n 0.30000 10979.9n 0.30000 10980.0n 0.70000 11159.9n 0.70000 11160.0n 0.30000 11339.9n 0.30000 11340.0n 0.70000 11519.9n 0.70000 11520.0n 0.70000 11699.9n 0.70000 11700.0n 0.30000 11879.9n 0.30000 11880.0n 0.70000 12059.9n 0.70000 12060.0n 0.70000 12239.9n 0.70000 12240.0n 0.70000 12419.9n 0.70000 12420.0n 0.70000 12599.9n 0.70000 12600.0n 0.30000 12779.9n 0.30000 12780.0n 0.30000 12959.9n 0.30000 12960.0n 0.30000 13139.9n 0.30000 13140.0n 0.30000 13319.9n 0.30000 13320.0n 0.30000 13499.9n 0.30000 13500.0n 0.30000 13679.9n 0.30000 13680.0n 0.30000 13859.9n 0.30000 13860.0n 0.70000 14039.9n 0.70000 14040.0n 0.70000 14219.9n 0.70000 14220.0n 0.70000 14399.9n 0.70000 14400.0n 0.70000 14579.9n 0.70000 14580.0n 0.70000 14759.9n 0.70000 14760.0n 0.30000 14939.9n 0.30000 14940.0n 0.30000 15119.9n 0.30000 15120.0n 0.70000 15299.9n 0.70000 15300.0n 0.30000 15479.9n 0.30000 15480.0n 0.30000 15659.9n 0.30000 15660.0n 0.70000 15839.9n 0.70000 15840.0n 0.30000 16019.9n 0.30000 16020.0n 0.30000 16199.9n 0.30000 16200.0n 0.70000 16379.9n 0.70000 16380.0n 0.70000 16559.9n 0.70000 16560.0n 0.30000 16739.9n 0.30000 16740.0n 0.70000 16919.9n 0.70000 16920.0n 0.70000 17099.9n 0.70000 17100.0n 0.30000 17279.9n 0.30000 17280.0n 0.70000 17459.9n 0.70000 17460.0n 0.70000 17639.9n 0.70000 17640.0n 0.30000 17819.9n 0.30000 17820.0n 0.70000 17999.9n 0.70000 18000.0n 0.30000 18179.9n 0.30000 18180.0n 0.30000 18359.9n 0.30000 18360.0n 0.70000 18539.9n 0.70000 18540.0n 0.30000 18719.9n 0.30000 18720.0n 0.30000 18899.9n 0.30000 18900.0n 0.30000 19079.9n 0.30000 19080.0n 0.30000 19259.9n 0.30000 19260.0n 0.70000 19439.9n 0.70000 19440.0n 0.30000 19619.9n 0.30000 19620.0n 0.70000 19799.9n 0.70000 19800.0n 0.30000 19979.9n 0.30000 19980.0n 0.30000 20159.9n 0.30000 20160.0n 0.70000 20339.9n 0.70000 20340.0n 0.70000 20519.9n 0.70000 20520.0n 0.30000 20699.9n 0.30000 20700.0n 0.70000 20879.9n 0.70000 20880.0n 0.30000 21059.9n 0.30000 21060.0n 0.70000 21239.9n 0.70000 21240.0n 0.30000 21419.9n 0.30000 21420.0n 0.70000 21599.9n 0.70000 21600.0n 0.70000 21779.9n 0.70000 21780.0n 0.70000 21959.9n 0.70000 21960.0n 0.30000 22139.9n 0.30000 22140.0n 0.70000 22319.9n 0.70000 22320.0n 0.30000 22499.9n 0.30000 22500.0n 0.70000 22679.9n 0.70000 22680.0n 0.70000 22859.9n 0.70000 22860.0n 0.30000 23039.9n 0.30000 23040.0n 0.30000 23219.9n 0.30000 23220.0n 0.70000 23399.9n 0.70000 23400.0n 0.30000 23579.9n 0.30000 23580.0n 0.30000 23759.9n 0.30000 23760.0n 0.70000 23939.9n 0.70000 23940.0n 0.30000 24119.9n 0.30000 24120.0n 0.30000 24299.9n 0.30000 24300.0n 0.70000 24479.9n 0.70000 24480.0n 0.70000 24659.9n 0.70000 24660.0n 0.70000 24839.9n 0.70000 24840.0n 0.30000 25019.9n 0.30000 25020.0n 0.30000 25199.9n 0.30000 25200.0n 0.70000 25379.9n 0.70000 25380.0n 0.70000 25559.9n 0.70000 25560.0n 0.70000 25739.9n 0.70000 25740.0n 0.30000 25919.9n 0.30000 25920.0n 0.70000 26099.9n 0.70000 26100.0n 0.30000 26279.9n 0.30000 26280.0n 0.30000 26459.9n 0.30000 26460.0n 0.70000 26639.9n 0.70000 26640.0n 0.30000 26819.9n 0.30000 26820.0n 0.30000 26999.9n 0.30000 27000.0n 0.70000 27179.9n 0.70000 27180.0n 0.70000 27359.9n 0.70000 27360.0n 0.70000 27539.9n 0.70000 27540.0n 0.30000 27719.9n 0.30000 27720.0n 0.30000 27899.9n 0.30000 27900.0n 0.70000 28079.9n 0.70000 28080.0n 0.30000 28259.9n 0.30000 28260.0n 0.30000 28439.9n 0.30000 28440.0n 0.70000 28619.9n 0.70000 28620.0n 0.70000 28799.9n 0.70000 28800.0n 0.70000 28979.9n 0.70000 28980.0n 0.70000 29159.9n 0.70000 29160.0n 0.30000 29339.9n 0.30000 29340.0n 0.30000 29519.9n 0.30000 29520.0n 0.30000 29699.9n 0.30000 29700.0n 0.70000 29879.9n 0.70000 29880.0n 0.70000 30059.9n 0.70000 30060.0n 0.70000 30239.9n 0.70000 30240.0n 0.30000 30419.9n 0.30000 30420.0n 0.30000 30599.9n 0.30000 30600.0n 0.70000 30779.9n 0.70000 30780.0n 0.70000 30959.9n 0.70000 30960.0n 0.30000 31139.9n 0.30000 31140.0n 0.70000 31319.9n 0.70000 31320.0n 0.30000 31499.9n 0.30000 31500.0n 0.70000 31679.9n 0.70000 31680.0n 0.70000 31859.9n 0.70000 31860.0n 0.70000 32039.9n 0.70000 32040.0n 0.30000 32219.9n 0.30000 32220.0n 0.30000 32399.9n 0.30000 32400.0n 0.70000 32579.9n 0.70000 32580.0n 0.70000 32759.9n 0.70000 32760.0n 0.30000 32939.9n 0.30000 32940.0n 0.30000 33119.9n 0.30000 33120.0n 0.30000 33299.9n 0.30000 33300.0n 0.30000 33479.9n 0.30000 33480.0n 0.70000 33659.9n 0.70000 33660.0n 0.30000 33839.9n 0.30000 33840.0n 0.30000 34019.9n 0.30000 34020.0n 0.30000 34199.9n 0.30000 34200.0n 0.70000 34379.9n 0.70000 34380.0n 0.70000 34559.9n 0.70000 34560.0n 0.70000 34739.9n 0.70000 34740.0n 0.70000 34919.9n 0.70000 34920.0n 0.70000 35099.9n 0.70000 35100.0n 0.30000 35279.9n 0.30000 35280.0n 0.30000 35459.9n 0.30000 35460.0n 0.70000 35639.9n 0.70000 35640.0n 0.30000 35819.9n 0.30000 35820.0n 0.30000 35999.9n 0.30000 36000.0n 0.70000 36179.9n 0.70000 36180.0n 0.30000 36359.9n 0.30000 36360.0n 0.30000 36539.9n 0.30000 36540.0n 0.30000 36719.9n 0.30000 36720.0n 0.70000 36899.9n 0.70000 36900.0n 0.30000 37079.9n 0.30000 37080.0n 0.70000 37259.9n 0.70000 37260.0n 0.30000 37439.9n 0.30000 37440.0n 0.30000 37619.9n 0.30000 37620.0n 0.70000 37799.9n 0.70000 37800.0n 0.70000 37979.9n 0.70000 37980.0n 0.30000 38159.9n 0.30000 38160.0n 0.30000 38339.9n 0.30000 38340.0n 0.70000 38519.9n 0.70000 38520.0n 0.70000 38699.9n 0.70000 38700.0n 0.30000 38879.9n 0.30000 38880.0n 0.70000 39059.9n 0.70000 39060.0n 0.30000 39239.9n 0.30000 39240.0n 0.70000 39419.9n 0.70000 39420.0n 0.70000 39599.9n 0.70000 39600.0n 0.30000 39779.9n 0.30000 39780.0n 0.70000 39959.9n 0.70000 39960.0n 0.70000 40139.9n 0.70000 40140.0n 0.30000 40319.9n 0.30000 40320.0n 0.70000 40499.9n 0.70000 40500.0n 0.30000 40679.9n 0.30000 40680.0n 0.30000 40859.9n 0.30000 40860.0n 0.30000 41039.9n 0.30000 41040.0n 0.30000 41219.9n 0.30000 41220.0n 0.30000 41399.9n 0.30000 41400.0n 0.30000 41579.9n 0.30000 41580.0n 0.30000 41759.9n 0.30000 41760.0n 0.70000 41939.9n 0.70000 41940.0n 0.70000 42119.9n 0.70000 42120.0n 0.30000 42299.9n 0.30000 42300.0n 0.70000 42479.9n 0.70000 42480.0n 0.30000 42659.9n 0.30000 42660.0n 0.70000 42839.9n 0.70000 42840.0n 0.30000 43019.9n 0.30000 43020.0n 0.70000 43199.9n 0.70000 43200.0n 0.30000 43379.9n 0.30000 43380.0n 0.70000 43559.9n 0.70000 43560.0n 0.30000 43739.9n 0.30000 43740.0n 0.70000 43919.9n 0.70000 43920.0n 0.70000 44099.9n 0.70000 44100.0n 0.70000 44279.9n 0.70000 44280.0n 0.70000 44459.9n 0.70000 44460.0n 0.30000 44639.9n 0.30000 44640.0n 0.30000 44819.9n 0.30000 44820.0n 0.30000 44999.9n 0.30000 45000.0n 0.70000 45179.9n 0.70000 45180.0n 0.30000 45359.9n 0.30000 45360.0n 0.70000 45539.9n 0.70000 45540.0n 0.70000 45719.9n 0.70000 45720.0n 0.70000 45899.9n 0.70000 45900.0n 0.70000 46079.9n 0.70000 46080.0n 0.30000 46259.9n 0.30000 46260.0n 0.30000 46439.9n 0.30000 46440.0n 0.70000 46619.9n 0.70000 46620.0n 0.70000 46799.9n 0.70000 46800.0n 0.30000 46979.9n 0.30000 46980.0n 0.30000 47159.9n 0.30000 47160.0n 0.70000 47339.9n 0.70000 47340.0n 0.30000 47519.9n 0.30000 47520.0n 0.70000 47699.9n 0.70000 47700.0n 0.30000 47879.9n 0.30000 47880.0n 0.70000 48059.9n 0.70000 48060.0n 0.30000 48239.9n 0.30000 48240.0n 0.30000 48419.9n 0.30000 48420.0n 0.30000 48599.9n 0.30000 48600.0n 0.30000 48779.9n 0.30000 48780.0n 0.70000 48959.9n 0.70000 48960.0n 0.70000 49139.9n 0.70000 49140.0n 0.30000 49319.9n 0.30000 49320.0n 0.30000 49499.9n 0.30000 49500.0n 0.70000 49679.9n 0.70000 49680.0n 0.30000 49859.9n 0.30000 49860.0n 0.70000 50039.9n 0.70000 50040.0n 0.30000 50219.9n 0.30000 50220.0n 0.70000 50399.9n 0.70000 50400.0n 0.70000 50579.9n 0.70000 50580.0n 0.70000 50759.9n 0.70000 50760.0n 0.70000 50939.9n 0.70000 50940.0n 0.30000 51119.9n 0.30000 51120.0n 0.70000 51299.9n 0.70000 51300.0n 0.70000 51479.9n 0.70000 51480.0n 0.70000 51659.9n 0.70000 51660.0n 0.30000 51839.9n 0.30000 51840.0n 0.70000 52019.9n 0.70000 52020.0n 0.70000 52199.9n 0.70000 52200.0n 0.70000 52379.9n 0.70000 52380.0n 0.70000 52559.9n 0.70000 52560.0n 0.70000 52739.9n 0.70000 52740.0n 0.70000 52919.9n 0.70000 52920.0n 0.30000 53099.9n 0.30000 53100.0n 0.70000 53279.9n 0.70000 53280.0n 0.30000 53459.9n 0.30000 53460.0n 0.30000 53639.9n 0.30000 53640.0n 0.70000 53819.9n 0.70000 53820.0n 0.30000 53999.9n 0.30000 54000.0n 0.70000 54179.9n 0.70000 54180.0n 0.30000 54359.9n 0.30000 54360.0n 0.30000 54539.9n 0.30000 54540.0n 0.30000 54719.9n 0.30000 54720.0n 0.70000 54899.9n 0.70000 54900.0n 0.30000 55079.9n 0.30000 55080.0n 0.30000 55259.9n 0.30000 55260.0n 0.30000 55439.9n 0.30000 55440.0n 0.70000 55619.9n 0.70000 55620.0n 0.30000 55799.9n 0.30000 55800.0n 0.30000 55979.9n 0.30000 55980.0n 0.70000 56159.9n 0.70000 56160.0n 0.30000 56339.9n 0.30000 56340.0n 0.70000 56519.9n 0.70000 56520.0n 0.70000 56699.9n 0.70000 56700.0n 0.30000 56879.9n 0.30000 56880.0n 0.30000 57059.9n 0.30000 57060.0n 0.70000 57239.9n 0.70000 57240.0n 0.70000 57419.9n 0.70000 57420.0n 0.30000 57599.9n 0.30000 57600.0n 0.30000 57779.9n 0.30000 57780.0n 0.70000 57959.9n 0.70000 57960.0n 0.30000 58139.9n 0.30000 58140.0n 0.30000 58319.9n 0.30000 58320.0n 0.70000 58499.9n 0.70000 58500.0n 0.30000 58679.9n 0.30000 58680.0n 0.30000 58859.9n 0.30000 58860.0n 0.70000 59039.9n 0.70000 59040.0n 0.70000 59219.9n 0.70000 59220.0n 0.30000 59399.9n 0.30000 59400.0n 0.70000 59579.9n 0.70000 59580.0n 0.70000 59759.9n 0.70000 59760.0n 0.70000 59939.9n 0.70000 59940.0n 0.70000 60119.9n 0.70000 60120.0n 0.30000 60299.9n 0.30000 60300.0n 0.30000 60479.9n 0.30000 60480.0n 0.30000 60659.9n 0.30000 60660.0n 0.30000 60839.9n 0.30000 60840.0n 0.30000 61019.9n 0.30000 61020.0n 0.30000 61199.9n 0.30000 61200.0n 0.70000 61379.9n 0.70000 61380.0n 0.70000 61559.9n 0.70000 61560.0n 0.70000 61739.9n 0.70000 61740.0n 0.30000 61919.9n 0.30000 61920.0n 0.70000 62099.9n 0.70000 62100.0n 0.30000 62279.9n 0.30000 62280.0n 0.70000 62459.9n 0.70000 62460.0n 0.70000 62639.9n 0.70000 62640.0n 0.30000 62819.9n 0.30000 62820.0n 0.30000 62999.9n 0.30000 63000.0n 0.70000 63179.9n 0.70000 63180.0n 0.70000 63359.9n 0.70000 63360.0n 0.70000 63539.9n 0.70000 63540.0n 0.70000 63719.9n 0.70000 63720.0n 0.70000 63899.9n 0.70000 63900.0n 0.70000 64079.9n 0.70000 64080.0n 0.70000 64259.9n 0.70000 64260.0n 0.30000 64439.9n 0.30000 64440.0n 0.70000 64619.9n 0.70000 64620.0n 0.70000 64799.9n 0.70000 64800.0n 0.30000 64979.9n 0.30000 64980.0n 0.30000 65159.9n 0.30000 65160.0n 0.30000 65339.9n 0.30000 65340.0n 0.70000 65519.9n 0.70000 65520.0n 0.70000 65699.9n 0.70000 65700.0n 0.30000 65879.9n 0.30000 65880.0n 0.30000 66059.9n 0.30000 66060.0n 0.70000 66239.9n 0.70000 66240.0n 0.70000 66419.9n 0.70000 66420.0n 0.30000 66599.9n 0.30000 66600.0n 0.30000 66779.9n 0.30000 66780.0n 0.70000 66959.9n 0.70000 66960.0n 0.70000 67139.9n 0.70000 67140.0n 0.30000 67319.9n 0.30000 67320.0n 0.30000 67499.9n 0.30000 67500.0n 0.30000 67679.9n 0.30000 67680.0n 0.30000 67859.9n 0.30000 67860.0n 0.70000 68039.9n 0.70000 68040.0n 0.30000 68219.9n 0.30000 68220.0n 0.70000 68399.9n 0.70000 68400.0n 0.30000 68579.9n 0.30000 68580.0n 0.30000 68759.9n 0.30000 68760.0n 0.30000 68939.9n 0.30000 68940.0n 0.70000 69119.9n 0.70000 69120.0n 0.70000 69299.9n 0.70000 69300.0n 0.30000 69479.9n 0.30000 69480.0n 0.30000 69659.9n 0.30000 69660.0n 0.30000 69839.9n 0.30000 69840.0n 0.70000 70019.9n 0.70000 70020.0n 0.30000 70199.9n 0.30000 70200.0n 0.70000 70379.9n 0.70000 70380.0n 0.70000 70559.9n 0.70000 70560.0n 0.30000 70739.9n 0.30000 70740.0n 0.70000 70919.9n 0.70000 70920.0n 0.30000 71099.9n 0.30000 71100.0n 0.30000 71279.9n 0.30000 71280.0n 0.70000 71459.9n 0.70000 71460.0n 0.30000 71639.9n 0.30000 71640.0n 0.30000 71819.9n 0.30000 71820.0n 0.70000 71999.9n 0.70000 72000.0n 0.30000 72179.9n 0.30000 72180.0n 0.70000 72359.9n 0.70000 72360.0n 0.70000 72539.9n 0.70000 72540.0n 0.30000 72719.9n 0.30000 72720.0n 0.70000 72899.9n 0.70000 72900.0n 0.30000 73079.9n 0.30000 73080.0n 0.30000 73259.9n 0.30000 73260.0n 0.70000 73439.9n 0.70000 73440.0n 0.30000 73619.9n 0.30000 73620.0n 0.70000 73799.9n 0.70000 73800.0n 0.30000 73979.9n 0.30000 73980.0n 0.70000 74159.9n 0.70000 74160.0n 0.30000 74339.9n 0.30000 74340.0n 0.70000 74519.9n 0.70000 74520.0n 0.70000 74699.9n 0.70000 74700.0n 0.70000 74879.9n 0.70000 74880.0n 0.30000 75059.9n 0.30000 75060.0n 0.30000 75239.9n 0.30000 75240.0n 0.70000 75419.9n 0.70000 75420.0n 0.30000 75599.9n 0.30000 75600.0n 0.30000 75779.9n 0.30000 75780.0n 0.70000 75959.9n 0.70000 75960.0n 0.30000 76139.9n 0.30000 76140.0n 0.70000 76319.9n 0.70000 76320.0n 0.30000 76499.9n 0.30000 76500.0n 0.30000 76679.9n 0.30000 76680.0n 0.30000 76859.9n 0.30000 76860.0n 0.30000 77039.9n 0.30000 77040.0n 0.30000 77219.9n 0.30000 77220.0n 0.30000 77399.9n 0.30000 77400.0n 0.70000 77579.9n 0.70000 77580.0n 0.70000 77759.9n 0.70000 77760.0n 0.70000 77939.9n 0.70000 77940.0n 0.70000 78119.9n 0.70000 78120.0n 0.70000 78299.9n 0.70000 78300.0n 0.70000 78479.9n 0.70000 78480.0n 0.30000 78659.9n 0.30000 78660.0n 0.30000 78839.9n 0.30000 78840.0n 0.70000 79019.9n 0.70000 79020.0n 0.70000 79199.9n 0.70000 79200.0n 0.70000 79379.9n 0.70000 79380.0n 0.70000 79559.9n 0.70000 79560.0n 0.30000 79739.9n 0.30000 79740.0n 0.70000 79919.9n 0.70000 79920.0n 0.70000 80099.9n 0.70000 80100.0n 0.70000 80279.9n 0.70000 80280.0n 0.30000 80459.9n 0.30000 80460.0n 0.30000 80639.9n 0.30000 80640.0n 0.70000 80819.9n 0.70000 80820.0n 0.30000 80999.9n 0.30000 81000.0n 0.70000 81179.9n 0.70000 81180.0n 0.70000 81359.9n 0.70000 81360.0n 0.70000 81539.9n 0.70000 81540.0n 0.70000 81719.9n 0.70000 81720.0n 0.70000 81899.9n 0.70000 81900.0n 0.30000 82079.9n 0.30000 82080.0n 0.30000 82259.9n 0.30000 82260.0n 0.30000 82439.9n 0.30000 82440.0n 0.30000 82619.9n 0.30000 82620.0n 0.30000 82799.9n 0.30000 82800.0n 0.30000 82979.9n 0.30000 82980.0n 0.30000 83159.9n 0.30000 83160.0n 0.70000 83339.9n 0.70000 83340.0n 0.30000 83519.9n 0.30000 83520.0n 0.30000 83699.9n 0.30000 83700.0n 0.70000 83879.9n 0.70000 83880.0n 0.30000 84059.9n 0.30000 84060.0n 0.70000 84239.9n 0.70000 84240.0n 0.30000 84419.9n 0.30000 84420.0n 0.70000 84599.9n 0.70000 84600.0n 0.70000 84779.9n 0.70000 84780.0n 0.70000 84959.9n 0.70000 84960.0n 0.70000 85139.9n 0.70000 85140.0n 0.70000 85319.9n 0.70000 85320.0n 0.30000 85499.9n 0.30000 85500.0n 0.70000 85679.9n 0.70000 85680.0n 0.30000 85859.9n 0.30000 85860.0n 0.30000 86039.9n 0.30000 86040.0n 0.70000 86219.9n 0.70000 86220.0n 0.30000 86399.9n 0.30000 86400.0n 0.70000 86579.9n 0.70000 86580.0n 0.70000 86759.9n 0.70000 86760.0n 0.30000 86939.9n 0.30000 86940.0n 0.70000 87119.9n 0.70000 87120.0n 0.30000 87299.9n 0.30000 87300.0n 0.70000 87479.9n 0.70000 87480.0n 0.30000 87659.9n 0.30000 87660.0n 0.30000 87839.9n 0.30000 87840.0n 0.70000 88019.9n 0.70000 88020.0n 0.30000 88199.9n 0.30000 88200.0n 0.30000 88379.9n 0.30000 88380.0n 0.30000 88559.9n 0.30000 88560.0n 0.70000 88739.9n 0.70000 88740.0n 0.30000 88919.9n 0.30000 88920.0n 0.30000 89099.9n 0.30000 89100.0n 0.30000 89279.9n 0.30000 89280.0n 0.30000 89459.9n 0.30000 89460.0n 0.30000 89639.9n 0.30000 89640.0n 0.70000 89819.9n 0.70000 89820.0n 0.70000 89999.9n 0.70000 90000.0n 0.70000 90179.9n 0.70000 90180.0n 0.70000 90359.9n 0.70000 90360.0n 0.30000 90539.9n 0.30000 90540.0n 0.30000 90719.9n 0.30000 90720.0n 0.70000 90899.9n 0.70000 90900.0n 0.70000 91079.9n 0.70000 91080.0n 0.70000 91259.9n 0.70000 91260.0n 0.30000 91439.9n 0.30000 91440.0n 0.70000 91619.9n 0.70000 91620.0n 0.30000 91799.9n 0.30000 91800.0n 0.70000 91979.9n 0.70000 91980.0n 0.70000 92159.9n 0.70000 92160.0n 0.30000 92339.9n 0.30000 92340.0n 0.70000 92519.9n 0.70000 92520.0n 0.70000 92699.9n 0.70000 92700.0n 0.30000 92879.9n 0.30000 92880.0n 0.30000 93059.9n 0.30000 93060.0n 0.30000 93239.9n 0.30000 93240.0n 0.30000 93419.9n 0.30000 93420.0n 0.70000 93599.9n 0.70000 93600.0n 0.70000 93779.9n 0.70000 93780.0n 0.30000 93959.9n 0.30000 93960.0n 0.70000 94139.9n 0.70000 94140.0n 0.30000 94319.9n 0.30000 94320.0n 0.70000 94499.9n 0.70000 94500.0n 0.30000 94679.9n 0.30000 94680.0n 0.70000 94859.9n 0.70000 94860.0n 0.70000 95039.9n 0.70000 95040.0n 0.70000 95219.9n 0.70000 95220.0n 0.70000 95399.9n 0.70000 95400.0n 0.30000 95579.9n 0.30000 95580.0n 0.30000 95759.9n 0.30000 95760.0n 0.70000 95939.9n 0.70000 95940.0n 0.70000 96119.9n 0.70000 96120.0n 0.30000 96299.9n 0.30000 96300.0n 0.30000 96479.9n 0.30000 96480.0n 0.70000 96659.9n 0.70000 96660.0n 0.70000 96839.9n 0.70000 96840.0n 0.70000 97019.9n 0.70000 97020.0n 0.30000 97199.9n 0.30000 97200.0n 0.30000 97379.9n 0.30000 97380.0n 0.70000 97559.9n 0.70000 97560.0n 0.30000 97739.9n 0.30000 97740.0n 0.30000 97919.9n 0.30000 97920.0n 0.70000 98099.9n 0.70000 98100.0n 0.30000 98279.9n 0.30000 98280.0n 0.30000 98459.9n 0.30000 98460.0n 0.30000 98639.9n 0.30000 98640.0n 0.70000 98819.9n 0.70000 98820.0n 0.70000 98999.9n 0.70000 99000.0n 0.70000 99179.9n 0.70000 99180.0n 0.70000 99359.9n 0.70000 99360.0n 0.30000 99539.9n 0.30000 99540.0n 0.30000 99719.9n 0.30000 99720.0n 0.70000 99899.9n 0.70000 99900.0n 0.70000 100079.9n 0.70000 100080.0n 0.30000 100259.9n 0.30000 100260.0n 0.30000 100439.9n 0.30000 100440.0n 0.30000 100619.9n 0.30000 100620.0n 0.70000 100799.9n 0.70000 100800.0n 0.30000 100979.9n 0.30000 100980.0n 0.30000 101159.9n 0.30000 101160.0n 0.70000 101339.9n 0.70000 101340.0n 0.30000 101519.9n 0.30000 101520.0n 0.30000 101699.9n 0.30000 101700.0n 0.70000 101879.9n 0.70000 101880.0n 0.70000 102059.9n 0.70000 102060.0n 0.70000 102239.9n 0.70000 102240.0n 0.70000 102419.9n 0.70000 102420.0n 0.30000 102599.9n 0.30000 102600.0n 0.30000 102779.9n 0.30000 102780.0n 0.70000 102959.9n 0.70000 102960.0n 0.30000 103139.9n 0.30000 103140.0n 0.30000 103319.9n 0.30000 103320.0n 0.70000 103499.9n 0.70000 103500.0n 0.70000 103679.9n 0.70000 103680.0n 0.30000 103859.9n 0.30000 103860.0n 0.70000 104039.9n 0.70000 104040.0n 0.30000 104219.9n 0.30000 104220.0n 0.30000 104399.9n 0.30000 104400.0n 0.30000 104579.9n 0.30000 104580.0n 0.30000 104759.9n 0.30000 104760.0n 0.70000 104939.9n 0.70000 104940.0n 0.70000 105119.9n 0.70000 105120.0n 0.70000 105299.9n 0.70000 105300.0n 0.30000 105479.9n 0.30000 105480.0n 0.70000 105659.9n 0.70000 105660.0n 0.70000 105839.9n 0.70000 105840.0n 0.70000 106019.9n 0.70000 106020.0n 0.70000 106199.9n 0.70000 106200.0n 0.30000 106379.9n 0.30000 106380.0n 0.30000 106559.9n 0.30000 106560.0n 0.30000 106739.9n 0.30000 106740.0n 0.30000 106919.9n 0.30000 106920.0n 0.70000 107099.9n 0.70000 107100.0n 0.70000 107279.9n 0.70000 107280.0n 0.30000 107459.9n 0.30000 107460.0n 0.30000 107639.9n 0.30000 107640.0n 0.30000 107819.9n 0.30000 107820.0n 0.70000 107999.9n 0.70000 108000.0n 0.30000 108179.9n 0.30000 108180.0n 0.70000 108359.9n 0.70000 108360.0n 0.70000 108539.9n 0.70000 108540.0n 0.70000 108719.9n 0.70000 108720.0n 0.30000 108899.9n 0.30000 108900.0n 0.70000 109079.9n 0.70000 109080.0n 0.70000 109259.9n 0.70000 109260.0n 0.30000 109439.9n 0.30000 109440.0n 0.70000 109619.9n 0.70000 109620.0n 0.30000 109799.9n 0.30000 109800.0n 0.70000 109979.9n 0.70000 109980.0n 0.30000 110159.9n 0.30000 110160.0n 0.30000 110339.9n 0.30000 110340.0n 0.30000 110519.9n 0.30000 110520.0n 0.70000 110699.9n 0.70000 110700.0n 0.30000 110879.9n 0.30000 110880.0n 0.70000 111059.9n 0.70000 111060.0n 0.30000 111239.9n 0.30000 111240.0n 0.70000 111419.9n 0.70000 111420.0n 0.70000 111599.9n 0.70000 111600.0n 0.30000 111779.9n 0.30000 111780.0n 0.30000 111959.9n 0.30000 111960.0n 0.70000 112139.9n 0.70000 112140.0n 0.70000 112319.9n 0.70000 112320.0n 0.30000 112499.9n 0.30000 112500.0n 0.70000 112679.9n 0.70000 112680.0n 0.30000 112859.9n 0.30000 112860.0n 0.30000 113039.9n 0.30000 113040.0n 0.70000 113219.9n 0.70000 113220.0n 0.30000 113399.9n 0.30000 113400.0n 0.30000 113579.9n 0.30000 113580.0n 0.70000 113759.9n 0.70000 113760.0n 0.70000 113939.9n 0.70000 113940.0n 0.30000 114119.9n 0.30000 114120.0n 0.70000 114299.9n 0.70000 114300.0n 0.70000 114479.9n 0.70000 114480.0n 0.70000 114659.9n 0.70000 114660.0n 0.30000 114839.9n 0.30000 114840.0n 0.30000 115019.9n 0.30000 115020.0n 0.70000 115199.9n 0.70000 115200.0n 0.30000 115379.9n 0.30000 115380.0n 0.70000 115559.9n 0.70000 115560.0n 0.70000 115739.9n 0.70000 115740.0n 0.70000 115919.9n 0.70000 115920.0n 0.70000 116099.9n 0.70000 116100.0n 0.70000 116279.9n 0.70000 116280.0n 0.70000 116459.9n 0.70000 116460.0n 0.30000 116639.9n 0.30000 116640.0n 0.30000 116819.9n 0.30000 116820.0n 0.30000 116999.9n 0.30000 117000.0n 0.70000 117179.9n 0.70000 117180.0n 0.70000 117359.9n 0.70000 117360.0n 0.30000 117539.9n 0.30000 117540.0n 0.30000 117719.9n 0.30000 117720.0n 0.70000 117899.9n 0.70000 117900.0n 0.70000 118079.9n 0.70000 118080.0n 0.30000 118259.9n 0.30000 118260.0n 0.30000 118439.9n 0.30000 118440.0n 0.70000 118619.9n 0.70000 118620.0n 0.70000 118799.9n 0.70000 118800.0n 0.30000 118979.9n 0.30000 118980.0n 0.30000 119159.9n 0.30000 119160.0n 0.30000 119339.9n 0.30000 119340.0n 0.30000 119519.9n 0.30000 119520.0n 0.30000 119699.9n 0.30000 119700.0n 0.30000 119879.9n 0.30000 119880.0n 0.70000 120059.9n 0.70000 120060.0n 0.70000 120239.9n 0.70000 120240.0n 0.30000 120419.9n 0.30000 120420.0n 0.70000 120599.9n 0.70000 120600.0n 0.70000 120779.9n 0.70000 120780.0n 0.30000 120959.9n 0.30000 120960.0n 0.30000 121139.9n 0.30000 121140.0n 0.70000 121319.9n 0.70000 121320.0n 0.70000 121499.9n 0.70000 121500.0n 0.70000 121679.9n 0.70000 121680.0n 0.70000 121859.9n 0.70000 121860.0n 0.70000 122039.9n 0.70000 122040.0n 0.30000 122219.9n 0.30000 122220.0n 0.70000 122399.9n 0.70000 122400.0n 0.70000 122579.9n 0.70000 122580.0n 0.70000 122759.9n 0.70000 122760.0n 0.30000 122939.9n 0.30000 122940.0n 0.30000 123119.9n 0.30000 123120.0n 0.30000 123299.9n 0.30000 123300.0n 0.30000 123479.9n 0.30000 123480.0n 0.70000 123659.9n 0.70000 123660.0n 0.70000 123839.9n 0.70000 123840.0n 0.70000 124019.9n 0.70000 124020.0n 0.30000 124199.9n 0.30000 124200.0n 0.70000 124379.9n 0.70000 124380.0n 0.30000 124559.9n 0.30000 124560.0n 0.70000 124739.9n 0.70000 124740.0n 0.30000 124919.9n 0.30000 124920.0n 0.30000 125099.9n 0.30000 125100.0n 0.30000 125279.9n 0.30000 125280.0n 0.30000 125459.9n 0.30000 125460.0n 0.70000 125639.9n 0.70000 125640.0n 0.30000 125819.9n 0.30000 125820.0n 0.30000 125999.9n 0.30000 126000.0n 0.70000 126179.9n 0.70000 126180.0n 0.70000 126359.9n 0.70000 126360.0n 0.30000 126539.9n 0.30000 126540.0n 0.30000 126719.9n 0.30000 126720.0n 0.70000 126899.9n 0.70000 126900.0n 0.30000 127079.9n 0.30000 127080.0n 0.70000 127259.9n 0.70000 127260.0n 0.30000 127439.9n 0.30000 127440.0n 0.70000 127619.9n 0.70000 127620.0n 0.70000 127799.9n 0.70000 127800.0n 0.70000 127979.9n 0.70000 127980.0n 0.70000 128159.9n 0.70000 128160.0n 0.30000 128339.9n 0.30000 128340.0n 0.30000 128519.9n 0.30000 128520.0n 0.70000 128699.9n 0.70000 128700.0n 0.70000 128879.9n 0.70000 128880.0n 0.70000 129059.9n 0.70000 129060.0n 0.70000 129239.9n 0.70000 129240.0n 0.30000 129419.9n 0.30000 129420.0n 0.30000 129599.9n 0.30000 129600.0n 0.70000 129779.9n 0.70000 129780.0n 0.30000 129959.9n 0.30000 129960.0n 0.70000 130139.9n 0.70000 130140.0n 0.30000 130319.9n 0.30000 130320.0n 0.30000 130499.9n 0.30000 130500.0n 0.30000 130679.9n 0.30000 130680.0n 0.30000 130859.9n 0.30000 130860.0n 0.30000 131039.9n 0.30000 131040.0n 0.70000 131219.9n 0.70000 131220.0n 0.70000 131399.9n 0.70000 131400.0n 0.30000 131579.9n 0.30000 131580.0n 0.70000 131759.9n 0.70000 131760.0n 0.70000 131939.9n 0.70000 131940.0n 0.30000 132119.9n 0.30000 132120.0n 0.30000 132299.9n 0.30000 132300.0n 0.30000 132479.9n 0.30000 132480.0n 0.70000 132659.9n 0.70000 132660.0n 0.70000 132839.9n 0.70000 132840.0n 0.30000 133019.9n 0.30000 133020.0n 0.70000 133199.9n 0.70000 133200.0n 0.70000 133379.9n 0.70000 133380.0n 0.30000 133559.9n 0.30000 133560.0n 0.30000 133739.9n 0.30000 133740.0n 0.30000 133919.9n 0.30000 133920.0n 0.30000 134099.9n 0.30000 134100.0n 0.30000 134279.9n 0.30000 134280.0n 0.30000 134459.9n 0.30000 134460.0n 0.30000 134639.9n 0.30000 134640.0n 0.70000 134819.9n 0.70000 134820.0n 0.70000 134999.9n 0.70000 135000.0n 0.30000 135179.9n 0.30000 135180.0n 0.70000 135359.9n 0.70000 135360.0n 0.30000 135539.9n 0.30000 135540.0n 0.30000 135719.9n 0.30000 135720.0n 0.70000 135899.9n 0.70000 135900.0n 0.70000 136079.9n 0.70000 136080.0n 0.30000 136259.9n 0.30000 136260.0n 0.70000 136439.9n 0.70000 136440.0n 0.30000 136619.9n 0.30000 136620.0n 0.70000 136799.9n 0.70000 136800.0n 0.30000 136979.9n 0.30000 136980.0n 0.30000 137159.9n 0.30000 137160.0n 0.70000 137339.9n 0.70000 137340.0n 0.30000 137519.9n 0.30000 137520.0n 0.70000 137699.9n 0.70000 137700.0n 0.70000 137879.9n 0.70000 137880.0n 0.70000 138059.9n 0.70000 138060.0n 0.70000 138239.9n 0.70000 138240.0n 0.70000 138419.9n 0.70000 138420.0n 0.30000 138599.9n 0.30000 138600.0n 0.30000 138779.9n 0.30000 138780.0n 0.70000 138959.9n 0.70000 138960.0n 0.30000 139139.9n 0.30000 139140.0n 0.30000 139319.9n 0.30000 139320.0n 0.70000 139499.9n 0.70000 139500.0n 0.30000 139679.9n 0.30000 139680.0n 0.70000 139859.9n 0.70000 139860.0n 0.70000 140039.9n 0.70000 140040.0n 0.30000 140219.9n 0.30000 140220.0n 0.70000 140399.9n 0.70000 140400.0n 0.70000 140579.9n 0.70000 140580.0n 0.70000 140759.9n 0.70000 140760.0n 0.70000 140939.9n 0.70000 140940.0n 0.30000 141119.9n 0.30000 141120.0n 0.30000 141299.9n 0.30000 141300.0n 0.30000 141479.9n 0.30000 141480.0n 0.70000 141659.9n 0.70000 141660.0n 0.70000 141839.9n 0.70000 141840.0n 0.30000 142019.9n 0.30000 142020.0n 0.30000 142199.9n 0.30000 142200.0n 0.30000 142379.9n 0.30000 142380.0n 0.70000 142559.9n 0.70000 142560.0n 0.30000 142739.9n 0.30000 142740.0n 0.70000 142919.9n 0.70000 142920.0n 0.30000 143099.9n 0.30000 143100.0n 0.70000 143279.9n 0.70000 143280.0n 0.30000 143459.9n 0.30000 143460.0n 0.70000 143639.9n 0.70000 143640.0n 0.30000 143819.9n 0.30000 143820.0n 0.70000 143999.9n 0.70000 144000.0n 0.30000 144179.9n 0.30000 144180.0n 0.30000 144359.9n 0.30000 144360.0n 0.70000 144539.9n 0.70000 144540.0n 0.30000 144719.9n 0.30000 144720.0n 0.70000 144899.9n 0.70000 144900.0n 0.70000 145079.9n 0.70000 145080.0n 0.30000 145259.9n 0.30000 145260.0n 0.30000 145439.9n 0.30000 145440.0n 0.70000 145619.9n 0.70000 145620.0n 0.30000 145799.9n 0.30000 145800.0n 0.70000 145979.9n 0.70000 145980.0n 0.70000 146159.9n 0.70000 146160.0n 0.30000 146339.9n 0.30000 146340.0n 0.70000 146519.9n 0.70000 146520.0n 0.30000 146699.9n 0.30000 146700.0n 0.70000 146879.9n 0.70000 146880.0n 0.30000 147059.9n 0.30000 147060.0n 0.70000 147239.9n 0.70000 147240.0n 0.30000 147419.9n 0.30000 147420.0n 0.30000 147599.9n 0.30000 147600.0n 0.70000 147779.9n 0.70000 147780.0n 0.30000 147959.9n 0.30000 147960.0n 0.70000 148139.9n 0.70000 148140.0n 0.30000 148319.9n 0.30000 148320.0n 0.70000 148499.9n 0.70000 148500.0n 0.30000 148679.9n 0.30000 148680.0n 0.70000 148859.9n 0.70000 148860.0n 0.70000 149039.9n 0.70000 149040.0n 0.30000 149219.9n 0.30000 149220.0n 0.70000 149399.9n 0.70000 149400.0n 0.70000 149579.9n 0.70000 149580.0n 0.30000 149759.9n 0.30000 149760.0n 0.30000 149939.9n 0.30000 149940.0n 0.70000 150119.9n 0.70000 150120.0n 0.30000 150299.9n 0.30000 150300.0n 0.30000 150479.9n 0.30000 150480.0n 0.70000 150659.9n 0.70000 150660.0n 0.70000 150839.9n 0.70000 150840.0n 0.30000 151019.9n 0.30000 151020.0n 0.30000 151199.9n 0.30000 151200.0n 0.70000 151379.9n 0.70000 151380.0n 0.30000 151559.9n 0.30000 151560.0n 0.30000 151739.9n 0.30000 151740.0n 0.30000 151919.9n 0.30000 151920.0n 0.30000 152099.9n 0.30000 152100.0n 0.30000 152279.9n 0.30000 152280.0n 0.70000 152459.9n 0.70000 152460.0n 0.30000 152639.9n 0.30000 152640.0n 0.70000 152819.9n 0.70000 152820.0n 0.70000 152999.9n 0.70000 153000.0n 0.30000 153179.9n 0.30000 153180.0n 0.30000 153359.9n 0.30000 153360.0n 0.70000 153539.9n 0.70000 153540.0n 0.30000 153719.9n 0.30000 153720.0n 0.70000 153899.9n 0.70000 153900.0n 0.70000 154079.9n 0.70000 154080.0n 0.30000 154259.9n 0.30000 154260.0n 0.70000 154439.9n 0.70000 154440.0n 0.70000 154619.9n 0.70000 154620.0n 0.70000 154799.9n 0.70000 154800.0n 0.70000 154979.9n 0.70000 154980.0n 0.30000 155159.9n 0.30000 155160.0n 0.70000 155339.9n 0.70000 155340.0n 0.70000 155519.9n 0.70000 155520.0n 0.30000 155699.9n 0.30000 155700.0n 0.70000 155879.9n 0.70000 155880.0n 0.70000 156059.9n 0.70000 156060.0n 0.70000 156239.9n 0.70000 156240.0n 0.30000 156419.9n 0.30000 156420.0n 0.30000 156599.9n 0.30000 156600.0n 0.30000 156779.9n 0.30000 156780.0n 0.30000 156959.9n 0.30000 156960.0n 0.30000 157139.9n 0.30000 157140.0n 0.30000 157319.9n 0.30000 157320.0n 0.70000 157499.9n 0.70000 157500.0n 0.70000 157679.9n 0.70000 157680.0n 0.30000 157859.9n 0.30000 157860.0n 0.70000 158039.9n 0.70000 158040.0n 0.30000 158219.9n 0.30000 158220.0n 0.70000 158399.9n 0.70000 158400.0n 0.30000 158579.9n 0.30000 158580.0n 0.30000 158759.9n 0.30000 158760.0n 0.70000 158939.9n 0.70000 158940.0n 0.70000 159119.9n 0.70000 159120.0n 0.70000 159299.9n 0.70000 159300.0n 0.70000 159479.9n 0.70000 159480.0n 0.30000 159659.9n 0.30000 159660.0n 0.70000 159839.9n 0.70000 159840.0n 0.70000 160019.9n 0.70000 160020.0n 0.30000 160199.9n 0.30000 160200.0n 0.30000 160379.9n 0.30000 160380.0n 0.70000 160559.9n 0.70000 160560.0n 0.70000 160739.9n 0.70000 160740.0n 0.70000 160919.9n 0.70000 160920.0n 0.30000 161099.9n 0.30000 161100.0n 0.30000 161279.9n 0.30000 161280.0n 0.30000 161459.9n 0.30000 161460.0n 0.70000 161639.9n 0.70000 161640.0n 0.30000 161819.9n 0.30000 161820.0n 0.30000 161999.9n 0.30000 162000.0n 0.30000 162179.9n 0.30000 162180.0n 0.70000 162359.9n 0.70000 162360.0n 0.30000 162539.9n 0.30000 162540.0n 0.30000 162719.9n 0.30000 162720.0n 0.70000 162899.9n 0.70000 162900.0n 0.30000 163079.9n 0.30000 163080.0n 0.70000 163259.9n 0.70000 163260.0n 0.70000 163439.9n 0.70000 163440.0n 0.30000 163619.9n 0.30000 163620.0n 0.70000 163799.9n 0.70000 163800.0n 0.30000 163979.9n 0.30000 163980.0n 0.30000 164159.9n 0.30000 164160.0n 0.30000 164339.9n 0.30000 164340.0n 0.30000 164519.9n 0.30000 164520.0n 0.30000 164699.9n 0.30000 164700.0n 0.70000 164879.9n 0.70000 164880.0n 0.70000 165059.9n 0.70000 165060.0n 0.70000 165239.9n 0.70000 165240.0n 0.70000 165419.9n 0.70000 165420.0n 0.70000 165599.9n 0.70000 165600.0n 0.70000 165779.9n 0.70000 165780.0n 0.70000 165959.9n 0.70000 165960.0n 0.30000 166139.9n 0.30000 166140.0n 0.30000 166319.9n 0.30000 166320.0n 0.30000 166499.9n 0.30000 166500.0n 0.70000 166679.9n 0.70000 166680.0n 0.70000 166859.9n 0.70000 166860.0n 0.70000 167039.9n 0.70000 167040.0n 0.70000 167219.9n 0.70000 167220.0n 0.70000 167399.9n 0.70000 167400.0n 0.30000 167579.9n 0.30000 167580.0n 0.30000 167759.9n 0.30000 167760.0n 0.70000 167939.9n 0.70000 167940.0n 0.70000 168119.9n 0.70000 168120.0n 0.70000 168299.9n 0.70000 168300.0n 0.70000 168479.9n 0.70000 168480.0n 0.30000 168659.9n 0.30000 168660.0n 0.70000 168839.9n 0.70000 168840.0n 0.70000 169019.9n 0.70000 169020.0n 0.30000 169199.9n 0.30000 169200.0n 0.30000 169379.9n 0.30000 169380.0n 0.30000 169559.9n 0.30000 169560.0n 0.30000 169739.9n 0.30000 169740.0n 0.70000 169919.9n 0.70000 169920.0n 0.30000 170099.9n 0.30000 170100.0n 0.70000 170279.9n 0.70000 170280.0n 0.70000 170459.9n 0.70000 170460.0n 0.30000 170639.9n 0.30000 170640.0n 0.30000 170819.9n 0.30000 170820.0n 0.30000 170999.9n 0.30000 171000.0n 0.30000 171179.9n 0.30000 171180.0n 0.70000 171359.9n 0.70000 171360.0n 0.70000 171539.9n 0.70000 171540.0n 0.70000 171719.9n 0.70000 171720.0n 0.70000 171899.9n 0.70000 171900.0n 0.70000 172079.9n 0.70000 172080.0n 0.30000 172259.9n 0.30000 172260.0n 0.30000 172439.9n 0.30000 172440.0n 0.30000 172619.9n 0.30000 172620.0n 0.30000 172799.9n 0.30000 172800.0n 0.50000 172979.9n 0.50000 172980.0n 0.50000 173159.9n 0.50000 173160.0n 0.50000 173339.9n 0.50000 173340.0n 0.50000 173519.9n 0.50000 173520.0n 0.50000 173699.9n 0.50000 173700.0n 0.50000 173879.9n 0.50000 173880.0n 0.50000 174059.9n 0.50000 174060.0n 0.50000 174239.9n 0.50000 174240.0n 0.50000 174419.9n 0.50000 174420.0n 0.50000 174599.9n 0.50000 174600.0n 0.50000 174779.9n 0.50000 174780.0n 0.50000 174959.9n 0.50000 174960.0n 0.50000 175139.9n 0.50000 175140.0n 0.50000 175319.9n 0.50000 175320.0n 0.50000 175499.9n 0.50000 175500.0n 0.50000 175679.9n 0.50000 175680.0n 0.50000 175859.9n 0.50000 175860.0n 0.50000 176039.9n 0.50000 176040.0n 0.50000 176219.9n 0.50000 176220.0n 0.50000 176399.9n 0.50000 176400.0n 0.50000 176579.9n 0.50000 176580.0n 0.50000 176759.9n 0.50000 176760.0n 0.50000 176939.9n 0.50000 176940.0n 0.50000 177119.9n 0.50000 177120.0n 0.50000 177299.9n 0.50000 177300.0n 0.50000 177479.9n 0.50000 177480.0n 0.50000 177659.9n 0.50000 177660.0n 0.50000 177839.9n 0.50000 177840.0n 0.50000 178019.9n 0.50000 178020.0n 0.50000 178199.9n 0.50000 178200.0n 0.50000 178379.9n 0.50000 178380.0n 0.50000 178559.9n 0.50000 178560.0n 0.50000 178739.9n 0.50000 178740.0n 0.50000 178919.9n 0.50000 178920.0n 0.50000 179099.9n 0.50000 179100.0n 0.50000 179279.9n 0.50000 179280.0n 0.50000 179459.9n 0.50000 179460.0n 0.50000 179639.9n 0.50000 179640.0n 0.50000 179819.9n 0.50000 179820.0n 0.50000 179999.9n 0.50000 180000.0n 0.50000 180179.9n 0.50000 180180.0n 0.50000 180359.9n 0.50000 180360.0n 0.50000 180539.9n 0.50000 180540.0n 0.50000 180719.9n 0.50000 180720.0n 0.50000 180899.9n 0.50000 180900.0n 0.50000 181079.9n 0.50000 181080.0n 0.50000 181259.9n 0.50000 181260.0n 0.50000 181439.9n 0.50000 181440.0n 0.50000 181619.9n 0.50000 181620.0n 0.50000 181799.9n 0.50000 181800.0n 0.50000 181979.9n 0.50000 181980.0n 0.50000 182159.9n 0.50000 182160.0n 0.50000 182339.9n 0.50000 182340.0n 0.50000 182519.9n 0.50000 182520.0n 0.50000 182699.9n 0.50000 182700.0n 0.50000 182879.9n 0.50000 182880.0n 0.50000 183059.9n 0.50000 183060.0n 0.50000 183239.9n 0.50000 183240.0n 0.50000 183419.9n 0.50000 183420.0n 0.50000)
Vxon0 xon0 0 PWL(0.0n 0.30000 179.9n 0.30000 180.0n 0.70000 359.9n 0.70000 360.0n 0.30000 539.9n 0.30000 540.0n 0.30000 719.9n 0.30000 720.0n 0.30000 899.9n 0.30000 900.0n 0.70000 1079.9n 0.70000 1080.0n 0.70000 1259.9n 0.70000 1260.0n 0.70000 1439.9n 0.70000 1440.0n 0.30000 1619.9n 0.30000 1620.0n 0.70000 1799.9n 0.70000 1800.0n 0.70000 1979.9n 0.70000 1980.0n 0.30000 2159.9n 0.30000 2160.0n 0.70000 2339.9n 0.70000 2340.0n 0.70000 2519.9n 0.70000 2520.0n 0.30000 2699.9n 0.30000 2700.0n 0.30000 2879.9n 0.30000 2880.0n 0.70000 3059.9n 0.70000 3060.0n 0.70000 3239.9n 0.70000 3240.0n 0.70000 3419.9n 0.70000 3420.0n 0.30000 3599.9n 0.30000 3600.0n 0.70000 3779.9n 0.70000 3780.0n 0.30000 3959.9n 0.30000 3960.0n 0.70000 4139.9n 0.70000 4140.0n 0.70000 4319.9n 0.70000 4320.0n 0.30000 4499.9n 0.30000 4500.0n 0.70000 4679.9n 0.70000 4680.0n 0.30000 4859.9n 0.30000 4860.0n 0.30000 5039.9n 0.30000 5040.0n 0.30000 5219.9n 0.30000 5220.0n 0.30000 5399.9n 0.30000 5400.0n 0.30000 5579.9n 0.30000 5580.0n 0.70000 5759.9n 0.70000 5760.0n 0.30000 5939.9n 0.30000 5940.0n 0.70000 6119.9n 0.70000 6120.0n 0.30000 6299.9n 0.30000 6300.0n 0.30000 6479.9n 0.30000 6480.0n 0.70000 6659.9n 0.70000 6660.0n 0.70000 6839.9n 0.70000 6840.0n 0.70000 7019.9n 0.70000 7020.0n 0.70000 7199.9n 0.70000 7200.0n 0.70000 7379.9n 0.70000 7380.0n 0.70000 7559.9n 0.70000 7560.0n 0.70000 7739.9n 0.70000 7740.0n 0.30000 7919.9n 0.30000 7920.0n 0.30000 8099.9n 0.30000 8100.0n 0.30000 8279.9n 0.30000 8280.0n 0.70000 8459.9n 0.70000 8460.0n 0.30000 8639.9n 0.30000 8640.0n 0.30000 8819.9n 0.30000 8820.0n 0.30000 8999.9n 0.30000 9000.0n 0.30000 9179.9n 0.30000 9180.0n 0.30000 9359.9n 0.30000 9360.0n 0.70000 9539.9n 0.70000 9540.0n 0.70000 9719.9n 0.70000 9720.0n 0.30000 9899.9n 0.30000 9900.0n 0.70000 10079.9n 0.70000 10080.0n 0.30000 10259.9n 0.30000 10260.0n 0.70000 10439.9n 0.70000 10440.0n 0.30000 10619.9n 0.30000 10620.0n 0.70000 10799.9n 0.70000 10800.0n 0.70000 10979.9n 0.70000 10980.0n 0.30000 11159.9n 0.30000 11160.0n 0.70000 11339.9n 0.70000 11340.0n 0.30000 11519.9n 0.30000 11520.0n 0.30000 11699.9n 0.30000 11700.0n 0.70000 11879.9n 0.70000 11880.0n 0.30000 12059.9n 0.30000 12060.0n 0.30000 12239.9n 0.30000 12240.0n 0.30000 12419.9n 0.30000 12420.0n 0.30000 12599.9n 0.30000 12600.0n 0.70000 12779.9n 0.70000 12780.0n 0.70000 12959.9n 0.70000 12960.0n 0.70000 13139.9n 0.70000 13140.0n 0.70000 13319.9n 0.70000 13320.0n 0.70000 13499.9n 0.70000 13500.0n 0.70000 13679.9n 0.70000 13680.0n 0.70000 13859.9n 0.70000 13860.0n 0.30000 14039.9n 0.30000 14040.0n 0.30000 14219.9n 0.30000 14220.0n 0.30000 14399.9n 0.30000 14400.0n 0.30000 14579.9n 0.30000 14580.0n 0.30000 14759.9n 0.30000 14760.0n 0.70000 14939.9n 0.70000 14940.0n 0.70000 15119.9n 0.70000 15120.0n 0.30000 15299.9n 0.30000 15300.0n 0.70000 15479.9n 0.70000 15480.0n 0.70000 15659.9n 0.70000 15660.0n 0.30000 15839.9n 0.30000 15840.0n 0.70000 16019.9n 0.70000 16020.0n 0.70000 16199.9n 0.70000 16200.0n 0.30000 16379.9n 0.30000 16380.0n 0.30000 16559.9n 0.30000 16560.0n 0.70000 16739.9n 0.70000 16740.0n 0.30000 16919.9n 0.30000 16920.0n 0.30000 17099.9n 0.30000 17100.0n 0.70000 17279.9n 0.70000 17280.0n 0.30000 17459.9n 0.30000 17460.0n 0.30000 17639.9n 0.30000 17640.0n 0.70000 17819.9n 0.70000 17820.0n 0.30000 17999.9n 0.30000 18000.0n 0.70000 18179.9n 0.70000 18180.0n 0.70000 18359.9n 0.70000 18360.0n 0.30000 18539.9n 0.30000 18540.0n 0.70000 18719.9n 0.70000 18720.0n 0.70000 18899.9n 0.70000 18900.0n 0.70000 19079.9n 0.70000 19080.0n 0.70000 19259.9n 0.70000 19260.0n 0.30000 19439.9n 0.30000 19440.0n 0.70000 19619.9n 0.70000 19620.0n 0.30000 19799.9n 0.30000 19800.0n 0.70000 19979.9n 0.70000 19980.0n 0.70000 20159.9n 0.70000 20160.0n 0.30000 20339.9n 0.30000 20340.0n 0.30000 20519.9n 0.30000 20520.0n 0.70000 20699.9n 0.70000 20700.0n 0.30000 20879.9n 0.30000 20880.0n 0.70000 21059.9n 0.70000 21060.0n 0.30000 21239.9n 0.30000 21240.0n 0.70000 21419.9n 0.70000 21420.0n 0.30000 21599.9n 0.30000 21600.0n 0.30000 21779.9n 0.30000 21780.0n 0.30000 21959.9n 0.30000 21960.0n 0.70000 22139.9n 0.70000 22140.0n 0.30000 22319.9n 0.30000 22320.0n 0.70000 22499.9n 0.70000 22500.0n 0.30000 22679.9n 0.30000 22680.0n 0.30000 22859.9n 0.30000 22860.0n 0.70000 23039.9n 0.70000 23040.0n 0.70000 23219.9n 0.70000 23220.0n 0.30000 23399.9n 0.30000 23400.0n 0.70000 23579.9n 0.70000 23580.0n 0.70000 23759.9n 0.70000 23760.0n 0.30000 23939.9n 0.30000 23940.0n 0.70000 24119.9n 0.70000 24120.0n 0.70000 24299.9n 0.70000 24300.0n 0.30000 24479.9n 0.30000 24480.0n 0.30000 24659.9n 0.30000 24660.0n 0.30000 24839.9n 0.30000 24840.0n 0.70000 25019.9n 0.70000 25020.0n 0.70000 25199.9n 0.70000 25200.0n 0.30000 25379.9n 0.30000 25380.0n 0.30000 25559.9n 0.30000 25560.0n 0.30000 25739.9n 0.30000 25740.0n 0.70000 25919.9n 0.70000 25920.0n 0.30000 26099.9n 0.30000 26100.0n 0.70000 26279.9n 0.70000 26280.0n 0.70000 26459.9n 0.70000 26460.0n 0.30000 26639.9n 0.30000 26640.0n 0.70000 26819.9n 0.70000 26820.0n 0.70000 26999.9n 0.70000 27000.0n 0.30000 27179.9n 0.30000 27180.0n 0.30000 27359.9n 0.30000 27360.0n 0.30000 27539.9n 0.30000 27540.0n 0.70000 27719.9n 0.70000 27720.0n 0.70000 27899.9n 0.70000 27900.0n 0.30000 28079.9n 0.30000 28080.0n 0.70000 28259.9n 0.70000 28260.0n 0.70000 28439.9n 0.70000 28440.0n 0.30000 28619.9n 0.30000 28620.0n 0.30000 28799.9n 0.30000 28800.0n 0.30000 28979.9n 0.30000 28980.0n 0.30000 29159.9n 0.30000 29160.0n 0.70000 29339.9n 0.70000 29340.0n 0.70000 29519.9n 0.70000 29520.0n 0.70000 29699.9n 0.70000 29700.0n 0.30000 29879.9n 0.30000 29880.0n 0.30000 30059.9n 0.30000 30060.0n 0.30000 30239.9n 0.30000 30240.0n 0.70000 30419.9n 0.70000 30420.0n 0.70000 30599.9n 0.70000 30600.0n 0.30000 30779.9n 0.30000 30780.0n 0.30000 30959.9n 0.30000 30960.0n 0.70000 31139.9n 0.70000 31140.0n 0.30000 31319.9n 0.30000 31320.0n 0.70000 31499.9n 0.70000 31500.0n 0.30000 31679.9n 0.30000 31680.0n 0.30000 31859.9n 0.30000 31860.0n 0.30000 32039.9n 0.30000 32040.0n 0.70000 32219.9n 0.70000 32220.0n 0.70000 32399.9n 0.70000 32400.0n 0.30000 32579.9n 0.30000 32580.0n 0.30000 32759.9n 0.30000 32760.0n 0.70000 32939.9n 0.70000 32940.0n 0.70000 33119.9n 0.70000 33120.0n 0.70000 33299.9n 0.70000 33300.0n 0.70000 33479.9n 0.70000 33480.0n 0.30000 33659.9n 0.30000 33660.0n 0.70000 33839.9n 0.70000 33840.0n 0.70000 34019.9n 0.70000 34020.0n 0.70000 34199.9n 0.70000 34200.0n 0.30000 34379.9n 0.30000 34380.0n 0.30000 34559.9n 0.30000 34560.0n 0.30000 34739.9n 0.30000 34740.0n 0.30000 34919.9n 0.30000 34920.0n 0.30000 35099.9n 0.30000 35100.0n 0.70000 35279.9n 0.70000 35280.0n 0.70000 35459.9n 0.70000 35460.0n 0.30000 35639.9n 0.30000 35640.0n 0.70000 35819.9n 0.70000 35820.0n 0.70000 35999.9n 0.70000 36000.0n 0.30000 36179.9n 0.30000 36180.0n 0.70000 36359.9n 0.70000 36360.0n 0.70000 36539.9n 0.70000 36540.0n 0.70000 36719.9n 0.70000 36720.0n 0.30000 36899.9n 0.30000 36900.0n 0.70000 37079.9n 0.70000 37080.0n 0.30000 37259.9n 0.30000 37260.0n 0.70000 37439.9n 0.70000 37440.0n 0.70000 37619.9n 0.70000 37620.0n 0.30000 37799.9n 0.30000 37800.0n 0.30000 37979.9n 0.30000 37980.0n 0.70000 38159.9n 0.70000 38160.0n 0.70000 38339.9n 0.70000 38340.0n 0.30000 38519.9n 0.30000 38520.0n 0.30000 38699.9n 0.30000 38700.0n 0.70000 38879.9n 0.70000 38880.0n 0.30000 39059.9n 0.30000 39060.0n 0.70000 39239.9n 0.70000 39240.0n 0.30000 39419.9n 0.30000 39420.0n 0.30000 39599.9n 0.30000 39600.0n 0.70000 39779.9n 0.70000 39780.0n 0.30000 39959.9n 0.30000 39960.0n 0.30000 40139.9n 0.30000 40140.0n 0.70000 40319.9n 0.70000 40320.0n 0.30000 40499.9n 0.30000 40500.0n 0.70000 40679.9n 0.70000 40680.0n 0.70000 40859.9n 0.70000 40860.0n 0.70000 41039.9n 0.70000 41040.0n 0.70000 41219.9n 0.70000 41220.0n 0.70000 41399.9n 0.70000 41400.0n 0.70000 41579.9n 0.70000 41580.0n 0.70000 41759.9n 0.70000 41760.0n 0.30000 41939.9n 0.30000 41940.0n 0.30000 42119.9n 0.30000 42120.0n 0.70000 42299.9n 0.70000 42300.0n 0.30000 42479.9n 0.30000 42480.0n 0.70000 42659.9n 0.70000 42660.0n 0.30000 42839.9n 0.30000 42840.0n 0.70000 43019.9n 0.70000 43020.0n 0.30000 43199.9n 0.30000 43200.0n 0.70000 43379.9n 0.70000 43380.0n 0.30000 43559.9n 0.30000 43560.0n 0.70000 43739.9n 0.70000 43740.0n 0.30000 43919.9n 0.30000 43920.0n 0.30000 44099.9n 0.30000 44100.0n 0.30000 44279.9n 0.30000 44280.0n 0.30000 44459.9n 0.30000 44460.0n 0.70000 44639.9n 0.70000 44640.0n 0.70000 44819.9n 0.70000 44820.0n 0.70000 44999.9n 0.70000 45000.0n 0.30000 45179.9n 0.30000 45180.0n 0.70000 45359.9n 0.70000 45360.0n 0.30000 45539.9n 0.30000 45540.0n 0.30000 45719.9n 0.30000 45720.0n 0.30000 45899.9n 0.30000 45900.0n 0.30000 46079.9n 0.30000 46080.0n 0.70000 46259.9n 0.70000 46260.0n 0.70000 46439.9n 0.70000 46440.0n 0.30000 46619.9n 0.30000 46620.0n 0.30000 46799.9n 0.30000 46800.0n 0.70000 46979.9n 0.70000 46980.0n 0.70000 47159.9n 0.70000 47160.0n 0.30000 47339.9n 0.30000 47340.0n 0.70000 47519.9n 0.70000 47520.0n 0.30000 47699.9n 0.30000 47700.0n 0.70000 47879.9n 0.70000 47880.0n 0.30000 48059.9n 0.30000 48060.0n 0.70000 48239.9n 0.70000 48240.0n 0.70000 48419.9n 0.70000 48420.0n 0.70000 48599.9n 0.70000 48600.0n 0.70000 48779.9n 0.70000 48780.0n 0.30000 48959.9n 0.30000 48960.0n 0.30000 49139.9n 0.30000 49140.0n 0.70000 49319.9n 0.70000 49320.0n 0.70000 49499.9n 0.70000 49500.0n 0.30000 49679.9n 0.30000 49680.0n 0.70000 49859.9n 0.70000 49860.0n 0.30000 50039.9n 0.30000 50040.0n 0.70000 50219.9n 0.70000 50220.0n 0.30000 50399.9n 0.30000 50400.0n 0.30000 50579.9n 0.30000 50580.0n 0.30000 50759.9n 0.30000 50760.0n 0.30000 50939.9n 0.30000 50940.0n 0.70000 51119.9n 0.70000 51120.0n 0.30000 51299.9n 0.30000 51300.0n 0.30000 51479.9n 0.30000 51480.0n 0.30000 51659.9n 0.30000 51660.0n 0.70000 51839.9n 0.70000 51840.0n 0.30000 52019.9n 0.30000 52020.0n 0.30000 52199.9n 0.30000 52200.0n 0.30000 52379.9n 0.30000 52380.0n 0.30000 52559.9n 0.30000 52560.0n 0.30000 52739.9n 0.30000 52740.0n 0.30000 52919.9n 0.30000 52920.0n 0.70000 53099.9n 0.70000 53100.0n 0.30000 53279.9n 0.30000 53280.0n 0.70000 53459.9n 0.70000 53460.0n 0.70000 53639.9n 0.70000 53640.0n 0.30000 53819.9n 0.30000 53820.0n 0.70000 53999.9n 0.70000 54000.0n 0.30000 54179.9n 0.30000 54180.0n 0.70000 54359.9n 0.70000 54360.0n 0.70000 54539.9n 0.70000 54540.0n 0.70000 54719.9n 0.70000 54720.0n 0.30000 54899.9n 0.30000 54900.0n 0.70000 55079.9n 0.70000 55080.0n 0.70000 55259.9n 0.70000 55260.0n 0.70000 55439.9n 0.70000 55440.0n 0.30000 55619.9n 0.30000 55620.0n 0.70000 55799.9n 0.70000 55800.0n 0.70000 55979.9n 0.70000 55980.0n 0.30000 56159.9n 0.30000 56160.0n 0.70000 56339.9n 0.70000 56340.0n 0.30000 56519.9n 0.30000 56520.0n 0.30000 56699.9n 0.30000 56700.0n 0.70000 56879.9n 0.70000 56880.0n 0.70000 57059.9n 0.70000 57060.0n 0.30000 57239.9n 0.30000 57240.0n 0.30000 57419.9n 0.30000 57420.0n 0.70000 57599.9n 0.70000 57600.0n 0.70000 57779.9n 0.70000 57780.0n 0.30000 57959.9n 0.30000 57960.0n 0.70000 58139.9n 0.70000 58140.0n 0.70000 58319.9n 0.70000 58320.0n 0.30000 58499.9n 0.30000 58500.0n 0.70000 58679.9n 0.70000 58680.0n 0.70000 58859.9n 0.70000 58860.0n 0.30000 59039.9n 0.30000 59040.0n 0.30000 59219.9n 0.30000 59220.0n 0.70000 59399.9n 0.70000 59400.0n 0.30000 59579.9n 0.30000 59580.0n 0.30000 59759.9n 0.30000 59760.0n 0.30000 59939.9n 0.30000 59940.0n 0.30000 60119.9n 0.30000 60120.0n 0.70000 60299.9n 0.70000 60300.0n 0.70000 60479.9n 0.70000 60480.0n 0.70000 60659.9n 0.70000 60660.0n 0.70000 60839.9n 0.70000 60840.0n 0.70000 61019.9n 0.70000 61020.0n 0.70000 61199.9n 0.70000 61200.0n 0.30000 61379.9n 0.30000 61380.0n 0.30000 61559.9n 0.30000 61560.0n 0.30000 61739.9n 0.30000 61740.0n 0.70000 61919.9n 0.70000 61920.0n 0.30000 62099.9n 0.30000 62100.0n 0.70000 62279.9n 0.70000 62280.0n 0.30000 62459.9n 0.30000 62460.0n 0.30000 62639.9n 0.30000 62640.0n 0.70000 62819.9n 0.70000 62820.0n 0.70000 62999.9n 0.70000 63000.0n 0.30000 63179.9n 0.30000 63180.0n 0.30000 63359.9n 0.30000 63360.0n 0.30000 63539.9n 0.30000 63540.0n 0.30000 63719.9n 0.30000 63720.0n 0.30000 63899.9n 0.30000 63900.0n 0.30000 64079.9n 0.30000 64080.0n 0.30000 64259.9n 0.30000 64260.0n 0.70000 64439.9n 0.70000 64440.0n 0.30000 64619.9n 0.30000 64620.0n 0.30000 64799.9n 0.30000 64800.0n 0.70000 64979.9n 0.70000 64980.0n 0.70000 65159.9n 0.70000 65160.0n 0.70000 65339.9n 0.70000 65340.0n 0.30000 65519.9n 0.30000 65520.0n 0.30000 65699.9n 0.30000 65700.0n 0.70000 65879.9n 0.70000 65880.0n 0.70000 66059.9n 0.70000 66060.0n 0.30000 66239.9n 0.30000 66240.0n 0.30000 66419.9n 0.30000 66420.0n 0.70000 66599.9n 0.70000 66600.0n 0.70000 66779.9n 0.70000 66780.0n 0.30000 66959.9n 0.30000 66960.0n 0.30000 67139.9n 0.30000 67140.0n 0.70000 67319.9n 0.70000 67320.0n 0.70000 67499.9n 0.70000 67500.0n 0.70000 67679.9n 0.70000 67680.0n 0.70000 67859.9n 0.70000 67860.0n 0.30000 68039.9n 0.30000 68040.0n 0.70000 68219.9n 0.70000 68220.0n 0.30000 68399.9n 0.30000 68400.0n 0.70000 68579.9n 0.70000 68580.0n 0.70000 68759.9n 0.70000 68760.0n 0.70000 68939.9n 0.70000 68940.0n 0.30000 69119.9n 0.30000 69120.0n 0.30000 69299.9n 0.30000 69300.0n 0.70000 69479.9n 0.70000 69480.0n 0.70000 69659.9n 0.70000 69660.0n 0.70000 69839.9n 0.70000 69840.0n 0.30000 70019.9n 0.30000 70020.0n 0.70000 70199.9n 0.70000 70200.0n 0.30000 70379.9n 0.30000 70380.0n 0.30000 70559.9n 0.30000 70560.0n 0.70000 70739.9n 0.70000 70740.0n 0.30000 70919.9n 0.30000 70920.0n 0.70000 71099.9n 0.70000 71100.0n 0.70000 71279.9n 0.70000 71280.0n 0.30000 71459.9n 0.30000 71460.0n 0.70000 71639.9n 0.70000 71640.0n 0.70000 71819.9n 0.70000 71820.0n 0.30000 71999.9n 0.30000 72000.0n 0.70000 72179.9n 0.70000 72180.0n 0.30000 72359.9n 0.30000 72360.0n 0.30000 72539.9n 0.30000 72540.0n 0.70000 72719.9n 0.70000 72720.0n 0.30000 72899.9n 0.30000 72900.0n 0.70000 73079.9n 0.70000 73080.0n 0.70000 73259.9n 0.70000 73260.0n 0.30000 73439.9n 0.30000 73440.0n 0.70000 73619.9n 0.70000 73620.0n 0.30000 73799.9n 0.30000 73800.0n 0.70000 73979.9n 0.70000 73980.0n 0.30000 74159.9n 0.30000 74160.0n 0.70000 74339.9n 0.70000 74340.0n 0.30000 74519.9n 0.30000 74520.0n 0.30000 74699.9n 0.30000 74700.0n 0.30000 74879.9n 0.30000 74880.0n 0.70000 75059.9n 0.70000 75060.0n 0.70000 75239.9n 0.70000 75240.0n 0.30000 75419.9n 0.30000 75420.0n 0.70000 75599.9n 0.70000 75600.0n 0.70000 75779.9n 0.70000 75780.0n 0.30000 75959.9n 0.30000 75960.0n 0.70000 76139.9n 0.70000 76140.0n 0.30000 76319.9n 0.30000 76320.0n 0.70000 76499.9n 0.70000 76500.0n 0.70000 76679.9n 0.70000 76680.0n 0.70000 76859.9n 0.70000 76860.0n 0.70000 77039.9n 0.70000 77040.0n 0.70000 77219.9n 0.70000 77220.0n 0.70000 77399.9n 0.70000 77400.0n 0.30000 77579.9n 0.30000 77580.0n 0.30000 77759.9n 0.30000 77760.0n 0.30000 77939.9n 0.30000 77940.0n 0.30000 78119.9n 0.30000 78120.0n 0.30000 78299.9n 0.30000 78300.0n 0.30000 78479.9n 0.30000 78480.0n 0.70000 78659.9n 0.70000 78660.0n 0.70000 78839.9n 0.70000 78840.0n 0.30000 79019.9n 0.30000 79020.0n 0.30000 79199.9n 0.30000 79200.0n 0.30000 79379.9n 0.30000 79380.0n 0.30000 79559.9n 0.30000 79560.0n 0.70000 79739.9n 0.70000 79740.0n 0.30000 79919.9n 0.30000 79920.0n 0.30000 80099.9n 0.30000 80100.0n 0.30000 80279.9n 0.30000 80280.0n 0.70000 80459.9n 0.70000 80460.0n 0.70000 80639.9n 0.70000 80640.0n 0.30000 80819.9n 0.30000 80820.0n 0.70000 80999.9n 0.70000 81000.0n 0.30000 81179.9n 0.30000 81180.0n 0.30000 81359.9n 0.30000 81360.0n 0.30000 81539.9n 0.30000 81540.0n 0.30000 81719.9n 0.30000 81720.0n 0.30000 81899.9n 0.30000 81900.0n 0.70000 82079.9n 0.70000 82080.0n 0.70000 82259.9n 0.70000 82260.0n 0.70000 82439.9n 0.70000 82440.0n 0.70000 82619.9n 0.70000 82620.0n 0.70000 82799.9n 0.70000 82800.0n 0.70000 82979.9n 0.70000 82980.0n 0.70000 83159.9n 0.70000 83160.0n 0.30000 83339.9n 0.30000 83340.0n 0.70000 83519.9n 0.70000 83520.0n 0.70000 83699.9n 0.70000 83700.0n 0.30000 83879.9n 0.30000 83880.0n 0.70000 84059.9n 0.70000 84060.0n 0.30000 84239.9n 0.30000 84240.0n 0.70000 84419.9n 0.70000 84420.0n 0.30000 84599.9n 0.30000 84600.0n 0.30000 84779.9n 0.30000 84780.0n 0.30000 84959.9n 0.30000 84960.0n 0.30000 85139.9n 0.30000 85140.0n 0.30000 85319.9n 0.30000 85320.0n 0.70000 85499.9n 0.70000 85500.0n 0.30000 85679.9n 0.30000 85680.0n 0.70000 85859.9n 0.70000 85860.0n 0.70000 86039.9n 0.70000 86040.0n 0.30000 86219.9n 0.30000 86220.0n 0.70000 86399.9n 0.70000 86400.0n 0.30000 86579.9n 0.30000 86580.0n 0.30000 86759.9n 0.30000 86760.0n 0.70000 86939.9n 0.70000 86940.0n 0.30000 87119.9n 0.30000 87120.0n 0.70000 87299.9n 0.70000 87300.0n 0.30000 87479.9n 0.30000 87480.0n 0.70000 87659.9n 0.70000 87660.0n 0.70000 87839.9n 0.70000 87840.0n 0.30000 88019.9n 0.30000 88020.0n 0.70000 88199.9n 0.70000 88200.0n 0.70000 88379.9n 0.70000 88380.0n 0.70000 88559.9n 0.70000 88560.0n 0.30000 88739.9n 0.30000 88740.0n 0.70000 88919.9n 0.70000 88920.0n 0.70000 89099.9n 0.70000 89100.0n 0.70000 89279.9n 0.70000 89280.0n 0.70000 89459.9n 0.70000 89460.0n 0.70000 89639.9n 0.70000 89640.0n 0.30000 89819.9n 0.30000 89820.0n 0.30000 89999.9n 0.30000 90000.0n 0.30000 90179.9n 0.30000 90180.0n 0.30000 90359.9n 0.30000 90360.0n 0.70000 90539.9n 0.70000 90540.0n 0.70000 90719.9n 0.70000 90720.0n 0.30000 90899.9n 0.30000 90900.0n 0.30000 91079.9n 0.30000 91080.0n 0.30000 91259.9n 0.30000 91260.0n 0.70000 91439.9n 0.70000 91440.0n 0.30000 91619.9n 0.30000 91620.0n 0.70000 91799.9n 0.70000 91800.0n 0.30000 91979.9n 0.30000 91980.0n 0.30000 92159.9n 0.30000 92160.0n 0.70000 92339.9n 0.70000 92340.0n 0.30000 92519.9n 0.30000 92520.0n 0.30000 92699.9n 0.30000 92700.0n 0.70000 92879.9n 0.70000 92880.0n 0.70000 93059.9n 0.70000 93060.0n 0.70000 93239.9n 0.70000 93240.0n 0.70000 93419.9n 0.70000 93420.0n 0.30000 93599.9n 0.30000 93600.0n 0.30000 93779.9n 0.30000 93780.0n 0.70000 93959.9n 0.70000 93960.0n 0.30000 94139.9n 0.30000 94140.0n 0.70000 94319.9n 0.70000 94320.0n 0.30000 94499.9n 0.30000 94500.0n 0.70000 94679.9n 0.70000 94680.0n 0.30000 94859.9n 0.30000 94860.0n 0.30000 95039.9n 0.30000 95040.0n 0.30000 95219.9n 0.30000 95220.0n 0.30000 95399.9n 0.30000 95400.0n 0.70000 95579.9n 0.70000 95580.0n 0.70000 95759.9n 0.70000 95760.0n 0.30000 95939.9n 0.30000 95940.0n 0.30000 96119.9n 0.30000 96120.0n 0.70000 96299.9n 0.70000 96300.0n 0.70000 96479.9n 0.70000 96480.0n 0.30000 96659.9n 0.30000 96660.0n 0.30000 96839.9n 0.30000 96840.0n 0.30000 97019.9n 0.30000 97020.0n 0.70000 97199.9n 0.70000 97200.0n 0.70000 97379.9n 0.70000 97380.0n 0.30000 97559.9n 0.30000 97560.0n 0.70000 97739.9n 0.70000 97740.0n 0.70000 97919.9n 0.70000 97920.0n 0.30000 98099.9n 0.30000 98100.0n 0.70000 98279.9n 0.70000 98280.0n 0.70000 98459.9n 0.70000 98460.0n 0.70000 98639.9n 0.70000 98640.0n 0.30000 98819.9n 0.30000 98820.0n 0.30000 98999.9n 0.30000 99000.0n 0.30000 99179.9n 0.30000 99180.0n 0.30000 99359.9n 0.30000 99360.0n 0.70000 99539.9n 0.70000 99540.0n 0.70000 99719.9n 0.70000 99720.0n 0.30000 99899.9n 0.30000 99900.0n 0.30000 100079.9n 0.30000 100080.0n 0.70000 100259.9n 0.70000 100260.0n 0.70000 100439.9n 0.70000 100440.0n 0.70000 100619.9n 0.70000 100620.0n 0.30000 100799.9n 0.30000 100800.0n 0.70000 100979.9n 0.70000 100980.0n 0.70000 101159.9n 0.70000 101160.0n 0.30000 101339.9n 0.30000 101340.0n 0.70000 101519.9n 0.70000 101520.0n 0.70000 101699.9n 0.70000 101700.0n 0.30000 101879.9n 0.30000 101880.0n 0.30000 102059.9n 0.30000 102060.0n 0.30000 102239.9n 0.30000 102240.0n 0.30000 102419.9n 0.30000 102420.0n 0.70000 102599.9n 0.70000 102600.0n 0.70000 102779.9n 0.70000 102780.0n 0.30000 102959.9n 0.30000 102960.0n 0.70000 103139.9n 0.70000 103140.0n 0.70000 103319.9n 0.70000 103320.0n 0.30000 103499.9n 0.30000 103500.0n 0.30000 103679.9n 0.30000 103680.0n 0.70000 103859.9n 0.70000 103860.0n 0.30000 104039.9n 0.30000 104040.0n 0.70000 104219.9n 0.70000 104220.0n 0.70000 104399.9n 0.70000 104400.0n 0.70000 104579.9n 0.70000 104580.0n 0.70000 104759.9n 0.70000 104760.0n 0.30000 104939.9n 0.30000 104940.0n 0.30000 105119.9n 0.30000 105120.0n 0.30000 105299.9n 0.30000 105300.0n 0.70000 105479.9n 0.70000 105480.0n 0.30000 105659.9n 0.30000 105660.0n 0.30000 105839.9n 0.30000 105840.0n 0.30000 106019.9n 0.30000 106020.0n 0.30000 106199.9n 0.30000 106200.0n 0.70000 106379.9n 0.70000 106380.0n 0.70000 106559.9n 0.70000 106560.0n 0.70000 106739.9n 0.70000 106740.0n 0.70000 106919.9n 0.70000 106920.0n 0.30000 107099.9n 0.30000 107100.0n 0.30000 107279.9n 0.30000 107280.0n 0.70000 107459.9n 0.70000 107460.0n 0.70000 107639.9n 0.70000 107640.0n 0.70000 107819.9n 0.70000 107820.0n 0.30000 107999.9n 0.30000 108000.0n 0.70000 108179.9n 0.70000 108180.0n 0.30000 108359.9n 0.30000 108360.0n 0.30000 108539.9n 0.30000 108540.0n 0.30000 108719.9n 0.30000 108720.0n 0.70000 108899.9n 0.70000 108900.0n 0.30000 109079.9n 0.30000 109080.0n 0.30000 109259.9n 0.30000 109260.0n 0.70000 109439.9n 0.70000 109440.0n 0.30000 109619.9n 0.30000 109620.0n 0.70000 109799.9n 0.70000 109800.0n 0.30000 109979.9n 0.30000 109980.0n 0.70000 110159.9n 0.70000 110160.0n 0.70000 110339.9n 0.70000 110340.0n 0.70000 110519.9n 0.70000 110520.0n 0.30000 110699.9n 0.30000 110700.0n 0.70000 110879.9n 0.70000 110880.0n 0.30000 111059.9n 0.30000 111060.0n 0.70000 111239.9n 0.70000 111240.0n 0.30000 111419.9n 0.30000 111420.0n 0.30000 111599.9n 0.30000 111600.0n 0.70000 111779.9n 0.70000 111780.0n 0.70000 111959.9n 0.70000 111960.0n 0.30000 112139.9n 0.30000 112140.0n 0.30000 112319.9n 0.30000 112320.0n 0.70000 112499.9n 0.70000 112500.0n 0.30000 112679.9n 0.30000 112680.0n 0.70000 112859.9n 0.70000 112860.0n 0.70000 113039.9n 0.70000 113040.0n 0.30000 113219.9n 0.30000 113220.0n 0.70000 113399.9n 0.70000 113400.0n 0.70000 113579.9n 0.70000 113580.0n 0.30000 113759.9n 0.30000 113760.0n 0.30000 113939.9n 0.30000 113940.0n 0.70000 114119.9n 0.70000 114120.0n 0.30000 114299.9n 0.30000 114300.0n 0.30000 114479.9n 0.30000 114480.0n 0.30000 114659.9n 0.30000 114660.0n 0.70000 114839.9n 0.70000 114840.0n 0.70000 115019.9n 0.70000 115020.0n 0.30000 115199.9n 0.30000 115200.0n 0.70000 115379.9n 0.70000 115380.0n 0.30000 115559.9n 0.30000 115560.0n 0.30000 115739.9n 0.30000 115740.0n 0.30000 115919.9n 0.30000 115920.0n 0.30000 116099.9n 0.30000 116100.0n 0.30000 116279.9n 0.30000 116280.0n 0.30000 116459.9n 0.30000 116460.0n 0.70000 116639.9n 0.70000 116640.0n 0.70000 116819.9n 0.70000 116820.0n 0.70000 116999.9n 0.70000 117000.0n 0.30000 117179.9n 0.30000 117180.0n 0.30000 117359.9n 0.30000 117360.0n 0.70000 117539.9n 0.70000 117540.0n 0.70000 117719.9n 0.70000 117720.0n 0.30000 117899.9n 0.30000 117900.0n 0.30000 118079.9n 0.30000 118080.0n 0.70000 118259.9n 0.70000 118260.0n 0.70000 118439.9n 0.70000 118440.0n 0.30000 118619.9n 0.30000 118620.0n 0.30000 118799.9n 0.30000 118800.0n 0.70000 118979.9n 0.70000 118980.0n 0.70000 119159.9n 0.70000 119160.0n 0.70000 119339.9n 0.70000 119340.0n 0.70000 119519.9n 0.70000 119520.0n 0.70000 119699.9n 0.70000 119700.0n 0.70000 119879.9n 0.70000 119880.0n 0.30000 120059.9n 0.30000 120060.0n 0.30000 120239.9n 0.30000 120240.0n 0.70000 120419.9n 0.70000 120420.0n 0.30000 120599.9n 0.30000 120600.0n 0.30000 120779.9n 0.30000 120780.0n 0.70000 120959.9n 0.70000 120960.0n 0.70000 121139.9n 0.70000 121140.0n 0.30000 121319.9n 0.30000 121320.0n 0.30000 121499.9n 0.30000 121500.0n 0.30000 121679.9n 0.30000 121680.0n 0.30000 121859.9n 0.30000 121860.0n 0.30000 122039.9n 0.30000 122040.0n 0.70000 122219.9n 0.70000 122220.0n 0.30000 122399.9n 0.30000 122400.0n 0.30000 122579.9n 0.30000 122580.0n 0.30000 122759.9n 0.30000 122760.0n 0.70000 122939.9n 0.70000 122940.0n 0.70000 123119.9n 0.70000 123120.0n 0.70000 123299.9n 0.70000 123300.0n 0.70000 123479.9n 0.70000 123480.0n 0.30000 123659.9n 0.30000 123660.0n 0.30000 123839.9n 0.30000 123840.0n 0.30000 124019.9n 0.30000 124020.0n 0.70000 124199.9n 0.70000 124200.0n 0.30000 124379.9n 0.30000 124380.0n 0.70000 124559.9n 0.70000 124560.0n 0.30000 124739.9n 0.30000 124740.0n 0.70000 124919.9n 0.70000 124920.0n 0.70000 125099.9n 0.70000 125100.0n 0.70000 125279.9n 0.70000 125280.0n 0.70000 125459.9n 0.70000 125460.0n 0.30000 125639.9n 0.30000 125640.0n 0.70000 125819.9n 0.70000 125820.0n 0.70000 125999.9n 0.70000 126000.0n 0.30000 126179.9n 0.30000 126180.0n 0.30000 126359.9n 0.30000 126360.0n 0.70000 126539.9n 0.70000 126540.0n 0.70000 126719.9n 0.70000 126720.0n 0.30000 126899.9n 0.30000 126900.0n 0.70000 127079.9n 0.70000 127080.0n 0.30000 127259.9n 0.30000 127260.0n 0.70000 127439.9n 0.70000 127440.0n 0.30000 127619.9n 0.30000 127620.0n 0.30000 127799.9n 0.30000 127800.0n 0.30000 127979.9n 0.30000 127980.0n 0.30000 128159.9n 0.30000 128160.0n 0.70000 128339.9n 0.70000 128340.0n 0.70000 128519.9n 0.70000 128520.0n 0.30000 128699.9n 0.30000 128700.0n 0.30000 128879.9n 0.30000 128880.0n 0.30000 129059.9n 0.30000 129060.0n 0.30000 129239.9n 0.30000 129240.0n 0.70000 129419.9n 0.70000 129420.0n 0.70000 129599.9n 0.70000 129600.0n 0.30000 129779.9n 0.30000 129780.0n 0.70000 129959.9n 0.70000 129960.0n 0.30000 130139.9n 0.30000 130140.0n 0.70000 130319.9n 0.70000 130320.0n 0.70000 130499.9n 0.70000 130500.0n 0.70000 130679.9n 0.70000 130680.0n 0.70000 130859.9n 0.70000 130860.0n 0.70000 131039.9n 0.70000 131040.0n 0.30000 131219.9n 0.30000 131220.0n 0.30000 131399.9n 0.30000 131400.0n 0.70000 131579.9n 0.70000 131580.0n 0.30000 131759.9n 0.30000 131760.0n 0.30000 131939.9n 0.30000 131940.0n 0.70000 132119.9n 0.70000 132120.0n 0.70000 132299.9n 0.70000 132300.0n 0.70000 132479.9n 0.70000 132480.0n 0.30000 132659.9n 0.30000 132660.0n 0.30000 132839.9n 0.30000 132840.0n 0.70000 133019.9n 0.70000 133020.0n 0.30000 133199.9n 0.30000 133200.0n 0.30000 133379.9n 0.30000 133380.0n 0.70000 133559.9n 0.70000 133560.0n 0.70000 133739.9n 0.70000 133740.0n 0.70000 133919.9n 0.70000 133920.0n 0.70000 134099.9n 0.70000 134100.0n 0.70000 134279.9n 0.70000 134280.0n 0.70000 134459.9n 0.70000 134460.0n 0.70000 134639.9n 0.70000 134640.0n 0.30000 134819.9n 0.30000 134820.0n 0.30000 134999.9n 0.30000 135000.0n 0.70000 135179.9n 0.70000 135180.0n 0.30000 135359.9n 0.30000 135360.0n 0.70000 135539.9n 0.70000 135540.0n 0.70000 135719.9n 0.70000 135720.0n 0.30000 135899.9n 0.30000 135900.0n 0.30000 136079.9n 0.30000 136080.0n 0.70000 136259.9n 0.70000 136260.0n 0.30000 136439.9n 0.30000 136440.0n 0.70000 136619.9n 0.70000 136620.0n 0.30000 136799.9n 0.30000 136800.0n 0.70000 136979.9n 0.70000 136980.0n 0.70000 137159.9n 0.70000 137160.0n 0.30000 137339.9n 0.30000 137340.0n 0.70000 137519.9n 0.70000 137520.0n 0.30000 137699.9n 0.30000 137700.0n 0.30000 137879.9n 0.30000 137880.0n 0.30000 138059.9n 0.30000 138060.0n 0.30000 138239.9n 0.30000 138240.0n 0.30000 138419.9n 0.30000 138420.0n 0.70000 138599.9n 0.70000 138600.0n 0.70000 138779.9n 0.70000 138780.0n 0.30000 138959.9n 0.30000 138960.0n 0.70000 139139.9n 0.70000 139140.0n 0.70000 139319.9n 0.70000 139320.0n 0.30000 139499.9n 0.30000 139500.0n 0.70000 139679.9n 0.70000 139680.0n 0.30000 139859.9n 0.30000 139860.0n 0.30000 140039.9n 0.30000 140040.0n 0.70000 140219.9n 0.70000 140220.0n 0.30000 140399.9n 0.30000 140400.0n 0.30000 140579.9n 0.30000 140580.0n 0.30000 140759.9n 0.30000 140760.0n 0.30000 140939.9n 0.30000 140940.0n 0.70000 141119.9n 0.70000 141120.0n 0.70000 141299.9n 0.70000 141300.0n 0.70000 141479.9n 0.70000 141480.0n 0.30000 141659.9n 0.30000 141660.0n 0.30000 141839.9n 0.30000 141840.0n 0.70000 142019.9n 0.70000 142020.0n 0.70000 142199.9n 0.70000 142200.0n 0.70000 142379.9n 0.70000 142380.0n 0.30000 142559.9n 0.30000 142560.0n 0.70000 142739.9n 0.70000 142740.0n 0.30000 142919.9n 0.30000 142920.0n 0.70000 143099.9n 0.70000 143100.0n 0.30000 143279.9n 0.30000 143280.0n 0.70000 143459.9n 0.70000 143460.0n 0.30000 143639.9n 0.30000 143640.0n 0.70000 143819.9n 0.70000 143820.0n 0.30000 143999.9n 0.30000 144000.0n 0.70000 144179.9n 0.70000 144180.0n 0.70000 144359.9n 0.70000 144360.0n 0.30000 144539.9n 0.30000 144540.0n 0.70000 144719.9n 0.70000 144720.0n 0.30000 144899.9n 0.30000 144900.0n 0.30000 145079.9n 0.30000 145080.0n 0.70000 145259.9n 0.70000 145260.0n 0.70000 145439.9n 0.70000 145440.0n 0.30000 145619.9n 0.30000 145620.0n 0.70000 145799.9n 0.70000 145800.0n 0.30000 145979.9n 0.30000 145980.0n 0.30000 146159.9n 0.30000 146160.0n 0.70000 146339.9n 0.70000 146340.0n 0.30000 146519.9n 0.30000 146520.0n 0.70000 146699.9n 0.70000 146700.0n 0.30000 146879.9n 0.30000 146880.0n 0.70000 147059.9n 0.70000 147060.0n 0.30000 147239.9n 0.30000 147240.0n 0.70000 147419.9n 0.70000 147420.0n 0.70000 147599.9n 0.70000 147600.0n 0.30000 147779.9n 0.30000 147780.0n 0.70000 147959.9n 0.70000 147960.0n 0.30000 148139.9n 0.30000 148140.0n 0.70000 148319.9n 0.70000 148320.0n 0.30000 148499.9n 0.30000 148500.0n 0.70000 148679.9n 0.70000 148680.0n 0.30000 148859.9n 0.30000 148860.0n 0.30000 149039.9n 0.30000 149040.0n 0.70000 149219.9n 0.70000 149220.0n 0.30000 149399.9n 0.30000 149400.0n 0.30000 149579.9n 0.30000 149580.0n 0.70000 149759.9n 0.70000 149760.0n 0.70000 149939.9n 0.70000 149940.0n 0.30000 150119.9n 0.30000 150120.0n 0.70000 150299.9n 0.70000 150300.0n 0.70000 150479.9n 0.70000 150480.0n 0.30000 150659.9n 0.30000 150660.0n 0.30000 150839.9n 0.30000 150840.0n 0.70000 151019.9n 0.70000 151020.0n 0.70000 151199.9n 0.70000 151200.0n 0.30000 151379.9n 0.30000 151380.0n 0.70000 151559.9n 0.70000 151560.0n 0.70000 151739.9n 0.70000 151740.0n 0.70000 151919.9n 0.70000 151920.0n 0.70000 152099.9n 0.70000 152100.0n 0.70000 152279.9n 0.70000 152280.0n 0.30000 152459.9n 0.30000 152460.0n 0.70000 152639.9n 0.70000 152640.0n 0.30000 152819.9n 0.30000 152820.0n 0.30000 152999.9n 0.30000 153000.0n 0.70000 153179.9n 0.70000 153180.0n 0.70000 153359.9n 0.70000 153360.0n 0.30000 153539.9n 0.30000 153540.0n 0.70000 153719.9n 0.70000 153720.0n 0.30000 153899.9n 0.30000 153900.0n 0.30000 154079.9n 0.30000 154080.0n 0.70000 154259.9n 0.70000 154260.0n 0.30000 154439.9n 0.30000 154440.0n 0.30000 154619.9n 0.30000 154620.0n 0.30000 154799.9n 0.30000 154800.0n 0.30000 154979.9n 0.30000 154980.0n 0.70000 155159.9n 0.70000 155160.0n 0.30000 155339.9n 0.30000 155340.0n 0.30000 155519.9n 0.30000 155520.0n 0.70000 155699.9n 0.70000 155700.0n 0.30000 155879.9n 0.30000 155880.0n 0.30000 156059.9n 0.30000 156060.0n 0.30000 156239.9n 0.30000 156240.0n 0.70000 156419.9n 0.70000 156420.0n 0.70000 156599.9n 0.70000 156600.0n 0.70000 156779.9n 0.70000 156780.0n 0.70000 156959.9n 0.70000 156960.0n 0.70000 157139.9n 0.70000 157140.0n 0.70000 157319.9n 0.70000 157320.0n 0.30000 157499.9n 0.30000 157500.0n 0.30000 157679.9n 0.30000 157680.0n 0.70000 157859.9n 0.70000 157860.0n 0.30000 158039.9n 0.30000 158040.0n 0.70000 158219.9n 0.70000 158220.0n 0.30000 158399.9n 0.30000 158400.0n 0.70000 158579.9n 0.70000 158580.0n 0.70000 158759.9n 0.70000 158760.0n 0.30000 158939.9n 0.30000 158940.0n 0.30000 159119.9n 0.30000 159120.0n 0.30000 159299.9n 0.30000 159300.0n 0.30000 159479.9n 0.30000 159480.0n 0.70000 159659.9n 0.70000 159660.0n 0.30000 159839.9n 0.30000 159840.0n 0.30000 160019.9n 0.30000 160020.0n 0.70000 160199.9n 0.70000 160200.0n 0.70000 160379.9n 0.70000 160380.0n 0.30000 160559.9n 0.30000 160560.0n 0.30000 160739.9n 0.30000 160740.0n 0.30000 160919.9n 0.30000 160920.0n 0.70000 161099.9n 0.70000 161100.0n 0.70000 161279.9n 0.70000 161280.0n 0.70000 161459.9n 0.70000 161460.0n 0.30000 161639.9n 0.30000 161640.0n 0.70000 161819.9n 0.70000 161820.0n 0.70000 161999.9n 0.70000 162000.0n 0.70000 162179.9n 0.70000 162180.0n 0.30000 162359.9n 0.30000 162360.0n 0.70000 162539.9n 0.70000 162540.0n 0.70000 162719.9n 0.70000 162720.0n 0.30000 162899.9n 0.30000 162900.0n 0.70000 163079.9n 0.70000 163080.0n 0.30000 163259.9n 0.30000 163260.0n 0.30000 163439.9n 0.30000 163440.0n 0.70000 163619.9n 0.70000 163620.0n 0.30000 163799.9n 0.30000 163800.0n 0.70000 163979.9n 0.70000 163980.0n 0.70000 164159.9n 0.70000 164160.0n 0.70000 164339.9n 0.70000 164340.0n 0.70000 164519.9n 0.70000 164520.0n 0.70000 164699.9n 0.70000 164700.0n 0.30000 164879.9n 0.30000 164880.0n 0.30000 165059.9n 0.30000 165060.0n 0.30000 165239.9n 0.30000 165240.0n 0.30000 165419.9n 0.30000 165420.0n 0.30000 165599.9n 0.30000 165600.0n 0.30000 165779.9n 0.30000 165780.0n 0.30000 165959.9n 0.30000 165960.0n 0.70000 166139.9n 0.70000 166140.0n 0.70000 166319.9n 0.70000 166320.0n 0.70000 166499.9n 0.70000 166500.0n 0.30000 166679.9n 0.30000 166680.0n 0.30000 166859.9n 0.30000 166860.0n 0.30000 167039.9n 0.30000 167040.0n 0.30000 167219.9n 0.30000 167220.0n 0.30000 167399.9n 0.30000 167400.0n 0.70000 167579.9n 0.70000 167580.0n 0.70000 167759.9n 0.70000 167760.0n 0.30000 167939.9n 0.30000 167940.0n 0.30000 168119.9n 0.30000 168120.0n 0.30000 168299.9n 0.30000 168300.0n 0.30000 168479.9n 0.30000 168480.0n 0.70000 168659.9n 0.70000 168660.0n 0.30000 168839.9n 0.30000 168840.0n 0.30000 169019.9n 0.30000 169020.0n 0.70000 169199.9n 0.70000 169200.0n 0.70000 169379.9n 0.70000 169380.0n 0.70000 169559.9n 0.70000 169560.0n 0.70000 169739.9n 0.70000 169740.0n 0.30000 169919.9n 0.30000 169920.0n 0.70000 170099.9n 0.70000 170100.0n 0.30000 170279.9n 0.30000 170280.0n 0.30000 170459.9n 0.30000 170460.0n 0.70000 170639.9n 0.70000 170640.0n 0.70000 170819.9n 0.70000 170820.0n 0.70000 170999.9n 0.70000 171000.0n 0.70000 171179.9n 0.70000 171180.0n 0.30000 171359.9n 0.30000 171360.0n 0.30000 171539.9n 0.30000 171540.0n 0.30000 171719.9n 0.30000 171720.0n 0.30000 171899.9n 0.30000 171900.0n 0.30000 172079.9n 0.30000 172080.0n 0.70000 172259.9n 0.70000 172260.0n 0.70000 172439.9n 0.70000 172440.0n 0.70000 172619.9n 0.70000 172620.0n 0.70000 172799.9n 0.70000 172800.0n 0.50000 172979.9n 0.50000 172980.0n 0.50000 173159.9n 0.50000 173160.0n 0.50000 173339.9n 0.50000 173340.0n 0.50000 173519.9n 0.50000 173520.0n 0.50000 173699.9n 0.50000 173700.0n 0.50000 173879.9n 0.50000 173880.0n 0.50000 174059.9n 0.50000 174060.0n 0.50000 174239.9n 0.50000 174240.0n 0.50000 174419.9n 0.50000 174420.0n 0.50000 174599.9n 0.50000 174600.0n 0.50000 174779.9n 0.50000 174780.0n 0.50000 174959.9n 0.50000 174960.0n 0.50000 175139.9n 0.50000 175140.0n 0.50000 175319.9n 0.50000 175320.0n 0.50000 175499.9n 0.50000 175500.0n 0.50000 175679.9n 0.50000 175680.0n 0.50000 175859.9n 0.50000 175860.0n 0.50000 176039.9n 0.50000 176040.0n 0.50000 176219.9n 0.50000 176220.0n 0.50000 176399.9n 0.50000 176400.0n 0.50000 176579.9n 0.50000 176580.0n 0.50000 176759.9n 0.50000 176760.0n 0.50000 176939.9n 0.50000 176940.0n 0.50000 177119.9n 0.50000 177120.0n 0.50000 177299.9n 0.50000 177300.0n 0.50000 177479.9n 0.50000 177480.0n 0.50000 177659.9n 0.50000 177660.0n 0.50000 177839.9n 0.50000 177840.0n 0.50000 178019.9n 0.50000 178020.0n 0.50000 178199.9n 0.50000 178200.0n 0.50000 178379.9n 0.50000 178380.0n 0.50000 178559.9n 0.50000 178560.0n 0.50000 178739.9n 0.50000 178740.0n 0.50000 178919.9n 0.50000 178920.0n 0.50000 179099.9n 0.50000 179100.0n 0.50000 179279.9n 0.50000 179280.0n 0.50000 179459.9n 0.50000 179460.0n 0.50000 179639.9n 0.50000 179640.0n 0.50000 179819.9n 0.50000 179820.0n 0.50000 179999.9n 0.50000 180000.0n 0.50000 180179.9n 0.50000 180180.0n 0.50000 180359.9n 0.50000 180360.0n 0.50000 180539.9n 0.50000 180540.0n 0.50000 180719.9n 0.50000 180720.0n 0.50000 180899.9n 0.50000 180900.0n 0.50000 181079.9n 0.50000 181080.0n 0.50000 181259.9n 0.50000 181260.0n 0.50000 181439.9n 0.50000 181440.0n 0.50000 181619.9n 0.50000 181620.0n 0.50000 181799.9n 0.50000 181800.0n 0.50000 181979.9n 0.50000 181980.0n 0.50000 182159.9n 0.50000 182160.0n 0.50000 182339.9n 0.50000 182340.0n 0.50000 182519.9n 0.50000 182520.0n 0.50000 182699.9n 0.50000 182700.0n 0.50000 182879.9n 0.50000 182880.0n 0.50000 183059.9n 0.50000 183060.0n 0.50000 183239.9n 0.50000 183240.0n 0.50000 183419.9n 0.50000 183420.0n 0.50000)
Vxop1 xop1 0 PWL(0.0n 0.30000 179.9n 0.30000 180.0n 0.70000 359.9n 0.70000 360.0n 0.30000 539.9n 0.30000 540.0n 0.30000 719.9n 0.30000 720.0n 0.30000 899.9n 0.30000 900.0n 0.70000 1079.9n 0.70000 1080.0n 0.70000 1259.9n 0.70000 1260.0n 0.70000 1439.9n 0.70000 1440.0n 0.30000 1619.9n 0.30000 1620.0n 0.70000 1799.9n 0.70000 1800.0n 0.70000 1979.9n 0.70000 1980.0n 0.30000 2159.9n 0.30000 2160.0n 0.70000 2339.9n 0.70000 2340.0n 0.70000 2519.9n 0.70000 2520.0n 0.30000 2699.9n 0.30000 2700.0n 0.30000 2879.9n 0.30000 2880.0n 0.70000 3059.9n 0.70000 3060.0n 0.70000 3239.9n 0.70000 3240.0n 0.70000 3419.9n 0.70000 3420.0n 0.30000 3599.9n 0.30000 3600.0n 0.70000 3779.9n 0.70000 3780.0n 0.30000 3959.9n 0.30000 3960.0n 0.70000 4139.9n 0.70000 4140.0n 0.70000 4319.9n 0.70000 4320.0n 0.30000 4499.9n 0.30000 4500.0n 0.70000 4679.9n 0.70000 4680.0n 0.30000 4859.9n 0.30000 4860.0n 0.30000 5039.9n 0.30000 5040.0n 0.30000 5219.9n 0.30000 5220.0n 0.30000 5399.9n 0.30000 5400.0n 0.30000 5579.9n 0.30000 5580.0n 0.70000 5759.9n 0.70000 5760.0n 0.30000 5939.9n 0.30000 5940.0n 0.70000 6119.9n 0.70000 6120.0n 0.30000 6299.9n 0.30000 6300.0n 0.30000 6479.9n 0.30000 6480.0n 0.70000 6659.9n 0.70000 6660.0n 0.70000 6839.9n 0.70000 6840.0n 0.70000 7019.9n 0.70000 7020.0n 0.70000 7199.9n 0.70000 7200.0n 0.70000 7379.9n 0.70000 7380.0n 0.70000 7559.9n 0.70000 7560.0n 0.70000 7739.9n 0.70000 7740.0n 0.30000 7919.9n 0.30000 7920.0n 0.30000 8099.9n 0.30000 8100.0n 0.30000 8279.9n 0.30000 8280.0n 0.70000 8459.9n 0.70000 8460.0n 0.30000 8639.9n 0.30000 8640.0n 0.30000 8819.9n 0.30000 8820.0n 0.30000 8999.9n 0.30000 9000.0n 0.30000 9179.9n 0.30000 9180.0n 0.30000 9359.9n 0.30000 9360.0n 0.70000 9539.9n 0.70000 9540.0n 0.70000 9719.9n 0.70000 9720.0n 0.30000 9899.9n 0.30000 9900.0n 0.70000 10079.9n 0.70000 10080.0n 0.30000 10259.9n 0.30000 10260.0n 0.70000 10439.9n 0.70000 10440.0n 0.30000 10619.9n 0.30000 10620.0n 0.70000 10799.9n 0.70000 10800.0n 0.70000 10979.9n 0.70000 10980.0n 0.30000 11159.9n 0.30000 11160.0n 0.70000 11339.9n 0.70000 11340.0n 0.30000 11519.9n 0.30000 11520.0n 0.30000 11699.9n 0.30000 11700.0n 0.70000 11879.9n 0.70000 11880.0n 0.30000 12059.9n 0.30000 12060.0n 0.30000 12239.9n 0.30000 12240.0n 0.30000 12419.9n 0.30000 12420.0n 0.30000 12599.9n 0.30000 12600.0n 0.70000 12779.9n 0.70000 12780.0n 0.70000 12959.9n 0.70000 12960.0n 0.70000 13139.9n 0.70000 13140.0n 0.70000 13319.9n 0.70000 13320.0n 0.70000 13499.9n 0.70000 13500.0n 0.70000 13679.9n 0.70000 13680.0n 0.70000 13859.9n 0.70000 13860.0n 0.30000 14039.9n 0.30000 14040.0n 0.30000 14219.9n 0.30000 14220.0n 0.30000 14399.9n 0.30000 14400.0n 0.30000 14579.9n 0.30000 14580.0n 0.30000 14759.9n 0.30000 14760.0n 0.70000 14939.9n 0.70000 14940.0n 0.70000 15119.9n 0.70000 15120.0n 0.30000 15299.9n 0.30000 15300.0n 0.70000 15479.9n 0.70000 15480.0n 0.70000 15659.9n 0.70000 15660.0n 0.30000 15839.9n 0.30000 15840.0n 0.70000 16019.9n 0.70000 16020.0n 0.70000 16199.9n 0.70000 16200.0n 0.30000 16379.9n 0.30000 16380.0n 0.30000 16559.9n 0.30000 16560.0n 0.70000 16739.9n 0.70000 16740.0n 0.30000 16919.9n 0.30000 16920.0n 0.30000 17099.9n 0.30000 17100.0n 0.70000 17279.9n 0.70000 17280.0n 0.30000 17459.9n 0.30000 17460.0n 0.30000 17639.9n 0.30000 17640.0n 0.70000 17819.9n 0.70000 17820.0n 0.30000 17999.9n 0.30000 18000.0n 0.70000 18179.9n 0.70000 18180.0n 0.70000 18359.9n 0.70000 18360.0n 0.30000 18539.9n 0.30000 18540.0n 0.70000 18719.9n 0.70000 18720.0n 0.70000 18899.9n 0.70000 18900.0n 0.70000 19079.9n 0.70000 19080.0n 0.70000 19259.9n 0.70000 19260.0n 0.30000 19439.9n 0.30000 19440.0n 0.70000 19619.9n 0.70000 19620.0n 0.30000 19799.9n 0.30000 19800.0n 0.70000 19979.9n 0.70000 19980.0n 0.70000 20159.9n 0.70000 20160.0n 0.30000 20339.9n 0.30000 20340.0n 0.30000 20519.9n 0.30000 20520.0n 0.70000 20699.9n 0.70000 20700.0n 0.30000 20879.9n 0.30000 20880.0n 0.70000 21059.9n 0.70000 21060.0n 0.30000 21239.9n 0.30000 21240.0n 0.70000 21419.9n 0.70000 21420.0n 0.30000 21599.9n 0.30000 21600.0n 0.30000 21779.9n 0.30000 21780.0n 0.30000 21959.9n 0.30000 21960.0n 0.70000 22139.9n 0.70000 22140.0n 0.30000 22319.9n 0.30000 22320.0n 0.70000 22499.9n 0.70000 22500.0n 0.30000 22679.9n 0.30000 22680.0n 0.30000 22859.9n 0.30000 22860.0n 0.70000 23039.9n 0.70000 23040.0n 0.70000 23219.9n 0.70000 23220.0n 0.30000 23399.9n 0.30000 23400.0n 0.70000 23579.9n 0.70000 23580.0n 0.70000 23759.9n 0.70000 23760.0n 0.30000 23939.9n 0.30000 23940.0n 0.70000 24119.9n 0.70000 24120.0n 0.70000 24299.9n 0.70000 24300.0n 0.30000 24479.9n 0.30000 24480.0n 0.30000 24659.9n 0.30000 24660.0n 0.30000 24839.9n 0.30000 24840.0n 0.70000 25019.9n 0.70000 25020.0n 0.70000 25199.9n 0.70000 25200.0n 0.30000 25379.9n 0.30000 25380.0n 0.30000 25559.9n 0.30000 25560.0n 0.30000 25739.9n 0.30000 25740.0n 0.70000 25919.9n 0.70000 25920.0n 0.30000 26099.9n 0.30000 26100.0n 0.70000 26279.9n 0.70000 26280.0n 0.70000 26459.9n 0.70000 26460.0n 0.30000 26639.9n 0.30000 26640.0n 0.70000 26819.9n 0.70000 26820.0n 0.70000 26999.9n 0.70000 27000.0n 0.30000 27179.9n 0.30000 27180.0n 0.30000 27359.9n 0.30000 27360.0n 0.30000 27539.9n 0.30000 27540.0n 0.70000 27719.9n 0.70000 27720.0n 0.70000 27899.9n 0.70000 27900.0n 0.30000 28079.9n 0.30000 28080.0n 0.70000 28259.9n 0.70000 28260.0n 0.70000 28439.9n 0.70000 28440.0n 0.30000 28619.9n 0.30000 28620.0n 0.30000 28799.9n 0.30000 28800.0n 0.30000 28979.9n 0.30000 28980.0n 0.30000 29159.9n 0.30000 29160.0n 0.70000 29339.9n 0.70000 29340.0n 0.70000 29519.9n 0.70000 29520.0n 0.70000 29699.9n 0.70000 29700.0n 0.30000 29879.9n 0.30000 29880.0n 0.30000 30059.9n 0.30000 30060.0n 0.30000 30239.9n 0.30000 30240.0n 0.70000 30419.9n 0.70000 30420.0n 0.70000 30599.9n 0.70000 30600.0n 0.30000 30779.9n 0.30000 30780.0n 0.30000 30959.9n 0.30000 30960.0n 0.70000 31139.9n 0.70000 31140.0n 0.30000 31319.9n 0.30000 31320.0n 0.70000 31499.9n 0.70000 31500.0n 0.30000 31679.9n 0.30000 31680.0n 0.30000 31859.9n 0.30000 31860.0n 0.30000 32039.9n 0.30000 32040.0n 0.70000 32219.9n 0.70000 32220.0n 0.70000 32399.9n 0.70000 32400.0n 0.30000 32579.9n 0.30000 32580.0n 0.30000 32759.9n 0.30000 32760.0n 0.70000 32939.9n 0.70000 32940.0n 0.70000 33119.9n 0.70000 33120.0n 0.70000 33299.9n 0.70000 33300.0n 0.70000 33479.9n 0.70000 33480.0n 0.30000 33659.9n 0.30000 33660.0n 0.70000 33839.9n 0.70000 33840.0n 0.70000 34019.9n 0.70000 34020.0n 0.70000 34199.9n 0.70000 34200.0n 0.30000 34379.9n 0.30000 34380.0n 0.30000 34559.9n 0.30000 34560.0n 0.30000 34739.9n 0.30000 34740.0n 0.30000 34919.9n 0.30000 34920.0n 0.30000 35099.9n 0.30000 35100.0n 0.70000 35279.9n 0.70000 35280.0n 0.70000 35459.9n 0.70000 35460.0n 0.30000 35639.9n 0.30000 35640.0n 0.70000 35819.9n 0.70000 35820.0n 0.70000 35999.9n 0.70000 36000.0n 0.30000 36179.9n 0.30000 36180.0n 0.70000 36359.9n 0.70000 36360.0n 0.70000 36539.9n 0.70000 36540.0n 0.70000 36719.9n 0.70000 36720.0n 0.30000 36899.9n 0.30000 36900.0n 0.70000 37079.9n 0.70000 37080.0n 0.30000 37259.9n 0.30000 37260.0n 0.70000 37439.9n 0.70000 37440.0n 0.70000 37619.9n 0.70000 37620.0n 0.30000 37799.9n 0.30000 37800.0n 0.30000 37979.9n 0.30000 37980.0n 0.70000 38159.9n 0.70000 38160.0n 0.70000 38339.9n 0.70000 38340.0n 0.30000 38519.9n 0.30000 38520.0n 0.30000 38699.9n 0.30000 38700.0n 0.70000 38879.9n 0.70000 38880.0n 0.30000 39059.9n 0.30000 39060.0n 0.70000 39239.9n 0.70000 39240.0n 0.30000 39419.9n 0.30000 39420.0n 0.30000 39599.9n 0.30000 39600.0n 0.70000 39779.9n 0.70000 39780.0n 0.30000 39959.9n 0.30000 39960.0n 0.30000 40139.9n 0.30000 40140.0n 0.70000 40319.9n 0.70000 40320.0n 0.30000 40499.9n 0.30000 40500.0n 0.70000 40679.9n 0.70000 40680.0n 0.70000 40859.9n 0.70000 40860.0n 0.70000 41039.9n 0.70000 41040.0n 0.70000 41219.9n 0.70000 41220.0n 0.70000 41399.9n 0.70000 41400.0n 0.70000 41579.9n 0.70000 41580.0n 0.70000 41759.9n 0.70000 41760.0n 0.30000 41939.9n 0.30000 41940.0n 0.30000 42119.9n 0.30000 42120.0n 0.70000 42299.9n 0.70000 42300.0n 0.30000 42479.9n 0.30000 42480.0n 0.70000 42659.9n 0.70000 42660.0n 0.30000 42839.9n 0.30000 42840.0n 0.70000 43019.9n 0.70000 43020.0n 0.30000 43199.9n 0.30000 43200.0n 0.70000 43379.9n 0.70000 43380.0n 0.30000 43559.9n 0.30000 43560.0n 0.70000 43739.9n 0.70000 43740.0n 0.30000 43919.9n 0.30000 43920.0n 0.30000 44099.9n 0.30000 44100.0n 0.30000 44279.9n 0.30000 44280.0n 0.30000 44459.9n 0.30000 44460.0n 0.70000 44639.9n 0.70000 44640.0n 0.70000 44819.9n 0.70000 44820.0n 0.70000 44999.9n 0.70000 45000.0n 0.30000 45179.9n 0.30000 45180.0n 0.70000 45359.9n 0.70000 45360.0n 0.30000 45539.9n 0.30000 45540.0n 0.30000 45719.9n 0.30000 45720.0n 0.30000 45899.9n 0.30000 45900.0n 0.30000 46079.9n 0.30000 46080.0n 0.70000 46259.9n 0.70000 46260.0n 0.70000 46439.9n 0.70000 46440.0n 0.30000 46619.9n 0.30000 46620.0n 0.30000 46799.9n 0.30000 46800.0n 0.70000 46979.9n 0.70000 46980.0n 0.70000 47159.9n 0.70000 47160.0n 0.30000 47339.9n 0.30000 47340.0n 0.70000 47519.9n 0.70000 47520.0n 0.30000 47699.9n 0.30000 47700.0n 0.70000 47879.9n 0.70000 47880.0n 0.30000 48059.9n 0.30000 48060.0n 0.70000 48239.9n 0.70000 48240.0n 0.70000 48419.9n 0.70000 48420.0n 0.70000 48599.9n 0.70000 48600.0n 0.70000 48779.9n 0.70000 48780.0n 0.30000 48959.9n 0.30000 48960.0n 0.30000 49139.9n 0.30000 49140.0n 0.70000 49319.9n 0.70000 49320.0n 0.70000 49499.9n 0.70000 49500.0n 0.30000 49679.9n 0.30000 49680.0n 0.70000 49859.9n 0.70000 49860.0n 0.30000 50039.9n 0.30000 50040.0n 0.70000 50219.9n 0.70000 50220.0n 0.30000 50399.9n 0.30000 50400.0n 0.30000 50579.9n 0.30000 50580.0n 0.30000 50759.9n 0.30000 50760.0n 0.30000 50939.9n 0.30000 50940.0n 0.70000 51119.9n 0.70000 51120.0n 0.30000 51299.9n 0.30000 51300.0n 0.30000 51479.9n 0.30000 51480.0n 0.30000 51659.9n 0.30000 51660.0n 0.70000 51839.9n 0.70000 51840.0n 0.30000 52019.9n 0.30000 52020.0n 0.30000 52199.9n 0.30000 52200.0n 0.30000 52379.9n 0.30000 52380.0n 0.30000 52559.9n 0.30000 52560.0n 0.30000 52739.9n 0.30000 52740.0n 0.30000 52919.9n 0.30000 52920.0n 0.70000 53099.9n 0.70000 53100.0n 0.30000 53279.9n 0.30000 53280.0n 0.70000 53459.9n 0.70000 53460.0n 0.70000 53639.9n 0.70000 53640.0n 0.30000 53819.9n 0.30000 53820.0n 0.70000 53999.9n 0.70000 54000.0n 0.30000 54179.9n 0.30000 54180.0n 0.70000 54359.9n 0.70000 54360.0n 0.70000 54539.9n 0.70000 54540.0n 0.70000 54719.9n 0.70000 54720.0n 0.30000 54899.9n 0.30000 54900.0n 0.70000 55079.9n 0.70000 55080.0n 0.70000 55259.9n 0.70000 55260.0n 0.70000 55439.9n 0.70000 55440.0n 0.30000 55619.9n 0.30000 55620.0n 0.70000 55799.9n 0.70000 55800.0n 0.70000 55979.9n 0.70000 55980.0n 0.30000 56159.9n 0.30000 56160.0n 0.70000 56339.9n 0.70000 56340.0n 0.30000 56519.9n 0.30000 56520.0n 0.30000 56699.9n 0.30000 56700.0n 0.70000 56879.9n 0.70000 56880.0n 0.70000 57059.9n 0.70000 57060.0n 0.30000 57239.9n 0.30000 57240.0n 0.30000 57419.9n 0.30000 57420.0n 0.70000 57599.9n 0.70000 57600.0n 0.70000 57779.9n 0.70000 57780.0n 0.30000 57959.9n 0.30000 57960.0n 0.70000 58139.9n 0.70000 58140.0n 0.70000 58319.9n 0.70000 58320.0n 0.30000 58499.9n 0.30000 58500.0n 0.70000 58679.9n 0.70000 58680.0n 0.70000 58859.9n 0.70000 58860.0n 0.30000 59039.9n 0.30000 59040.0n 0.30000 59219.9n 0.30000 59220.0n 0.70000 59399.9n 0.70000 59400.0n 0.30000 59579.9n 0.30000 59580.0n 0.30000 59759.9n 0.30000 59760.0n 0.30000 59939.9n 0.30000 59940.0n 0.30000 60119.9n 0.30000 60120.0n 0.70000 60299.9n 0.70000 60300.0n 0.70000 60479.9n 0.70000 60480.0n 0.70000 60659.9n 0.70000 60660.0n 0.70000 60839.9n 0.70000 60840.0n 0.70000 61019.9n 0.70000 61020.0n 0.70000 61199.9n 0.70000 61200.0n 0.30000 61379.9n 0.30000 61380.0n 0.30000 61559.9n 0.30000 61560.0n 0.30000 61739.9n 0.30000 61740.0n 0.70000 61919.9n 0.70000 61920.0n 0.30000 62099.9n 0.30000 62100.0n 0.70000 62279.9n 0.70000 62280.0n 0.30000 62459.9n 0.30000 62460.0n 0.30000 62639.9n 0.30000 62640.0n 0.70000 62819.9n 0.70000 62820.0n 0.70000 62999.9n 0.70000 63000.0n 0.30000 63179.9n 0.30000 63180.0n 0.30000 63359.9n 0.30000 63360.0n 0.30000 63539.9n 0.30000 63540.0n 0.30000 63719.9n 0.30000 63720.0n 0.30000 63899.9n 0.30000 63900.0n 0.30000 64079.9n 0.30000 64080.0n 0.30000 64259.9n 0.30000 64260.0n 0.70000 64439.9n 0.70000 64440.0n 0.30000 64619.9n 0.30000 64620.0n 0.30000 64799.9n 0.30000 64800.0n 0.70000 64979.9n 0.70000 64980.0n 0.70000 65159.9n 0.70000 65160.0n 0.70000 65339.9n 0.70000 65340.0n 0.30000 65519.9n 0.30000 65520.0n 0.30000 65699.9n 0.30000 65700.0n 0.70000 65879.9n 0.70000 65880.0n 0.70000 66059.9n 0.70000 66060.0n 0.30000 66239.9n 0.30000 66240.0n 0.30000 66419.9n 0.30000 66420.0n 0.70000 66599.9n 0.70000 66600.0n 0.70000 66779.9n 0.70000 66780.0n 0.30000 66959.9n 0.30000 66960.0n 0.30000 67139.9n 0.30000 67140.0n 0.70000 67319.9n 0.70000 67320.0n 0.70000 67499.9n 0.70000 67500.0n 0.70000 67679.9n 0.70000 67680.0n 0.70000 67859.9n 0.70000 67860.0n 0.30000 68039.9n 0.30000 68040.0n 0.70000 68219.9n 0.70000 68220.0n 0.30000 68399.9n 0.30000 68400.0n 0.70000 68579.9n 0.70000 68580.0n 0.70000 68759.9n 0.70000 68760.0n 0.70000 68939.9n 0.70000 68940.0n 0.30000 69119.9n 0.30000 69120.0n 0.30000 69299.9n 0.30000 69300.0n 0.70000 69479.9n 0.70000 69480.0n 0.70000 69659.9n 0.70000 69660.0n 0.70000 69839.9n 0.70000 69840.0n 0.30000 70019.9n 0.30000 70020.0n 0.70000 70199.9n 0.70000 70200.0n 0.30000 70379.9n 0.30000 70380.0n 0.30000 70559.9n 0.30000 70560.0n 0.70000 70739.9n 0.70000 70740.0n 0.30000 70919.9n 0.30000 70920.0n 0.70000 71099.9n 0.70000 71100.0n 0.70000 71279.9n 0.70000 71280.0n 0.30000 71459.9n 0.30000 71460.0n 0.70000 71639.9n 0.70000 71640.0n 0.70000 71819.9n 0.70000 71820.0n 0.30000 71999.9n 0.30000 72000.0n 0.70000 72179.9n 0.70000 72180.0n 0.30000 72359.9n 0.30000 72360.0n 0.30000 72539.9n 0.30000 72540.0n 0.70000 72719.9n 0.70000 72720.0n 0.30000 72899.9n 0.30000 72900.0n 0.70000 73079.9n 0.70000 73080.0n 0.70000 73259.9n 0.70000 73260.0n 0.30000 73439.9n 0.30000 73440.0n 0.70000 73619.9n 0.70000 73620.0n 0.30000 73799.9n 0.30000 73800.0n 0.70000 73979.9n 0.70000 73980.0n 0.30000 74159.9n 0.30000 74160.0n 0.70000 74339.9n 0.70000 74340.0n 0.30000 74519.9n 0.30000 74520.0n 0.30000 74699.9n 0.30000 74700.0n 0.30000 74879.9n 0.30000 74880.0n 0.70000 75059.9n 0.70000 75060.0n 0.70000 75239.9n 0.70000 75240.0n 0.30000 75419.9n 0.30000 75420.0n 0.70000 75599.9n 0.70000 75600.0n 0.70000 75779.9n 0.70000 75780.0n 0.30000 75959.9n 0.30000 75960.0n 0.70000 76139.9n 0.70000 76140.0n 0.30000 76319.9n 0.30000 76320.0n 0.70000 76499.9n 0.70000 76500.0n 0.70000 76679.9n 0.70000 76680.0n 0.70000 76859.9n 0.70000 76860.0n 0.70000 77039.9n 0.70000 77040.0n 0.70000 77219.9n 0.70000 77220.0n 0.70000 77399.9n 0.70000 77400.0n 0.30000 77579.9n 0.30000 77580.0n 0.30000 77759.9n 0.30000 77760.0n 0.30000 77939.9n 0.30000 77940.0n 0.30000 78119.9n 0.30000 78120.0n 0.30000 78299.9n 0.30000 78300.0n 0.30000 78479.9n 0.30000 78480.0n 0.70000 78659.9n 0.70000 78660.0n 0.70000 78839.9n 0.70000 78840.0n 0.30000 79019.9n 0.30000 79020.0n 0.30000 79199.9n 0.30000 79200.0n 0.30000 79379.9n 0.30000 79380.0n 0.30000 79559.9n 0.30000 79560.0n 0.70000 79739.9n 0.70000 79740.0n 0.30000 79919.9n 0.30000 79920.0n 0.30000 80099.9n 0.30000 80100.0n 0.30000 80279.9n 0.30000 80280.0n 0.70000 80459.9n 0.70000 80460.0n 0.70000 80639.9n 0.70000 80640.0n 0.30000 80819.9n 0.30000 80820.0n 0.70000 80999.9n 0.70000 81000.0n 0.30000 81179.9n 0.30000 81180.0n 0.30000 81359.9n 0.30000 81360.0n 0.30000 81539.9n 0.30000 81540.0n 0.30000 81719.9n 0.30000 81720.0n 0.30000 81899.9n 0.30000 81900.0n 0.70000 82079.9n 0.70000 82080.0n 0.70000 82259.9n 0.70000 82260.0n 0.70000 82439.9n 0.70000 82440.0n 0.70000 82619.9n 0.70000 82620.0n 0.70000 82799.9n 0.70000 82800.0n 0.70000 82979.9n 0.70000 82980.0n 0.70000 83159.9n 0.70000 83160.0n 0.30000 83339.9n 0.30000 83340.0n 0.70000 83519.9n 0.70000 83520.0n 0.70000 83699.9n 0.70000 83700.0n 0.30000 83879.9n 0.30000 83880.0n 0.70000 84059.9n 0.70000 84060.0n 0.30000 84239.9n 0.30000 84240.0n 0.70000 84419.9n 0.70000 84420.0n 0.30000 84599.9n 0.30000 84600.0n 0.30000 84779.9n 0.30000 84780.0n 0.30000 84959.9n 0.30000 84960.0n 0.30000 85139.9n 0.30000 85140.0n 0.30000 85319.9n 0.30000 85320.0n 0.70000 85499.9n 0.70000 85500.0n 0.30000 85679.9n 0.30000 85680.0n 0.70000 85859.9n 0.70000 85860.0n 0.70000 86039.9n 0.70000 86040.0n 0.30000 86219.9n 0.30000 86220.0n 0.70000 86399.9n 0.70000 86400.0n 0.30000 86579.9n 0.30000 86580.0n 0.30000 86759.9n 0.30000 86760.0n 0.70000 86939.9n 0.70000 86940.0n 0.30000 87119.9n 0.30000 87120.0n 0.70000 87299.9n 0.70000 87300.0n 0.30000 87479.9n 0.30000 87480.0n 0.70000 87659.9n 0.70000 87660.0n 0.70000 87839.9n 0.70000 87840.0n 0.30000 88019.9n 0.30000 88020.0n 0.70000 88199.9n 0.70000 88200.0n 0.70000 88379.9n 0.70000 88380.0n 0.70000 88559.9n 0.70000 88560.0n 0.30000 88739.9n 0.30000 88740.0n 0.70000 88919.9n 0.70000 88920.0n 0.70000 89099.9n 0.70000 89100.0n 0.70000 89279.9n 0.70000 89280.0n 0.70000 89459.9n 0.70000 89460.0n 0.70000 89639.9n 0.70000 89640.0n 0.30000 89819.9n 0.30000 89820.0n 0.30000 89999.9n 0.30000 90000.0n 0.30000 90179.9n 0.30000 90180.0n 0.30000 90359.9n 0.30000 90360.0n 0.70000 90539.9n 0.70000 90540.0n 0.70000 90719.9n 0.70000 90720.0n 0.30000 90899.9n 0.30000 90900.0n 0.30000 91079.9n 0.30000 91080.0n 0.30000 91259.9n 0.30000 91260.0n 0.70000 91439.9n 0.70000 91440.0n 0.30000 91619.9n 0.30000 91620.0n 0.70000 91799.9n 0.70000 91800.0n 0.30000 91979.9n 0.30000 91980.0n 0.30000 92159.9n 0.30000 92160.0n 0.70000 92339.9n 0.70000 92340.0n 0.30000 92519.9n 0.30000 92520.0n 0.30000 92699.9n 0.30000 92700.0n 0.70000 92879.9n 0.70000 92880.0n 0.70000 93059.9n 0.70000 93060.0n 0.70000 93239.9n 0.70000 93240.0n 0.70000 93419.9n 0.70000 93420.0n 0.30000 93599.9n 0.30000 93600.0n 0.30000 93779.9n 0.30000 93780.0n 0.70000 93959.9n 0.70000 93960.0n 0.30000 94139.9n 0.30000 94140.0n 0.70000 94319.9n 0.70000 94320.0n 0.30000 94499.9n 0.30000 94500.0n 0.70000 94679.9n 0.70000 94680.0n 0.30000 94859.9n 0.30000 94860.0n 0.30000 95039.9n 0.30000 95040.0n 0.30000 95219.9n 0.30000 95220.0n 0.30000 95399.9n 0.30000 95400.0n 0.70000 95579.9n 0.70000 95580.0n 0.70000 95759.9n 0.70000 95760.0n 0.30000 95939.9n 0.30000 95940.0n 0.30000 96119.9n 0.30000 96120.0n 0.70000 96299.9n 0.70000 96300.0n 0.70000 96479.9n 0.70000 96480.0n 0.30000 96659.9n 0.30000 96660.0n 0.30000 96839.9n 0.30000 96840.0n 0.30000 97019.9n 0.30000 97020.0n 0.70000 97199.9n 0.70000 97200.0n 0.70000 97379.9n 0.70000 97380.0n 0.30000 97559.9n 0.30000 97560.0n 0.70000 97739.9n 0.70000 97740.0n 0.70000 97919.9n 0.70000 97920.0n 0.30000 98099.9n 0.30000 98100.0n 0.70000 98279.9n 0.70000 98280.0n 0.70000 98459.9n 0.70000 98460.0n 0.70000 98639.9n 0.70000 98640.0n 0.30000 98819.9n 0.30000 98820.0n 0.30000 98999.9n 0.30000 99000.0n 0.30000 99179.9n 0.30000 99180.0n 0.30000 99359.9n 0.30000 99360.0n 0.70000 99539.9n 0.70000 99540.0n 0.70000 99719.9n 0.70000 99720.0n 0.30000 99899.9n 0.30000 99900.0n 0.30000 100079.9n 0.30000 100080.0n 0.70000 100259.9n 0.70000 100260.0n 0.70000 100439.9n 0.70000 100440.0n 0.70000 100619.9n 0.70000 100620.0n 0.30000 100799.9n 0.30000 100800.0n 0.70000 100979.9n 0.70000 100980.0n 0.70000 101159.9n 0.70000 101160.0n 0.30000 101339.9n 0.30000 101340.0n 0.70000 101519.9n 0.70000 101520.0n 0.70000 101699.9n 0.70000 101700.0n 0.30000 101879.9n 0.30000 101880.0n 0.30000 102059.9n 0.30000 102060.0n 0.30000 102239.9n 0.30000 102240.0n 0.30000 102419.9n 0.30000 102420.0n 0.70000 102599.9n 0.70000 102600.0n 0.70000 102779.9n 0.70000 102780.0n 0.30000 102959.9n 0.30000 102960.0n 0.70000 103139.9n 0.70000 103140.0n 0.70000 103319.9n 0.70000 103320.0n 0.30000 103499.9n 0.30000 103500.0n 0.30000 103679.9n 0.30000 103680.0n 0.70000 103859.9n 0.70000 103860.0n 0.30000 104039.9n 0.30000 104040.0n 0.70000 104219.9n 0.70000 104220.0n 0.70000 104399.9n 0.70000 104400.0n 0.70000 104579.9n 0.70000 104580.0n 0.70000 104759.9n 0.70000 104760.0n 0.30000 104939.9n 0.30000 104940.0n 0.30000 105119.9n 0.30000 105120.0n 0.30000 105299.9n 0.30000 105300.0n 0.70000 105479.9n 0.70000 105480.0n 0.30000 105659.9n 0.30000 105660.0n 0.30000 105839.9n 0.30000 105840.0n 0.30000 106019.9n 0.30000 106020.0n 0.30000 106199.9n 0.30000 106200.0n 0.70000 106379.9n 0.70000 106380.0n 0.70000 106559.9n 0.70000 106560.0n 0.70000 106739.9n 0.70000 106740.0n 0.70000 106919.9n 0.70000 106920.0n 0.30000 107099.9n 0.30000 107100.0n 0.30000 107279.9n 0.30000 107280.0n 0.70000 107459.9n 0.70000 107460.0n 0.70000 107639.9n 0.70000 107640.0n 0.70000 107819.9n 0.70000 107820.0n 0.30000 107999.9n 0.30000 108000.0n 0.70000 108179.9n 0.70000 108180.0n 0.30000 108359.9n 0.30000 108360.0n 0.30000 108539.9n 0.30000 108540.0n 0.30000 108719.9n 0.30000 108720.0n 0.70000 108899.9n 0.70000 108900.0n 0.30000 109079.9n 0.30000 109080.0n 0.30000 109259.9n 0.30000 109260.0n 0.70000 109439.9n 0.70000 109440.0n 0.30000 109619.9n 0.30000 109620.0n 0.70000 109799.9n 0.70000 109800.0n 0.30000 109979.9n 0.30000 109980.0n 0.70000 110159.9n 0.70000 110160.0n 0.70000 110339.9n 0.70000 110340.0n 0.70000 110519.9n 0.70000 110520.0n 0.30000 110699.9n 0.30000 110700.0n 0.70000 110879.9n 0.70000 110880.0n 0.30000 111059.9n 0.30000 111060.0n 0.70000 111239.9n 0.70000 111240.0n 0.30000 111419.9n 0.30000 111420.0n 0.30000 111599.9n 0.30000 111600.0n 0.70000 111779.9n 0.70000 111780.0n 0.70000 111959.9n 0.70000 111960.0n 0.30000 112139.9n 0.30000 112140.0n 0.30000 112319.9n 0.30000 112320.0n 0.70000 112499.9n 0.70000 112500.0n 0.30000 112679.9n 0.30000 112680.0n 0.70000 112859.9n 0.70000 112860.0n 0.70000 113039.9n 0.70000 113040.0n 0.30000 113219.9n 0.30000 113220.0n 0.70000 113399.9n 0.70000 113400.0n 0.70000 113579.9n 0.70000 113580.0n 0.30000 113759.9n 0.30000 113760.0n 0.30000 113939.9n 0.30000 113940.0n 0.70000 114119.9n 0.70000 114120.0n 0.30000 114299.9n 0.30000 114300.0n 0.30000 114479.9n 0.30000 114480.0n 0.30000 114659.9n 0.30000 114660.0n 0.70000 114839.9n 0.70000 114840.0n 0.70000 115019.9n 0.70000 115020.0n 0.30000 115199.9n 0.30000 115200.0n 0.70000 115379.9n 0.70000 115380.0n 0.30000 115559.9n 0.30000 115560.0n 0.30000 115739.9n 0.30000 115740.0n 0.30000 115919.9n 0.30000 115920.0n 0.30000 116099.9n 0.30000 116100.0n 0.30000 116279.9n 0.30000 116280.0n 0.30000 116459.9n 0.30000 116460.0n 0.70000 116639.9n 0.70000 116640.0n 0.70000 116819.9n 0.70000 116820.0n 0.70000 116999.9n 0.70000 117000.0n 0.30000 117179.9n 0.30000 117180.0n 0.30000 117359.9n 0.30000 117360.0n 0.70000 117539.9n 0.70000 117540.0n 0.70000 117719.9n 0.70000 117720.0n 0.30000 117899.9n 0.30000 117900.0n 0.30000 118079.9n 0.30000 118080.0n 0.70000 118259.9n 0.70000 118260.0n 0.70000 118439.9n 0.70000 118440.0n 0.30000 118619.9n 0.30000 118620.0n 0.30000 118799.9n 0.30000 118800.0n 0.70000 118979.9n 0.70000 118980.0n 0.70000 119159.9n 0.70000 119160.0n 0.70000 119339.9n 0.70000 119340.0n 0.70000 119519.9n 0.70000 119520.0n 0.70000 119699.9n 0.70000 119700.0n 0.70000 119879.9n 0.70000 119880.0n 0.30000 120059.9n 0.30000 120060.0n 0.30000 120239.9n 0.30000 120240.0n 0.70000 120419.9n 0.70000 120420.0n 0.30000 120599.9n 0.30000 120600.0n 0.30000 120779.9n 0.30000 120780.0n 0.70000 120959.9n 0.70000 120960.0n 0.70000 121139.9n 0.70000 121140.0n 0.30000 121319.9n 0.30000 121320.0n 0.30000 121499.9n 0.30000 121500.0n 0.30000 121679.9n 0.30000 121680.0n 0.30000 121859.9n 0.30000 121860.0n 0.30000 122039.9n 0.30000 122040.0n 0.70000 122219.9n 0.70000 122220.0n 0.30000 122399.9n 0.30000 122400.0n 0.30000 122579.9n 0.30000 122580.0n 0.30000 122759.9n 0.30000 122760.0n 0.70000 122939.9n 0.70000 122940.0n 0.70000 123119.9n 0.70000 123120.0n 0.70000 123299.9n 0.70000 123300.0n 0.70000 123479.9n 0.70000 123480.0n 0.30000 123659.9n 0.30000 123660.0n 0.30000 123839.9n 0.30000 123840.0n 0.30000 124019.9n 0.30000 124020.0n 0.70000 124199.9n 0.70000 124200.0n 0.30000 124379.9n 0.30000 124380.0n 0.70000 124559.9n 0.70000 124560.0n 0.30000 124739.9n 0.30000 124740.0n 0.70000 124919.9n 0.70000 124920.0n 0.70000 125099.9n 0.70000 125100.0n 0.70000 125279.9n 0.70000 125280.0n 0.70000 125459.9n 0.70000 125460.0n 0.30000 125639.9n 0.30000 125640.0n 0.70000 125819.9n 0.70000 125820.0n 0.70000 125999.9n 0.70000 126000.0n 0.30000 126179.9n 0.30000 126180.0n 0.30000 126359.9n 0.30000 126360.0n 0.70000 126539.9n 0.70000 126540.0n 0.70000 126719.9n 0.70000 126720.0n 0.30000 126899.9n 0.30000 126900.0n 0.70000 127079.9n 0.70000 127080.0n 0.30000 127259.9n 0.30000 127260.0n 0.70000 127439.9n 0.70000 127440.0n 0.30000 127619.9n 0.30000 127620.0n 0.30000 127799.9n 0.30000 127800.0n 0.30000 127979.9n 0.30000 127980.0n 0.30000 128159.9n 0.30000 128160.0n 0.70000 128339.9n 0.70000 128340.0n 0.70000 128519.9n 0.70000 128520.0n 0.30000 128699.9n 0.30000 128700.0n 0.30000 128879.9n 0.30000 128880.0n 0.30000 129059.9n 0.30000 129060.0n 0.30000 129239.9n 0.30000 129240.0n 0.70000 129419.9n 0.70000 129420.0n 0.70000 129599.9n 0.70000 129600.0n 0.30000 129779.9n 0.30000 129780.0n 0.70000 129959.9n 0.70000 129960.0n 0.30000 130139.9n 0.30000 130140.0n 0.70000 130319.9n 0.70000 130320.0n 0.70000 130499.9n 0.70000 130500.0n 0.70000 130679.9n 0.70000 130680.0n 0.70000 130859.9n 0.70000 130860.0n 0.70000 131039.9n 0.70000 131040.0n 0.30000 131219.9n 0.30000 131220.0n 0.30000 131399.9n 0.30000 131400.0n 0.70000 131579.9n 0.70000 131580.0n 0.30000 131759.9n 0.30000 131760.0n 0.30000 131939.9n 0.30000 131940.0n 0.70000 132119.9n 0.70000 132120.0n 0.70000 132299.9n 0.70000 132300.0n 0.70000 132479.9n 0.70000 132480.0n 0.30000 132659.9n 0.30000 132660.0n 0.30000 132839.9n 0.30000 132840.0n 0.70000 133019.9n 0.70000 133020.0n 0.30000 133199.9n 0.30000 133200.0n 0.30000 133379.9n 0.30000 133380.0n 0.70000 133559.9n 0.70000 133560.0n 0.70000 133739.9n 0.70000 133740.0n 0.70000 133919.9n 0.70000 133920.0n 0.70000 134099.9n 0.70000 134100.0n 0.70000 134279.9n 0.70000 134280.0n 0.70000 134459.9n 0.70000 134460.0n 0.70000 134639.9n 0.70000 134640.0n 0.30000 134819.9n 0.30000 134820.0n 0.30000 134999.9n 0.30000 135000.0n 0.70000 135179.9n 0.70000 135180.0n 0.30000 135359.9n 0.30000 135360.0n 0.70000 135539.9n 0.70000 135540.0n 0.70000 135719.9n 0.70000 135720.0n 0.30000 135899.9n 0.30000 135900.0n 0.30000 136079.9n 0.30000 136080.0n 0.70000 136259.9n 0.70000 136260.0n 0.30000 136439.9n 0.30000 136440.0n 0.70000 136619.9n 0.70000 136620.0n 0.30000 136799.9n 0.30000 136800.0n 0.70000 136979.9n 0.70000 136980.0n 0.70000 137159.9n 0.70000 137160.0n 0.30000 137339.9n 0.30000 137340.0n 0.70000 137519.9n 0.70000 137520.0n 0.30000 137699.9n 0.30000 137700.0n 0.30000 137879.9n 0.30000 137880.0n 0.30000 138059.9n 0.30000 138060.0n 0.30000 138239.9n 0.30000 138240.0n 0.30000 138419.9n 0.30000 138420.0n 0.70000 138599.9n 0.70000 138600.0n 0.70000 138779.9n 0.70000 138780.0n 0.30000 138959.9n 0.30000 138960.0n 0.70000 139139.9n 0.70000 139140.0n 0.70000 139319.9n 0.70000 139320.0n 0.30000 139499.9n 0.30000 139500.0n 0.70000 139679.9n 0.70000 139680.0n 0.30000 139859.9n 0.30000 139860.0n 0.30000 140039.9n 0.30000 140040.0n 0.70000 140219.9n 0.70000 140220.0n 0.30000 140399.9n 0.30000 140400.0n 0.30000 140579.9n 0.30000 140580.0n 0.30000 140759.9n 0.30000 140760.0n 0.30000 140939.9n 0.30000 140940.0n 0.70000 141119.9n 0.70000 141120.0n 0.70000 141299.9n 0.70000 141300.0n 0.70000 141479.9n 0.70000 141480.0n 0.30000 141659.9n 0.30000 141660.0n 0.30000 141839.9n 0.30000 141840.0n 0.70000 142019.9n 0.70000 142020.0n 0.70000 142199.9n 0.70000 142200.0n 0.70000 142379.9n 0.70000 142380.0n 0.30000 142559.9n 0.30000 142560.0n 0.70000 142739.9n 0.70000 142740.0n 0.30000 142919.9n 0.30000 142920.0n 0.70000 143099.9n 0.70000 143100.0n 0.30000 143279.9n 0.30000 143280.0n 0.70000 143459.9n 0.70000 143460.0n 0.30000 143639.9n 0.30000 143640.0n 0.70000 143819.9n 0.70000 143820.0n 0.30000 143999.9n 0.30000 144000.0n 0.70000 144179.9n 0.70000 144180.0n 0.70000 144359.9n 0.70000 144360.0n 0.30000 144539.9n 0.30000 144540.0n 0.70000 144719.9n 0.70000 144720.0n 0.30000 144899.9n 0.30000 144900.0n 0.30000 145079.9n 0.30000 145080.0n 0.70000 145259.9n 0.70000 145260.0n 0.70000 145439.9n 0.70000 145440.0n 0.30000 145619.9n 0.30000 145620.0n 0.70000 145799.9n 0.70000 145800.0n 0.30000 145979.9n 0.30000 145980.0n 0.30000 146159.9n 0.30000 146160.0n 0.70000 146339.9n 0.70000 146340.0n 0.30000 146519.9n 0.30000 146520.0n 0.70000 146699.9n 0.70000 146700.0n 0.30000 146879.9n 0.30000 146880.0n 0.70000 147059.9n 0.70000 147060.0n 0.30000 147239.9n 0.30000 147240.0n 0.70000 147419.9n 0.70000 147420.0n 0.70000 147599.9n 0.70000 147600.0n 0.30000 147779.9n 0.30000 147780.0n 0.70000 147959.9n 0.70000 147960.0n 0.30000 148139.9n 0.30000 148140.0n 0.70000 148319.9n 0.70000 148320.0n 0.30000 148499.9n 0.30000 148500.0n 0.70000 148679.9n 0.70000 148680.0n 0.30000 148859.9n 0.30000 148860.0n 0.30000 149039.9n 0.30000 149040.0n 0.70000 149219.9n 0.70000 149220.0n 0.30000 149399.9n 0.30000 149400.0n 0.30000 149579.9n 0.30000 149580.0n 0.70000 149759.9n 0.70000 149760.0n 0.70000 149939.9n 0.70000 149940.0n 0.30000 150119.9n 0.30000 150120.0n 0.70000 150299.9n 0.70000 150300.0n 0.70000 150479.9n 0.70000 150480.0n 0.30000 150659.9n 0.30000 150660.0n 0.30000 150839.9n 0.30000 150840.0n 0.70000 151019.9n 0.70000 151020.0n 0.70000 151199.9n 0.70000 151200.0n 0.30000 151379.9n 0.30000 151380.0n 0.70000 151559.9n 0.70000 151560.0n 0.70000 151739.9n 0.70000 151740.0n 0.70000 151919.9n 0.70000 151920.0n 0.70000 152099.9n 0.70000 152100.0n 0.70000 152279.9n 0.70000 152280.0n 0.30000 152459.9n 0.30000 152460.0n 0.70000 152639.9n 0.70000 152640.0n 0.30000 152819.9n 0.30000 152820.0n 0.30000 152999.9n 0.30000 153000.0n 0.70000 153179.9n 0.70000 153180.0n 0.70000 153359.9n 0.70000 153360.0n 0.30000 153539.9n 0.30000 153540.0n 0.70000 153719.9n 0.70000 153720.0n 0.30000 153899.9n 0.30000 153900.0n 0.30000 154079.9n 0.30000 154080.0n 0.70000 154259.9n 0.70000 154260.0n 0.30000 154439.9n 0.30000 154440.0n 0.30000 154619.9n 0.30000 154620.0n 0.30000 154799.9n 0.30000 154800.0n 0.30000 154979.9n 0.30000 154980.0n 0.70000 155159.9n 0.70000 155160.0n 0.30000 155339.9n 0.30000 155340.0n 0.30000 155519.9n 0.30000 155520.0n 0.70000 155699.9n 0.70000 155700.0n 0.30000 155879.9n 0.30000 155880.0n 0.30000 156059.9n 0.30000 156060.0n 0.30000 156239.9n 0.30000 156240.0n 0.70000 156419.9n 0.70000 156420.0n 0.70000 156599.9n 0.70000 156600.0n 0.70000 156779.9n 0.70000 156780.0n 0.70000 156959.9n 0.70000 156960.0n 0.70000 157139.9n 0.70000 157140.0n 0.70000 157319.9n 0.70000 157320.0n 0.30000 157499.9n 0.30000 157500.0n 0.30000 157679.9n 0.30000 157680.0n 0.70000 157859.9n 0.70000 157860.0n 0.30000 158039.9n 0.30000 158040.0n 0.70000 158219.9n 0.70000 158220.0n 0.30000 158399.9n 0.30000 158400.0n 0.70000 158579.9n 0.70000 158580.0n 0.70000 158759.9n 0.70000 158760.0n 0.30000 158939.9n 0.30000 158940.0n 0.30000 159119.9n 0.30000 159120.0n 0.30000 159299.9n 0.30000 159300.0n 0.30000 159479.9n 0.30000 159480.0n 0.70000 159659.9n 0.70000 159660.0n 0.30000 159839.9n 0.30000 159840.0n 0.30000 160019.9n 0.30000 160020.0n 0.70000 160199.9n 0.70000 160200.0n 0.70000 160379.9n 0.70000 160380.0n 0.30000 160559.9n 0.30000 160560.0n 0.30000 160739.9n 0.30000 160740.0n 0.30000 160919.9n 0.30000 160920.0n 0.70000 161099.9n 0.70000 161100.0n 0.70000 161279.9n 0.70000 161280.0n 0.70000 161459.9n 0.70000 161460.0n 0.30000 161639.9n 0.30000 161640.0n 0.70000 161819.9n 0.70000 161820.0n 0.70000 161999.9n 0.70000 162000.0n 0.70000 162179.9n 0.70000 162180.0n 0.30000 162359.9n 0.30000 162360.0n 0.70000 162539.9n 0.70000 162540.0n 0.70000 162719.9n 0.70000 162720.0n 0.30000 162899.9n 0.30000 162900.0n 0.70000 163079.9n 0.70000 163080.0n 0.30000 163259.9n 0.30000 163260.0n 0.30000 163439.9n 0.30000 163440.0n 0.70000 163619.9n 0.70000 163620.0n 0.30000 163799.9n 0.30000 163800.0n 0.70000 163979.9n 0.70000 163980.0n 0.70000 164159.9n 0.70000 164160.0n 0.70000 164339.9n 0.70000 164340.0n 0.70000 164519.9n 0.70000 164520.0n 0.70000 164699.9n 0.70000 164700.0n 0.30000 164879.9n 0.30000 164880.0n 0.30000 165059.9n 0.30000 165060.0n 0.30000 165239.9n 0.30000 165240.0n 0.30000 165419.9n 0.30000 165420.0n 0.30000 165599.9n 0.30000 165600.0n 0.30000 165779.9n 0.30000 165780.0n 0.30000 165959.9n 0.30000 165960.0n 0.70000 166139.9n 0.70000 166140.0n 0.70000 166319.9n 0.70000 166320.0n 0.70000 166499.9n 0.70000 166500.0n 0.30000 166679.9n 0.30000 166680.0n 0.30000 166859.9n 0.30000 166860.0n 0.30000 167039.9n 0.30000 167040.0n 0.30000 167219.9n 0.30000 167220.0n 0.30000 167399.9n 0.30000 167400.0n 0.70000 167579.9n 0.70000 167580.0n 0.70000 167759.9n 0.70000 167760.0n 0.30000 167939.9n 0.30000 167940.0n 0.30000 168119.9n 0.30000 168120.0n 0.30000 168299.9n 0.30000 168300.0n 0.30000 168479.9n 0.30000 168480.0n 0.70000 168659.9n 0.70000 168660.0n 0.30000 168839.9n 0.30000 168840.0n 0.30000 169019.9n 0.30000 169020.0n 0.70000 169199.9n 0.70000 169200.0n 0.70000 169379.9n 0.70000 169380.0n 0.70000 169559.9n 0.70000 169560.0n 0.70000 169739.9n 0.70000 169740.0n 0.30000 169919.9n 0.30000 169920.0n 0.70000 170099.9n 0.70000 170100.0n 0.30000 170279.9n 0.30000 170280.0n 0.30000 170459.9n 0.30000 170460.0n 0.70000 170639.9n 0.70000 170640.0n 0.70000 170819.9n 0.70000 170820.0n 0.70000 170999.9n 0.70000 171000.0n 0.70000 171179.9n 0.70000 171180.0n 0.30000 171359.9n 0.30000 171360.0n 0.30000 171539.9n 0.30000 171540.0n 0.30000 171719.9n 0.30000 171720.0n 0.30000 171899.9n 0.30000 171900.0n 0.30000 172079.9n 0.30000 172080.0n 0.70000 172259.9n 0.70000 172260.0n 0.70000 172439.9n 0.70000 172440.0n 0.70000 172619.9n 0.70000 172620.0n 0.70000 172799.9n 0.70000 172800.0n 0.50000 172979.9n 0.50000 172980.0n 0.50000 173159.9n 0.50000 173160.0n 0.50000 173339.9n 0.50000 173340.0n 0.50000 173519.9n 0.50000 173520.0n 0.50000 173699.9n 0.50000 173700.0n 0.50000 173879.9n 0.50000 173880.0n 0.50000 174059.9n 0.50000 174060.0n 0.50000 174239.9n 0.50000 174240.0n 0.50000 174419.9n 0.50000 174420.0n 0.50000 174599.9n 0.50000 174600.0n 0.50000 174779.9n 0.50000 174780.0n 0.50000 174959.9n 0.50000 174960.0n 0.50000 175139.9n 0.50000 175140.0n 0.50000 175319.9n 0.50000 175320.0n 0.50000 175499.9n 0.50000 175500.0n 0.50000 175679.9n 0.50000 175680.0n 0.50000 175859.9n 0.50000 175860.0n 0.50000 176039.9n 0.50000 176040.0n 0.50000 176219.9n 0.50000 176220.0n 0.50000 176399.9n 0.50000 176400.0n 0.50000 176579.9n 0.50000 176580.0n 0.50000 176759.9n 0.50000 176760.0n 0.50000 176939.9n 0.50000 176940.0n 0.50000 177119.9n 0.50000 177120.0n 0.50000 177299.9n 0.50000 177300.0n 0.50000 177479.9n 0.50000 177480.0n 0.50000 177659.9n 0.50000 177660.0n 0.50000 177839.9n 0.50000 177840.0n 0.50000 178019.9n 0.50000 178020.0n 0.50000 178199.9n 0.50000 178200.0n 0.50000 178379.9n 0.50000 178380.0n 0.50000 178559.9n 0.50000 178560.0n 0.50000 178739.9n 0.50000 178740.0n 0.50000 178919.9n 0.50000 178920.0n 0.50000 179099.9n 0.50000 179100.0n 0.50000 179279.9n 0.50000 179280.0n 0.50000 179459.9n 0.50000 179460.0n 0.50000 179639.9n 0.50000 179640.0n 0.50000 179819.9n 0.50000 179820.0n 0.50000 179999.9n 0.50000 180000.0n 0.50000 180179.9n 0.50000 180180.0n 0.50000 180359.9n 0.50000 180360.0n 0.50000 180539.9n 0.50000 180540.0n 0.50000 180719.9n 0.50000 180720.0n 0.50000 180899.9n 0.50000 180900.0n 0.50000 181079.9n 0.50000 181080.0n 0.50000 181259.9n 0.50000 181260.0n 0.50000 181439.9n 0.50000 181440.0n 0.50000 181619.9n 0.50000 181620.0n 0.50000 181799.9n 0.50000 181800.0n 0.50000 181979.9n 0.50000 181980.0n 0.50000 182159.9n 0.50000 182160.0n 0.50000 182339.9n 0.50000 182340.0n 0.50000 182519.9n 0.50000 182520.0n 0.50000 182699.9n 0.50000 182700.0n 0.50000 182879.9n 0.50000 182880.0n 0.50000 183059.9n 0.50000 183060.0n 0.50000 183239.9n 0.50000 183240.0n 0.50000 183419.9n 0.50000 183420.0n 0.50000)
Vxon1 xon1 0 PWL(0.0n 0.70000 179.9n 0.70000 180.0n 0.30000 359.9n 0.30000 360.0n 0.70000 539.9n 0.70000 540.0n 0.70000 719.9n 0.70000 720.0n 0.70000 899.9n 0.70000 900.0n 0.30000 1079.9n 0.30000 1080.0n 0.30000 1259.9n 0.30000 1260.0n 0.30000 1439.9n 0.30000 1440.0n 0.70000 1619.9n 0.70000 1620.0n 0.30000 1799.9n 0.30000 1800.0n 0.30000 1979.9n 0.30000 1980.0n 0.70000 2159.9n 0.70000 2160.0n 0.30000 2339.9n 0.30000 2340.0n 0.30000 2519.9n 0.30000 2520.0n 0.70000 2699.9n 0.70000 2700.0n 0.70000 2879.9n 0.70000 2880.0n 0.30000 3059.9n 0.30000 3060.0n 0.30000 3239.9n 0.30000 3240.0n 0.30000 3419.9n 0.30000 3420.0n 0.70000 3599.9n 0.70000 3600.0n 0.30000 3779.9n 0.30000 3780.0n 0.70000 3959.9n 0.70000 3960.0n 0.30000 4139.9n 0.30000 4140.0n 0.30000 4319.9n 0.30000 4320.0n 0.70000 4499.9n 0.70000 4500.0n 0.30000 4679.9n 0.30000 4680.0n 0.70000 4859.9n 0.70000 4860.0n 0.70000 5039.9n 0.70000 5040.0n 0.70000 5219.9n 0.70000 5220.0n 0.70000 5399.9n 0.70000 5400.0n 0.70000 5579.9n 0.70000 5580.0n 0.30000 5759.9n 0.30000 5760.0n 0.70000 5939.9n 0.70000 5940.0n 0.30000 6119.9n 0.30000 6120.0n 0.70000 6299.9n 0.70000 6300.0n 0.70000 6479.9n 0.70000 6480.0n 0.30000 6659.9n 0.30000 6660.0n 0.30000 6839.9n 0.30000 6840.0n 0.30000 7019.9n 0.30000 7020.0n 0.30000 7199.9n 0.30000 7200.0n 0.30000 7379.9n 0.30000 7380.0n 0.30000 7559.9n 0.30000 7560.0n 0.30000 7739.9n 0.30000 7740.0n 0.70000 7919.9n 0.70000 7920.0n 0.70000 8099.9n 0.70000 8100.0n 0.70000 8279.9n 0.70000 8280.0n 0.30000 8459.9n 0.30000 8460.0n 0.70000 8639.9n 0.70000 8640.0n 0.70000 8819.9n 0.70000 8820.0n 0.70000 8999.9n 0.70000 9000.0n 0.70000 9179.9n 0.70000 9180.0n 0.70000 9359.9n 0.70000 9360.0n 0.30000 9539.9n 0.30000 9540.0n 0.30000 9719.9n 0.30000 9720.0n 0.70000 9899.9n 0.70000 9900.0n 0.30000 10079.9n 0.30000 10080.0n 0.70000 10259.9n 0.70000 10260.0n 0.30000 10439.9n 0.30000 10440.0n 0.70000 10619.9n 0.70000 10620.0n 0.30000 10799.9n 0.30000 10800.0n 0.30000 10979.9n 0.30000 10980.0n 0.70000 11159.9n 0.70000 11160.0n 0.30000 11339.9n 0.30000 11340.0n 0.70000 11519.9n 0.70000 11520.0n 0.70000 11699.9n 0.70000 11700.0n 0.30000 11879.9n 0.30000 11880.0n 0.70000 12059.9n 0.70000 12060.0n 0.70000 12239.9n 0.70000 12240.0n 0.70000 12419.9n 0.70000 12420.0n 0.70000 12599.9n 0.70000 12600.0n 0.30000 12779.9n 0.30000 12780.0n 0.30000 12959.9n 0.30000 12960.0n 0.30000 13139.9n 0.30000 13140.0n 0.30000 13319.9n 0.30000 13320.0n 0.30000 13499.9n 0.30000 13500.0n 0.30000 13679.9n 0.30000 13680.0n 0.30000 13859.9n 0.30000 13860.0n 0.70000 14039.9n 0.70000 14040.0n 0.70000 14219.9n 0.70000 14220.0n 0.70000 14399.9n 0.70000 14400.0n 0.70000 14579.9n 0.70000 14580.0n 0.70000 14759.9n 0.70000 14760.0n 0.30000 14939.9n 0.30000 14940.0n 0.30000 15119.9n 0.30000 15120.0n 0.70000 15299.9n 0.70000 15300.0n 0.30000 15479.9n 0.30000 15480.0n 0.30000 15659.9n 0.30000 15660.0n 0.70000 15839.9n 0.70000 15840.0n 0.30000 16019.9n 0.30000 16020.0n 0.30000 16199.9n 0.30000 16200.0n 0.70000 16379.9n 0.70000 16380.0n 0.70000 16559.9n 0.70000 16560.0n 0.30000 16739.9n 0.30000 16740.0n 0.70000 16919.9n 0.70000 16920.0n 0.70000 17099.9n 0.70000 17100.0n 0.30000 17279.9n 0.30000 17280.0n 0.70000 17459.9n 0.70000 17460.0n 0.70000 17639.9n 0.70000 17640.0n 0.30000 17819.9n 0.30000 17820.0n 0.70000 17999.9n 0.70000 18000.0n 0.30000 18179.9n 0.30000 18180.0n 0.30000 18359.9n 0.30000 18360.0n 0.70000 18539.9n 0.70000 18540.0n 0.30000 18719.9n 0.30000 18720.0n 0.30000 18899.9n 0.30000 18900.0n 0.30000 19079.9n 0.30000 19080.0n 0.30000 19259.9n 0.30000 19260.0n 0.70000 19439.9n 0.70000 19440.0n 0.30000 19619.9n 0.30000 19620.0n 0.70000 19799.9n 0.70000 19800.0n 0.30000 19979.9n 0.30000 19980.0n 0.30000 20159.9n 0.30000 20160.0n 0.70000 20339.9n 0.70000 20340.0n 0.70000 20519.9n 0.70000 20520.0n 0.30000 20699.9n 0.30000 20700.0n 0.70000 20879.9n 0.70000 20880.0n 0.30000 21059.9n 0.30000 21060.0n 0.70000 21239.9n 0.70000 21240.0n 0.30000 21419.9n 0.30000 21420.0n 0.70000 21599.9n 0.70000 21600.0n 0.70000 21779.9n 0.70000 21780.0n 0.70000 21959.9n 0.70000 21960.0n 0.30000 22139.9n 0.30000 22140.0n 0.70000 22319.9n 0.70000 22320.0n 0.30000 22499.9n 0.30000 22500.0n 0.70000 22679.9n 0.70000 22680.0n 0.70000 22859.9n 0.70000 22860.0n 0.30000 23039.9n 0.30000 23040.0n 0.30000 23219.9n 0.30000 23220.0n 0.70000 23399.9n 0.70000 23400.0n 0.30000 23579.9n 0.30000 23580.0n 0.30000 23759.9n 0.30000 23760.0n 0.70000 23939.9n 0.70000 23940.0n 0.30000 24119.9n 0.30000 24120.0n 0.30000 24299.9n 0.30000 24300.0n 0.70000 24479.9n 0.70000 24480.0n 0.70000 24659.9n 0.70000 24660.0n 0.70000 24839.9n 0.70000 24840.0n 0.30000 25019.9n 0.30000 25020.0n 0.30000 25199.9n 0.30000 25200.0n 0.70000 25379.9n 0.70000 25380.0n 0.70000 25559.9n 0.70000 25560.0n 0.70000 25739.9n 0.70000 25740.0n 0.30000 25919.9n 0.30000 25920.0n 0.70000 26099.9n 0.70000 26100.0n 0.30000 26279.9n 0.30000 26280.0n 0.30000 26459.9n 0.30000 26460.0n 0.70000 26639.9n 0.70000 26640.0n 0.30000 26819.9n 0.30000 26820.0n 0.30000 26999.9n 0.30000 27000.0n 0.70000 27179.9n 0.70000 27180.0n 0.70000 27359.9n 0.70000 27360.0n 0.70000 27539.9n 0.70000 27540.0n 0.30000 27719.9n 0.30000 27720.0n 0.30000 27899.9n 0.30000 27900.0n 0.70000 28079.9n 0.70000 28080.0n 0.30000 28259.9n 0.30000 28260.0n 0.30000 28439.9n 0.30000 28440.0n 0.70000 28619.9n 0.70000 28620.0n 0.70000 28799.9n 0.70000 28800.0n 0.70000 28979.9n 0.70000 28980.0n 0.70000 29159.9n 0.70000 29160.0n 0.30000 29339.9n 0.30000 29340.0n 0.30000 29519.9n 0.30000 29520.0n 0.30000 29699.9n 0.30000 29700.0n 0.70000 29879.9n 0.70000 29880.0n 0.70000 30059.9n 0.70000 30060.0n 0.70000 30239.9n 0.70000 30240.0n 0.30000 30419.9n 0.30000 30420.0n 0.30000 30599.9n 0.30000 30600.0n 0.70000 30779.9n 0.70000 30780.0n 0.70000 30959.9n 0.70000 30960.0n 0.30000 31139.9n 0.30000 31140.0n 0.70000 31319.9n 0.70000 31320.0n 0.30000 31499.9n 0.30000 31500.0n 0.70000 31679.9n 0.70000 31680.0n 0.70000 31859.9n 0.70000 31860.0n 0.70000 32039.9n 0.70000 32040.0n 0.30000 32219.9n 0.30000 32220.0n 0.30000 32399.9n 0.30000 32400.0n 0.70000 32579.9n 0.70000 32580.0n 0.70000 32759.9n 0.70000 32760.0n 0.30000 32939.9n 0.30000 32940.0n 0.30000 33119.9n 0.30000 33120.0n 0.30000 33299.9n 0.30000 33300.0n 0.30000 33479.9n 0.30000 33480.0n 0.70000 33659.9n 0.70000 33660.0n 0.30000 33839.9n 0.30000 33840.0n 0.30000 34019.9n 0.30000 34020.0n 0.30000 34199.9n 0.30000 34200.0n 0.70000 34379.9n 0.70000 34380.0n 0.70000 34559.9n 0.70000 34560.0n 0.70000 34739.9n 0.70000 34740.0n 0.70000 34919.9n 0.70000 34920.0n 0.70000 35099.9n 0.70000 35100.0n 0.30000 35279.9n 0.30000 35280.0n 0.30000 35459.9n 0.30000 35460.0n 0.70000 35639.9n 0.70000 35640.0n 0.30000 35819.9n 0.30000 35820.0n 0.30000 35999.9n 0.30000 36000.0n 0.70000 36179.9n 0.70000 36180.0n 0.30000 36359.9n 0.30000 36360.0n 0.30000 36539.9n 0.30000 36540.0n 0.30000 36719.9n 0.30000 36720.0n 0.70000 36899.9n 0.70000 36900.0n 0.30000 37079.9n 0.30000 37080.0n 0.70000 37259.9n 0.70000 37260.0n 0.30000 37439.9n 0.30000 37440.0n 0.30000 37619.9n 0.30000 37620.0n 0.70000 37799.9n 0.70000 37800.0n 0.70000 37979.9n 0.70000 37980.0n 0.30000 38159.9n 0.30000 38160.0n 0.30000 38339.9n 0.30000 38340.0n 0.70000 38519.9n 0.70000 38520.0n 0.70000 38699.9n 0.70000 38700.0n 0.30000 38879.9n 0.30000 38880.0n 0.70000 39059.9n 0.70000 39060.0n 0.30000 39239.9n 0.30000 39240.0n 0.70000 39419.9n 0.70000 39420.0n 0.70000 39599.9n 0.70000 39600.0n 0.30000 39779.9n 0.30000 39780.0n 0.70000 39959.9n 0.70000 39960.0n 0.70000 40139.9n 0.70000 40140.0n 0.30000 40319.9n 0.30000 40320.0n 0.70000 40499.9n 0.70000 40500.0n 0.30000 40679.9n 0.30000 40680.0n 0.30000 40859.9n 0.30000 40860.0n 0.30000 41039.9n 0.30000 41040.0n 0.30000 41219.9n 0.30000 41220.0n 0.30000 41399.9n 0.30000 41400.0n 0.30000 41579.9n 0.30000 41580.0n 0.30000 41759.9n 0.30000 41760.0n 0.70000 41939.9n 0.70000 41940.0n 0.70000 42119.9n 0.70000 42120.0n 0.30000 42299.9n 0.30000 42300.0n 0.70000 42479.9n 0.70000 42480.0n 0.30000 42659.9n 0.30000 42660.0n 0.70000 42839.9n 0.70000 42840.0n 0.30000 43019.9n 0.30000 43020.0n 0.70000 43199.9n 0.70000 43200.0n 0.30000 43379.9n 0.30000 43380.0n 0.70000 43559.9n 0.70000 43560.0n 0.30000 43739.9n 0.30000 43740.0n 0.70000 43919.9n 0.70000 43920.0n 0.70000 44099.9n 0.70000 44100.0n 0.70000 44279.9n 0.70000 44280.0n 0.70000 44459.9n 0.70000 44460.0n 0.30000 44639.9n 0.30000 44640.0n 0.30000 44819.9n 0.30000 44820.0n 0.30000 44999.9n 0.30000 45000.0n 0.70000 45179.9n 0.70000 45180.0n 0.30000 45359.9n 0.30000 45360.0n 0.70000 45539.9n 0.70000 45540.0n 0.70000 45719.9n 0.70000 45720.0n 0.70000 45899.9n 0.70000 45900.0n 0.70000 46079.9n 0.70000 46080.0n 0.30000 46259.9n 0.30000 46260.0n 0.30000 46439.9n 0.30000 46440.0n 0.70000 46619.9n 0.70000 46620.0n 0.70000 46799.9n 0.70000 46800.0n 0.30000 46979.9n 0.30000 46980.0n 0.30000 47159.9n 0.30000 47160.0n 0.70000 47339.9n 0.70000 47340.0n 0.30000 47519.9n 0.30000 47520.0n 0.70000 47699.9n 0.70000 47700.0n 0.30000 47879.9n 0.30000 47880.0n 0.70000 48059.9n 0.70000 48060.0n 0.30000 48239.9n 0.30000 48240.0n 0.30000 48419.9n 0.30000 48420.0n 0.30000 48599.9n 0.30000 48600.0n 0.30000 48779.9n 0.30000 48780.0n 0.70000 48959.9n 0.70000 48960.0n 0.70000 49139.9n 0.70000 49140.0n 0.30000 49319.9n 0.30000 49320.0n 0.30000 49499.9n 0.30000 49500.0n 0.70000 49679.9n 0.70000 49680.0n 0.30000 49859.9n 0.30000 49860.0n 0.70000 50039.9n 0.70000 50040.0n 0.30000 50219.9n 0.30000 50220.0n 0.70000 50399.9n 0.70000 50400.0n 0.70000 50579.9n 0.70000 50580.0n 0.70000 50759.9n 0.70000 50760.0n 0.70000 50939.9n 0.70000 50940.0n 0.30000 51119.9n 0.30000 51120.0n 0.70000 51299.9n 0.70000 51300.0n 0.70000 51479.9n 0.70000 51480.0n 0.70000 51659.9n 0.70000 51660.0n 0.30000 51839.9n 0.30000 51840.0n 0.70000 52019.9n 0.70000 52020.0n 0.70000 52199.9n 0.70000 52200.0n 0.70000 52379.9n 0.70000 52380.0n 0.70000 52559.9n 0.70000 52560.0n 0.70000 52739.9n 0.70000 52740.0n 0.70000 52919.9n 0.70000 52920.0n 0.30000 53099.9n 0.30000 53100.0n 0.70000 53279.9n 0.70000 53280.0n 0.30000 53459.9n 0.30000 53460.0n 0.30000 53639.9n 0.30000 53640.0n 0.70000 53819.9n 0.70000 53820.0n 0.30000 53999.9n 0.30000 54000.0n 0.70000 54179.9n 0.70000 54180.0n 0.30000 54359.9n 0.30000 54360.0n 0.30000 54539.9n 0.30000 54540.0n 0.30000 54719.9n 0.30000 54720.0n 0.70000 54899.9n 0.70000 54900.0n 0.30000 55079.9n 0.30000 55080.0n 0.30000 55259.9n 0.30000 55260.0n 0.30000 55439.9n 0.30000 55440.0n 0.70000 55619.9n 0.70000 55620.0n 0.30000 55799.9n 0.30000 55800.0n 0.30000 55979.9n 0.30000 55980.0n 0.70000 56159.9n 0.70000 56160.0n 0.30000 56339.9n 0.30000 56340.0n 0.70000 56519.9n 0.70000 56520.0n 0.70000 56699.9n 0.70000 56700.0n 0.30000 56879.9n 0.30000 56880.0n 0.30000 57059.9n 0.30000 57060.0n 0.70000 57239.9n 0.70000 57240.0n 0.70000 57419.9n 0.70000 57420.0n 0.30000 57599.9n 0.30000 57600.0n 0.30000 57779.9n 0.30000 57780.0n 0.70000 57959.9n 0.70000 57960.0n 0.30000 58139.9n 0.30000 58140.0n 0.30000 58319.9n 0.30000 58320.0n 0.70000 58499.9n 0.70000 58500.0n 0.30000 58679.9n 0.30000 58680.0n 0.30000 58859.9n 0.30000 58860.0n 0.70000 59039.9n 0.70000 59040.0n 0.70000 59219.9n 0.70000 59220.0n 0.30000 59399.9n 0.30000 59400.0n 0.70000 59579.9n 0.70000 59580.0n 0.70000 59759.9n 0.70000 59760.0n 0.70000 59939.9n 0.70000 59940.0n 0.70000 60119.9n 0.70000 60120.0n 0.30000 60299.9n 0.30000 60300.0n 0.30000 60479.9n 0.30000 60480.0n 0.30000 60659.9n 0.30000 60660.0n 0.30000 60839.9n 0.30000 60840.0n 0.30000 61019.9n 0.30000 61020.0n 0.30000 61199.9n 0.30000 61200.0n 0.70000 61379.9n 0.70000 61380.0n 0.70000 61559.9n 0.70000 61560.0n 0.70000 61739.9n 0.70000 61740.0n 0.30000 61919.9n 0.30000 61920.0n 0.70000 62099.9n 0.70000 62100.0n 0.30000 62279.9n 0.30000 62280.0n 0.70000 62459.9n 0.70000 62460.0n 0.70000 62639.9n 0.70000 62640.0n 0.30000 62819.9n 0.30000 62820.0n 0.30000 62999.9n 0.30000 63000.0n 0.70000 63179.9n 0.70000 63180.0n 0.70000 63359.9n 0.70000 63360.0n 0.70000 63539.9n 0.70000 63540.0n 0.70000 63719.9n 0.70000 63720.0n 0.70000 63899.9n 0.70000 63900.0n 0.70000 64079.9n 0.70000 64080.0n 0.70000 64259.9n 0.70000 64260.0n 0.30000 64439.9n 0.30000 64440.0n 0.70000 64619.9n 0.70000 64620.0n 0.70000 64799.9n 0.70000 64800.0n 0.30000 64979.9n 0.30000 64980.0n 0.30000 65159.9n 0.30000 65160.0n 0.30000 65339.9n 0.30000 65340.0n 0.70000 65519.9n 0.70000 65520.0n 0.70000 65699.9n 0.70000 65700.0n 0.30000 65879.9n 0.30000 65880.0n 0.30000 66059.9n 0.30000 66060.0n 0.70000 66239.9n 0.70000 66240.0n 0.70000 66419.9n 0.70000 66420.0n 0.30000 66599.9n 0.30000 66600.0n 0.30000 66779.9n 0.30000 66780.0n 0.70000 66959.9n 0.70000 66960.0n 0.70000 67139.9n 0.70000 67140.0n 0.30000 67319.9n 0.30000 67320.0n 0.30000 67499.9n 0.30000 67500.0n 0.30000 67679.9n 0.30000 67680.0n 0.30000 67859.9n 0.30000 67860.0n 0.70000 68039.9n 0.70000 68040.0n 0.30000 68219.9n 0.30000 68220.0n 0.70000 68399.9n 0.70000 68400.0n 0.30000 68579.9n 0.30000 68580.0n 0.30000 68759.9n 0.30000 68760.0n 0.30000 68939.9n 0.30000 68940.0n 0.70000 69119.9n 0.70000 69120.0n 0.70000 69299.9n 0.70000 69300.0n 0.30000 69479.9n 0.30000 69480.0n 0.30000 69659.9n 0.30000 69660.0n 0.30000 69839.9n 0.30000 69840.0n 0.70000 70019.9n 0.70000 70020.0n 0.30000 70199.9n 0.30000 70200.0n 0.70000 70379.9n 0.70000 70380.0n 0.70000 70559.9n 0.70000 70560.0n 0.30000 70739.9n 0.30000 70740.0n 0.70000 70919.9n 0.70000 70920.0n 0.30000 71099.9n 0.30000 71100.0n 0.30000 71279.9n 0.30000 71280.0n 0.70000 71459.9n 0.70000 71460.0n 0.30000 71639.9n 0.30000 71640.0n 0.30000 71819.9n 0.30000 71820.0n 0.70000 71999.9n 0.70000 72000.0n 0.30000 72179.9n 0.30000 72180.0n 0.70000 72359.9n 0.70000 72360.0n 0.70000 72539.9n 0.70000 72540.0n 0.30000 72719.9n 0.30000 72720.0n 0.70000 72899.9n 0.70000 72900.0n 0.30000 73079.9n 0.30000 73080.0n 0.30000 73259.9n 0.30000 73260.0n 0.70000 73439.9n 0.70000 73440.0n 0.30000 73619.9n 0.30000 73620.0n 0.70000 73799.9n 0.70000 73800.0n 0.30000 73979.9n 0.30000 73980.0n 0.70000 74159.9n 0.70000 74160.0n 0.30000 74339.9n 0.30000 74340.0n 0.70000 74519.9n 0.70000 74520.0n 0.70000 74699.9n 0.70000 74700.0n 0.70000 74879.9n 0.70000 74880.0n 0.30000 75059.9n 0.30000 75060.0n 0.30000 75239.9n 0.30000 75240.0n 0.70000 75419.9n 0.70000 75420.0n 0.30000 75599.9n 0.30000 75600.0n 0.30000 75779.9n 0.30000 75780.0n 0.70000 75959.9n 0.70000 75960.0n 0.30000 76139.9n 0.30000 76140.0n 0.70000 76319.9n 0.70000 76320.0n 0.30000 76499.9n 0.30000 76500.0n 0.30000 76679.9n 0.30000 76680.0n 0.30000 76859.9n 0.30000 76860.0n 0.30000 77039.9n 0.30000 77040.0n 0.30000 77219.9n 0.30000 77220.0n 0.30000 77399.9n 0.30000 77400.0n 0.70000 77579.9n 0.70000 77580.0n 0.70000 77759.9n 0.70000 77760.0n 0.70000 77939.9n 0.70000 77940.0n 0.70000 78119.9n 0.70000 78120.0n 0.70000 78299.9n 0.70000 78300.0n 0.70000 78479.9n 0.70000 78480.0n 0.30000 78659.9n 0.30000 78660.0n 0.30000 78839.9n 0.30000 78840.0n 0.70000 79019.9n 0.70000 79020.0n 0.70000 79199.9n 0.70000 79200.0n 0.70000 79379.9n 0.70000 79380.0n 0.70000 79559.9n 0.70000 79560.0n 0.30000 79739.9n 0.30000 79740.0n 0.70000 79919.9n 0.70000 79920.0n 0.70000 80099.9n 0.70000 80100.0n 0.70000 80279.9n 0.70000 80280.0n 0.30000 80459.9n 0.30000 80460.0n 0.30000 80639.9n 0.30000 80640.0n 0.70000 80819.9n 0.70000 80820.0n 0.30000 80999.9n 0.30000 81000.0n 0.70000 81179.9n 0.70000 81180.0n 0.70000 81359.9n 0.70000 81360.0n 0.70000 81539.9n 0.70000 81540.0n 0.70000 81719.9n 0.70000 81720.0n 0.70000 81899.9n 0.70000 81900.0n 0.30000 82079.9n 0.30000 82080.0n 0.30000 82259.9n 0.30000 82260.0n 0.30000 82439.9n 0.30000 82440.0n 0.30000 82619.9n 0.30000 82620.0n 0.30000 82799.9n 0.30000 82800.0n 0.30000 82979.9n 0.30000 82980.0n 0.30000 83159.9n 0.30000 83160.0n 0.70000 83339.9n 0.70000 83340.0n 0.30000 83519.9n 0.30000 83520.0n 0.30000 83699.9n 0.30000 83700.0n 0.70000 83879.9n 0.70000 83880.0n 0.30000 84059.9n 0.30000 84060.0n 0.70000 84239.9n 0.70000 84240.0n 0.30000 84419.9n 0.30000 84420.0n 0.70000 84599.9n 0.70000 84600.0n 0.70000 84779.9n 0.70000 84780.0n 0.70000 84959.9n 0.70000 84960.0n 0.70000 85139.9n 0.70000 85140.0n 0.70000 85319.9n 0.70000 85320.0n 0.30000 85499.9n 0.30000 85500.0n 0.70000 85679.9n 0.70000 85680.0n 0.30000 85859.9n 0.30000 85860.0n 0.30000 86039.9n 0.30000 86040.0n 0.70000 86219.9n 0.70000 86220.0n 0.30000 86399.9n 0.30000 86400.0n 0.70000 86579.9n 0.70000 86580.0n 0.70000 86759.9n 0.70000 86760.0n 0.30000 86939.9n 0.30000 86940.0n 0.70000 87119.9n 0.70000 87120.0n 0.30000 87299.9n 0.30000 87300.0n 0.70000 87479.9n 0.70000 87480.0n 0.30000 87659.9n 0.30000 87660.0n 0.30000 87839.9n 0.30000 87840.0n 0.70000 88019.9n 0.70000 88020.0n 0.30000 88199.9n 0.30000 88200.0n 0.30000 88379.9n 0.30000 88380.0n 0.30000 88559.9n 0.30000 88560.0n 0.70000 88739.9n 0.70000 88740.0n 0.30000 88919.9n 0.30000 88920.0n 0.30000 89099.9n 0.30000 89100.0n 0.30000 89279.9n 0.30000 89280.0n 0.30000 89459.9n 0.30000 89460.0n 0.30000 89639.9n 0.30000 89640.0n 0.70000 89819.9n 0.70000 89820.0n 0.70000 89999.9n 0.70000 90000.0n 0.70000 90179.9n 0.70000 90180.0n 0.70000 90359.9n 0.70000 90360.0n 0.30000 90539.9n 0.30000 90540.0n 0.30000 90719.9n 0.30000 90720.0n 0.70000 90899.9n 0.70000 90900.0n 0.70000 91079.9n 0.70000 91080.0n 0.70000 91259.9n 0.70000 91260.0n 0.30000 91439.9n 0.30000 91440.0n 0.70000 91619.9n 0.70000 91620.0n 0.30000 91799.9n 0.30000 91800.0n 0.70000 91979.9n 0.70000 91980.0n 0.70000 92159.9n 0.70000 92160.0n 0.30000 92339.9n 0.30000 92340.0n 0.70000 92519.9n 0.70000 92520.0n 0.70000 92699.9n 0.70000 92700.0n 0.30000 92879.9n 0.30000 92880.0n 0.30000 93059.9n 0.30000 93060.0n 0.30000 93239.9n 0.30000 93240.0n 0.30000 93419.9n 0.30000 93420.0n 0.70000 93599.9n 0.70000 93600.0n 0.70000 93779.9n 0.70000 93780.0n 0.30000 93959.9n 0.30000 93960.0n 0.70000 94139.9n 0.70000 94140.0n 0.30000 94319.9n 0.30000 94320.0n 0.70000 94499.9n 0.70000 94500.0n 0.30000 94679.9n 0.30000 94680.0n 0.70000 94859.9n 0.70000 94860.0n 0.70000 95039.9n 0.70000 95040.0n 0.70000 95219.9n 0.70000 95220.0n 0.70000 95399.9n 0.70000 95400.0n 0.30000 95579.9n 0.30000 95580.0n 0.30000 95759.9n 0.30000 95760.0n 0.70000 95939.9n 0.70000 95940.0n 0.70000 96119.9n 0.70000 96120.0n 0.30000 96299.9n 0.30000 96300.0n 0.30000 96479.9n 0.30000 96480.0n 0.70000 96659.9n 0.70000 96660.0n 0.70000 96839.9n 0.70000 96840.0n 0.70000 97019.9n 0.70000 97020.0n 0.30000 97199.9n 0.30000 97200.0n 0.30000 97379.9n 0.30000 97380.0n 0.70000 97559.9n 0.70000 97560.0n 0.30000 97739.9n 0.30000 97740.0n 0.30000 97919.9n 0.30000 97920.0n 0.70000 98099.9n 0.70000 98100.0n 0.30000 98279.9n 0.30000 98280.0n 0.30000 98459.9n 0.30000 98460.0n 0.30000 98639.9n 0.30000 98640.0n 0.70000 98819.9n 0.70000 98820.0n 0.70000 98999.9n 0.70000 99000.0n 0.70000 99179.9n 0.70000 99180.0n 0.70000 99359.9n 0.70000 99360.0n 0.30000 99539.9n 0.30000 99540.0n 0.30000 99719.9n 0.30000 99720.0n 0.70000 99899.9n 0.70000 99900.0n 0.70000 100079.9n 0.70000 100080.0n 0.30000 100259.9n 0.30000 100260.0n 0.30000 100439.9n 0.30000 100440.0n 0.30000 100619.9n 0.30000 100620.0n 0.70000 100799.9n 0.70000 100800.0n 0.30000 100979.9n 0.30000 100980.0n 0.30000 101159.9n 0.30000 101160.0n 0.70000 101339.9n 0.70000 101340.0n 0.30000 101519.9n 0.30000 101520.0n 0.30000 101699.9n 0.30000 101700.0n 0.70000 101879.9n 0.70000 101880.0n 0.70000 102059.9n 0.70000 102060.0n 0.70000 102239.9n 0.70000 102240.0n 0.70000 102419.9n 0.70000 102420.0n 0.30000 102599.9n 0.30000 102600.0n 0.30000 102779.9n 0.30000 102780.0n 0.70000 102959.9n 0.70000 102960.0n 0.30000 103139.9n 0.30000 103140.0n 0.30000 103319.9n 0.30000 103320.0n 0.70000 103499.9n 0.70000 103500.0n 0.70000 103679.9n 0.70000 103680.0n 0.30000 103859.9n 0.30000 103860.0n 0.70000 104039.9n 0.70000 104040.0n 0.30000 104219.9n 0.30000 104220.0n 0.30000 104399.9n 0.30000 104400.0n 0.30000 104579.9n 0.30000 104580.0n 0.30000 104759.9n 0.30000 104760.0n 0.70000 104939.9n 0.70000 104940.0n 0.70000 105119.9n 0.70000 105120.0n 0.70000 105299.9n 0.70000 105300.0n 0.30000 105479.9n 0.30000 105480.0n 0.70000 105659.9n 0.70000 105660.0n 0.70000 105839.9n 0.70000 105840.0n 0.70000 106019.9n 0.70000 106020.0n 0.70000 106199.9n 0.70000 106200.0n 0.30000 106379.9n 0.30000 106380.0n 0.30000 106559.9n 0.30000 106560.0n 0.30000 106739.9n 0.30000 106740.0n 0.30000 106919.9n 0.30000 106920.0n 0.70000 107099.9n 0.70000 107100.0n 0.70000 107279.9n 0.70000 107280.0n 0.30000 107459.9n 0.30000 107460.0n 0.30000 107639.9n 0.30000 107640.0n 0.30000 107819.9n 0.30000 107820.0n 0.70000 107999.9n 0.70000 108000.0n 0.30000 108179.9n 0.30000 108180.0n 0.70000 108359.9n 0.70000 108360.0n 0.70000 108539.9n 0.70000 108540.0n 0.70000 108719.9n 0.70000 108720.0n 0.30000 108899.9n 0.30000 108900.0n 0.70000 109079.9n 0.70000 109080.0n 0.70000 109259.9n 0.70000 109260.0n 0.30000 109439.9n 0.30000 109440.0n 0.70000 109619.9n 0.70000 109620.0n 0.30000 109799.9n 0.30000 109800.0n 0.70000 109979.9n 0.70000 109980.0n 0.30000 110159.9n 0.30000 110160.0n 0.30000 110339.9n 0.30000 110340.0n 0.30000 110519.9n 0.30000 110520.0n 0.70000 110699.9n 0.70000 110700.0n 0.30000 110879.9n 0.30000 110880.0n 0.70000 111059.9n 0.70000 111060.0n 0.30000 111239.9n 0.30000 111240.0n 0.70000 111419.9n 0.70000 111420.0n 0.70000 111599.9n 0.70000 111600.0n 0.30000 111779.9n 0.30000 111780.0n 0.30000 111959.9n 0.30000 111960.0n 0.70000 112139.9n 0.70000 112140.0n 0.70000 112319.9n 0.70000 112320.0n 0.30000 112499.9n 0.30000 112500.0n 0.70000 112679.9n 0.70000 112680.0n 0.30000 112859.9n 0.30000 112860.0n 0.30000 113039.9n 0.30000 113040.0n 0.70000 113219.9n 0.70000 113220.0n 0.30000 113399.9n 0.30000 113400.0n 0.30000 113579.9n 0.30000 113580.0n 0.70000 113759.9n 0.70000 113760.0n 0.70000 113939.9n 0.70000 113940.0n 0.30000 114119.9n 0.30000 114120.0n 0.70000 114299.9n 0.70000 114300.0n 0.70000 114479.9n 0.70000 114480.0n 0.70000 114659.9n 0.70000 114660.0n 0.30000 114839.9n 0.30000 114840.0n 0.30000 115019.9n 0.30000 115020.0n 0.70000 115199.9n 0.70000 115200.0n 0.30000 115379.9n 0.30000 115380.0n 0.70000 115559.9n 0.70000 115560.0n 0.70000 115739.9n 0.70000 115740.0n 0.70000 115919.9n 0.70000 115920.0n 0.70000 116099.9n 0.70000 116100.0n 0.70000 116279.9n 0.70000 116280.0n 0.70000 116459.9n 0.70000 116460.0n 0.30000 116639.9n 0.30000 116640.0n 0.30000 116819.9n 0.30000 116820.0n 0.30000 116999.9n 0.30000 117000.0n 0.70000 117179.9n 0.70000 117180.0n 0.70000 117359.9n 0.70000 117360.0n 0.30000 117539.9n 0.30000 117540.0n 0.30000 117719.9n 0.30000 117720.0n 0.70000 117899.9n 0.70000 117900.0n 0.70000 118079.9n 0.70000 118080.0n 0.30000 118259.9n 0.30000 118260.0n 0.30000 118439.9n 0.30000 118440.0n 0.70000 118619.9n 0.70000 118620.0n 0.70000 118799.9n 0.70000 118800.0n 0.30000 118979.9n 0.30000 118980.0n 0.30000 119159.9n 0.30000 119160.0n 0.30000 119339.9n 0.30000 119340.0n 0.30000 119519.9n 0.30000 119520.0n 0.30000 119699.9n 0.30000 119700.0n 0.30000 119879.9n 0.30000 119880.0n 0.70000 120059.9n 0.70000 120060.0n 0.70000 120239.9n 0.70000 120240.0n 0.30000 120419.9n 0.30000 120420.0n 0.70000 120599.9n 0.70000 120600.0n 0.70000 120779.9n 0.70000 120780.0n 0.30000 120959.9n 0.30000 120960.0n 0.30000 121139.9n 0.30000 121140.0n 0.70000 121319.9n 0.70000 121320.0n 0.70000 121499.9n 0.70000 121500.0n 0.70000 121679.9n 0.70000 121680.0n 0.70000 121859.9n 0.70000 121860.0n 0.70000 122039.9n 0.70000 122040.0n 0.30000 122219.9n 0.30000 122220.0n 0.70000 122399.9n 0.70000 122400.0n 0.70000 122579.9n 0.70000 122580.0n 0.70000 122759.9n 0.70000 122760.0n 0.30000 122939.9n 0.30000 122940.0n 0.30000 123119.9n 0.30000 123120.0n 0.30000 123299.9n 0.30000 123300.0n 0.30000 123479.9n 0.30000 123480.0n 0.70000 123659.9n 0.70000 123660.0n 0.70000 123839.9n 0.70000 123840.0n 0.70000 124019.9n 0.70000 124020.0n 0.30000 124199.9n 0.30000 124200.0n 0.70000 124379.9n 0.70000 124380.0n 0.30000 124559.9n 0.30000 124560.0n 0.70000 124739.9n 0.70000 124740.0n 0.30000 124919.9n 0.30000 124920.0n 0.30000 125099.9n 0.30000 125100.0n 0.30000 125279.9n 0.30000 125280.0n 0.30000 125459.9n 0.30000 125460.0n 0.70000 125639.9n 0.70000 125640.0n 0.30000 125819.9n 0.30000 125820.0n 0.30000 125999.9n 0.30000 126000.0n 0.70000 126179.9n 0.70000 126180.0n 0.70000 126359.9n 0.70000 126360.0n 0.30000 126539.9n 0.30000 126540.0n 0.30000 126719.9n 0.30000 126720.0n 0.70000 126899.9n 0.70000 126900.0n 0.30000 127079.9n 0.30000 127080.0n 0.70000 127259.9n 0.70000 127260.0n 0.30000 127439.9n 0.30000 127440.0n 0.70000 127619.9n 0.70000 127620.0n 0.70000 127799.9n 0.70000 127800.0n 0.70000 127979.9n 0.70000 127980.0n 0.70000 128159.9n 0.70000 128160.0n 0.30000 128339.9n 0.30000 128340.0n 0.30000 128519.9n 0.30000 128520.0n 0.70000 128699.9n 0.70000 128700.0n 0.70000 128879.9n 0.70000 128880.0n 0.70000 129059.9n 0.70000 129060.0n 0.70000 129239.9n 0.70000 129240.0n 0.30000 129419.9n 0.30000 129420.0n 0.30000 129599.9n 0.30000 129600.0n 0.70000 129779.9n 0.70000 129780.0n 0.30000 129959.9n 0.30000 129960.0n 0.70000 130139.9n 0.70000 130140.0n 0.30000 130319.9n 0.30000 130320.0n 0.30000 130499.9n 0.30000 130500.0n 0.30000 130679.9n 0.30000 130680.0n 0.30000 130859.9n 0.30000 130860.0n 0.30000 131039.9n 0.30000 131040.0n 0.70000 131219.9n 0.70000 131220.0n 0.70000 131399.9n 0.70000 131400.0n 0.30000 131579.9n 0.30000 131580.0n 0.70000 131759.9n 0.70000 131760.0n 0.70000 131939.9n 0.70000 131940.0n 0.30000 132119.9n 0.30000 132120.0n 0.30000 132299.9n 0.30000 132300.0n 0.30000 132479.9n 0.30000 132480.0n 0.70000 132659.9n 0.70000 132660.0n 0.70000 132839.9n 0.70000 132840.0n 0.30000 133019.9n 0.30000 133020.0n 0.70000 133199.9n 0.70000 133200.0n 0.70000 133379.9n 0.70000 133380.0n 0.30000 133559.9n 0.30000 133560.0n 0.30000 133739.9n 0.30000 133740.0n 0.30000 133919.9n 0.30000 133920.0n 0.30000 134099.9n 0.30000 134100.0n 0.30000 134279.9n 0.30000 134280.0n 0.30000 134459.9n 0.30000 134460.0n 0.30000 134639.9n 0.30000 134640.0n 0.70000 134819.9n 0.70000 134820.0n 0.70000 134999.9n 0.70000 135000.0n 0.30000 135179.9n 0.30000 135180.0n 0.70000 135359.9n 0.70000 135360.0n 0.30000 135539.9n 0.30000 135540.0n 0.30000 135719.9n 0.30000 135720.0n 0.70000 135899.9n 0.70000 135900.0n 0.70000 136079.9n 0.70000 136080.0n 0.30000 136259.9n 0.30000 136260.0n 0.70000 136439.9n 0.70000 136440.0n 0.30000 136619.9n 0.30000 136620.0n 0.70000 136799.9n 0.70000 136800.0n 0.30000 136979.9n 0.30000 136980.0n 0.30000 137159.9n 0.30000 137160.0n 0.70000 137339.9n 0.70000 137340.0n 0.30000 137519.9n 0.30000 137520.0n 0.70000 137699.9n 0.70000 137700.0n 0.70000 137879.9n 0.70000 137880.0n 0.70000 138059.9n 0.70000 138060.0n 0.70000 138239.9n 0.70000 138240.0n 0.70000 138419.9n 0.70000 138420.0n 0.30000 138599.9n 0.30000 138600.0n 0.30000 138779.9n 0.30000 138780.0n 0.70000 138959.9n 0.70000 138960.0n 0.30000 139139.9n 0.30000 139140.0n 0.30000 139319.9n 0.30000 139320.0n 0.70000 139499.9n 0.70000 139500.0n 0.30000 139679.9n 0.30000 139680.0n 0.70000 139859.9n 0.70000 139860.0n 0.70000 140039.9n 0.70000 140040.0n 0.30000 140219.9n 0.30000 140220.0n 0.70000 140399.9n 0.70000 140400.0n 0.70000 140579.9n 0.70000 140580.0n 0.70000 140759.9n 0.70000 140760.0n 0.70000 140939.9n 0.70000 140940.0n 0.30000 141119.9n 0.30000 141120.0n 0.30000 141299.9n 0.30000 141300.0n 0.30000 141479.9n 0.30000 141480.0n 0.70000 141659.9n 0.70000 141660.0n 0.70000 141839.9n 0.70000 141840.0n 0.30000 142019.9n 0.30000 142020.0n 0.30000 142199.9n 0.30000 142200.0n 0.30000 142379.9n 0.30000 142380.0n 0.70000 142559.9n 0.70000 142560.0n 0.30000 142739.9n 0.30000 142740.0n 0.70000 142919.9n 0.70000 142920.0n 0.30000 143099.9n 0.30000 143100.0n 0.70000 143279.9n 0.70000 143280.0n 0.30000 143459.9n 0.30000 143460.0n 0.70000 143639.9n 0.70000 143640.0n 0.30000 143819.9n 0.30000 143820.0n 0.70000 143999.9n 0.70000 144000.0n 0.30000 144179.9n 0.30000 144180.0n 0.30000 144359.9n 0.30000 144360.0n 0.70000 144539.9n 0.70000 144540.0n 0.30000 144719.9n 0.30000 144720.0n 0.70000 144899.9n 0.70000 144900.0n 0.70000 145079.9n 0.70000 145080.0n 0.30000 145259.9n 0.30000 145260.0n 0.30000 145439.9n 0.30000 145440.0n 0.70000 145619.9n 0.70000 145620.0n 0.30000 145799.9n 0.30000 145800.0n 0.70000 145979.9n 0.70000 145980.0n 0.70000 146159.9n 0.70000 146160.0n 0.30000 146339.9n 0.30000 146340.0n 0.70000 146519.9n 0.70000 146520.0n 0.30000 146699.9n 0.30000 146700.0n 0.70000 146879.9n 0.70000 146880.0n 0.30000 147059.9n 0.30000 147060.0n 0.70000 147239.9n 0.70000 147240.0n 0.30000 147419.9n 0.30000 147420.0n 0.30000 147599.9n 0.30000 147600.0n 0.70000 147779.9n 0.70000 147780.0n 0.30000 147959.9n 0.30000 147960.0n 0.70000 148139.9n 0.70000 148140.0n 0.30000 148319.9n 0.30000 148320.0n 0.70000 148499.9n 0.70000 148500.0n 0.30000 148679.9n 0.30000 148680.0n 0.70000 148859.9n 0.70000 148860.0n 0.70000 149039.9n 0.70000 149040.0n 0.30000 149219.9n 0.30000 149220.0n 0.70000 149399.9n 0.70000 149400.0n 0.70000 149579.9n 0.70000 149580.0n 0.30000 149759.9n 0.30000 149760.0n 0.30000 149939.9n 0.30000 149940.0n 0.70000 150119.9n 0.70000 150120.0n 0.30000 150299.9n 0.30000 150300.0n 0.30000 150479.9n 0.30000 150480.0n 0.70000 150659.9n 0.70000 150660.0n 0.70000 150839.9n 0.70000 150840.0n 0.30000 151019.9n 0.30000 151020.0n 0.30000 151199.9n 0.30000 151200.0n 0.70000 151379.9n 0.70000 151380.0n 0.30000 151559.9n 0.30000 151560.0n 0.30000 151739.9n 0.30000 151740.0n 0.30000 151919.9n 0.30000 151920.0n 0.30000 152099.9n 0.30000 152100.0n 0.30000 152279.9n 0.30000 152280.0n 0.70000 152459.9n 0.70000 152460.0n 0.30000 152639.9n 0.30000 152640.0n 0.70000 152819.9n 0.70000 152820.0n 0.70000 152999.9n 0.70000 153000.0n 0.30000 153179.9n 0.30000 153180.0n 0.30000 153359.9n 0.30000 153360.0n 0.70000 153539.9n 0.70000 153540.0n 0.30000 153719.9n 0.30000 153720.0n 0.70000 153899.9n 0.70000 153900.0n 0.70000 154079.9n 0.70000 154080.0n 0.30000 154259.9n 0.30000 154260.0n 0.70000 154439.9n 0.70000 154440.0n 0.70000 154619.9n 0.70000 154620.0n 0.70000 154799.9n 0.70000 154800.0n 0.70000 154979.9n 0.70000 154980.0n 0.30000 155159.9n 0.30000 155160.0n 0.70000 155339.9n 0.70000 155340.0n 0.70000 155519.9n 0.70000 155520.0n 0.30000 155699.9n 0.30000 155700.0n 0.70000 155879.9n 0.70000 155880.0n 0.70000 156059.9n 0.70000 156060.0n 0.70000 156239.9n 0.70000 156240.0n 0.30000 156419.9n 0.30000 156420.0n 0.30000 156599.9n 0.30000 156600.0n 0.30000 156779.9n 0.30000 156780.0n 0.30000 156959.9n 0.30000 156960.0n 0.30000 157139.9n 0.30000 157140.0n 0.30000 157319.9n 0.30000 157320.0n 0.70000 157499.9n 0.70000 157500.0n 0.70000 157679.9n 0.70000 157680.0n 0.30000 157859.9n 0.30000 157860.0n 0.70000 158039.9n 0.70000 158040.0n 0.30000 158219.9n 0.30000 158220.0n 0.70000 158399.9n 0.70000 158400.0n 0.30000 158579.9n 0.30000 158580.0n 0.30000 158759.9n 0.30000 158760.0n 0.70000 158939.9n 0.70000 158940.0n 0.70000 159119.9n 0.70000 159120.0n 0.70000 159299.9n 0.70000 159300.0n 0.70000 159479.9n 0.70000 159480.0n 0.30000 159659.9n 0.30000 159660.0n 0.70000 159839.9n 0.70000 159840.0n 0.70000 160019.9n 0.70000 160020.0n 0.30000 160199.9n 0.30000 160200.0n 0.30000 160379.9n 0.30000 160380.0n 0.70000 160559.9n 0.70000 160560.0n 0.70000 160739.9n 0.70000 160740.0n 0.70000 160919.9n 0.70000 160920.0n 0.30000 161099.9n 0.30000 161100.0n 0.30000 161279.9n 0.30000 161280.0n 0.30000 161459.9n 0.30000 161460.0n 0.70000 161639.9n 0.70000 161640.0n 0.30000 161819.9n 0.30000 161820.0n 0.30000 161999.9n 0.30000 162000.0n 0.30000 162179.9n 0.30000 162180.0n 0.70000 162359.9n 0.70000 162360.0n 0.30000 162539.9n 0.30000 162540.0n 0.30000 162719.9n 0.30000 162720.0n 0.70000 162899.9n 0.70000 162900.0n 0.30000 163079.9n 0.30000 163080.0n 0.70000 163259.9n 0.70000 163260.0n 0.70000 163439.9n 0.70000 163440.0n 0.30000 163619.9n 0.30000 163620.0n 0.70000 163799.9n 0.70000 163800.0n 0.30000 163979.9n 0.30000 163980.0n 0.30000 164159.9n 0.30000 164160.0n 0.30000 164339.9n 0.30000 164340.0n 0.30000 164519.9n 0.30000 164520.0n 0.30000 164699.9n 0.30000 164700.0n 0.70000 164879.9n 0.70000 164880.0n 0.70000 165059.9n 0.70000 165060.0n 0.70000 165239.9n 0.70000 165240.0n 0.70000 165419.9n 0.70000 165420.0n 0.70000 165599.9n 0.70000 165600.0n 0.70000 165779.9n 0.70000 165780.0n 0.70000 165959.9n 0.70000 165960.0n 0.30000 166139.9n 0.30000 166140.0n 0.30000 166319.9n 0.30000 166320.0n 0.30000 166499.9n 0.30000 166500.0n 0.70000 166679.9n 0.70000 166680.0n 0.70000 166859.9n 0.70000 166860.0n 0.70000 167039.9n 0.70000 167040.0n 0.70000 167219.9n 0.70000 167220.0n 0.70000 167399.9n 0.70000 167400.0n 0.30000 167579.9n 0.30000 167580.0n 0.30000 167759.9n 0.30000 167760.0n 0.70000 167939.9n 0.70000 167940.0n 0.70000 168119.9n 0.70000 168120.0n 0.70000 168299.9n 0.70000 168300.0n 0.70000 168479.9n 0.70000 168480.0n 0.30000 168659.9n 0.30000 168660.0n 0.70000 168839.9n 0.70000 168840.0n 0.70000 169019.9n 0.70000 169020.0n 0.30000 169199.9n 0.30000 169200.0n 0.30000 169379.9n 0.30000 169380.0n 0.30000 169559.9n 0.30000 169560.0n 0.30000 169739.9n 0.30000 169740.0n 0.70000 169919.9n 0.70000 169920.0n 0.30000 170099.9n 0.30000 170100.0n 0.70000 170279.9n 0.70000 170280.0n 0.70000 170459.9n 0.70000 170460.0n 0.30000 170639.9n 0.30000 170640.0n 0.30000 170819.9n 0.30000 170820.0n 0.30000 170999.9n 0.30000 171000.0n 0.30000 171179.9n 0.30000 171180.0n 0.70000 171359.9n 0.70000 171360.0n 0.70000 171539.9n 0.70000 171540.0n 0.70000 171719.9n 0.70000 171720.0n 0.70000 171899.9n 0.70000 171900.0n 0.70000 172079.9n 0.70000 172080.0n 0.30000 172259.9n 0.30000 172260.0n 0.30000 172439.9n 0.30000 172440.0n 0.30000 172619.9n 0.30000 172620.0n 0.30000 172799.9n 0.30000 172800.0n 0.50000 172979.9n 0.50000 172980.0n 0.50000 173159.9n 0.50000 173160.0n 0.50000 173339.9n 0.50000 173340.0n 0.50000 173519.9n 0.50000 173520.0n 0.50000 173699.9n 0.50000 173700.0n 0.50000 173879.9n 0.50000 173880.0n 0.50000 174059.9n 0.50000 174060.0n 0.50000 174239.9n 0.50000 174240.0n 0.50000 174419.9n 0.50000 174420.0n 0.50000 174599.9n 0.50000 174600.0n 0.50000 174779.9n 0.50000 174780.0n 0.50000 174959.9n 0.50000 174960.0n 0.50000 175139.9n 0.50000 175140.0n 0.50000 175319.9n 0.50000 175320.0n 0.50000 175499.9n 0.50000 175500.0n 0.50000 175679.9n 0.50000 175680.0n 0.50000 175859.9n 0.50000 175860.0n 0.50000 176039.9n 0.50000 176040.0n 0.50000 176219.9n 0.50000 176220.0n 0.50000 176399.9n 0.50000 176400.0n 0.50000 176579.9n 0.50000 176580.0n 0.50000 176759.9n 0.50000 176760.0n 0.50000 176939.9n 0.50000 176940.0n 0.50000 177119.9n 0.50000 177120.0n 0.50000 177299.9n 0.50000 177300.0n 0.50000 177479.9n 0.50000 177480.0n 0.50000 177659.9n 0.50000 177660.0n 0.50000 177839.9n 0.50000 177840.0n 0.50000 178019.9n 0.50000 178020.0n 0.50000 178199.9n 0.50000 178200.0n 0.50000 178379.9n 0.50000 178380.0n 0.50000 178559.9n 0.50000 178560.0n 0.50000 178739.9n 0.50000 178740.0n 0.50000 178919.9n 0.50000 178920.0n 0.50000 179099.9n 0.50000 179100.0n 0.50000 179279.9n 0.50000 179280.0n 0.50000 179459.9n 0.50000 179460.0n 0.50000 179639.9n 0.50000 179640.0n 0.50000 179819.9n 0.50000 179820.0n 0.50000 179999.9n 0.50000 180000.0n 0.50000 180179.9n 0.50000 180180.0n 0.50000 180359.9n 0.50000 180360.0n 0.50000 180539.9n 0.50000 180540.0n 0.50000 180719.9n 0.50000 180720.0n 0.50000 180899.9n 0.50000 180900.0n 0.50000 181079.9n 0.50000 181080.0n 0.50000 181259.9n 0.50000 181260.0n 0.50000 181439.9n 0.50000 181440.0n 0.50000 181619.9n 0.50000 181620.0n 0.50000 181799.9n 0.50000 181800.0n 0.50000 181979.9n 0.50000 181980.0n 0.50000 182159.9n 0.50000 182160.0n 0.50000 182339.9n 0.50000 182340.0n 0.50000 182519.9n 0.50000 182520.0n 0.50000 182699.9n 0.50000 182700.0n 0.50000 182879.9n 0.50000 182880.0n 0.50000 183059.9n 0.50000 183060.0n 0.50000 183239.9n 0.50000 183240.0n 0.50000 183419.9n 0.50000 183420.0n 0.50000)
Vwih_p_0_0 wih_p_0_0 0 0.9
Vwih_n_0_0 wih_n_0_0 0 0.3
Vwih_p_1_0 wih_p_1_0 0 0.3
Vwih_n_1_0 wih_n_1_0 0 0.8077526372768347
Vwih_p_2_0 wih_p_2_0 0 0.9
Vwih_n_2_0 wih_n_2_0 0 0.3
Xcm_xh0 xhp0 xhn0 vdd cmld
Rnd_xh0 xhp0 xhn0 20k
Cxh0p xhp0 0 1e-13
Cxh0n xhn0 0 1e-13
Xih_0_0 a_xp0 a_xn0 wih_p_0_0 wih_n_0_0 xhp0 xhn0 vdd vbsyn gsyn
Xih_1_0 a_xp1 a_xn1 wih_p_1_0 wih_n_1_0 xhp0 xhn0 vdd vbsyn gsyn
Xih_2_0 a_xp2 a_xn2 wih_p_2_0 wih_n_2_0 xhp0 xhn0 vdd vbsyn gsyn
Xn0 xhp0 xhn0 ahp0 ahn0 vdd vbneu dneuron
Vwih_p_0_1 wih_p_0_1 0 0.4076074543279496
Vwih_n_0_1 wih_n_0_1 0 0.5923925456720505
Vwih_p_1_1 wih_p_1_1 0 0.6875517955179162
Vwih_n_1_1 wih_n_1_1 0 0.31244820448208377
Vwih_p_2_1 wih_p_2_1 0 0.9
Vwih_n_2_1 wih_n_2_1 0 0.3
Xcm_xh1 xhp1 xhn1 vdd cmld
Rnd_xh1 xhp1 xhn1 20k
Cxh1p xhp1 0 1e-13
Cxh1n xhn1 0 1e-13
Xih_0_1 a_xp0 a_xn0 wih_p_0_1 wih_n_0_1 xhp1 xhn1 vdd vbsyn gsyn
Xih_1_1 a_xp1 a_xn1 wih_p_1_1 wih_n_1_1 xhp1 xhn1 vdd vbsyn gsyn
Xih_2_1 a_xp2 a_xn2 wih_p_2_1 wih_n_2_1 xhp1 xhn1 vdd vbsyn gsyn
Xn1 xhp1 xhn1 ahp1 ahn1 vdd vbneu dneuron
Vwih_p_0_2 wih_p_0_2 0 0.6986905748958001
Vwih_n_0_2 wih_n_0_2 0 0.30130942510419984
Vwih_p_1_2 wih_p_1_2 0 0.8611596583173695
Vwih_n_1_2 wih_n_1_2 0 0.3
Vwih_p_2_2 wih_p_2_2 0 0.3
Vwih_n_2_2 wih_n_2_2 0 0.9
Xcm_xh2 xhp2 xhn2 vdd cmld
Rnd_xh2 xhp2 xhn2 20k
Cxh2p xhp2 0 1e-13
Cxh2n xhn2 0 1e-13
Xih_0_2 a_xp0 a_xn0 wih_p_0_2 wih_n_0_2 xhp2 xhn2 vdd vbsyn gsyn
Xih_1_2 a_xp1 a_xn1 wih_p_1_2 wih_n_1_2 xhp2 xhn2 vdd vbsyn gsyn
Xih_2_2 a_xp2 a_xn2 wih_p_2_2 wih_n_2_2 xhp2 xhn2 vdd vbsyn gsyn
Xn2 xhp2 xhn2 ahp2 ahn2 vdd vbneu dneuron
Vwih_p_0_3 wih_p_0_3 0 0.3
Vwih_n_0_3 wih_n_0_3 0 0.7073156875091838
Vwih_p_1_3 wih_p_1_3 0 0.9
Vwih_n_1_3 wih_n_1_3 0 0.3
Vwih_p_2_3 wih_p_2_3 0 0.3968886139217385
Vwih_n_2_3 wih_n_2_3 0 0.6031113860782614
Xcm_xh3 xhp3 xhn3 vdd cmld
Rnd_xh3 xhp3 xhn3 20k
Cxh3p xhp3 0 1e-13
Cxh3n xhn3 0 1e-13
Xih_0_3 a_xp0 a_xn0 wih_p_0_3 wih_n_0_3 xhp3 xhn3 vdd vbsyn gsyn
Xih_1_3 a_xp1 a_xn1 wih_p_1_3 wih_n_1_3 xhp3 xhn3 vdd vbsyn gsyn
Xih_2_3 a_xp2 a_xn2 wih_p_2_3 wih_n_2_3 xhp3 xhn3 vdd vbsyn gsyn
Xn3 xhp3 xhn3 ahp3 ahn3 vdd vbneu dneuron
Vwih_p_0_4 wih_p_0_4 0 0.643383333655023
Vwih_n_0_4 wih_n_0_4 0 0.356616666344977
Vwih_p_1_4 wih_p_1_4 0 0.426609605197966
Vwih_n_1_4 wih_n_1_4 0 0.573390394802034
Vwih_p_2_4 wih_p_2_4 0 0.3
Vwih_n_2_4 wih_n_2_4 0 0.779710110256914
Xcm_xh4 xhp4 xhn4 vdd cmld
Rnd_xh4 xhp4 xhn4 20k
Cxh4p xhp4 0 1e-13
Cxh4n xhn4 0 1e-13
Xih_0_4 a_xp0 a_xn0 wih_p_0_4 wih_n_0_4 xhp4 xhn4 vdd vbsyn gsyn
Xih_1_4 a_xp1 a_xn1 wih_p_1_4 wih_n_1_4 xhp4 xhn4 vdd vbsyn gsyn
Xih_2_4 a_xp2 a_xn2 wih_p_2_4 wih_n_2_4 xhp4 xhn4 vdd vbsyn gsyn
Xn4 xhp4 xhn4 ahp4 ahn4 vdd vbneu dneuron
Vwih_p_0_5 wih_p_0_5 0 0.3
Vwih_n_0_5 wih_n_0_5 0 0.9
Vwih_p_1_5 wih_p_1_5 0 0.3
Vwih_n_1_5 wih_n_1_5 0 0.9
Vwih_p_2_5 wih_p_2_5 0 0.9
Vwih_n_2_5 wih_n_2_5 0 0.3
Xcm_xh5 xhp5 xhn5 vdd cmld
Rnd_xh5 xhp5 xhn5 20k
Cxh5p xhp5 0 1e-13
Cxh5n xhn5 0 1e-13
Xih_0_5 a_xp0 a_xn0 wih_p_0_5 wih_n_0_5 xhp5 xhn5 vdd vbsyn gsyn
Xih_1_5 a_xp1 a_xn1 wih_p_1_5 wih_n_1_5 xhp5 xhn5 vdd vbsyn gsyn
Xih_2_5 a_xp2 a_xn2 wih_p_2_5 wih_n_2_5 xhp5 xhn5 vdd vbsyn gsyn
Xn5 xhp5 xhn5 ahp5 ahn5 vdd vbneu dneuron
Vwih_p_0_6 wih_p_0_6 0 0.4644227134047597
Vwih_n_0_6 wih_n_0_6 0 0.5355772865952403
Vwih_p_1_6 wih_p_1_6 0 0.3
Vwih_n_1_6 wih_n_1_6 0 0.9
Vwih_p_2_6 wih_p_2_6 0 0.3
Vwih_n_2_6 wih_n_2_6 0 0.9
Xcm_xh6 xhp6 xhn6 vdd cmld
Rnd_xh6 xhp6 xhn6 20k
Cxh6p xhp6 0 1e-13
Cxh6n xhn6 0 1e-13
Xih_0_6 a_xp0 a_xn0 wih_p_0_6 wih_n_0_6 xhp6 xhn6 vdd vbsyn gsyn
Xih_1_6 a_xp1 a_xn1 wih_p_1_6 wih_n_1_6 xhp6 xhn6 vdd vbsyn gsyn
Xih_2_6 a_xp2 a_xn2 wih_p_2_6 wih_n_2_6 xhp6 xhn6 vdd vbsyn gsyn
Xn6 xhp6 xhn6 ahp6 ahn6 vdd vbneu dneuron
Vwih_p_0_7 wih_p_0_7 0 0.8930428788399948
Vwih_n_0_7 wih_n_0_7 0 0.3
Vwih_p_1_7 wih_p_1_7 0 0.3
Vwih_n_1_7 wih_n_1_7 0 0.9
Vwih_p_2_7 wih_p_2_7 0 0.3
Vwih_n_2_7 wih_n_2_7 0 0.7814083238372862
Xcm_xh7 xhp7 xhn7 vdd cmld
Rnd_xh7 xhp7 xhn7 20k
Cxh7p xhp7 0 1e-13
Cxh7n xhn7 0 1e-13
Xih_0_7 a_xp0 a_xn0 wih_p_0_7 wih_n_0_7 xhp7 xhn7 vdd vbsyn gsyn
Xih_1_7 a_xp1 a_xn1 wih_p_1_7 wih_n_1_7 xhp7 xhn7 vdd vbsyn gsyn
Xih_2_7 a_xp2 a_xn2 wih_p_2_7 wih_n_2_7 xhp7 xhn7 vdd vbsyn gsyn
Xn7 xhp7 xhn7 ahp7 ahn7 vdd vbneu dneuron
Vwih_p_0_8 wih_p_0_8 0 0.3
Vwih_n_0_8 wih_n_0_8 0 0.9
Vwih_p_1_8 wih_p_1_8 0 0.3
Vwih_n_1_8 wih_n_1_8 0 0.9
Vwih_p_2_8 wih_p_2_8 0 0.9
Vwih_n_2_8 wih_n_2_8 0 0.3
Xcm_xh8 xhp8 xhn8 vdd cmld
Rnd_xh8 xhp8 xhn8 20k
Cxh8p xhp8 0 1e-13
Cxh8n xhn8 0 1e-13
Xih_0_8 a_xp0 a_xn0 wih_p_0_8 wih_n_0_8 xhp8 xhn8 vdd vbsyn gsyn
Xih_1_8 a_xp1 a_xn1 wih_p_1_8 wih_n_1_8 xhp8 xhn8 vdd vbsyn gsyn
Xih_2_8 a_xp2 a_xn2 wih_p_2_8 wih_n_2_8 xhp8 xhn8 vdd vbsyn gsyn
Xn8 xhp8 xhn8 ahp8 ahn8 vdd vbneu dneuron
Vwih_p_0_9 wih_p_0_9 0 0.43659969851895275
Vwih_n_0_9 wih_n_0_9 0 0.5634003014810472
Vwih_p_1_9 wih_p_1_9 0 0.35532188681769517
Vwih_n_1_9 wih_n_1_9 0 0.6446781131823048
Vwih_p_2_9 wih_p_2_9 0 0.3
Vwih_n_2_9 wih_n_2_9 0 0.770652332104687
Xcm_xh9 xhp9 xhn9 vdd cmld
Rnd_xh9 xhp9 xhn9 20k
Cxh9p xhp9 0 1e-13
Cxh9n xhn9 0 1e-13
Xih_0_9 a_xp0 a_xn0 wih_p_0_9 wih_n_0_9 xhp9 xhn9 vdd vbsyn gsyn
Xih_1_9 a_xp1 a_xn1 wih_p_1_9 wih_n_1_9 xhp9 xhn9 vdd vbsyn gsyn
Xih_2_9 a_xp2 a_xn2 wih_p_2_9 wih_n_2_9 xhp9 xhn9 vdd vbsyn gsyn
Xn9 xhp9 xhn9 ahp9 ahn9 vdd vbneu dneuron
Vwih_p_0_10 wih_p_0_10 0 0.8206037983083873
Vwih_n_0_10 wih_n_0_10 0 0.3
Vwih_p_1_10 wih_p_1_10 0 0.5276620970012434
Vwih_n_1_10 wih_n_1_10 0 0.47233790299875655
Vwih_p_2_10 wih_p_2_10 0 0.6315537008964082
Vwih_n_2_10 wih_n_2_10 0 0.36844629910359183
Xcm_xh10 xhp10 xhn10 vdd cmld
Rnd_xh10 xhp10 xhn10 20k
Cxh10p xhp10 0 1e-13
Cxh10n xhn10 0 1e-13
Xih_0_10 a_xp0 a_xn0 wih_p_0_10 wih_n_0_10 xhp10 xhn10 vdd vbsyn gsyn
Xih_1_10 a_xp1 a_xn1 wih_p_1_10 wih_n_1_10 xhp10 xhn10 vdd vbsyn gsyn
Xih_2_10 a_xp2 a_xn2 wih_p_2_10 wih_n_2_10 xhp10 xhn10 vdd vbsyn gsyn
Xn10 xhp10 xhn10 ahp10 ahn10 vdd vbneu dneuron
Vwih_p_0_11 wih_p_0_11 0 0.5615896328228672
Vwih_n_0_11 wih_n_0_11 0 0.4384103671771328
Vwih_p_1_11 wih_p_1_11 0 0.3392052445189821
Vwih_n_1_11 wih_n_1_11 0 0.6607947554810178
Vwih_p_2_11 wih_p_2_11 0 0.3
Vwih_n_2_11 wih_n_2_11 0 0.7163998120574444
Xcm_xh11 xhp11 xhn11 vdd cmld
Rnd_xh11 xhp11 xhn11 20k
Cxh11p xhp11 0 1e-13
Cxh11n xhn11 0 1e-13
Xih_0_11 a_xp0 a_xn0 wih_p_0_11 wih_n_0_11 xhp11 xhn11 vdd vbsyn gsyn
Xih_1_11 a_xp1 a_xn1 wih_p_1_11 wih_n_1_11 xhp11 xhn11 vdd vbsyn gsyn
Xih_2_11 a_xp2 a_xn2 wih_p_2_11 wih_n_2_11 xhp11 xhn11 vdd vbsyn gsyn
Xn11 xhp11 xhn11 ahp11 ahn11 vdd vbneu dneuron
Vwih_p_0_12 wih_p_0_12 0 0.3
Vwih_n_0_12 wih_n_0_12 0 0.9
Vwih_p_1_12 wih_p_1_12 0 0.3
Vwih_n_1_12 wih_n_1_12 0 0.7213002021183876
Vwih_p_2_12 wih_p_2_12 0 0.9
Vwih_n_2_12 wih_n_2_12 0 0.3
Xcm_xh12 xhp12 xhn12 vdd cmld
Rnd_xh12 xhp12 xhn12 20k
Cxh12p xhp12 0 1e-13
Cxh12n xhn12 0 1e-13
Xih_0_12 a_xp0 a_xn0 wih_p_0_12 wih_n_0_12 xhp12 xhn12 vdd vbsyn gsyn
Xih_1_12 a_xp1 a_xn1 wih_p_1_12 wih_n_1_12 xhp12 xhn12 vdd vbsyn gsyn
Xih_2_12 a_xp2 a_xn2 wih_p_2_12 wih_n_2_12 xhp12 xhn12 vdd vbsyn gsyn
Xn12 xhp12 xhn12 ahp12 ahn12 vdd vbneu dneuron
Vwih_p_0_13 wih_p_0_13 0 0.3
Vwih_n_0_13 wih_n_0_13 0 0.9
Vwih_p_1_13 wih_p_1_13 0 0.5019673310802524
Vwih_n_1_13 wih_n_1_13 0 0.4980326689197476
Vwih_p_2_13 wih_p_2_13 0 0.6510764412903762
Vwih_n_2_13 wih_n_2_13 0 0.3489235587096237
Xcm_xh13 xhp13 xhn13 vdd cmld
Rnd_xh13 xhp13 xhn13 20k
Cxh13p xhp13 0 1e-13
Cxh13n xhn13 0 1e-13
Xih_0_13 a_xp0 a_xn0 wih_p_0_13 wih_n_0_13 xhp13 xhn13 vdd vbsyn gsyn
Xih_1_13 a_xp1 a_xn1 wih_p_1_13 wih_n_1_13 xhp13 xhn13 vdd vbsyn gsyn
Xih_2_13 a_xp2 a_xn2 wih_p_2_13 wih_n_2_13 xhp13 xhn13 vdd vbsyn gsyn
Xn13 xhp13 xhn13 ahp13 ahn13 vdd vbneu dneuron
Vwih_p_0_14 wih_p_0_14 0 0.9
Vwih_n_0_14 wih_n_0_14 0 0.3
Vwih_p_1_14 wih_p_1_14 0 0.9
Vwih_n_1_14 wih_n_1_14 0 0.3
Vwih_p_2_14 wih_p_2_14 0 0.321441830538693
Vwih_n_2_14 wih_n_2_14 0 0.678558169461307
Xcm_xh14 xhp14 xhn14 vdd cmld
Rnd_xh14 xhp14 xhn14 20k
Cxh14p xhp14 0 1e-13
Cxh14n xhn14 0 1e-13
Xih_0_14 a_xp0 a_xn0 wih_p_0_14 wih_n_0_14 xhp14 xhn14 vdd vbsyn gsyn
Xih_1_14 a_xp1 a_xn1 wih_p_1_14 wih_n_1_14 xhp14 xhn14 vdd vbsyn gsyn
Xih_2_14 a_xp2 a_xn2 wih_p_2_14 wih_n_2_14 xhp14 xhn14 vdd vbsyn gsyn
Xn14 xhp14 xhn14 ahp14 ahn14 vdd vbneu dneuron
Vwih_p_0_15 wih_p_0_15 0 0.3
Vwih_n_0_15 wih_n_0_15 0 0.8946964794631206
Vwih_p_1_15 wih_p_1_15 0 0.9
Vwih_n_1_15 wih_n_1_15 0 0.3
Vwih_p_2_15 wih_p_2_15 0 0.5958540050197993
Vwih_n_2_15 wih_n_2_15 0 0.4041459949802006
Xcm_xh15 xhp15 xhn15 vdd cmld
Rnd_xh15 xhp15 xhn15 20k
Cxh15p xhp15 0 1e-13
Cxh15n xhn15 0 1e-13
Xih_0_15 a_xp0 a_xn0 wih_p_0_15 wih_n_0_15 xhp15 xhn15 vdd vbsyn gsyn
Xih_1_15 a_xp1 a_xn1 wih_p_1_15 wih_n_1_15 xhp15 xhn15 vdd vbsyn gsyn
Xih_2_15 a_xp2 a_xn2 wih_p_2_15 wih_n_2_15 xhp15 xhn15 vdd vbsyn gsyn
Xn15 xhp15 xhn15 ahp15 ahn15 vdd vbneu dneuron
Vwih_p_0_16 wih_p_0_16 0 0.9
Vwih_n_0_16 wih_n_0_16 0 0.3
Vwih_p_1_16 wih_p_1_16 0 0.8264016782997259
Vwih_n_1_16 wih_n_1_16 0 0.3
Vwih_p_2_16 wih_p_2_16 0 0.3
Vwih_n_2_16 wih_n_2_16 0 0.8009587065328215
Xcm_xh16 xhp16 xhn16 vdd cmld
Rnd_xh16 xhp16 xhn16 20k
Cxh16p xhp16 0 1e-13
Cxh16n xhn16 0 1e-13
Xih_0_16 a_xp0 a_xn0 wih_p_0_16 wih_n_0_16 xhp16 xhn16 vdd vbsyn gsyn
Xih_1_16 a_xp1 a_xn1 wih_p_1_16 wih_n_1_16 xhp16 xhn16 vdd vbsyn gsyn
Xih_2_16 a_xp2 a_xn2 wih_p_2_16 wih_n_2_16 xhp16 xhn16 vdd vbsyn gsyn
Xn16 xhp16 xhn16 ahp16 ahn16 vdd vbneu dneuron
Vwih_p_0_17 wih_p_0_17 0 0.4115141976338063
Vwih_n_0_17 wih_n_0_17 0 0.5884858023661936
Vwih_p_1_17 wih_p_1_17 0 0.6903674851964131
Vwih_n_1_17 wih_n_1_17 0 0.3096325148035869
Vwih_p_2_17 wih_p_2_17 0 0.7253099866650734
Vwih_n_2_17 wih_n_2_17 0 0.3
Xcm_xh17 xhp17 xhn17 vdd cmld
Rnd_xh17 xhp17 xhn17 20k
Cxh17p xhp17 0 1e-13
Cxh17n xhn17 0 1e-13
Xih_0_17 a_xp0 a_xn0 wih_p_0_17 wih_n_0_17 xhp17 xhn17 vdd vbsyn gsyn
Xih_1_17 a_xp1 a_xn1 wih_p_1_17 wih_n_1_17 xhp17 xhn17 vdd vbsyn gsyn
Xih_2_17 a_xp2 a_xn2 wih_p_2_17 wih_n_2_17 xhp17 xhn17 vdd vbsyn gsyn
Xn17 xhp17 xhn17 ahp17 ahn17 vdd vbneu dneuron
Vwih_p_0_18 wih_p_0_18 0 0.3
Vwih_n_0_18 wih_n_0_18 0 0.9
Vwih_p_1_18 wih_p_1_18 0 0.3
Vwih_n_1_18 wih_n_1_18 0 0.9
Vwih_p_2_18 wih_p_2_18 0 0.3
Vwih_n_2_18 wih_n_2_18 0 0.9
Xcm_xh18 xhp18 xhn18 vdd cmld
Rnd_xh18 xhp18 xhn18 20k
Cxh18p xhp18 0 1e-13
Cxh18n xhn18 0 1e-13
Xih_0_18 a_xp0 a_xn0 wih_p_0_18 wih_n_0_18 xhp18 xhn18 vdd vbsyn gsyn
Xih_1_18 a_xp1 a_xn1 wih_p_1_18 wih_n_1_18 xhp18 xhn18 vdd vbsyn gsyn
Xih_2_18 a_xp2 a_xn2 wih_p_2_18 wih_n_2_18 xhp18 xhn18 vdd vbsyn gsyn
Xn18 xhp18 xhn18 ahp18 ahn18 vdd vbneu dneuron
Vwih_p_0_19 wih_p_0_19 0 0.7777220499589362
Vwih_n_0_19 wih_n_0_19 0 0.3
Vwih_p_1_19 wih_p_1_19 0 0.4310427827422266
Vwih_n_1_19 wih_n_1_19 0 0.5689572172577734
Vwih_p_2_19 wih_p_2_19 0 0.3
Vwih_n_2_19 wih_n_2_19 0 0.9
Xcm_xh19 xhp19 xhn19 vdd cmld
Rnd_xh19 xhp19 xhn19 20k
Cxh19p xhp19 0 1e-13
Cxh19n xhn19 0 1e-13
Xih_0_19 a_xp0 a_xn0 wih_p_0_19 wih_n_0_19 xhp19 xhn19 vdd vbsyn gsyn
Xih_1_19 a_xp1 a_xn1 wih_p_1_19 wih_n_1_19 xhp19 xhn19 vdd vbsyn gsyn
Xih_2_19 a_xp2 a_xn2 wih_p_2_19 wih_n_2_19 xhp19 xhn19 vdd vbsyn gsyn
Xn19 xhp19 xhn19 ahp19 ahn19 vdd vbneu dneuron
Vwih_p_0_20 wih_p_0_20 0 0.3
Vwih_n_0_20 wih_n_0_20 0 0.7478781116735951
Vwih_p_1_20 wih_p_1_20 0 0.3
Vwih_n_1_20 wih_n_1_20 0 0.9
Vwih_p_2_20 wih_p_2_20 0 0.3815696565850669
Vwih_n_2_20 wih_n_2_20 0 0.6184303434149331
Xcm_xh20 xhp20 xhn20 vdd cmld
Rnd_xh20 xhp20 xhn20 20k
Cxh20p xhp20 0 1e-13
Cxh20n xhn20 0 1e-13
Xih_0_20 a_xp0 a_xn0 wih_p_0_20 wih_n_0_20 xhp20 xhn20 vdd vbsyn gsyn
Xih_1_20 a_xp1 a_xn1 wih_p_1_20 wih_n_1_20 xhp20 xhn20 vdd vbsyn gsyn
Xih_2_20 a_xp2 a_xn2 wih_p_2_20 wih_n_2_20 xhp20 xhn20 vdd vbsyn gsyn
Xn20 xhp20 xhn20 ahp20 ahn20 vdd vbneu dneuron
Vwih_p_0_21 wih_p_0_21 0 0.3
Vwih_n_0_21 wih_n_0_21 0 0.8894118236059116
Vwih_p_1_21 wih_p_1_21 0 0.3
Vwih_n_1_21 wih_n_1_21 0 0.7510846099149556
Vwih_p_2_21 wih_p_2_21 0 0.46204030518827083
Vwih_n_2_21 wih_n_2_21 0 0.5379596948117292
Xcm_xh21 xhp21 xhn21 vdd cmld
Rnd_xh21 xhp21 xhn21 20k
Cxh21p xhp21 0 1e-13
Cxh21n xhn21 0 1e-13
Xih_0_21 a_xp0 a_xn0 wih_p_0_21 wih_n_0_21 xhp21 xhn21 vdd vbsyn gsyn
Xih_1_21 a_xp1 a_xn1 wih_p_1_21 wih_n_1_21 xhp21 xhn21 vdd vbsyn gsyn
Xih_2_21 a_xp2 a_xn2 wih_p_2_21 wih_n_2_21 xhp21 xhn21 vdd vbsyn gsyn
Xn21 xhp21 xhn21 ahp21 ahn21 vdd vbneu dneuron
Vwih_p_0_22 wih_p_0_22 0 0.582183485192292
Vwih_n_0_22 wih_n_0_22 0 0.417816514807708
Vwih_p_1_22 wih_p_1_22 0 0.5267999164136071
Vwih_n_1_22 wih_n_1_22 0 0.47320008358639293
Vwih_p_2_22 wih_p_2_22 0 0.9
Vwih_n_2_22 wih_n_2_22 0 0.3
Xcm_xh22 xhp22 xhn22 vdd cmld
Rnd_xh22 xhp22 xhn22 20k
Cxh22p xhp22 0 1e-13
Cxh22n xhn22 0 1e-13
Xih_0_22 a_xp0 a_xn0 wih_p_0_22 wih_n_0_22 xhp22 xhn22 vdd vbsyn gsyn
Xih_1_22 a_xp1 a_xn1 wih_p_1_22 wih_n_1_22 xhp22 xhn22 vdd vbsyn gsyn
Xih_2_22 a_xp2 a_xn2 wih_p_2_22 wih_n_2_22 xhp22 xhn22 vdd vbsyn gsyn
Xn22 xhp22 xhn22 ahp22 ahn22 vdd vbneu dneuron
Vwih_p_0_23 wih_p_0_23 0 0.9
Vwih_n_0_23 wih_n_0_23 0 0.3
Vwih_p_1_23 wih_p_1_23 0 0.8833839713323164
Vwih_n_1_23 wih_n_1_23 0 0.3
Vwih_p_2_23 wih_p_2_23 0 0.41466542792757277
Vwih_n_2_23 wih_n_2_23 0 0.5853345720724272
Xcm_xh23 xhp23 xhn23 vdd cmld
Rnd_xh23 xhp23 xhn23 20k
Cxh23p xhp23 0 1e-13
Cxh23n xhn23 0 1e-13
Xih_0_23 a_xp0 a_xn0 wih_p_0_23 wih_n_0_23 xhp23 xhn23 vdd vbsyn gsyn
Xih_1_23 a_xp1 a_xn1 wih_p_1_23 wih_n_1_23 xhp23 xhn23 vdd vbsyn gsyn
Xih_2_23 a_xp2 a_xn2 wih_p_2_23 wih_n_2_23 xhp23 xhn23 vdd vbsyn gsyn
Xn23 xhp23 xhn23 ahp23 ahn23 vdd vbneu dneuron
Xcm_mo0 mop0 mon0 vdd cmld
Rmo0 mop0 mon0 20k
Cmo0p mop0 0 1e-13
Cmo0n mon0 0 1e-13
Cwp_0_0 who_p_0_0 0 20p
Cwn_0_0 who_n_0_0 0 20p
Rwp_0_0 who_p_0_0 wcm 200meg
Rwn_0_0 who_n_0_0 wcm 200meg
Xsyn_0_0 ahp0 ahn0 who_p_0_0 who_n_0_0 mop0 mon0 vdd vbsyn gsyn
Cwp_1_0 who_p_1_0 0 20p
Cwn_1_0 who_n_1_0 0 20p
Rwp_1_0 who_p_1_0 wcm 200meg
Rwn_1_0 who_n_1_0 wcm 200meg
Xsyn_1_0 ahp1 ahn1 who_p_1_0 who_n_1_0 mop0 mon0 vdd vbsyn gsyn
Cwp_2_0 who_p_2_0 0 20p
Cwn_2_0 who_n_2_0 0 20p
Rwp_2_0 who_p_2_0 wcm 200meg
Rwn_2_0 who_n_2_0 wcm 200meg
Xsyn_2_0 ahp2 ahn2 who_p_2_0 who_n_2_0 mop0 mon0 vdd vbsyn gsyn
Cwp_3_0 who_p_3_0 0 20p
Cwn_3_0 who_n_3_0 0 20p
Rwp_3_0 who_p_3_0 wcm 200meg
Rwn_3_0 who_n_3_0 wcm 200meg
Xsyn_3_0 ahp3 ahn3 who_p_3_0 who_n_3_0 mop0 mon0 vdd vbsyn gsyn
Cwp_4_0 who_p_4_0 0 20p
Cwn_4_0 who_n_4_0 0 20p
Rwp_4_0 who_p_4_0 wcm 200meg
Rwn_4_0 who_n_4_0 wcm 200meg
Xsyn_4_0 ahp4 ahn4 who_p_4_0 who_n_4_0 mop0 mon0 vdd vbsyn gsyn
Cwp_5_0 who_p_5_0 0 20p
Cwn_5_0 who_n_5_0 0 20p
Rwp_5_0 who_p_5_0 wcm 200meg
Rwn_5_0 who_n_5_0 wcm 200meg
Xsyn_5_0 ahp5 ahn5 who_p_5_0 who_n_5_0 mop0 mon0 vdd vbsyn gsyn
Cwp_6_0 who_p_6_0 0 20p
Cwn_6_0 who_n_6_0 0 20p
Rwp_6_0 who_p_6_0 wcm 200meg
Rwn_6_0 who_n_6_0 wcm 200meg
Xsyn_6_0 ahp6 ahn6 who_p_6_0 who_n_6_0 mop0 mon0 vdd vbsyn gsyn
Cwp_7_0 who_p_7_0 0 20p
Cwn_7_0 who_n_7_0 0 20p
Rwp_7_0 who_p_7_0 wcm 200meg
Rwn_7_0 who_n_7_0 wcm 200meg
Xsyn_7_0 ahp7 ahn7 who_p_7_0 who_n_7_0 mop0 mon0 vdd vbsyn gsyn
Cwp_8_0 who_p_8_0 0 20p
Cwn_8_0 who_n_8_0 0 20p
Rwp_8_0 who_p_8_0 wcm 200meg
Rwn_8_0 who_n_8_0 wcm 200meg
Xsyn_8_0 ahp8 ahn8 who_p_8_0 who_n_8_0 mop0 mon0 vdd vbsyn gsyn
Cwp_9_0 who_p_9_0 0 20p
Cwn_9_0 who_n_9_0 0 20p
Rwp_9_0 who_p_9_0 wcm 200meg
Rwn_9_0 who_n_9_0 wcm 200meg
Xsyn_9_0 ahp9 ahn9 who_p_9_0 who_n_9_0 mop0 mon0 vdd vbsyn gsyn
Cwp_10_0 who_p_10_0 0 20p
Cwn_10_0 who_n_10_0 0 20p
Rwp_10_0 who_p_10_0 wcm 200meg
Rwn_10_0 who_n_10_0 wcm 200meg
Xsyn_10_0 ahp10 ahn10 who_p_10_0 who_n_10_0 mop0 mon0 vdd vbsyn gsyn
Cwp_11_0 who_p_11_0 0 20p
Cwn_11_0 who_n_11_0 0 20p
Rwp_11_0 who_p_11_0 wcm 200meg
Rwn_11_0 who_n_11_0 wcm 200meg
Xsyn_11_0 ahp11 ahn11 who_p_11_0 who_n_11_0 mop0 mon0 vdd vbsyn gsyn
Cwp_12_0 who_p_12_0 0 20p
Cwn_12_0 who_n_12_0 0 20p
Rwp_12_0 who_p_12_0 wcm 200meg
Rwn_12_0 who_n_12_0 wcm 200meg
Xsyn_12_0 ahp12 ahn12 who_p_12_0 who_n_12_0 mop0 mon0 vdd vbsyn gsyn
Cwp_13_0 who_p_13_0 0 20p
Cwn_13_0 who_n_13_0 0 20p
Rwp_13_0 who_p_13_0 wcm 200meg
Rwn_13_0 who_n_13_0 wcm 200meg
Xsyn_13_0 ahp13 ahn13 who_p_13_0 who_n_13_0 mop0 mon0 vdd vbsyn gsyn
Cwp_14_0 who_p_14_0 0 20p
Cwn_14_0 who_n_14_0 0 20p
Rwp_14_0 who_p_14_0 wcm 200meg
Rwn_14_0 who_n_14_0 wcm 200meg
Xsyn_14_0 ahp14 ahn14 who_p_14_0 who_n_14_0 mop0 mon0 vdd vbsyn gsyn
Cwp_15_0 who_p_15_0 0 20p
Cwn_15_0 who_n_15_0 0 20p
Rwp_15_0 who_p_15_0 wcm 200meg
Rwn_15_0 who_n_15_0 wcm 200meg
Xsyn_15_0 ahp15 ahn15 who_p_15_0 who_n_15_0 mop0 mon0 vdd vbsyn gsyn
Cwp_16_0 who_p_16_0 0 20p
Cwn_16_0 who_n_16_0 0 20p
Rwp_16_0 who_p_16_0 wcm 200meg
Rwn_16_0 who_n_16_0 wcm 200meg
Xsyn_16_0 ahp16 ahn16 who_p_16_0 who_n_16_0 mop0 mon0 vdd vbsyn gsyn
Cwp_17_0 who_p_17_0 0 20p
Cwn_17_0 who_n_17_0 0 20p
Rwp_17_0 who_p_17_0 wcm 200meg
Rwn_17_0 who_n_17_0 wcm 200meg
Xsyn_17_0 ahp17 ahn17 who_p_17_0 who_n_17_0 mop0 mon0 vdd vbsyn gsyn
Cwp_18_0 who_p_18_0 0 20p
Cwn_18_0 who_n_18_0 0 20p
Rwp_18_0 who_p_18_0 wcm 200meg
Rwn_18_0 who_n_18_0 wcm 200meg
Xsyn_18_0 ahp18 ahn18 who_p_18_0 who_n_18_0 mop0 mon0 vdd vbsyn gsyn
Cwp_19_0 who_p_19_0 0 20p
Cwn_19_0 who_n_19_0 0 20p
Rwp_19_0 who_p_19_0 wcm 200meg
Rwn_19_0 who_n_19_0 wcm 200meg
Xsyn_19_0 ahp19 ahn19 who_p_19_0 who_n_19_0 mop0 mon0 vdd vbsyn gsyn
Cwp_20_0 who_p_20_0 0 20p
Cwn_20_0 who_n_20_0 0 20p
Rwp_20_0 who_p_20_0 wcm 200meg
Rwn_20_0 who_n_20_0 wcm 200meg
Xsyn_20_0 ahp20 ahn20 who_p_20_0 who_n_20_0 mop0 mon0 vdd vbsyn gsyn
Cwp_21_0 who_p_21_0 0 20p
Cwn_21_0 who_n_21_0 0 20p
Rwp_21_0 who_p_21_0 wcm 200meg
Rwn_21_0 who_n_21_0 wcm 200meg
Xsyn_21_0 ahp21 ahn21 who_p_21_0 who_n_21_0 mop0 mon0 vdd vbsyn gsyn
Cwp_22_0 who_p_22_0 0 20p
Cwn_22_0 who_n_22_0 0 20p
Rwp_22_0 who_p_22_0 wcm 200meg
Rwn_22_0 who_n_22_0 wcm 200meg
Xsyn_22_0 ahp22 ahn22 who_p_22_0 who_n_22_0 mop0 mon0 vdd vbsyn gsyn
Cwp_23_0 who_p_23_0 0 20p
Cwn_23_0 who_n_23_0 0 20p
Rwp_23_0 who_p_23_0 wcm 200meg
Rwn_23_0 who_n_23_0 wcm 200meg
Xsyn_23_0 ahp23 ahn23 who_p_23_0 who_n_23_0 mop0 mon0 vdd vbsyn gsyn
Xeo0 xop0 xon0 mop0 mon0 eop0 eon0 vdd gm esub
Xcm_mo1 mop1 mon1 vdd cmld
Rmo1 mop1 mon1 20k
Cmo1p mop1 0 1e-13
Cmo1n mon1 0 1e-13
Cwp_0_1 who_p_0_1 0 20p
Cwn_0_1 who_n_0_1 0 20p
Rwp_0_1 who_p_0_1 wcm 200meg
Rwn_0_1 who_n_0_1 wcm 200meg
Xsyn_0_1 ahp0 ahn0 who_p_0_1 who_n_0_1 mop1 mon1 vdd vbsyn gsyn
Cwp_1_1 who_p_1_1 0 20p
Cwn_1_1 who_n_1_1 0 20p
Rwp_1_1 who_p_1_1 wcm 200meg
Rwn_1_1 who_n_1_1 wcm 200meg
Xsyn_1_1 ahp1 ahn1 who_p_1_1 who_n_1_1 mop1 mon1 vdd vbsyn gsyn
Cwp_2_1 who_p_2_1 0 20p
Cwn_2_1 who_n_2_1 0 20p
Rwp_2_1 who_p_2_1 wcm 200meg
Rwn_2_1 who_n_2_1 wcm 200meg
Xsyn_2_1 ahp2 ahn2 who_p_2_1 who_n_2_1 mop1 mon1 vdd vbsyn gsyn
Cwp_3_1 who_p_3_1 0 20p
Cwn_3_1 who_n_3_1 0 20p
Rwp_3_1 who_p_3_1 wcm 200meg
Rwn_3_1 who_n_3_1 wcm 200meg
Xsyn_3_1 ahp3 ahn3 who_p_3_1 who_n_3_1 mop1 mon1 vdd vbsyn gsyn
Cwp_4_1 who_p_4_1 0 20p
Cwn_4_1 who_n_4_1 0 20p
Rwp_4_1 who_p_4_1 wcm 200meg
Rwn_4_1 who_n_4_1 wcm 200meg
Xsyn_4_1 ahp4 ahn4 who_p_4_1 who_n_4_1 mop1 mon1 vdd vbsyn gsyn
Cwp_5_1 who_p_5_1 0 20p
Cwn_5_1 who_n_5_1 0 20p
Rwp_5_1 who_p_5_1 wcm 200meg
Rwn_5_1 who_n_5_1 wcm 200meg
Xsyn_5_1 ahp5 ahn5 who_p_5_1 who_n_5_1 mop1 mon1 vdd vbsyn gsyn
Cwp_6_1 who_p_6_1 0 20p
Cwn_6_1 who_n_6_1 0 20p
Rwp_6_1 who_p_6_1 wcm 200meg
Rwn_6_1 who_n_6_1 wcm 200meg
Xsyn_6_1 ahp6 ahn6 who_p_6_1 who_n_6_1 mop1 mon1 vdd vbsyn gsyn
Cwp_7_1 who_p_7_1 0 20p
Cwn_7_1 who_n_7_1 0 20p
Rwp_7_1 who_p_7_1 wcm 200meg
Rwn_7_1 who_n_7_1 wcm 200meg
Xsyn_7_1 ahp7 ahn7 who_p_7_1 who_n_7_1 mop1 mon1 vdd vbsyn gsyn
Cwp_8_1 who_p_8_1 0 20p
Cwn_8_1 who_n_8_1 0 20p
Rwp_8_1 who_p_8_1 wcm 200meg
Rwn_8_1 who_n_8_1 wcm 200meg
Xsyn_8_1 ahp8 ahn8 who_p_8_1 who_n_8_1 mop1 mon1 vdd vbsyn gsyn
Cwp_9_1 who_p_9_1 0 20p
Cwn_9_1 who_n_9_1 0 20p
Rwp_9_1 who_p_9_1 wcm 200meg
Rwn_9_1 who_n_9_1 wcm 200meg
Xsyn_9_1 ahp9 ahn9 who_p_9_1 who_n_9_1 mop1 mon1 vdd vbsyn gsyn
Cwp_10_1 who_p_10_1 0 20p
Cwn_10_1 who_n_10_1 0 20p
Rwp_10_1 who_p_10_1 wcm 200meg
Rwn_10_1 who_n_10_1 wcm 200meg
Xsyn_10_1 ahp10 ahn10 who_p_10_1 who_n_10_1 mop1 mon1 vdd vbsyn gsyn
Cwp_11_1 who_p_11_1 0 20p
Cwn_11_1 who_n_11_1 0 20p
Rwp_11_1 who_p_11_1 wcm 200meg
Rwn_11_1 who_n_11_1 wcm 200meg
Xsyn_11_1 ahp11 ahn11 who_p_11_1 who_n_11_1 mop1 mon1 vdd vbsyn gsyn
Cwp_12_1 who_p_12_1 0 20p
Cwn_12_1 who_n_12_1 0 20p
Rwp_12_1 who_p_12_1 wcm 200meg
Rwn_12_1 who_n_12_1 wcm 200meg
Xsyn_12_1 ahp12 ahn12 who_p_12_1 who_n_12_1 mop1 mon1 vdd vbsyn gsyn
Cwp_13_1 who_p_13_1 0 20p
Cwn_13_1 who_n_13_1 0 20p
Rwp_13_1 who_p_13_1 wcm 200meg
Rwn_13_1 who_n_13_1 wcm 200meg
Xsyn_13_1 ahp13 ahn13 who_p_13_1 who_n_13_1 mop1 mon1 vdd vbsyn gsyn
Cwp_14_1 who_p_14_1 0 20p
Cwn_14_1 who_n_14_1 0 20p
Rwp_14_1 who_p_14_1 wcm 200meg
Rwn_14_1 who_n_14_1 wcm 200meg
Xsyn_14_1 ahp14 ahn14 who_p_14_1 who_n_14_1 mop1 mon1 vdd vbsyn gsyn
Cwp_15_1 who_p_15_1 0 20p
Cwn_15_1 who_n_15_1 0 20p
Rwp_15_1 who_p_15_1 wcm 200meg
Rwn_15_1 who_n_15_1 wcm 200meg
Xsyn_15_1 ahp15 ahn15 who_p_15_1 who_n_15_1 mop1 mon1 vdd vbsyn gsyn
Cwp_16_1 who_p_16_1 0 20p
Cwn_16_1 who_n_16_1 0 20p
Rwp_16_1 who_p_16_1 wcm 200meg
Rwn_16_1 who_n_16_1 wcm 200meg
Xsyn_16_1 ahp16 ahn16 who_p_16_1 who_n_16_1 mop1 mon1 vdd vbsyn gsyn
Cwp_17_1 who_p_17_1 0 20p
Cwn_17_1 who_n_17_1 0 20p
Rwp_17_1 who_p_17_1 wcm 200meg
Rwn_17_1 who_n_17_1 wcm 200meg
Xsyn_17_1 ahp17 ahn17 who_p_17_1 who_n_17_1 mop1 mon1 vdd vbsyn gsyn
Cwp_18_1 who_p_18_1 0 20p
Cwn_18_1 who_n_18_1 0 20p
Rwp_18_1 who_p_18_1 wcm 200meg
Rwn_18_1 who_n_18_1 wcm 200meg
Xsyn_18_1 ahp18 ahn18 who_p_18_1 who_n_18_1 mop1 mon1 vdd vbsyn gsyn
Cwp_19_1 who_p_19_1 0 20p
Cwn_19_1 who_n_19_1 0 20p
Rwp_19_1 who_p_19_1 wcm 200meg
Rwn_19_1 who_n_19_1 wcm 200meg
Xsyn_19_1 ahp19 ahn19 who_p_19_1 who_n_19_1 mop1 mon1 vdd vbsyn gsyn
Cwp_20_1 who_p_20_1 0 20p
Cwn_20_1 who_n_20_1 0 20p
Rwp_20_1 who_p_20_1 wcm 200meg
Rwn_20_1 who_n_20_1 wcm 200meg
Xsyn_20_1 ahp20 ahn20 who_p_20_1 who_n_20_1 mop1 mon1 vdd vbsyn gsyn
Cwp_21_1 who_p_21_1 0 20p
Cwn_21_1 who_n_21_1 0 20p
Rwp_21_1 who_p_21_1 wcm 200meg
Rwn_21_1 who_n_21_1 wcm 200meg
Xsyn_21_1 ahp21 ahn21 who_p_21_1 who_n_21_1 mop1 mon1 vdd vbsyn gsyn
Cwp_22_1 who_p_22_1 0 20p
Cwn_22_1 who_n_22_1 0 20p
Rwp_22_1 who_p_22_1 wcm 200meg
Rwn_22_1 who_n_22_1 wcm 200meg
Xsyn_22_1 ahp22 ahn22 who_p_22_1 who_n_22_1 mop1 mon1 vdd vbsyn gsyn
Cwp_23_1 who_p_23_1 0 20p
Cwn_23_1 who_n_23_1 0 20p
Rwp_23_1 who_p_23_1 wcm 200meg
Rwn_23_1 who_n_23_1 wcm 200meg
Xsyn_23_1 ahp23 ahn23 who_p_23_1 who_n_23_1 mop1 mon1 vdd vbsyn gsyn
Xeo1 xop1 xon1 mop1 mon1 eop1 eon1 vdd gm esub
Xlrn_0_0 eop0 eon0 ahp0 ahn0 who_p_0_0 who_n_0_0 vdd gbl gprod
Xlrn_1_0 eop0 eon0 ahp1 ahn1 who_p_1_0 who_n_1_0 vdd gbl gprod
Xlrn_2_0 eop0 eon0 ahp2 ahn2 who_p_2_0 who_n_2_0 vdd gbl gprod
Xlrn_3_0 eop0 eon0 ahp3 ahn3 who_p_3_0 who_n_3_0 vdd gbl gprod
Xlrn_4_0 eop0 eon0 ahp4 ahn4 who_p_4_0 who_n_4_0 vdd gbl gprod
Xlrn_5_0 eop0 eon0 ahp5 ahn5 who_p_5_0 who_n_5_0 vdd gbl gprod
Xlrn_6_0 eop0 eon0 ahp6 ahn6 who_p_6_0 who_n_6_0 vdd gbl gprod
Xlrn_7_0 eop0 eon0 ahp7 ahn7 who_p_7_0 who_n_7_0 vdd gbl gprod
Xlrn_8_0 eop0 eon0 ahp8 ahn8 who_p_8_0 who_n_8_0 vdd gbl gprod
Xlrn_9_0 eop0 eon0 ahp9 ahn9 who_p_9_0 who_n_9_0 vdd gbl gprod
Xlrn_10_0 eop0 eon0 ahp10 ahn10 who_p_10_0 who_n_10_0 vdd gbl gprod
Xlrn_11_0 eop0 eon0 ahp11 ahn11 who_p_11_0 who_n_11_0 vdd gbl gprod
Xlrn_12_0 eop0 eon0 ahp12 ahn12 who_p_12_0 who_n_12_0 vdd gbl gprod
Xlrn_13_0 eop0 eon0 ahp13 ahn13 who_p_13_0 who_n_13_0 vdd gbl gprod
Xlrn_14_0 eop0 eon0 ahp14 ahn14 who_p_14_0 who_n_14_0 vdd gbl gprod
Xlrn_15_0 eop0 eon0 ahp15 ahn15 who_p_15_0 who_n_15_0 vdd gbl gprod
Xlrn_16_0 eop0 eon0 ahp16 ahn16 who_p_16_0 who_n_16_0 vdd gbl gprod
Xlrn_17_0 eop0 eon0 ahp17 ahn17 who_p_17_0 who_n_17_0 vdd gbl gprod
Xlrn_18_0 eop0 eon0 ahp18 ahn18 who_p_18_0 who_n_18_0 vdd gbl gprod
Xlrn_19_0 eop0 eon0 ahp19 ahn19 who_p_19_0 who_n_19_0 vdd gbl gprod
Xlrn_20_0 eop0 eon0 ahp20 ahn20 who_p_20_0 who_n_20_0 vdd gbl gprod
Xlrn_21_0 eop0 eon0 ahp21 ahn21 who_p_21_0 who_n_21_0 vdd gbl gprod
Xlrn_22_0 eop0 eon0 ahp22 ahn22 who_p_22_0 who_n_22_0 vdd gbl gprod
Xlrn_23_0 eop0 eon0 ahp23 ahn23 who_p_23_0 who_n_23_0 vdd gbl gprod
Xlrn_0_1 eop1 eon1 ahp0 ahn0 who_p_0_1 who_n_0_1 vdd gbl gprod
Xlrn_1_1 eop1 eon1 ahp1 ahn1 who_p_1_1 who_n_1_1 vdd gbl gprod
Xlrn_2_1 eop1 eon1 ahp2 ahn2 who_p_2_1 who_n_2_1 vdd gbl gprod
Xlrn_3_1 eop1 eon1 ahp3 ahn3 who_p_3_1 who_n_3_1 vdd gbl gprod
Xlrn_4_1 eop1 eon1 ahp4 ahn4 who_p_4_1 who_n_4_1 vdd gbl gprod
Xlrn_5_1 eop1 eon1 ahp5 ahn5 who_p_5_1 who_n_5_1 vdd gbl gprod
Xlrn_6_1 eop1 eon1 ahp6 ahn6 who_p_6_1 who_n_6_1 vdd gbl gprod
Xlrn_7_1 eop1 eon1 ahp7 ahn7 who_p_7_1 who_n_7_1 vdd gbl gprod
Xlrn_8_1 eop1 eon1 ahp8 ahn8 who_p_8_1 who_n_8_1 vdd gbl gprod
Xlrn_9_1 eop1 eon1 ahp9 ahn9 who_p_9_1 who_n_9_1 vdd gbl gprod
Xlrn_10_1 eop1 eon1 ahp10 ahn10 who_p_10_1 who_n_10_1 vdd gbl gprod
Xlrn_11_1 eop1 eon1 ahp11 ahn11 who_p_11_1 who_n_11_1 vdd gbl gprod
Xlrn_12_1 eop1 eon1 ahp12 ahn12 who_p_12_1 who_n_12_1 vdd gbl gprod
Xlrn_13_1 eop1 eon1 ahp13 ahn13 who_p_13_1 who_n_13_1 vdd gbl gprod
Xlrn_14_1 eop1 eon1 ahp14 ahn14 who_p_14_1 who_n_14_1 vdd gbl gprod
Xlrn_15_1 eop1 eon1 ahp15 ahn15 who_p_15_1 who_n_15_1 vdd gbl gprod
Xlrn_16_1 eop1 eon1 ahp16 ahn16 who_p_16_1 who_n_16_1 vdd gbl gprod
Xlrn_17_1 eop1 eon1 ahp17 ahn17 who_p_17_1 who_n_17_1 vdd gbl gprod
Xlrn_18_1 eop1 eon1 ahp18 ahn18 who_p_18_1 who_n_18_1 vdd gbl gprod
Xlrn_19_1 eop1 eon1 ahp19 ahn19 who_p_19_1 who_n_19_1 vdd gbl gprod
Xlrn_20_1 eop1 eon1 ahp20 ahn20 who_p_20_1 who_n_20_1 vdd gbl gprod
Xlrn_21_1 eop1 eon1 ahp21 ahn21 who_p_21_1 who_n_21_1 vdd gbl gprod
Xlrn_22_1 eop1 eon1 ahp22 ahn22 who_p_22_1 who_n_22_1 vdd gbl gprod
Xlrn_23_1 eop1 eon1 ahp23 ahn23 who_p_23_1 who_n_23_1 vdd gbl gprod
.ic v(who_p_0_0)=0.5 v(who_n_0_0)=0.5
.ic v(who_p_1_0)=0.5 v(who_n_1_0)=0.5
.ic v(who_p_2_0)=0.5 v(who_n_2_0)=0.5
.ic v(who_p_3_0)=0.5 v(who_n_3_0)=0.5
.ic v(who_p_4_0)=0.5 v(who_n_4_0)=0.5
.ic v(who_p_5_0)=0.5 v(who_n_5_0)=0.5
.ic v(who_p_6_0)=0.5 v(who_n_6_0)=0.5
.ic v(who_p_7_0)=0.5 v(who_n_7_0)=0.5
.ic v(who_p_8_0)=0.5 v(who_n_8_0)=0.5
.ic v(who_p_9_0)=0.5 v(who_n_9_0)=0.5
.ic v(who_p_10_0)=0.5 v(who_n_10_0)=0.5
.ic v(who_p_11_0)=0.5 v(who_n_11_0)=0.5
.ic v(who_p_12_0)=0.5 v(who_n_12_0)=0.5
.ic v(who_p_13_0)=0.5 v(who_n_13_0)=0.5
.ic v(who_p_14_0)=0.5 v(who_n_14_0)=0.5
.ic v(who_p_15_0)=0.5 v(who_n_15_0)=0.5
.ic v(who_p_16_0)=0.5 v(who_n_16_0)=0.5
.ic v(who_p_17_0)=0.5 v(who_n_17_0)=0.5
.ic v(who_p_18_0)=0.5 v(who_n_18_0)=0.5
.ic v(who_p_19_0)=0.5 v(who_n_19_0)=0.5
.ic v(who_p_20_0)=0.5 v(who_n_20_0)=0.5
.ic v(who_p_21_0)=0.5 v(who_n_21_0)=0.5
.ic v(who_p_22_0)=0.5 v(who_n_22_0)=0.5
.ic v(who_p_23_0)=0.5 v(who_n_23_0)=0.5
.ic v(who_p_0_1)=0.5 v(who_n_0_1)=0.5
.ic v(who_p_1_1)=0.5 v(who_n_1_1)=0.5
.ic v(who_p_2_1)=0.5 v(who_n_2_1)=0.5
.ic v(who_p_3_1)=0.5 v(who_n_3_1)=0.5
.ic v(who_p_4_1)=0.5 v(who_n_4_1)=0.5
.ic v(who_p_5_1)=0.5 v(who_n_5_1)=0.5
.ic v(who_p_6_1)=0.5 v(who_n_6_1)=0.5
.ic v(who_p_7_1)=0.5 v(who_n_7_1)=0.5
.ic v(who_p_8_1)=0.5 v(who_n_8_1)=0.5
.ic v(who_p_9_1)=0.5 v(who_n_9_1)=0.5
.ic v(who_p_10_1)=0.5 v(who_n_10_1)=0.5
.ic v(who_p_11_1)=0.5 v(who_n_11_1)=0.5
.ic v(who_p_12_1)=0.5 v(who_n_12_1)=0.5
.ic v(who_p_13_1)=0.5 v(who_n_13_1)=0.5
.ic v(who_p_14_1)=0.5 v(who_n_14_1)=0.5
.ic v(who_p_15_1)=0.5 v(who_n_15_1)=0.5
.ic v(who_p_16_1)=0.5 v(who_n_16_1)=0.5
.ic v(who_p_17_1)=0.5 v(who_n_17_1)=0.5
.ic v(who_p_18_1)=0.5 v(who_n_18_1)=0.5
.ic v(who_p_19_1)=0.5 v(who_n_19_1)=0.5
.ic v(who_p_20_1)=0.5 v(who_n_20_1)=0.5
.ic v(who_p_21_1)=0.5 v(who_n_21_1)=0.5
.ic v(who_p_22_1)=0.5 v(who_n_22_1)=0.5
.ic v(who_p_23_1)=0.5 v(who_n_23_1)=0.5
.options gmin=1e-10 reltol=2e-3 cshunt=1e-14 method=gear
.control
tran 2n 183600n uic
wrdata ps_h24.dat v(mop0) v(mon0) v(mop1) v(mon1) v(ahp0) v(ahn0) v(ahp1) v(ahn1) v(ahp2) v(ahn2) v(ahp3) v(ahn3) v(ahp4) v(ahn4) v(ahp5) v(ahn5) v(ahp6) v(ahn6) v(ahp7) v(ahn7) v(ahp8) v(ahn8) v(ahp9) v(ahn9) v(ahp10) v(ahn10) v(ahp11) v(ahn11) v(ahp12) v(ahn12) v(ahp13) v(ahn13) v(ahp14) v(ahn14) v(ahp15) v(ahn15) v(ahp16) v(ahn16) v(ahp17) v(ahn17) v(ahp18) v(ahn18) v(ahp19) v(ahn19) v(ahp20) v(ahn20) v(ahp21) v(ahn21) v(ahp22) v(ahn22) v(ahp23) v(ahn23) v(who_p_0_0) v(who_n_0_0) v(who_p_1_0) v(who_n_1_0) v(who_p_2_0) v(who_n_2_0) v(who_p_3_0) v(who_n_3_0) v(who_p_4_0) v(who_n_4_0) v(who_p_5_0) v(who_n_5_0) v(who_p_6_0) v(who_n_6_0) v(who_p_7_0) v(who_n_7_0) v(who_p_8_0) v(who_n_8_0) v(who_p_9_0) v(who_n_9_0) v(who_p_10_0) v(who_n_10_0) v(who_p_11_0) v(who_n_11_0) v(who_p_12_0) v(who_n_12_0) v(who_p_13_0) v(who_n_13_0) v(who_p_14_0) v(who_n_14_0) v(who_p_15_0) v(who_n_15_0) v(who_p_16_0) v(who_n_16_0) v(who_p_17_0) v(who_n_17_0) v(who_p_18_0) v(who_n_18_0) v(who_p_19_0) v(who_n_19_0) v(who_p_20_0) v(who_n_20_0) v(who_p_21_0) v(who_n_21_0) v(who_p_22_0) v(who_n_22_0) v(who_p_23_0) v(who_n_23_0) v(who_p_0_1) v(who_n_0_1) v(who_p_1_1) v(who_n_1_1) v(who_p_2_1) v(who_n_2_1) v(who_p_3_1) v(who_n_3_1) v(who_p_4_1) v(who_n_4_1) v(who_p_5_1) v(who_n_5_1) v(who_p_6_1) v(who_n_6_1) v(who_p_7_1) v(who_n_7_1) v(who_p_8_1) v(who_n_8_1) v(who_p_9_1) v(who_n_9_1) v(who_p_10_1) v(who_n_10_1) v(who_p_11_1) v(who_n_11_1) v(who_p_12_1) v(who_n_12_1) v(who_p_13_1) v(who_n_13_1) v(who_p_14_1) v(who_n_14_1) v(who_p_15_1) v(who_n_15_1) v(who_p_16_1) v(who_n_16_1) v(who_p_17_1) v(who_n_17_1) v(who_p_18_1) v(who_n_18_1) v(who_p_19_1) v(who_n_19_1) v(who_p_20_1) v(who_n_20_1) v(who_p_21_1) v(who_n_21_1) v(who_p_22_1) v(who_n_22_1) v(who_p_23_1) v(who_n_23_1)
.endc
.end
