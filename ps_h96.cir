fully in-spice PC learner
.model NNR NMOS (LEVEL=1 VTO=0.2 KP=120u LAMBDA=0.02 GAMMA=0 PHI=0.7)
.model PNR PMOS (LEVEL=1 VTO=-0.2 KP=40u LAMBDA=0.02 GAMMA=0 PHI=0.7)
.subckt gsyn inp inn wp wn outp outn vdd vbn
Mtail nt vbn 0 0 NNR W=400u L=100u
M5 na wp s5 0 NNR W=200u L=100u
Rd5 s5 nt 12k
M6 nb wn s6 0 NNR W=200u L=100u
Rd6 s6 nt 12k
M1 outp inp s1 0 NNR W=200u L=100u
Rd1 s1 na 12k
M2 outn inn s2 0 NNR W=200u L=100u
Rd2 s2 na 12k
M3 outn inp s3 0 NNR W=200u L=100u
Rd3 s3 nb 12k
M4 outp inn s4 0 NNR W=200u L=100u
Rd4 s4 nb 12k
.ends
.subckt gsynR inp inn wp wn outp outn vdd vbn
Mtail nt vbn 0 0 NNR W=400u L=100u
M5 na wp s5 0 NNR W=200u L=100u
Rd5 s5 nt 12k
M6 nb wn s6 0 NNR W=200u L=100u
Rd6 s6 nt 12k
M1 outp inp s1 0 NNR W=200u L=100u
Rd1 s1 na 12k
M2 outn inn s2 0 NNR W=200u L=100u
Rd2 s2 na 12k
M3 outn inp s3 0 NNR W=200u L=100u
Rd3 s3 nb 12k
M4 outp inn s4 0 NNR W=200u L=100u
Rd4 s4 nb 12k
.ends
.subckt cmld p n vdd
Rcs1 p cmx 300k
Rcs2 n cmx 300k
MLp p cmx vdd vdd PNR W=8000u L=100u
MLn n cmx vdd vdd PNR W=8000u L=100u
.ends
.subckt cmldW p n vdd
Rcs1 p cmx 300k
Rcs2 n cmx 300k
MLp p cmx vdd vdd PNR W=3000u L=100u
MLn n cmx vdd vdd PNR W=3000u L=100u
Rpd1 p 0 150k
Rpd2 n 0 150k
.ends
.subckt cmldR p n vdd vref vbn
Rcs1 p cmx 300k
Rcs2 n cmx 300k
Mt nt vbn 0 0 NNR W=200u L=100u
Ma da cmx nt 0 NNR W=100u L=100u
Mb db vref nt 0 NNR W=100u L=100u
MLa da da vdd vdd PNR W=100u L=100u
MLb db da vdd vdd PNR W=100u L=100u
MLp p db vdd vdd PNR W=8000u L=100u
MLn n db vdd vdd PNR W=8000u L=100u
.ends
.subckt dneuron up un ap an vdd vbn
M1 an up tn 0 NNR W=200u L=100u
M2 ap un tn 0 NNR W=200u L=100u
Mt tn vbn 0 0 NNR W=200u L=100u
Xcm ap an vdd cmld
.ends
.subckt esub xp xn mp mn ep en vdd vbn
Mtx ntx vbn 0 0 NNR W=400u L=100u
M1x ep xn ntx 0 NNR W=200u L=100u
M2x en xp ntx 0 NNR W=200u L=100u
Mtm ntm vbn 0 0 NNR W=400u L=100u
M1m ep mp ntm 0 NNR W=200u L=100u
M2m en mn ntm 0 NNR W=200u L=100u
RLp vdd ep 50k
RLn vdd en 50k
.ends
.subckt gprod xp xn yp yn wp wn vdd vbn
Mtail nt vbn 0 0 NNR W=400u L=100u
M5 na yp sy5 0 NNR W=200u L=100u
Rg5 sy5 nt 12k
M6 nb yn sy6 0 NNR W=200u L=100u
Rg6 sy6 nt 12k
M1 iop xp sx1 0 NNR W=200u L=100u
Rg1 sx1 na 12k
M2 ion xn sx2 0 NNR W=200u L=100u
Rg2 sx2 na 12k
M3 ion xp sx3 0 NNR W=200u L=100u
Rg3 sx3 nb 12k
M4 iop xn sx4 0 NNR W=200u L=100u
Rg4 sx4 nb 12k
Mlp iop iop vdd vdd PNR W=200u L=100u
Mln ion ion vdd vdd PNR W=200u L=100u
Mpu_wp wp iop vdd vdd PNR W=200u L=100u
MpRn nrn ion vdd vdd PNR W=200u L=100u
MnRn nrn nrn 0 0 NNR W=200u L=100u
Mpd_wp wp nrn 0 0 NNR W=200u L=100u
Mpu_wn wn ion vdd vdd PNR W=200u L=100u
MpRp nrp iop vdd vdd PNR W=200u L=100u
MnRp nrp nrp 0 0 NNR W=200u L=100u
Mpd_wn wn nrp 0 0 NNR W=200u L=100u
.ends
.subckt comp inp inn out vdd vbn
Mt nt vbn 0 0 NNR W=200u L=100u
M1 d1 inp nt 0 NNR W=200u L=100u
M2 out inn nt 0 NNR W=200u L=100u
M3 d1 d1 vdd vdd PNR W=200u L=100u
M4 out d1 vdd vdd PNR W=200u L=100u
.ends
Vdd vdd 0 1.0
Vbsyn vbsyn 0 1.1
Vbneu vbneu 0 0.35
Vgm gm 0 0.6
Vwcm wcm 0 0.5
Vgbl gbl 0 PWL(0.0n 0.85000 129.9n 0.85000 130.0n 0.85000 259.9n 0.85000 260.0n 0.85000 389.9n 0.85000 390.0n 0.85000 519.9n 0.85000 520.0n 0.85000 649.9n 0.85000 650.0n 0.85000 779.9n 0.85000 780.0n 0.85000 909.9n 0.85000 910.0n 0.85000 1039.9n 0.85000 1040.0n 0.85000 1169.9n 0.85000 1170.0n 0.85000 1299.9n 0.85000 1300.0n 0.85000 1429.9n 0.85000 1430.0n 0.85000 1559.9n 0.85000 1560.0n 0.85000 1689.9n 0.85000 1690.0n 0.85000 1819.9n 0.85000 1820.0n 0.85000 1949.9n 0.85000 1950.0n 0.85000 2079.9n 0.85000 2080.0n 0.85000 2209.9n 0.85000 2210.0n 0.85000 2339.9n 0.85000 2340.0n 0.85000 2469.9n 0.85000 2470.0n 0.85000 2599.9n 0.85000 2600.0n 0.85000 2729.9n 0.85000 2730.0n 0.85000 2859.9n 0.85000 2860.0n 0.85000 2989.9n 0.85000 2990.0n 0.85000 3119.9n 0.85000 3120.0n 0.85000 3249.9n 0.85000 3250.0n 0.85000 3379.9n 0.85000 3380.0n 0.85000 3509.9n 0.85000 3510.0n 0.85000 3639.9n 0.85000 3640.0n 0.85000 3769.9n 0.85000 3770.0n 0.85000 3899.9n 0.85000 3900.0n 0.85000 4029.9n 0.85000 4030.0n 0.85000 4159.9n 0.85000 4160.0n 0.85000 4289.9n 0.85000 4290.0n 0.85000 4419.9n 0.85000 4420.0n 0.85000 4549.9n 0.85000 4550.0n 0.85000 4679.9n 0.85000 4680.0n 0.85000 4809.9n 0.85000 4810.0n 0.85000 4939.9n 0.85000 4940.0n 0.85000 5069.9n 0.85000 5070.0n 0.85000 5199.9n 0.85000 5200.0n 0.85000 5329.9n 0.85000 5330.0n 0.85000 5459.9n 0.85000 5460.0n 0.85000 5589.9n 0.85000 5590.0n 0.85000 5719.9n 0.85000 5720.0n 0.85000 5849.9n 0.85000 5850.0n 0.85000 5979.9n 0.85000 5980.0n 0.85000 6109.9n 0.85000 6110.0n 0.85000 6239.9n 0.85000 6240.0n 0.85000 6369.9n 0.85000 6370.0n 0.85000 6499.9n 0.85000 6500.0n 0.85000 6629.9n 0.85000 6630.0n 0.85000 6759.9n 0.85000 6760.0n 0.85000 6889.9n 0.85000 6890.0n 0.85000 7019.9n 0.85000 7020.0n 0.85000 7149.9n 0.85000 7150.0n 0.85000 7279.9n 0.85000 7280.0n 0.85000 7409.9n 0.85000 7410.0n 0.85000 7539.9n 0.85000 7540.0n 0.85000 7669.9n 0.85000 7670.0n 0.85000 7799.9n 0.85000 7800.0n 0.85000 7929.9n 0.85000 7930.0n 0.85000 8059.9n 0.85000 8060.0n 0.85000 8189.9n 0.85000 8190.0n 0.85000 8319.9n 0.85000 8320.0n 0.85000 8449.9n 0.85000 8450.0n 0.85000 8579.9n 0.85000 8580.0n 0.85000 8709.9n 0.85000 8710.0n 0.85000 8839.9n 0.85000 8840.0n 0.85000 8969.9n 0.85000 8970.0n 0.85000 9099.9n 0.85000 9100.0n 0.85000 9229.9n 0.85000 9230.0n 0.85000 9359.9n 0.85000 9360.0n 0.85000 9489.9n 0.85000 9490.0n 0.85000 9619.9n 0.85000 9620.0n 0.85000 9749.9n 0.85000 9750.0n 0.85000 9879.9n 0.85000 9880.0n 0.85000 10009.9n 0.85000 10010.0n 0.85000 10139.9n 0.85000 10140.0n 0.85000 10269.9n 0.85000 10270.0n 0.85000 10399.9n 0.85000 10400.0n 0.85000 10529.9n 0.85000 10530.0n 0.85000 10659.9n 0.85000 10660.0n 0.85000 10789.9n 0.85000 10790.0n 0.85000 10919.9n 0.85000 10920.0n 0.85000 11049.9n 0.85000 11050.0n 0.85000 11179.9n 0.85000 11180.0n 0.85000 11309.9n 0.85000 11310.0n 0.85000 11439.9n 0.85000 11440.0n 0.85000 11569.9n 0.85000 11570.0n 0.85000 11699.9n 0.85000 11700.0n 0.85000 11829.9n 0.85000 11830.0n 0.85000 11959.9n 0.85000 11960.0n 0.85000 12089.9n 0.85000 12090.0n 0.85000 12219.9n 0.85000 12220.0n 0.85000 12349.9n 0.85000 12350.0n 0.85000 12479.9n 0.85000 12480.0n 0.85000 12609.9n 0.85000 12610.0n 0.85000 12739.9n 0.85000 12740.0n 0.85000 12869.9n 0.85000 12870.0n 0.85000 12999.9n 0.85000 13000.0n 0.85000 13129.9n 0.85000 13130.0n 0.85000 13259.9n 0.85000 13260.0n 0.85000 13389.9n 0.85000 13390.0n 0.85000 13519.9n 0.85000 13520.0n 0.85000 13649.9n 0.85000 13650.0n 0.85000 13779.9n 0.85000 13780.0n 0.85000 13909.9n 0.85000 13910.0n 0.85000 14039.9n 0.85000 14040.0n 0.85000 14169.9n 0.85000 14170.0n 0.85000 14299.9n 0.85000 14300.0n 0.85000 14429.9n 0.85000 14430.0n 0.85000 14559.9n 0.85000 14560.0n 0.85000 14689.9n 0.85000 14690.0n 0.85000 14819.9n 0.85000 14820.0n 0.85000 14949.9n 0.85000 14950.0n 0.85000 15079.9n 0.85000 15080.0n 0.85000 15209.9n 0.85000 15210.0n 0.85000 15339.9n 0.85000 15340.0n 0.85000 15469.9n 0.85000 15470.0n 0.85000 15599.9n 0.85000 15600.0n 0.85000 15729.9n 0.85000 15730.0n 0.85000 15859.9n 0.85000 15860.0n 0.85000 15989.9n 0.85000 15990.0n 0.85000 16119.9n 0.85000 16120.0n 0.85000 16249.9n 0.85000 16250.0n 0.85000 16379.9n 0.85000 16380.0n 0.85000 16509.9n 0.85000 16510.0n 0.85000 16639.9n 0.85000 16640.0n 0.85000 16769.9n 0.85000 16770.0n 0.85000 16899.9n 0.85000 16900.0n 0.85000 17029.9n 0.85000 17030.0n 0.85000 17159.9n 0.85000 17160.0n 0.85000 17289.9n 0.85000 17290.0n 0.85000 17419.9n 0.85000 17420.0n 0.85000 17549.9n 0.85000 17550.0n 0.85000 17679.9n 0.85000 17680.0n 0.85000 17809.9n 0.85000 17810.0n 0.85000 17939.9n 0.85000 17940.0n 0.85000 18069.9n 0.85000 18070.0n 0.85000 18199.9n 0.85000 18200.0n 0.85000 18329.9n 0.85000 18330.0n 0.85000 18459.9n 0.85000 18460.0n 0.85000 18589.9n 0.85000 18590.0n 0.85000 18719.9n 0.85000 18720.0n 0.85000 18849.9n 0.85000 18850.0n 0.85000 18979.9n 0.85000 18980.0n 0.85000 19109.9n 0.85000 19110.0n 0.85000 19239.9n 0.85000 19240.0n 0.85000 19369.9n 0.85000 19370.0n 0.85000 19499.9n 0.85000 19500.0n 0.85000 19629.9n 0.85000 19630.0n 0.85000 19759.9n 0.85000 19760.0n 0.85000 19889.9n 0.85000 19890.0n 0.85000 20019.9n 0.85000 20020.0n 0.85000 20149.9n 0.85000 20150.0n 0.85000 20279.9n 0.85000 20280.0n 0.85000 20409.9n 0.85000 20410.0n 0.85000 20539.9n 0.85000 20540.0n 0.85000 20669.9n 0.85000 20670.0n 0.85000 20799.9n 0.85000 20800.0n 0.85000 20929.9n 0.85000 20930.0n 0.85000 21059.9n 0.85000 21060.0n 0.85000 21189.9n 0.85000 21190.0n 0.85000 21319.9n 0.85000 21320.0n 0.85000 21449.9n 0.85000 21450.0n 0.85000 21579.9n 0.85000 21580.0n 0.85000 21709.9n 0.85000 21710.0n 0.85000 21839.9n 0.85000 21840.0n 0.00000 21969.9n 0.00000 21970.0n 0.00000 22099.9n 0.00000 22100.0n 0.00000 22229.9n 0.00000 22230.0n 0.00000 22359.9n 0.00000 22360.0n 0.00000 22489.9n 0.00000 22490.0n 0.00000 22619.9n 0.00000 22620.0n 0.00000 22749.9n 0.00000 22750.0n 0.00000 22879.9n 0.00000 22880.0n 0.00000 23009.9n 0.00000 23010.0n 0.00000 23139.9n 0.00000 23140.0n 0.00000 23269.9n 0.00000 23270.0n 0.00000 23399.9n 0.00000 23400.0n 0.00000 23529.9n 0.00000 23530.0n 0.00000 23659.9n 0.00000 23660.0n 0.00000 23789.9n 0.00000 23790.0n 0.00000 23919.9n 0.00000 23920.0n 0.00000 24049.9n 0.00000 24050.0n 0.00000 24179.9n 0.00000 24180.0n 0.00000 24309.9n 0.00000 24310.0n 0.00000 24439.9n 0.00000 24440.0n 0.00000 24569.9n 0.00000 24570.0n 0.00000 24699.9n 0.00000 24700.0n 0.00000 24829.9n 0.00000 24830.0n 0.00000 24959.9n 0.00000 24960.0n 0.00000 25089.9n 0.00000 25090.0n 0.00000 25219.9n 0.00000 25220.0n 0.00000 25349.9n 0.00000 25350.0n 0.00000 25479.9n 0.00000 25480.0n 0.00000 25609.9n 0.00000 25610.0n 0.00000 25739.9n 0.00000 25740.0n 0.00000 25869.9n 0.00000 25870.0n 0.00000 25999.9n 0.00000 26000.0n 0.00000 26129.9n 0.00000 26130.0n 0.00000 26259.9n 0.00000 26260.0n 0.00000 26389.9n 0.00000 26390.0n 0.00000 26519.9n 0.00000 26520.0n 0.00000 26649.9n 0.00000 26650.0n 0.00000 26779.9n 0.00000 26780.0n 0.00000 26909.9n 0.00000 26910.0n 0.00000 27039.9n 0.00000 27040.0n 0.00000 27169.9n 0.00000 27170.0n 0.00000 27299.9n 0.00000 27300.0n 0.00000 27429.9n 0.00000 27430.0n 0.00000 27559.9n 0.00000 27560.0n 0.00000 27689.9n 0.00000 27690.0n 0.00000 27819.9n 0.00000 27820.0n 0.00000 27949.9n 0.00000 27950.0n 0.00000 28079.9n 0.00000 28080.0n 0.85000 28209.9n 0.85000 28210.0n 0.85000 28339.9n 0.85000 28340.0n 0.85000 28469.9n 0.85000 28470.0n 0.85000 28599.9n 0.85000 28600.0n 0.85000 28729.9n 0.85000 28730.0n 0.85000 28859.9n 0.85000 28860.0n 0.85000 28989.9n 0.85000 28990.0n 0.85000 29119.9n 0.85000 29120.0n 0.85000 29249.9n 0.85000 29250.0n 0.85000 29379.9n 0.85000 29380.0n 0.85000 29509.9n 0.85000 29510.0n 0.85000 29639.9n 0.85000 29640.0n 0.85000 29769.9n 0.85000 29770.0n 0.85000 29899.9n 0.85000 29900.0n 0.85000 30029.9n 0.85000 30030.0n 0.85000 30159.9n 0.85000 30160.0n 0.85000 30289.9n 0.85000 30290.0n 0.85000 30419.9n 0.85000 30420.0n 0.85000 30549.9n 0.85000 30550.0n 0.85000 30679.9n 0.85000 30680.0n 0.85000 30809.9n 0.85000 30810.0n 0.85000 30939.9n 0.85000 30940.0n 0.85000 31069.9n 0.85000 31070.0n 0.85000 31199.9n 0.85000 31200.0n 0.85000 31329.9n 0.85000 31330.0n 0.85000 31459.9n 0.85000 31460.0n 0.85000 31589.9n 0.85000 31590.0n 0.85000 31719.9n 0.85000 31720.0n 0.85000 31849.9n 0.85000 31850.0n 0.85000 31979.9n 0.85000 31980.0n 0.85000 32109.9n 0.85000 32110.0n 0.85000 32239.9n 0.85000 32240.0n 0.85000 32369.9n 0.85000 32370.0n 0.85000 32499.9n 0.85000 32500.0n 0.85000 32629.9n 0.85000 32630.0n 0.85000 32759.9n 0.85000 32760.0n 0.85000 32889.9n 0.85000 32890.0n 0.85000 33019.9n 0.85000 33020.0n 0.85000 33149.9n 0.85000 33150.0n 0.85000 33279.9n 0.85000 33280.0n 0.85000 33409.9n 0.85000 33410.0n 0.85000 33539.9n 0.85000 33540.0n 0.85000 33669.9n 0.85000 33670.0n 0.85000 33799.9n 0.85000 33800.0n 0.85000 33929.9n 0.85000 33930.0n 0.85000 34059.9n 0.85000 34060.0n 0.85000 34189.9n 0.85000 34190.0n 0.85000 34319.9n 0.85000 34320.0n 0.85000 34449.9n 0.85000 34450.0n 0.85000 34579.9n 0.85000 34580.0n 0.85000 34709.9n 0.85000 34710.0n 0.85000 34839.9n 0.85000 34840.0n 0.85000 34969.9n 0.85000 34970.0n 0.85000 35099.9n 0.85000 35100.0n 0.85000 35229.9n 0.85000 35230.0n 0.85000 35359.9n 0.85000 35360.0n 0.85000 35489.9n 0.85000 35490.0n 0.85000 35619.9n 0.85000 35620.0n 0.85000 35749.9n 0.85000 35750.0n 0.85000 35879.9n 0.85000 35880.0n 0.85000 36009.9n 0.85000 36010.0n 0.85000 36139.9n 0.85000 36140.0n 0.85000 36269.9n 0.85000 36270.0n 0.85000 36399.9n 0.85000 36400.0n 0.85000 36529.9n 0.85000 36530.0n 0.85000 36659.9n 0.85000 36660.0n 0.85000 36789.9n 0.85000 36790.0n 0.85000 36919.9n 0.85000 36920.0n 0.85000 37049.9n 0.85000 37050.0n 0.85000 37179.9n 0.85000 37180.0n 0.85000 37309.9n 0.85000 37310.0n 0.85000 37439.9n 0.85000 37440.0n 0.85000 37569.9n 0.85000 37570.0n 0.85000 37699.9n 0.85000 37700.0n 0.85000 37829.9n 0.85000 37830.0n 0.85000 37959.9n 0.85000 37960.0n 0.85000 38089.9n 0.85000 38090.0n 0.85000 38219.9n 0.85000 38220.0n 0.85000 38349.9n 0.85000 38350.0n 0.85000 38479.9n 0.85000 38480.0n 0.85000 38609.9n 0.85000 38610.0n 0.85000 38739.9n 0.85000 38740.0n 0.85000 38869.9n 0.85000 38870.0n 0.85000 38999.9n 0.85000 39000.0n 0.85000 39129.9n 0.85000 39130.0n 0.85000 39259.9n 0.85000 39260.0n 0.85000 39389.9n 0.85000 39390.0n 0.85000 39519.9n 0.85000 39520.0n 0.85000 39649.9n 0.85000 39650.0n 0.85000 39779.9n 0.85000 39780.0n 0.85000 39909.9n 0.85000 39910.0n 0.85000 40039.9n 0.85000 40040.0n 0.85000 40169.9n 0.85000 40170.0n 0.85000 40299.9n 0.85000 40300.0n 0.85000 40429.9n 0.85000 40430.0n 0.85000 40559.9n 0.85000 40560.0n 0.85000 40689.9n 0.85000 40690.0n 0.85000 40819.9n 0.85000 40820.0n 0.85000 40949.9n 0.85000 40950.0n 0.85000 41079.9n 0.85000 41080.0n 0.85000 41209.9n 0.85000 41210.0n 0.85000 41339.9n 0.85000 41340.0n 0.85000 41469.9n 0.85000 41470.0n 0.85000 41599.9n 0.85000 41600.0n 0.85000 41729.9n 0.85000 41730.0n 0.85000 41859.9n 0.85000 41860.0n 0.85000 41989.9n 0.85000 41990.0n 0.85000 42119.9n 0.85000 42120.0n 0.85000 42249.9n 0.85000 42250.0n 0.85000 42379.9n 0.85000 42380.0n 0.85000 42509.9n 0.85000 42510.0n 0.85000 42639.9n 0.85000 42640.0n 0.85000 42769.9n 0.85000 42770.0n 0.85000 42899.9n 0.85000 42900.0n 0.85000 43029.9n 0.85000 43030.0n 0.85000 43159.9n 0.85000 43160.0n 0.85000 43289.9n 0.85000 43290.0n 0.85000 43419.9n 0.85000 43420.0n 0.85000 43549.9n 0.85000 43550.0n 0.85000 43679.9n 0.85000 43680.0n 0.85000 43809.9n 0.85000 43810.0n 0.85000 43939.9n 0.85000 43940.0n 0.85000 44069.9n 0.85000 44070.0n 0.85000 44199.9n 0.85000 44200.0n 0.85000 44329.9n 0.85000 44330.0n 0.85000 44459.9n 0.85000 44460.0n 0.85000 44589.9n 0.85000 44590.0n 0.85000 44719.9n 0.85000 44720.0n 0.85000 44849.9n 0.85000 44850.0n 0.85000 44979.9n 0.85000 44980.0n 0.85000 45109.9n 0.85000 45110.0n 0.85000 45239.9n 0.85000 45240.0n 0.85000 45369.9n 0.85000 45370.0n 0.85000 45499.9n 0.85000 45500.0n 0.85000 45629.9n 0.85000 45630.0n 0.85000 45759.9n 0.85000 45760.0n 0.85000 45889.9n 0.85000 45890.0n 0.85000 46019.9n 0.85000 46020.0n 0.85000 46149.9n 0.85000 46150.0n 0.85000 46279.9n 0.85000 46280.0n 0.85000 46409.9n 0.85000 46410.0n 0.85000 46539.9n 0.85000 46540.0n 0.85000 46669.9n 0.85000 46670.0n 0.85000 46799.9n 0.85000 46800.0n 0.85000 46929.9n 0.85000 46930.0n 0.85000 47059.9n 0.85000 47060.0n 0.85000 47189.9n 0.85000 47190.0n 0.85000 47319.9n 0.85000 47320.0n 0.85000 47449.9n 0.85000 47450.0n 0.85000 47579.9n 0.85000 47580.0n 0.85000 47709.9n 0.85000 47710.0n 0.85000 47839.9n 0.85000 47840.0n 0.85000 47969.9n 0.85000 47970.0n 0.85000 48099.9n 0.85000 48100.0n 0.85000 48229.9n 0.85000 48230.0n 0.85000 48359.9n 0.85000 48360.0n 0.85000 48489.9n 0.85000 48490.0n 0.85000 48619.9n 0.85000 48620.0n 0.85000 48749.9n 0.85000 48750.0n 0.85000 48879.9n 0.85000 48880.0n 0.85000 49009.9n 0.85000 49010.0n 0.85000 49139.9n 0.85000 49140.0n 0.85000 49269.9n 0.85000 49270.0n 0.85000 49399.9n 0.85000 49400.0n 0.85000 49529.9n 0.85000 49530.0n 0.85000 49659.9n 0.85000 49660.0n 0.85000 49789.9n 0.85000 49790.0n 0.85000 49919.9n 0.85000 49920.0n 0.00000 50049.9n 0.00000 50050.0n 0.00000 50179.9n 0.00000 50180.0n 0.00000 50309.9n 0.00000 50310.0n 0.00000 50439.9n 0.00000 50440.0n 0.00000 50569.9n 0.00000 50570.0n 0.00000 50699.9n 0.00000 50700.0n 0.00000 50829.9n 0.00000 50830.0n 0.00000 50959.9n 0.00000 50960.0n 0.00000 51089.9n 0.00000 51090.0n 0.00000 51219.9n 0.00000 51220.0n 0.00000 51349.9n 0.00000 51350.0n 0.00000 51479.9n 0.00000 51480.0n 0.00000 51609.9n 0.00000 51610.0n 0.00000 51739.9n 0.00000 51740.0n 0.00000 51869.9n 0.00000 51870.0n 0.00000 51999.9n 0.00000 52000.0n 0.00000 52129.9n 0.00000 52130.0n 0.00000 52259.9n 0.00000 52260.0n 0.00000 52389.9n 0.00000 52390.0n 0.00000 52519.9n 0.00000 52520.0n 0.00000 52649.9n 0.00000 52650.0n 0.00000 52779.9n 0.00000 52780.0n 0.00000 52909.9n 0.00000 52910.0n 0.00000 53039.9n 0.00000 53040.0n 0.00000 53169.9n 0.00000 53170.0n 0.00000 53299.9n 0.00000 53300.0n 0.00000 53429.9n 0.00000 53430.0n 0.00000 53559.9n 0.00000 53560.0n 0.00000 53689.9n 0.00000 53690.0n 0.00000 53819.9n 0.00000 53820.0n 0.00000 53949.9n 0.00000 53950.0n 0.00000 54079.9n 0.00000 54080.0n 0.00000 54209.9n 0.00000 54210.0n 0.00000 54339.9n 0.00000 54340.0n 0.00000 54469.9n 0.00000 54470.0n 0.00000 54599.9n 0.00000 54600.0n 0.00000 54729.9n 0.00000 54730.0n 0.00000 54859.9n 0.00000 54860.0n 0.00000 54989.9n 0.00000 54990.0n 0.00000 55119.9n 0.00000 55120.0n 0.00000 55249.9n 0.00000 55250.0n 0.00000 55379.9n 0.00000 55380.0n 0.00000 55509.9n 0.00000 55510.0n 0.00000 55639.9n 0.00000 55640.0n 0.00000 55769.9n 0.00000 55770.0n 0.00000 55899.9n 0.00000 55900.0n 0.00000 56029.9n 0.00000 56030.0n 0.00000 56159.9n 0.00000 56160.0n 0.85000 56289.9n 0.85000 56290.0n 0.85000 56419.9n 0.85000 56420.0n 0.85000 56549.9n 0.85000 56550.0n 0.85000 56679.9n 0.85000 56680.0n 0.85000 56809.9n 0.85000 56810.0n 0.85000 56939.9n 0.85000 56940.0n 0.85000 57069.9n 0.85000 57070.0n 0.85000 57199.9n 0.85000 57200.0n 0.85000 57329.9n 0.85000 57330.0n 0.85000 57459.9n 0.85000 57460.0n 0.85000 57589.9n 0.85000 57590.0n 0.85000 57719.9n 0.85000 57720.0n 0.85000 57849.9n 0.85000 57850.0n 0.85000 57979.9n 0.85000 57980.0n 0.85000 58109.9n 0.85000 58110.0n 0.85000 58239.9n 0.85000 58240.0n 0.85000 58369.9n 0.85000 58370.0n 0.85000 58499.9n 0.85000 58500.0n 0.85000 58629.9n 0.85000 58630.0n 0.85000 58759.9n 0.85000 58760.0n 0.85000 58889.9n 0.85000 58890.0n 0.85000 59019.9n 0.85000 59020.0n 0.85000 59149.9n 0.85000 59150.0n 0.85000 59279.9n 0.85000 59280.0n 0.85000 59409.9n 0.85000 59410.0n 0.85000 59539.9n 0.85000 59540.0n 0.85000 59669.9n 0.85000 59670.0n 0.85000 59799.9n 0.85000 59800.0n 0.85000 59929.9n 0.85000 59930.0n 0.85000 60059.9n 0.85000 60060.0n 0.85000 60189.9n 0.85000 60190.0n 0.85000 60319.9n 0.85000 60320.0n 0.85000 60449.9n 0.85000 60450.0n 0.85000 60579.9n 0.85000 60580.0n 0.85000 60709.9n 0.85000 60710.0n 0.85000 60839.9n 0.85000 60840.0n 0.85000 60969.9n 0.85000 60970.0n 0.85000 61099.9n 0.85000 61100.0n 0.85000 61229.9n 0.85000 61230.0n 0.85000 61359.9n 0.85000 61360.0n 0.85000 61489.9n 0.85000 61490.0n 0.85000 61619.9n 0.85000 61620.0n 0.85000 61749.9n 0.85000 61750.0n 0.85000 61879.9n 0.85000 61880.0n 0.85000 62009.9n 0.85000 62010.0n 0.85000 62139.9n 0.85000 62140.0n 0.85000 62269.9n 0.85000 62270.0n 0.85000 62399.9n 0.85000 62400.0n 0.85000 62529.9n 0.85000 62530.0n 0.85000 62659.9n 0.85000 62660.0n 0.85000 62789.9n 0.85000 62790.0n 0.85000 62919.9n 0.85000 62920.0n 0.85000 63049.9n 0.85000 63050.0n 0.85000 63179.9n 0.85000 63180.0n 0.85000 63309.9n 0.85000 63310.0n 0.85000 63439.9n 0.85000 63440.0n 0.85000 63569.9n 0.85000 63570.0n 0.85000 63699.9n 0.85000 63700.0n 0.85000 63829.9n 0.85000 63830.0n 0.85000 63959.9n 0.85000 63960.0n 0.85000 64089.9n 0.85000 64090.0n 0.85000 64219.9n 0.85000 64220.0n 0.85000 64349.9n 0.85000 64350.0n 0.85000 64479.9n 0.85000 64480.0n 0.85000 64609.9n 0.85000 64610.0n 0.85000 64739.9n 0.85000 64740.0n 0.85000 64869.9n 0.85000 64870.0n 0.85000 64999.9n 0.85000 65000.0n 0.85000 65129.9n 0.85000 65130.0n 0.85000 65259.9n 0.85000 65260.0n 0.85000 65389.9n 0.85000 65390.0n 0.85000 65519.9n 0.85000 65520.0n 0.85000 65649.9n 0.85000 65650.0n 0.85000 65779.9n 0.85000 65780.0n 0.85000 65909.9n 0.85000 65910.0n 0.85000 66039.9n 0.85000 66040.0n 0.85000 66169.9n 0.85000 66170.0n 0.85000 66299.9n 0.85000 66300.0n 0.85000 66429.9n 0.85000 66430.0n 0.85000 66559.9n 0.85000 66560.0n 0.85000 66689.9n 0.85000 66690.0n 0.85000 66819.9n 0.85000 66820.0n 0.85000 66949.9n 0.85000 66950.0n 0.85000 67079.9n 0.85000 67080.0n 0.85000 67209.9n 0.85000 67210.0n 0.85000 67339.9n 0.85000 67340.0n 0.85000 67469.9n 0.85000 67470.0n 0.85000 67599.9n 0.85000 67600.0n 0.85000 67729.9n 0.85000 67730.0n 0.85000 67859.9n 0.85000 67860.0n 0.85000 67989.9n 0.85000 67990.0n 0.85000 68119.9n 0.85000 68120.0n 0.85000 68249.9n 0.85000 68250.0n 0.85000 68379.9n 0.85000 68380.0n 0.85000 68509.9n 0.85000 68510.0n 0.85000 68639.9n 0.85000 68640.0n 0.85000 68769.9n 0.85000 68770.0n 0.85000 68899.9n 0.85000 68900.0n 0.85000 69029.9n 0.85000 69030.0n 0.85000 69159.9n 0.85000 69160.0n 0.85000 69289.9n 0.85000 69290.0n 0.85000 69419.9n 0.85000 69420.0n 0.85000 69549.9n 0.85000 69550.0n 0.85000 69679.9n 0.85000 69680.0n 0.85000 69809.9n 0.85000 69810.0n 0.85000 69939.9n 0.85000 69940.0n 0.85000 70069.9n 0.85000 70070.0n 0.85000 70199.9n 0.85000 70200.0n 0.85000 70329.9n 0.85000 70330.0n 0.85000 70459.9n 0.85000 70460.0n 0.85000 70589.9n 0.85000 70590.0n 0.85000 70719.9n 0.85000 70720.0n 0.85000 70849.9n 0.85000 70850.0n 0.85000 70979.9n 0.85000 70980.0n 0.85000 71109.9n 0.85000 71110.0n 0.85000 71239.9n 0.85000 71240.0n 0.85000 71369.9n 0.85000 71370.0n 0.85000 71499.9n 0.85000 71500.0n 0.85000 71629.9n 0.85000 71630.0n 0.85000 71759.9n 0.85000 71760.0n 0.85000 71889.9n 0.85000 71890.0n 0.85000 72019.9n 0.85000 72020.0n 0.85000 72149.9n 0.85000 72150.0n 0.85000 72279.9n 0.85000 72280.0n 0.85000 72409.9n 0.85000 72410.0n 0.85000 72539.9n 0.85000 72540.0n 0.85000 72669.9n 0.85000 72670.0n 0.85000 72799.9n 0.85000 72800.0n 0.85000 72929.9n 0.85000 72930.0n 0.85000 73059.9n 0.85000 73060.0n 0.85000 73189.9n 0.85000 73190.0n 0.85000 73319.9n 0.85000 73320.0n 0.85000 73449.9n 0.85000 73450.0n 0.85000 73579.9n 0.85000 73580.0n 0.85000 73709.9n 0.85000 73710.0n 0.85000 73839.9n 0.85000 73840.0n 0.85000 73969.9n 0.85000 73970.0n 0.85000 74099.9n 0.85000 74100.0n 0.85000 74229.9n 0.85000 74230.0n 0.85000 74359.9n 0.85000 74360.0n 0.85000 74489.9n 0.85000 74490.0n 0.85000 74619.9n 0.85000 74620.0n 0.85000 74749.9n 0.85000 74750.0n 0.85000 74879.9n 0.85000 74880.0n 0.85000 75009.9n 0.85000 75010.0n 0.85000 75139.9n 0.85000 75140.0n 0.85000 75269.9n 0.85000 75270.0n 0.85000 75399.9n 0.85000 75400.0n 0.85000 75529.9n 0.85000 75530.0n 0.85000 75659.9n 0.85000 75660.0n 0.85000 75789.9n 0.85000 75790.0n 0.85000 75919.9n 0.85000 75920.0n 0.85000 76049.9n 0.85000 76050.0n 0.85000 76179.9n 0.85000 76180.0n 0.85000 76309.9n 0.85000 76310.0n 0.85000 76439.9n 0.85000 76440.0n 0.85000 76569.9n 0.85000 76570.0n 0.85000 76699.9n 0.85000 76700.0n 0.85000 76829.9n 0.85000 76830.0n 0.85000 76959.9n 0.85000 76960.0n 0.85000 77089.9n 0.85000 77090.0n 0.85000 77219.9n 0.85000 77220.0n 0.85000 77349.9n 0.85000 77350.0n 0.85000 77479.9n 0.85000 77480.0n 0.85000 77609.9n 0.85000 77610.0n 0.85000 77739.9n 0.85000 77740.0n 0.85000 77869.9n 0.85000 77870.0n 0.85000 77999.9n 0.85000 78000.0n 0.00000 78129.9n 0.00000 78130.0n 0.00000 78259.9n 0.00000 78260.0n 0.00000 78389.9n 0.00000 78390.0n 0.00000 78519.9n 0.00000 78520.0n 0.00000 78649.9n 0.00000 78650.0n 0.00000 78779.9n 0.00000 78780.0n 0.00000 78909.9n 0.00000 78910.0n 0.00000 79039.9n 0.00000 79040.0n 0.00000 79169.9n 0.00000 79170.0n 0.00000 79299.9n 0.00000 79300.0n 0.00000 79429.9n 0.00000 79430.0n 0.00000 79559.9n 0.00000 79560.0n 0.00000 79689.9n 0.00000 79690.0n 0.00000 79819.9n 0.00000 79820.0n 0.00000 79949.9n 0.00000 79950.0n 0.00000 80079.9n 0.00000 80080.0n 0.00000 80209.9n 0.00000 80210.0n 0.00000 80339.9n 0.00000 80340.0n 0.00000 80469.9n 0.00000 80470.0n 0.00000 80599.9n 0.00000 80600.0n 0.00000 80729.9n 0.00000 80730.0n 0.00000 80859.9n 0.00000 80860.0n 0.00000 80989.9n 0.00000 80990.0n 0.00000 81119.9n 0.00000 81120.0n 0.00000 81249.9n 0.00000 81250.0n 0.00000 81379.9n 0.00000 81380.0n 0.00000 81509.9n 0.00000 81510.0n 0.00000 81639.9n 0.00000 81640.0n 0.00000 81769.9n 0.00000 81770.0n 0.00000 81899.9n 0.00000 81900.0n 0.00000 82029.9n 0.00000 82030.0n 0.00000 82159.9n 0.00000 82160.0n 0.00000 82289.9n 0.00000 82290.0n 0.00000 82419.9n 0.00000 82420.0n 0.00000 82549.9n 0.00000 82550.0n 0.00000 82679.9n 0.00000 82680.0n 0.00000 82809.9n 0.00000 82810.0n 0.00000 82939.9n 0.00000 82940.0n 0.00000 83069.9n 0.00000 83070.0n 0.00000 83199.9n 0.00000 83200.0n 0.00000 83329.9n 0.00000 83330.0n 0.00000 83459.9n 0.00000 83460.0n 0.00000 83589.9n 0.00000 83590.0n 0.00000 83719.9n 0.00000 83720.0n 0.00000 83849.9n 0.00000 83850.0n 0.00000 83979.9n 0.00000 83980.0n 0.00000 84109.9n 0.00000 84110.0n 0.00000 84239.9n 0.00000 84240.0n 0.85000 84369.9n 0.85000 84370.0n 0.85000 84499.9n 0.85000 84500.0n 0.85000 84629.9n 0.85000 84630.0n 0.85000 84759.9n 0.85000 84760.0n 0.85000 84889.9n 0.85000 84890.0n 0.85000 85019.9n 0.85000 85020.0n 0.85000 85149.9n 0.85000 85150.0n 0.85000 85279.9n 0.85000 85280.0n 0.85000 85409.9n 0.85000 85410.0n 0.85000 85539.9n 0.85000 85540.0n 0.85000 85669.9n 0.85000 85670.0n 0.85000 85799.9n 0.85000 85800.0n 0.85000 85929.9n 0.85000 85930.0n 0.85000 86059.9n 0.85000 86060.0n 0.85000 86189.9n 0.85000 86190.0n 0.85000 86319.9n 0.85000 86320.0n 0.85000 86449.9n 0.85000 86450.0n 0.85000 86579.9n 0.85000 86580.0n 0.85000 86709.9n 0.85000 86710.0n 0.85000 86839.9n 0.85000 86840.0n 0.85000 86969.9n 0.85000 86970.0n 0.85000 87099.9n 0.85000 87100.0n 0.85000 87229.9n 0.85000 87230.0n 0.85000 87359.9n 0.85000 87360.0n 0.85000 87489.9n 0.85000 87490.0n 0.85000 87619.9n 0.85000 87620.0n 0.85000 87749.9n 0.85000 87750.0n 0.85000 87879.9n 0.85000 87880.0n 0.85000 88009.9n 0.85000 88010.0n 0.85000 88139.9n 0.85000 88140.0n 0.85000 88269.9n 0.85000 88270.0n 0.85000 88399.9n 0.85000 88400.0n 0.85000 88529.9n 0.85000 88530.0n 0.85000 88659.9n 0.85000 88660.0n 0.85000 88789.9n 0.85000 88790.0n 0.85000 88919.9n 0.85000 88920.0n 0.85000 89049.9n 0.85000 89050.0n 0.85000 89179.9n 0.85000 89180.0n 0.85000 89309.9n 0.85000 89310.0n 0.85000 89439.9n 0.85000 89440.0n 0.85000 89569.9n 0.85000 89570.0n 0.85000 89699.9n 0.85000 89700.0n 0.85000 89829.9n 0.85000 89830.0n 0.85000 89959.9n 0.85000 89960.0n 0.85000 90089.9n 0.85000 90090.0n 0.85000 90219.9n 0.85000 90220.0n 0.85000 90349.9n 0.85000 90350.0n 0.85000 90479.9n 0.85000 90480.0n 0.85000 90609.9n 0.85000 90610.0n 0.85000 90739.9n 0.85000 90740.0n 0.85000 90869.9n 0.85000 90870.0n 0.85000 90999.9n 0.85000 91000.0n 0.85000 91129.9n 0.85000 91130.0n 0.85000 91259.9n 0.85000 91260.0n 0.85000 91389.9n 0.85000 91390.0n 0.85000 91519.9n 0.85000 91520.0n 0.85000 91649.9n 0.85000 91650.0n 0.85000 91779.9n 0.85000 91780.0n 0.85000 91909.9n 0.85000 91910.0n 0.85000 92039.9n 0.85000 92040.0n 0.85000 92169.9n 0.85000 92170.0n 0.85000 92299.9n 0.85000 92300.0n 0.85000 92429.9n 0.85000 92430.0n 0.85000 92559.9n 0.85000 92560.0n 0.85000 92689.9n 0.85000 92690.0n 0.85000 92819.9n 0.85000 92820.0n 0.85000 92949.9n 0.85000 92950.0n 0.85000 93079.9n 0.85000 93080.0n 0.85000 93209.9n 0.85000 93210.0n 0.85000 93339.9n 0.85000 93340.0n 0.85000 93469.9n 0.85000 93470.0n 0.85000 93599.9n 0.85000 93600.0n 0.85000 93729.9n 0.85000 93730.0n 0.85000 93859.9n 0.85000 93860.0n 0.85000 93989.9n 0.85000 93990.0n 0.85000 94119.9n 0.85000 94120.0n 0.85000 94249.9n 0.85000 94250.0n 0.85000 94379.9n 0.85000 94380.0n 0.85000 94509.9n 0.85000 94510.0n 0.85000 94639.9n 0.85000 94640.0n 0.85000 94769.9n 0.85000 94770.0n 0.85000 94899.9n 0.85000 94900.0n 0.85000 95029.9n 0.85000 95030.0n 0.85000 95159.9n 0.85000 95160.0n 0.85000 95289.9n 0.85000 95290.0n 0.85000 95419.9n 0.85000 95420.0n 0.85000 95549.9n 0.85000 95550.0n 0.85000 95679.9n 0.85000 95680.0n 0.85000 95809.9n 0.85000 95810.0n 0.85000 95939.9n 0.85000 95940.0n 0.85000 96069.9n 0.85000 96070.0n 0.85000 96199.9n 0.85000 96200.0n 0.85000 96329.9n 0.85000 96330.0n 0.85000 96459.9n 0.85000 96460.0n 0.85000 96589.9n 0.85000 96590.0n 0.85000 96719.9n 0.85000 96720.0n 0.85000 96849.9n 0.85000 96850.0n 0.85000 96979.9n 0.85000 96980.0n 0.85000 97109.9n 0.85000 97110.0n 0.85000 97239.9n 0.85000 97240.0n 0.85000 97369.9n 0.85000 97370.0n 0.85000 97499.9n 0.85000 97500.0n 0.85000 97629.9n 0.85000 97630.0n 0.85000 97759.9n 0.85000 97760.0n 0.85000 97889.9n 0.85000 97890.0n 0.85000 98019.9n 0.85000 98020.0n 0.85000 98149.9n 0.85000 98150.0n 0.85000 98279.9n 0.85000 98280.0n 0.85000 98409.9n 0.85000 98410.0n 0.85000 98539.9n 0.85000 98540.0n 0.85000 98669.9n 0.85000 98670.0n 0.85000 98799.9n 0.85000 98800.0n 0.85000 98929.9n 0.85000 98930.0n 0.85000 99059.9n 0.85000 99060.0n 0.85000 99189.9n 0.85000 99190.0n 0.85000 99319.9n 0.85000 99320.0n 0.85000 99449.9n 0.85000 99450.0n 0.85000 99579.9n 0.85000 99580.0n 0.85000 99709.9n 0.85000 99710.0n 0.85000 99839.9n 0.85000 99840.0n 0.85000 99969.9n 0.85000 99970.0n 0.85000 100099.9n 0.85000 100100.0n 0.85000 100229.9n 0.85000 100230.0n 0.85000 100359.9n 0.85000 100360.0n 0.85000 100489.9n 0.85000 100490.0n 0.85000 100619.9n 0.85000 100620.0n 0.85000 100749.9n 0.85000 100750.0n 0.85000 100879.9n 0.85000 100880.0n 0.85000 101009.9n 0.85000 101010.0n 0.85000 101139.9n 0.85000 101140.0n 0.85000 101269.9n 0.85000 101270.0n 0.85000 101399.9n 0.85000 101400.0n 0.85000 101529.9n 0.85000 101530.0n 0.85000 101659.9n 0.85000 101660.0n 0.85000 101789.9n 0.85000 101790.0n 0.85000 101919.9n 0.85000 101920.0n 0.85000 102049.9n 0.85000 102050.0n 0.85000 102179.9n 0.85000 102180.0n 0.85000 102309.9n 0.85000 102310.0n 0.85000 102439.9n 0.85000 102440.0n 0.85000 102569.9n 0.85000 102570.0n 0.85000 102699.9n 0.85000 102700.0n 0.85000 102829.9n 0.85000 102830.0n 0.85000 102959.9n 0.85000 102960.0n 0.85000 103089.9n 0.85000 103090.0n 0.85000 103219.9n 0.85000 103220.0n 0.85000 103349.9n 0.85000 103350.0n 0.85000 103479.9n 0.85000 103480.0n 0.85000 103609.9n 0.85000 103610.0n 0.85000 103739.9n 0.85000 103740.0n 0.85000 103869.9n 0.85000 103870.0n 0.85000 103999.9n 0.85000 104000.0n 0.85000 104129.9n 0.85000 104130.0n 0.85000 104259.9n 0.85000 104260.0n 0.85000 104389.9n 0.85000 104390.0n 0.85000 104519.9n 0.85000 104520.0n 0.85000 104649.9n 0.85000 104650.0n 0.85000 104779.9n 0.85000 104780.0n 0.85000 104909.9n 0.85000 104910.0n 0.85000 105039.9n 0.85000 105040.0n 0.85000 105169.9n 0.85000 105170.0n 0.85000 105299.9n 0.85000 105300.0n 0.85000 105429.9n 0.85000 105430.0n 0.85000 105559.9n 0.85000 105560.0n 0.85000 105689.9n 0.85000 105690.0n 0.85000 105819.9n 0.85000 105820.0n 0.85000 105949.9n 0.85000 105950.0n 0.85000 106079.9n 0.85000 106080.0n 0.00000 106209.9n 0.00000 106210.0n 0.00000 106339.9n 0.00000 106340.0n 0.00000 106469.9n 0.00000 106470.0n 0.00000 106599.9n 0.00000 106600.0n 0.00000 106729.9n 0.00000 106730.0n 0.00000 106859.9n 0.00000 106860.0n 0.00000 106989.9n 0.00000 106990.0n 0.00000 107119.9n 0.00000 107120.0n 0.00000 107249.9n 0.00000 107250.0n 0.00000 107379.9n 0.00000 107380.0n 0.00000 107509.9n 0.00000 107510.0n 0.00000 107639.9n 0.00000 107640.0n 0.00000 107769.9n 0.00000 107770.0n 0.00000 107899.9n 0.00000 107900.0n 0.00000 108029.9n 0.00000 108030.0n 0.00000 108159.9n 0.00000 108160.0n 0.00000 108289.9n 0.00000 108290.0n 0.00000 108419.9n 0.00000 108420.0n 0.00000 108549.9n 0.00000 108550.0n 0.00000 108679.9n 0.00000 108680.0n 0.00000 108809.9n 0.00000 108810.0n 0.00000 108939.9n 0.00000 108940.0n 0.00000 109069.9n 0.00000 109070.0n 0.00000 109199.9n 0.00000 109200.0n 0.00000 109329.9n 0.00000 109330.0n 0.00000 109459.9n 0.00000 109460.0n 0.00000 109589.9n 0.00000 109590.0n 0.00000 109719.9n 0.00000 109720.0n 0.00000 109849.9n 0.00000 109850.0n 0.00000 109979.9n 0.00000 109980.0n 0.00000 110109.9n 0.00000 110110.0n 0.00000 110239.9n 0.00000 110240.0n 0.00000 110369.9n 0.00000 110370.0n 0.00000 110499.9n 0.00000 110500.0n 0.00000 110629.9n 0.00000 110630.0n 0.00000 110759.9n 0.00000 110760.0n 0.00000 110889.9n 0.00000 110890.0n 0.00000 111019.9n 0.00000 111020.0n 0.00000 111149.9n 0.00000 111150.0n 0.00000 111279.9n 0.00000 111280.0n 0.00000 111409.9n 0.00000 111410.0n 0.00000 111539.9n 0.00000 111540.0n 0.00000 111669.9n 0.00000 111670.0n 0.00000 111799.9n 0.00000 111800.0n 0.00000 111929.9n 0.00000 111930.0n 0.00000 112059.9n 0.00000 112060.0n 0.00000 112189.9n 0.00000 112190.0n 0.00000 112319.9n 0.00000 112320.0n 0.85000 112449.9n 0.85000 112450.0n 0.85000 112579.9n 0.85000 112580.0n 0.85000 112709.9n 0.85000 112710.0n 0.85000 112839.9n 0.85000 112840.0n 0.85000 112969.9n 0.85000 112970.0n 0.85000 113099.9n 0.85000 113100.0n 0.85000 113229.9n 0.85000 113230.0n 0.85000 113359.9n 0.85000 113360.0n 0.85000 113489.9n 0.85000 113490.0n 0.85000 113619.9n 0.85000 113620.0n 0.85000 113749.9n 0.85000 113750.0n 0.85000 113879.9n 0.85000 113880.0n 0.85000 114009.9n 0.85000 114010.0n 0.85000 114139.9n 0.85000 114140.0n 0.85000 114269.9n 0.85000 114270.0n 0.85000 114399.9n 0.85000 114400.0n 0.85000 114529.9n 0.85000 114530.0n 0.85000 114659.9n 0.85000 114660.0n 0.85000 114789.9n 0.85000 114790.0n 0.85000 114919.9n 0.85000 114920.0n 0.85000 115049.9n 0.85000 115050.0n 0.85000 115179.9n 0.85000 115180.0n 0.85000 115309.9n 0.85000 115310.0n 0.85000 115439.9n 0.85000 115440.0n 0.85000 115569.9n 0.85000 115570.0n 0.85000 115699.9n 0.85000 115700.0n 0.85000 115829.9n 0.85000 115830.0n 0.85000 115959.9n 0.85000 115960.0n 0.85000 116089.9n 0.85000 116090.0n 0.85000 116219.9n 0.85000 116220.0n 0.85000 116349.9n 0.85000 116350.0n 0.85000 116479.9n 0.85000 116480.0n 0.85000 116609.9n 0.85000 116610.0n 0.85000 116739.9n 0.85000 116740.0n 0.85000 116869.9n 0.85000 116870.0n 0.85000 116999.9n 0.85000 117000.0n 0.85000 117129.9n 0.85000 117130.0n 0.85000 117259.9n 0.85000 117260.0n 0.85000 117389.9n 0.85000 117390.0n 0.85000 117519.9n 0.85000 117520.0n 0.85000 117649.9n 0.85000 117650.0n 0.85000 117779.9n 0.85000 117780.0n 0.85000 117909.9n 0.85000 117910.0n 0.85000 118039.9n 0.85000 118040.0n 0.85000 118169.9n 0.85000 118170.0n 0.85000 118299.9n 0.85000 118300.0n 0.85000 118429.9n 0.85000 118430.0n 0.85000 118559.9n 0.85000 118560.0n 0.85000 118689.9n 0.85000 118690.0n 0.85000 118819.9n 0.85000 118820.0n 0.85000 118949.9n 0.85000 118950.0n 0.85000 119079.9n 0.85000 119080.0n 0.85000 119209.9n 0.85000 119210.0n 0.85000 119339.9n 0.85000 119340.0n 0.85000 119469.9n 0.85000 119470.0n 0.85000 119599.9n 0.85000 119600.0n 0.85000 119729.9n 0.85000 119730.0n 0.85000 119859.9n 0.85000 119860.0n 0.85000 119989.9n 0.85000 119990.0n 0.85000 120119.9n 0.85000 120120.0n 0.85000 120249.9n 0.85000 120250.0n 0.85000 120379.9n 0.85000 120380.0n 0.85000 120509.9n 0.85000 120510.0n 0.85000 120639.9n 0.85000 120640.0n 0.85000 120769.9n 0.85000 120770.0n 0.85000 120899.9n 0.85000 120900.0n 0.85000 121029.9n 0.85000 121030.0n 0.85000 121159.9n 0.85000 121160.0n 0.85000 121289.9n 0.85000 121290.0n 0.85000 121419.9n 0.85000 121420.0n 0.85000 121549.9n 0.85000 121550.0n 0.85000 121679.9n 0.85000 121680.0n 0.85000 121809.9n 0.85000 121810.0n 0.85000 121939.9n 0.85000 121940.0n 0.85000 122069.9n 0.85000 122070.0n 0.85000 122199.9n 0.85000 122200.0n 0.85000 122329.9n 0.85000 122330.0n 0.85000 122459.9n 0.85000 122460.0n 0.85000 122589.9n 0.85000 122590.0n 0.85000 122719.9n 0.85000 122720.0n 0.85000 122849.9n 0.85000 122850.0n 0.85000 122979.9n 0.85000 122980.0n 0.85000 123109.9n 0.85000 123110.0n 0.85000 123239.9n 0.85000 123240.0n 0.85000 123369.9n 0.85000 123370.0n 0.85000 123499.9n 0.85000 123500.0n 0.85000 123629.9n 0.85000 123630.0n 0.85000 123759.9n 0.85000 123760.0n 0.85000 123889.9n 0.85000 123890.0n 0.85000 124019.9n 0.85000 124020.0n 0.85000 124149.9n 0.85000 124150.0n 0.85000 124279.9n 0.85000 124280.0n 0.85000 124409.9n 0.85000 124410.0n 0.85000 124539.9n 0.85000 124540.0n 0.85000 124669.9n 0.85000 124670.0n 0.85000 124799.9n 0.85000 124800.0n 0.85000 124929.9n 0.85000 124930.0n 0.85000 125059.9n 0.85000 125060.0n 0.85000 125189.9n 0.85000 125190.0n 0.85000 125319.9n 0.85000 125320.0n 0.85000 125449.9n 0.85000 125450.0n 0.85000 125579.9n 0.85000 125580.0n 0.85000 125709.9n 0.85000 125710.0n 0.85000 125839.9n 0.85000 125840.0n 0.85000 125969.9n 0.85000 125970.0n 0.85000 126099.9n 0.85000 126100.0n 0.85000 126229.9n 0.85000 126230.0n 0.85000 126359.9n 0.85000 126360.0n 0.85000 126489.9n 0.85000 126490.0n 0.85000 126619.9n 0.85000 126620.0n 0.85000 126749.9n 0.85000 126750.0n 0.85000 126879.9n 0.85000 126880.0n 0.85000 127009.9n 0.85000 127010.0n 0.85000 127139.9n 0.85000 127140.0n 0.85000 127269.9n 0.85000 127270.0n 0.85000 127399.9n 0.85000 127400.0n 0.85000 127529.9n 0.85000 127530.0n 0.85000 127659.9n 0.85000 127660.0n 0.85000 127789.9n 0.85000 127790.0n 0.85000 127919.9n 0.85000 127920.0n 0.85000 128049.9n 0.85000 128050.0n 0.85000 128179.9n 0.85000 128180.0n 0.85000 128309.9n 0.85000 128310.0n 0.85000 128439.9n 0.85000 128440.0n 0.85000 128569.9n 0.85000 128570.0n 0.85000 128699.9n 0.85000 128700.0n 0.85000 128829.9n 0.85000 128830.0n 0.85000 128959.9n 0.85000 128960.0n 0.85000 129089.9n 0.85000 129090.0n 0.85000 129219.9n 0.85000 129220.0n 0.85000 129349.9n 0.85000 129350.0n 0.85000 129479.9n 0.85000 129480.0n 0.85000 129609.9n 0.85000 129610.0n 0.85000 129739.9n 0.85000 129740.0n 0.85000 129869.9n 0.85000 129870.0n 0.85000 129999.9n 0.85000 130000.0n 0.85000 130129.9n 0.85000 130130.0n 0.85000 130259.9n 0.85000 130260.0n 0.85000 130389.9n 0.85000 130390.0n 0.85000 130519.9n 0.85000 130520.0n 0.85000 130649.9n 0.85000 130650.0n 0.85000 130779.9n 0.85000 130780.0n 0.85000 130909.9n 0.85000 130910.0n 0.85000 131039.9n 0.85000 131040.0n 0.85000 131169.9n 0.85000 131170.0n 0.85000 131299.9n 0.85000 131300.0n 0.85000 131429.9n 0.85000 131430.0n 0.85000 131559.9n 0.85000 131560.0n 0.85000 131689.9n 0.85000 131690.0n 0.85000 131819.9n 0.85000 131820.0n 0.85000 131949.9n 0.85000 131950.0n 0.85000 132079.9n 0.85000 132080.0n 0.85000 132209.9n 0.85000 132210.0n 0.85000 132339.9n 0.85000 132340.0n 0.85000 132469.9n 0.85000 132470.0n 0.85000 132599.9n 0.85000 132600.0n 0.85000 132729.9n 0.85000 132730.0n 0.85000 132859.9n 0.85000 132860.0n 0.85000 132989.9n 0.85000 132990.0n 0.85000 133119.9n 0.85000 133120.0n 0.85000 133249.9n 0.85000 133250.0n 0.85000 133379.9n 0.85000 133380.0n 0.85000 133509.9n 0.85000 133510.0n 0.85000 133639.9n 0.85000 133640.0n 0.85000 133769.9n 0.85000 133770.0n 0.85000 133899.9n 0.85000 133900.0n 0.85000 134029.9n 0.85000 134030.0n 0.85000 134159.9n 0.85000 134160.0n 0.00000 134289.9n 0.00000 134290.0n 0.00000 134419.9n 0.00000 134420.0n 0.00000 134549.9n 0.00000 134550.0n 0.00000 134679.9n 0.00000 134680.0n 0.00000 134809.9n 0.00000 134810.0n 0.00000 134939.9n 0.00000 134940.0n 0.00000 135069.9n 0.00000 135070.0n 0.00000 135199.9n 0.00000 135200.0n 0.00000 135329.9n 0.00000 135330.0n 0.00000 135459.9n 0.00000 135460.0n 0.00000 135589.9n 0.00000 135590.0n 0.00000 135719.9n 0.00000 135720.0n 0.00000 135849.9n 0.00000 135850.0n 0.00000 135979.9n 0.00000 135980.0n 0.00000 136109.9n 0.00000 136110.0n 0.00000 136239.9n 0.00000 136240.0n 0.00000 136369.9n 0.00000 136370.0n 0.00000 136499.9n 0.00000 136500.0n 0.00000 136629.9n 0.00000 136630.0n 0.00000 136759.9n 0.00000 136760.0n 0.00000 136889.9n 0.00000 136890.0n 0.00000 137019.9n 0.00000 137020.0n 0.00000 137149.9n 0.00000 137150.0n 0.00000 137279.9n 0.00000 137280.0n 0.00000 137409.9n 0.00000 137410.0n 0.00000 137539.9n 0.00000 137540.0n 0.00000 137669.9n 0.00000 137670.0n 0.00000 137799.9n 0.00000 137800.0n 0.00000 137929.9n 0.00000 137930.0n 0.00000 138059.9n 0.00000 138060.0n 0.00000 138189.9n 0.00000 138190.0n 0.00000 138319.9n 0.00000 138320.0n 0.00000 138449.9n 0.00000 138450.0n 0.00000 138579.9n 0.00000 138580.0n 0.00000 138709.9n 0.00000 138710.0n 0.00000 138839.9n 0.00000 138840.0n 0.00000 138969.9n 0.00000 138970.0n 0.00000 139099.9n 0.00000 139100.0n 0.00000 139229.9n 0.00000 139230.0n 0.00000 139359.9n 0.00000 139360.0n 0.00000 139489.9n 0.00000 139490.0n 0.00000 139619.9n 0.00000 139620.0n 0.00000 139749.9n 0.00000 139750.0n 0.00000 139879.9n 0.00000 139880.0n 0.00000 140009.9n 0.00000 140010.0n 0.00000 140139.9n 0.00000 140140.0n 0.00000 140269.9n 0.00000 140270.0n 0.00000 140399.9n 0.00000 140400.0n 0.85000 140529.9n 0.85000 140530.0n 0.85000 140659.9n 0.85000 140660.0n 0.85000 140789.9n 0.85000 140790.0n 0.85000 140919.9n 0.85000 140920.0n 0.85000 141049.9n 0.85000 141050.0n 0.85000 141179.9n 0.85000 141180.0n 0.85000 141309.9n 0.85000 141310.0n 0.85000 141439.9n 0.85000 141440.0n 0.85000 141569.9n 0.85000 141570.0n 0.85000 141699.9n 0.85000 141700.0n 0.85000 141829.9n 0.85000 141830.0n 0.85000 141959.9n 0.85000 141960.0n 0.85000 142089.9n 0.85000 142090.0n 0.85000 142219.9n 0.85000 142220.0n 0.85000 142349.9n 0.85000 142350.0n 0.85000 142479.9n 0.85000 142480.0n 0.85000 142609.9n 0.85000 142610.0n 0.85000 142739.9n 0.85000 142740.0n 0.85000 142869.9n 0.85000 142870.0n 0.85000 142999.9n 0.85000 143000.0n 0.85000 143129.9n 0.85000 143130.0n 0.85000 143259.9n 0.85000 143260.0n 0.85000 143389.9n 0.85000 143390.0n 0.85000 143519.9n 0.85000 143520.0n 0.85000 143649.9n 0.85000 143650.0n 0.85000 143779.9n 0.85000 143780.0n 0.85000 143909.9n 0.85000 143910.0n 0.85000 144039.9n 0.85000 144040.0n 0.85000 144169.9n 0.85000 144170.0n 0.85000 144299.9n 0.85000 144300.0n 0.85000 144429.9n 0.85000 144430.0n 0.85000 144559.9n 0.85000 144560.0n 0.85000 144689.9n 0.85000 144690.0n 0.85000 144819.9n 0.85000 144820.0n 0.85000 144949.9n 0.85000 144950.0n 0.85000 145079.9n 0.85000 145080.0n 0.85000 145209.9n 0.85000 145210.0n 0.85000 145339.9n 0.85000 145340.0n 0.85000 145469.9n 0.85000 145470.0n 0.85000 145599.9n 0.85000 145600.0n 0.85000 145729.9n 0.85000 145730.0n 0.85000 145859.9n 0.85000 145860.0n 0.85000 145989.9n 0.85000 145990.0n 0.85000 146119.9n 0.85000 146120.0n 0.85000 146249.9n 0.85000 146250.0n 0.85000 146379.9n 0.85000 146380.0n 0.85000 146509.9n 0.85000 146510.0n 0.85000 146639.9n 0.85000 146640.0n 0.85000 146769.9n 0.85000 146770.0n 0.85000 146899.9n 0.85000 146900.0n 0.85000 147029.9n 0.85000 147030.0n 0.85000 147159.9n 0.85000 147160.0n 0.85000 147289.9n 0.85000 147290.0n 0.85000 147419.9n 0.85000 147420.0n 0.85000 147549.9n 0.85000 147550.0n 0.85000 147679.9n 0.85000 147680.0n 0.85000 147809.9n 0.85000 147810.0n 0.85000 147939.9n 0.85000 147940.0n 0.85000 148069.9n 0.85000 148070.0n 0.85000 148199.9n 0.85000 148200.0n 0.85000 148329.9n 0.85000 148330.0n 0.85000 148459.9n 0.85000 148460.0n 0.85000 148589.9n 0.85000 148590.0n 0.85000 148719.9n 0.85000 148720.0n 0.85000 148849.9n 0.85000 148850.0n 0.85000 148979.9n 0.85000 148980.0n 0.85000 149109.9n 0.85000 149110.0n 0.85000 149239.9n 0.85000 149240.0n 0.85000 149369.9n 0.85000 149370.0n 0.85000 149499.9n 0.85000 149500.0n 0.85000 149629.9n 0.85000 149630.0n 0.85000 149759.9n 0.85000 149760.0n 0.85000 149889.9n 0.85000 149890.0n 0.85000 150019.9n 0.85000 150020.0n 0.85000 150149.9n 0.85000 150150.0n 0.85000 150279.9n 0.85000 150280.0n 0.85000 150409.9n 0.85000 150410.0n 0.85000 150539.9n 0.85000 150540.0n 0.85000 150669.9n 0.85000 150670.0n 0.85000 150799.9n 0.85000 150800.0n 0.85000 150929.9n 0.85000 150930.0n 0.85000 151059.9n 0.85000 151060.0n 0.85000 151189.9n 0.85000 151190.0n 0.85000 151319.9n 0.85000 151320.0n 0.85000 151449.9n 0.85000 151450.0n 0.85000 151579.9n 0.85000 151580.0n 0.85000 151709.9n 0.85000 151710.0n 0.85000 151839.9n 0.85000 151840.0n 0.85000 151969.9n 0.85000 151970.0n 0.85000 152099.9n 0.85000 152100.0n 0.85000 152229.9n 0.85000 152230.0n 0.85000 152359.9n 0.85000 152360.0n 0.85000 152489.9n 0.85000 152490.0n 0.85000 152619.9n 0.85000 152620.0n 0.85000 152749.9n 0.85000 152750.0n 0.85000 152879.9n 0.85000 152880.0n 0.85000 153009.9n 0.85000 153010.0n 0.85000 153139.9n 0.85000 153140.0n 0.85000 153269.9n 0.85000 153270.0n 0.85000 153399.9n 0.85000 153400.0n 0.85000 153529.9n 0.85000 153530.0n 0.85000 153659.9n 0.85000 153660.0n 0.85000 153789.9n 0.85000 153790.0n 0.85000 153919.9n 0.85000 153920.0n 0.85000 154049.9n 0.85000 154050.0n 0.85000 154179.9n 0.85000 154180.0n 0.85000 154309.9n 0.85000 154310.0n 0.85000 154439.9n 0.85000 154440.0n 0.85000 154569.9n 0.85000 154570.0n 0.85000 154699.9n 0.85000 154700.0n 0.85000 154829.9n 0.85000 154830.0n 0.85000 154959.9n 0.85000 154960.0n 0.85000 155089.9n 0.85000 155090.0n 0.85000 155219.9n 0.85000 155220.0n 0.85000 155349.9n 0.85000 155350.0n 0.85000 155479.9n 0.85000 155480.0n 0.85000 155609.9n 0.85000 155610.0n 0.85000 155739.9n 0.85000 155740.0n 0.85000 155869.9n 0.85000 155870.0n 0.85000 155999.9n 0.85000 156000.0n 0.85000 156129.9n 0.85000 156130.0n 0.85000 156259.9n 0.85000 156260.0n 0.85000 156389.9n 0.85000 156390.0n 0.85000 156519.9n 0.85000 156520.0n 0.85000 156649.9n 0.85000 156650.0n 0.85000 156779.9n 0.85000 156780.0n 0.85000 156909.9n 0.85000 156910.0n 0.85000 157039.9n 0.85000 157040.0n 0.85000 157169.9n 0.85000 157170.0n 0.85000 157299.9n 0.85000 157300.0n 0.85000 157429.9n 0.85000 157430.0n 0.85000 157559.9n 0.85000 157560.0n 0.85000 157689.9n 0.85000 157690.0n 0.85000 157819.9n 0.85000 157820.0n 0.85000 157949.9n 0.85000 157950.0n 0.85000 158079.9n 0.85000 158080.0n 0.85000 158209.9n 0.85000 158210.0n 0.85000 158339.9n 0.85000 158340.0n 0.85000 158469.9n 0.85000 158470.0n 0.85000 158599.9n 0.85000 158600.0n 0.85000 158729.9n 0.85000 158730.0n 0.85000 158859.9n 0.85000 158860.0n 0.85000 158989.9n 0.85000 158990.0n 0.85000 159119.9n 0.85000 159120.0n 0.85000 159249.9n 0.85000 159250.0n 0.85000 159379.9n 0.85000 159380.0n 0.85000 159509.9n 0.85000 159510.0n 0.85000 159639.9n 0.85000 159640.0n 0.85000 159769.9n 0.85000 159770.0n 0.85000 159899.9n 0.85000 159900.0n 0.85000 160029.9n 0.85000 160030.0n 0.85000 160159.9n 0.85000 160160.0n 0.85000 160289.9n 0.85000 160290.0n 0.85000 160419.9n 0.85000 160420.0n 0.85000 160549.9n 0.85000 160550.0n 0.85000 160679.9n 0.85000 160680.0n 0.85000 160809.9n 0.85000 160810.0n 0.85000 160939.9n 0.85000 160940.0n 0.85000 161069.9n 0.85000 161070.0n 0.85000 161199.9n 0.85000 161200.0n 0.85000 161329.9n 0.85000 161330.0n 0.85000 161459.9n 0.85000 161460.0n 0.85000 161589.9n 0.85000 161590.0n 0.85000 161719.9n 0.85000 161720.0n 0.85000 161849.9n 0.85000 161850.0n 0.85000 161979.9n 0.85000 161980.0n 0.85000 162109.9n 0.85000 162110.0n 0.85000 162239.9n 0.85000 162240.0n 0.00000 162369.9n 0.00000 162370.0n 0.00000 162499.9n 0.00000 162500.0n 0.00000 162629.9n 0.00000 162630.0n 0.00000 162759.9n 0.00000 162760.0n 0.00000 162889.9n 0.00000 162890.0n 0.00000 163019.9n 0.00000 163020.0n 0.00000 163149.9n 0.00000 163150.0n 0.00000 163279.9n 0.00000 163280.0n 0.00000 163409.9n 0.00000 163410.0n 0.00000 163539.9n 0.00000 163540.0n 0.00000 163669.9n 0.00000 163670.0n 0.00000 163799.9n 0.00000 163800.0n 0.00000 163929.9n 0.00000 163930.0n 0.00000 164059.9n 0.00000 164060.0n 0.00000 164189.9n 0.00000 164190.0n 0.00000 164319.9n 0.00000 164320.0n 0.00000 164449.9n 0.00000 164450.0n 0.00000 164579.9n 0.00000 164580.0n 0.00000 164709.9n 0.00000 164710.0n 0.00000 164839.9n 0.00000 164840.0n 0.00000 164969.9n 0.00000 164970.0n 0.00000 165099.9n 0.00000 165100.0n 0.00000 165229.9n 0.00000 165230.0n 0.00000 165359.9n 0.00000 165360.0n 0.00000 165489.9n 0.00000 165490.0n 0.00000 165619.9n 0.00000 165620.0n 0.00000 165749.9n 0.00000 165750.0n 0.00000 165879.9n 0.00000 165880.0n 0.00000 166009.9n 0.00000 166010.0n 0.00000 166139.9n 0.00000 166140.0n 0.00000 166269.9n 0.00000 166270.0n 0.00000 166399.9n 0.00000 166400.0n 0.00000 166529.9n 0.00000 166530.0n 0.00000 166659.9n 0.00000 166660.0n 0.00000 166789.9n 0.00000 166790.0n 0.00000 166919.9n 0.00000 166920.0n 0.00000 167049.9n 0.00000 167050.0n 0.00000 167179.9n 0.00000 167180.0n 0.00000 167309.9n 0.00000 167310.0n 0.00000 167439.9n 0.00000 167440.0n 0.00000 167569.9n 0.00000 167570.0n 0.00000 167699.9n 0.00000 167700.0n 0.00000 167829.9n 0.00000 167830.0n 0.00000 167959.9n 0.00000 167960.0n 0.00000 168089.9n 0.00000 168090.0n 0.00000 168219.9n 0.00000 168220.0n 0.00000 168349.9n 0.00000 168350.0n 0.00000)
Vxp0 a_xp0 0 PWL(0.0n 0.20119 129.9n 0.20119 130.0n 0.69969 259.9n 0.69969 260.0n 0.55066 389.9n 0.55066 390.0n 0.10559 519.9n 0.10559 520.0n 0.26419 649.9n 0.26419 650.0n 0.73600 779.9n 0.73600 780.0n 0.70685 909.9n 0.70685 910.0n 0.31139 1039.9n 0.31139 1040.0n 0.21498 1169.9n 0.21498 1170.0n 0.96459 1299.9n 0.96459 1300.0n 0.43581 1429.9n 0.43581 1430.0n 1.36668 1559.9n 1.36668 1560.0n 0.53141 1689.9n 0.53141 1690.0n 0.17082 1819.9n 0.17082 1820.0n 0.55006 1949.9n 0.55006 1950.0n 0.47556 2079.9n 0.47556 2080.0n -0.31038 2209.9n -0.31038 2210.0n 0.35630 2339.9n 0.35630 2340.0n 0.56449 2469.9n 0.56449 2470.0n -0.14927 2599.9n -0.14927 2600.0n 0.27076 2729.9n 0.27076 2730.0n -0.04662 2859.9n -0.04662 2860.0n 0.69502 2989.9n 0.69502 2990.0n 0.24079 3119.9n 0.24079 3120.0n 0.52079 3249.9n 0.52079 3250.0n 0.88832 3379.9n 0.88832 3380.0n 0.27643 3509.9n 0.27643 3510.0n 1.07007 3639.9n 1.07007 3640.0n -0.31038 3769.9n -0.31038 3770.0n 0.55066 3899.9n 0.55066 3900.0n -0.04662 4029.9n -0.04662 4030.0n 0.27076 4159.9n 0.27076 4160.0n 0.69969 4289.9n 0.69969 4290.0n 0.55006 4419.9n 0.55006 4420.0n 0.20119 4549.9n 0.20119 4550.0n -0.14927 4679.9n -0.14927 4680.0n 0.52079 4809.9n 0.52079 4810.0n 0.17082 4939.9n 0.17082 4940.0n 0.10559 5069.9n 0.10559 5070.0n 0.35630 5199.9n 0.35630 5200.0n 0.56449 5329.9n 0.56449 5330.0n 0.73600 5459.9n 0.73600 5460.0n 1.36668 5589.9n 1.36668 5590.0n 0.53141 5719.9n 0.53141 5720.0n 0.69502 5849.9n 0.69502 5850.0n 1.07007 5979.9n 1.07007 5980.0n 0.96459 6109.9n 0.96459 6110.0n 0.21498 6239.9n 0.21498 6240.0n 0.26419 6369.9n 0.26419 6370.0n 0.24079 6499.9n 0.24079 6500.0n 0.47556 6629.9n 0.47556 6630.0n 0.43581 6759.9n 0.43581 6760.0n 0.88832 6889.9n 0.88832 6890.0n 0.70685 7019.9n 0.70685 7020.0n 0.27643 7149.9n 0.27643 7150.0n 0.31139 7279.9n 0.31139 7280.0n 0.10559 7409.9n 0.10559 7410.0n -0.04662 7539.9n -0.04662 7540.0n 0.53141 7669.9n 0.53141 7670.0n 0.31139 7799.9n 0.31139 7800.0n 0.88832 7929.9n 0.88832 7930.0n 0.96459 8059.9n 0.96459 8060.0n -0.31038 8189.9n -0.31038 8190.0n 1.07007 8319.9n 1.07007 8320.0n 0.17082 8449.9n 0.17082 8450.0n -0.14927 8579.9n -0.14927 8580.0n 0.69502 8709.9n 0.69502 8710.0n 0.70685 8839.9n 0.70685 8840.0n 0.55006 8969.9n 0.55006 8970.0n 0.27643 9099.9n 0.27643 9100.0n 0.35630 9229.9n 0.35630 9230.0n 1.36668 9359.9n 1.36668 9360.0n 0.27076 9489.9n 0.27076 9490.0n 0.47556 9619.9n 0.47556 9620.0n 0.24079 9749.9n 0.24079 9750.0n 0.21498 9879.9n 0.21498 9880.0n 0.20119 10009.9n 0.20119 10010.0n 0.43581 10139.9n 0.43581 10140.0n 0.69969 10269.9n 0.69969 10270.0n 0.73600 10399.9n 0.73600 10400.0n 0.55066 10529.9n 0.55066 10530.0n 0.56449 10659.9n 0.56449 10660.0n 0.26419 10789.9n 0.26419 10790.0n 0.52079 10919.9n 0.52079 10920.0n 0.70685 11049.9n 0.70685 11050.0n 1.07007 11179.9n 1.07007 11180.0n 0.10559 11309.9n 0.10559 11310.0n 0.17082 11439.9n 0.17082 11440.0n 0.52079 11569.9n 0.52079 11570.0n 0.20119 11699.9n 0.20119 11700.0n 0.69502 11829.9n 0.69502 11830.0n 0.27643 11959.9n 0.27643 11960.0n 0.55066 12089.9n 0.55066 12090.0n 0.27076 12219.9n 0.27076 12220.0n 0.24079 12349.9n 0.24079 12350.0n 0.21498 12479.9n 0.21498 12480.0n 0.88832 12609.9n 0.88832 12610.0n 0.55006 12739.9n 0.55006 12740.0n 0.73600 12869.9n 0.73600 12870.0n 0.35630 12999.9n 0.35630 13000.0n -0.31038 13129.9n -0.31038 13130.0n 0.96459 13259.9n 0.96459 13260.0n 0.53141 13389.9n 0.53141 13390.0n 0.43581 13519.9n 0.43581 13520.0n 1.36668 13649.9n 1.36668 13650.0n 0.31139 13779.9n 0.31139 13780.0n -0.14927 13909.9n -0.14927 13910.0n -0.04662 14039.9n -0.04662 14040.0n 0.56449 14169.9n 0.56449 14170.0n 0.69969 14299.9n 0.69969 14300.0n 0.26419 14429.9n 0.26419 14430.0n 0.47556 14559.9n 0.47556 14560.0n -0.31038 14689.9n -0.31038 14690.0n 0.43581 14819.9n 0.43581 14820.0n 0.88832 14949.9n 0.88832 14950.0n 0.73600 15079.9n 0.73600 15080.0n 0.47556 15209.9n 0.47556 15210.0n 0.27643 15339.9n 0.27643 15340.0n 0.53141 15469.9n 0.53141 15470.0n 0.69969 15599.9n 0.69969 15600.0n 0.27076 15729.9n 0.27076 15730.0n 0.56449 15859.9n 0.56449 15860.0n -0.04662 15989.9n -0.04662 15990.0n 0.20119 16119.9n 0.20119 16120.0n 1.07007 16249.9n 1.07007 16250.0n 0.10559 16379.9n 0.10559 16380.0n 0.31139 16509.9n 0.31139 16510.0n 0.52079 16639.9n 0.52079 16640.0n 0.55006 16769.9n 0.55006 16770.0n 0.26419 16899.9n 0.26419 16900.0n 1.36668 17029.9n 1.36668 17030.0n 0.69502 17159.9n 0.69502 17160.0n 0.24079 17289.9n 0.24079 17290.0n 0.35630 17419.9n 0.35630 17420.0n 0.17082 17549.9n 0.17082 17550.0n -0.14927 17679.9n -0.14927 17680.0n 0.55066 17809.9n 0.55066 17810.0n 0.70685 17939.9n 0.70685 17940.0n 0.96459 18069.9n 0.96459 18070.0n 0.21498 18199.9n 0.21498 18200.0n 0.20119 18329.9n 0.20119 18330.0n 0.10559 18459.9n 0.10559 18460.0n 0.73600 18589.9n 0.73600 18590.0n 0.24079 18719.9n 0.24079 18720.0n 0.70685 18849.9n 0.70685 18850.0n 0.55006 18979.9n 0.55006 18980.0n 0.53141 19109.9n 0.53141 19110.0n 0.88832 19239.9n 0.88832 19240.0n -0.14927 19369.9n -0.14927 19370.0n 0.69502 19499.9n 0.69502 19500.0n 0.56449 19629.9n 0.56449 19630.0n 1.07007 19759.9n 1.07007 19760.0n 0.47556 19889.9n 0.47556 19890.0n 0.43581 20019.9n 0.43581 20020.0n 0.26419 20149.9n 0.26419 20150.0n 0.69969 20279.9n 0.69969 20280.0n 0.17082 20409.9n 0.17082 20410.0n 0.27643 20539.9n 0.27643 20540.0n 0.31139 20669.9n 0.31139 20670.0n 0.96459 20799.9n 0.96459 20800.0n -0.31038 20929.9n -0.31038 20930.0n 0.27076 21059.9n 0.27076 21060.0n 0.52079 21189.9n 0.52079 21190.0n -0.04662 21319.9n -0.04662 21320.0n 0.55066 21449.9n 0.55066 21450.0n 0.35630 21579.9n 0.35630 21580.0n 1.36668 21709.9n 1.36668 21710.0n 0.21498 21839.9n 0.21498 21840.0n 0.48508 21969.9n 0.48508 21970.0n 0.86030 22099.9n 0.86030 22100.0n 0.57742 22229.9n 0.57742 22230.0n 0.79287 22359.9n 0.79287 22360.0n 0.60090 22489.9n 0.60090 22490.0n 0.23371 22619.9n 0.23371 22620.0n 0.12484 22749.9n 0.12484 22750.0n 0.48351 22879.9n 0.48351 22880.0n 0.52272 23009.9n 0.52272 23010.0n 0.10421 23139.9n 0.10421 23140.0n 0.26187 23269.9n 0.26187 23270.0n 0.26993 23399.9n 0.26993 23400.0n 0.61195 23529.9n 0.61195 23530.0n 0.55435 23659.9n 0.55435 23660.0n 0.15028 23789.9n 0.15028 23790.0n 0.68626 23919.9n 0.68626 23920.0n 0.46500 24049.9n 0.46500 24050.0n 0.34619 24179.9n 0.34619 24180.0n 0.41172 24309.9n 0.41172 24310.0n 0.70707 24439.9n 0.70707 24440.0n 0.65136 24569.9n 0.65136 24570.0n 0.60081 24699.9n 0.60081 24700.0n 0.71496 24829.9n 0.71496 24830.0n 0.09082 24959.9n 0.09082 24960.0n 1.38855 25089.9n 1.38855 25090.0n 1.21890 25219.9n 1.21890 25220.0n 1.28851 25349.9n 1.28851 25350.0n 1.24585 25479.9n 1.24585 25480.0n -0.15208 25609.9n -0.15208 25610.0n 0.58159 25739.9n 0.58159 25740.0n 0.75662 25869.9n 0.75662 25870.0n -0.49277 25999.9n -0.49277 26000.0n -0.19260 26129.9n -0.19260 26130.0n 1.27962 26259.9n 1.27962 26260.0n 0.44267 26389.9n 0.44267 26390.0n 0.04400 26519.9n 0.04400 26520.0n 1.04710 26649.9n 1.04710 26650.0n 0.19758 26779.9n 0.19758 26780.0n 0.60264 26909.9n 0.60264 26910.0n -0.04029 27039.9n -0.04029 27040.0n 0.36851 27169.9n 0.36851 27170.0n 0.18248 27299.9n 0.18248 27300.0n -0.19808 27429.9n -0.19808 27430.0n -0.39872 27559.9n -0.39872 27560.0n 0.71881 27689.9n 0.71881 27690.0n -0.46004 27819.9n -0.46004 27820.0n 1.19303 27949.9n 1.19303 27950.0n 0.06458 28079.9n 0.06458 28080.0n 0.55006 28209.9n 0.55006 28210.0n 0.24079 28339.9n 0.24079 28340.0n 0.26419 28469.9n 0.26419 28470.0n 0.27076 28599.9n 0.27076 28600.0n 0.53141 28729.9n 0.53141 28730.0n 0.69969 28859.9n 0.69969 28860.0n 0.27643 28989.9n 0.27643 28990.0n 0.21498 29119.9n 0.21498 29120.0n 0.17082 29249.9n 0.17082 29250.0n 0.69502 29379.9n 0.69502 29380.0n 0.43581 29509.9n 0.43581 29510.0n 0.10559 29639.9n 0.10559 29640.0n 0.31139 29769.9n 0.31139 29770.0n 0.88832 29899.9n 0.88832 29900.0n 0.20119 30029.9n 0.20119 30030.0n 0.96459 30159.9n 0.96459 30160.0n -0.31038 30289.9n -0.31038 30290.0n 0.47556 30419.9n 0.47556 30420.0n 1.36668 30549.9n 1.36668 30550.0n 1.07007 30679.9n 1.07007 30680.0n -0.04662 30809.9n -0.04662 30810.0n -0.14927 30939.9n -0.14927 30940.0n 0.55066 31069.9n 0.55066 31070.0n 0.70685 31199.9n 0.70685 31200.0n 0.56449 31329.9n 0.56449 31330.0n 0.52079 31459.9n 0.52079 31460.0n 0.35630 31589.9n 0.35630 31590.0n 0.73600 31719.9n 0.73600 31720.0n 0.27643 31849.9n 0.27643 31850.0n 0.17082 31979.9n 0.17082 31980.0n 1.36668 32109.9n 1.36668 32110.0n 0.26419 32239.9n 0.26419 32240.0n 0.52079 32369.9n 0.52079 32370.0n 0.55006 32499.9n 0.55006 32500.0n 0.21498 32629.9n 0.21498 32630.0n 0.56449 32759.9n 0.56449 32760.0n 0.55066 32889.9n 0.55066 32890.0n 0.20119 33019.9n 0.20119 33020.0n 0.24079 33149.9n 0.24079 33150.0n -0.14927 33279.9n -0.14927 33280.0n 0.88832 33409.9n 0.88832 33410.0n 0.31139 33539.9n 0.31139 33540.0n 0.35630 33669.9n 0.35630 33670.0n -0.31038 33799.9n -0.31038 33800.0n 0.73600 33929.9n 0.73600 33930.0n 1.07007 34059.9n 1.07007 34060.0n 0.27076 34189.9n 0.27076 34190.0n 0.96459 34319.9n 0.96459 34320.0n 0.53141 34449.9n 0.53141 34450.0n 0.43581 34579.9n 0.43581 34580.0n 0.10559 34709.9n 0.10559 34710.0n -0.04662 34839.9n -0.04662 34840.0n 0.69502 34969.9n 0.69502 34970.0n 0.69969 35099.9n 0.69969 35100.0n 0.70685 35229.9n 0.70685 35230.0n 0.47556 35359.9n 0.47556 35360.0n 0.21498 35489.9n 0.21498 35490.0n -0.31038 35619.9n -0.31038 35620.0n 0.53141 35749.9n 0.53141 35750.0n 0.56449 35879.9n 0.56449 35880.0n -0.14927 36009.9n -0.14927 36010.0n -0.04662 36139.9n -0.04662 36140.0n 0.55066 36269.9n 0.55066 36270.0n 0.52079 36399.9n 0.52079 36400.0n 0.24079 36529.9n 0.24079 36530.0n 0.35630 36659.9n 0.35630 36660.0n 0.27643 36789.9n 0.27643 36790.0n 0.27076 36919.9n 0.27076 36920.0n 0.47556 37049.9n 0.47556 37050.0n 0.31139 37179.9n 0.31139 37180.0n 0.69969 37309.9n 0.69969 37310.0n 0.10559 37439.9n 0.10559 37440.0n 1.36668 37569.9n 1.36668 37570.0n 0.88832 37699.9n 0.88832 37700.0n 0.73600 37829.9n 0.73600 37830.0n 0.70685 37959.9n 0.70685 37960.0n 0.55006 38089.9n 0.55006 38090.0n 0.69502 38219.9n 0.69502 38220.0n 1.07007 38349.9n 1.07007 38350.0n 0.96459 38479.9n 0.96459 38480.0n 0.43581 38609.9n 0.43581 38610.0n 0.17082 38739.9n 0.17082 38740.0n 0.26419 38869.9n 0.26419 38870.0n 0.20119 38999.9n 0.20119 39000.0n 0.96459 39129.9n 0.96459 39130.0n 1.07007 39259.9n 1.07007 39260.0n 0.53141 39389.9n 0.53141 39390.0n 0.27643 39519.9n 0.27643 39520.0n 0.55066 39649.9n 0.55066 39650.0n 0.26419 39779.9n 0.26419 39780.0n 0.56449 39909.9n 0.56449 39910.0n 0.73600 40039.9n 0.73600 40040.0n 0.55006 40169.9n 0.55006 40170.0n 0.31139 40299.9n 0.31139 40300.0n 0.70685 40429.9n 0.70685 40430.0n -0.31038 40559.9n -0.31038 40560.0n 0.69969 40689.9n 0.69969 40690.0n 0.35630 40819.9n 0.35630 40820.0n 1.36668 40949.9n 1.36668 40950.0n 0.69502 41079.9n 0.69502 41080.0n 0.88832 41209.9n 0.88832 41210.0n -0.04662 41339.9n -0.04662 41340.0n 0.20119 41469.9n 0.20119 41470.0n 0.21498 41599.9n 0.21498 41600.0n 0.43581 41729.9n 0.43581 41730.0n -0.14927 41859.9n -0.14927 41860.0n 0.52079 41989.9n 0.52079 41990.0n 0.17082 42119.9n 0.17082 42120.0n 0.27076 42249.9n 0.27076 42250.0n 0.47556 42379.9n 0.47556 42380.0n 0.24079 42509.9n 0.24079 42510.0n 0.10559 42639.9n 0.10559 42640.0n 0.27076 42769.9n 0.27076 42770.0n 0.31139 42899.9n 0.31139 42900.0n 0.52079 43029.9n 0.52079 43030.0n 0.35630 43159.9n 0.35630 43160.0n 0.56449 43289.9n 0.56449 43290.0n 0.20119 43419.9n 0.20119 43420.0n 0.70685 43549.9n 0.70685 43550.0n 0.27643 43679.9n 0.27643 43680.0n 0.10559 43809.9n 0.10559 43810.0n 0.43581 43939.9n 0.43581 43940.0n 0.24079 44069.9n 0.24079 44070.0n 0.69969 44199.9n 0.69969 44200.0n 0.55066 44329.9n 0.55066 44330.0n 1.07007 44459.9n 1.07007 44460.0n -0.31038 44589.9n -0.31038 44590.0n 0.53141 44719.9n 0.53141 44720.0n 0.55006 44849.9n 0.55006 44850.0n 0.21498 44979.9n 0.21498 44980.0n -0.04662 45109.9n -0.04662 45110.0n 0.26419 45239.9n 0.26419 45240.0n 0.88832 45369.9n 0.88832 45370.0n 0.96459 45499.9n 0.96459 45500.0n 0.17082 45629.9n 0.17082 45630.0n 0.69502 45759.9n 0.69502 45760.0n -0.14927 45889.9n -0.14927 45890.0n 1.36668 46019.9n 1.36668 46020.0n 0.73600 46149.9n 0.73600 46150.0n 0.47556 46279.9n 0.47556 46280.0n 0.69969 46409.9n 0.69969 46410.0n 0.56449 46539.9n 0.56449 46540.0n 0.52079 46669.9n 0.52079 46670.0n 0.69502 46799.9n 0.69502 46800.0n 0.24079 46929.9n 0.24079 46930.0n 0.17082 47059.9n 0.17082 47060.0n 0.10559 47189.9n 0.10559 47190.0n 0.27076 47319.9n 0.27076 47320.0n 0.88832 47449.9n 0.88832 47450.0n 0.27643 47579.9n 0.27643 47580.0n 0.53141 47709.9n 0.53141 47710.0n 0.70685 47839.9n 0.70685 47840.0n 0.31139 47969.9n 0.31139 47970.0n 0.20119 48099.9n 0.20119 48100.0n 1.36668 48229.9n 1.36668 48230.0n 0.21498 48359.9n 0.21498 48360.0n 0.55006 48489.9n 0.55006 48490.0n 0.96459 48619.9n 0.96459 48620.0n 0.55066 48749.9n 0.55066 48750.0n 0.26419 48879.9n 0.26419 48880.0n -0.31038 49009.9n -0.31038 49010.0n 0.73600 49139.9n 0.73600 49140.0n 0.47556 49269.9n 0.47556 49270.0n -0.04662 49399.9n -0.04662 49400.0n 0.43581 49529.9n 0.43581 49530.0n 0.35630 49659.9n 0.35630 49660.0n 1.07007 49789.9n 1.07007 49790.0n -0.14927 49919.9n -0.14927 49920.0n 0.48508 50049.9n 0.48508 50050.0n 0.86030 50179.9n 0.86030 50180.0n 0.57742 50309.9n 0.57742 50310.0n 0.79287 50439.9n 0.79287 50440.0n 0.60090 50569.9n 0.60090 50570.0n 0.23371 50699.9n 0.23371 50700.0n 0.12484 50829.9n 0.12484 50830.0n 0.48351 50959.9n 0.48351 50960.0n 0.52272 51089.9n 0.52272 51090.0n 0.10421 51219.9n 0.10421 51220.0n 0.26187 51349.9n 0.26187 51350.0n 0.26993 51479.9n 0.26993 51480.0n 0.61195 51609.9n 0.61195 51610.0n 0.55435 51739.9n 0.55435 51740.0n 0.15028 51869.9n 0.15028 51870.0n 0.68626 51999.9n 0.68626 52000.0n 0.46500 52129.9n 0.46500 52130.0n 0.34619 52259.9n 0.34619 52260.0n 0.41172 52389.9n 0.41172 52390.0n 0.70707 52519.9n 0.70707 52520.0n 0.65136 52649.9n 0.65136 52650.0n 0.60081 52779.9n 0.60081 52780.0n 0.71496 52909.9n 0.71496 52910.0n 0.09082 53039.9n 0.09082 53040.0n 1.38855 53169.9n 1.38855 53170.0n 1.21890 53299.9n 1.21890 53300.0n 1.28851 53429.9n 1.28851 53430.0n 1.24585 53559.9n 1.24585 53560.0n -0.15208 53689.9n -0.15208 53690.0n 0.58159 53819.9n 0.58159 53820.0n 0.75662 53949.9n 0.75662 53950.0n -0.49277 54079.9n -0.49277 54080.0n -0.19260 54209.9n -0.19260 54210.0n 1.27962 54339.9n 1.27962 54340.0n 0.44267 54469.9n 0.44267 54470.0n 0.04400 54599.9n 0.04400 54600.0n 1.04710 54729.9n 1.04710 54730.0n 0.19758 54859.9n 0.19758 54860.0n 0.60264 54989.9n 0.60264 54990.0n -0.04029 55119.9n -0.04029 55120.0n 0.36851 55249.9n 0.36851 55250.0n 0.18248 55379.9n 0.18248 55380.0n -0.19808 55509.9n -0.19808 55510.0n -0.39872 55639.9n -0.39872 55640.0n 0.71881 55769.9n 0.71881 55770.0n -0.46004 55899.9n -0.46004 55900.0n 1.19303 56029.9n 1.19303 56030.0n 0.06458 56159.9n 0.06458 56160.0n 0.21498 56289.9n 0.21498 56290.0n 0.10559 56419.9n 0.10559 56420.0n 0.27643 56549.9n 0.27643 56550.0n -0.31038 56679.9n -0.31038 56680.0n 0.24079 56809.9n 0.24079 56810.0n 1.36668 56939.9n 1.36668 56940.0n 0.47556 57069.9n 0.47556 57070.0n 0.88832 57199.9n 0.88832 57200.0n 0.27076 57329.9n 0.27076 57330.0n 0.55006 57459.9n 0.55006 57460.0n 0.55066 57589.9n 0.55066 57590.0n 0.31139 57719.9n 0.31139 57720.0n 0.52079 57849.9n 0.52079 57850.0n 0.69502 57979.9n 0.69502 57980.0n 0.56449 58109.9n 0.56449 58110.0n 0.35630 58239.9n 0.35630 58240.0n 0.53141 58369.9n 0.53141 58370.0n 1.07007 58499.9n 1.07007 58500.0n 0.26419 58629.9n 0.26419 58630.0n -0.04662 58759.9n -0.04662 58760.0n -0.14927 58889.9n -0.14927 58890.0n 0.43581 59019.9n 0.43581 59020.0n 0.20119 59149.9n 0.20119 59150.0n 0.70685 59279.9n 0.70685 59280.0n 0.73600 59409.9n 0.73600 59410.0n 0.96459 59539.9n 0.96459 59540.0n 0.17082 59669.9n 0.17082 59670.0n 0.69969 59799.9n 0.69969 59800.0n 0.73600 59929.9n 0.73600 59930.0n 0.56449 60059.9n 0.56449 60060.0n -0.04662 60189.9n -0.04662 60190.0n 0.21498 60319.9n 0.21498 60320.0n 0.52079 60449.9n 0.52079 60450.0n -0.31038 60579.9n -0.31038 60580.0n 0.26419 60709.9n 0.26419 60710.0n 0.31139 60839.9n 0.31139 60840.0n 0.47556 60969.9n 0.47556 60970.0n 0.27643 61099.9n 0.27643 61100.0n 0.35630 61229.9n 0.35630 61230.0n 0.69969 61359.9n 0.69969 61360.0n 0.55006 61489.9n 0.55006 61490.0n 0.27076 61619.9n 0.27076 61620.0n 0.88832 61749.9n 0.88832 61750.0n 0.24079 61879.9n 0.24079 61880.0n 0.17082 62009.9n 0.17082 62010.0n 1.07007 62139.9n 1.07007 62140.0n 0.43581 62269.9n 0.43581 62270.0n 1.36668 62399.9n 1.36668 62400.0n 0.70685 62529.9n 0.70685 62530.0n 0.69502 62659.9n 0.69502 62660.0n 0.20119 62789.9n 0.20119 62790.0n 0.53141 62919.9n 0.53141 62920.0n 0.10559 63049.9n 0.10559 63050.0n 0.96459 63179.9n 0.96459 63180.0n -0.14927 63309.9n -0.14927 63310.0n 0.55066 63439.9n 0.55066 63440.0n 1.36668 63569.9n 1.36668 63570.0n 0.21498 63699.9n 0.21498 63700.0n 0.20119 63829.9n 0.20119 63830.0n -0.31038 63959.9n -0.31038 63960.0n 0.88832 64089.9n 0.88832 64090.0n 0.73600 64219.9n 0.73600 64220.0n -0.04662 64349.9n -0.04662 64350.0n 0.10559 64479.9n 0.10559 64480.0n 0.24079 64609.9n 0.24079 64610.0n 0.27076 64739.9n 0.27076 64740.0n 0.47556 64869.9n 0.47556 64870.0n 0.56449 64999.9n 0.56449 65000.0n 0.69969 65129.9n 0.69969 65130.0n 0.26419 65259.9n 0.26419 65260.0n -0.14927 65389.9n -0.14927 65390.0n 1.07007 65519.9n 1.07007 65520.0n 0.69502 65649.9n 0.69502 65650.0n 0.55006 65779.9n 0.55006 65780.0n 0.52079 65909.9n 0.52079 65910.0n 0.96459 66039.9n 0.96459 66040.0n 0.70685 66169.9n 0.70685 66170.0n 0.43581 66299.9n 0.43581 66300.0n 0.17082 66429.9n 0.17082 66430.0n 0.31139 66559.9n 0.31139 66560.0n 0.27643 66689.9n 0.27643 66690.0n 0.55066 66819.9n 0.55066 66820.0n 0.53141 66949.9n 0.53141 66950.0n 0.35630 67079.9n 0.35630 67080.0n -0.04662 67209.9n -0.04662 67210.0n 0.55006 67339.9n 0.55006 67340.0n -0.14927 67469.9n -0.14927 67470.0n 0.69969 67599.9n 0.69969 67600.0n 0.69502 67729.9n 0.69502 67730.0n 0.53141 67859.9n 0.53141 67860.0n 0.70685 67989.9n 0.70685 67990.0n 0.43581 68119.9n 0.43581 68120.0n 0.17082 68249.9n 0.17082 68250.0n 0.27076 68379.9n 0.27076 68380.0n 0.88832 68509.9n 0.88832 68510.0n 0.55066 68639.9n 0.55066 68640.0n 0.35630 68769.9n 0.35630 68770.0n 1.36668 68899.9n 1.36668 68900.0n 0.26419 69029.9n 0.26419 69030.0n 0.31139 69159.9n 0.31139 69160.0n 0.10559 69289.9n 0.10559 69290.0n 0.20119 69419.9n 0.20119 69420.0n 0.27643 69549.9n 0.27643 69550.0n 0.21498 69679.9n 0.21498 69680.0n 0.73600 69809.9n 0.73600 69810.0n 0.47556 69939.9n 0.47556 69940.0n 0.56449 70069.9n 0.56449 70070.0n 1.07007 70199.9n 1.07007 70200.0n -0.31038 70329.9n -0.31038 70330.0n 0.96459 70459.9n 0.96459 70460.0n 0.52079 70589.9n 0.52079 70590.0n 0.24079 70719.9n 0.24079 70720.0n 0.53141 70849.9n 0.53141 70850.0n 0.69969 70979.9n 0.69969 70980.0n 0.55066 71109.9n 0.55066 71110.0n 0.70685 71239.9n 0.70685 71240.0n 0.24079 71369.9n 0.24079 71370.0n 0.35630 71499.9n 0.35630 71500.0n 0.43581 71629.9n 0.43581 71630.0n -0.04662 71759.9n -0.04662 71760.0n 0.47556 71889.9n 0.47556 71890.0n 0.96459 72019.9n 0.96459 72020.0n 1.07007 72149.9n 1.07007 72150.0n 0.20119 72279.9n 0.20119 72280.0n -0.31038 72409.9n -0.31038 72410.0n 0.52079 72539.9n 0.52079 72540.0n 0.26419 72669.9n 0.26419 72670.0n 0.55006 72799.9n 0.55006 72800.0n 1.36668 72929.9n 1.36668 72930.0n 0.73600 73059.9n 0.73600 73060.0n 0.21498 73189.9n 0.21498 73190.0n 0.56449 73319.9n 0.56449 73320.0n 0.10559 73449.9n 0.10559 73450.0n 0.27643 73579.9n 0.27643 73580.0n 0.17082 73709.9n 0.17082 73710.0n 0.88832 73839.9n 0.88832 73840.0n 0.69502 73969.9n 0.69502 73970.0n 0.27076 74099.9n 0.27076 74100.0n -0.14927 74229.9n -0.14927 74230.0n 0.31139 74359.9n 0.31139 74360.0n 0.70685 74489.9n 0.70685 74490.0n 0.69502 74619.9n 0.69502 74620.0n -0.04662 74749.9n -0.04662 74750.0n 0.96459 74879.9n 0.96459 74880.0n 1.07007 75009.9n 1.07007 75010.0n 0.35630 75139.9n 0.35630 75140.0n 0.69969 75269.9n 0.69969 75270.0n 0.27076 75399.9n 0.27076 75400.0n 0.20119 75529.9n 0.20119 75530.0n 0.53141 75659.9n 0.53141 75660.0n 0.88832 75789.9n 0.88832 75790.0n 0.52079 75919.9n 0.52079 75920.0n 0.27643 76049.9n 0.27643 76050.0n -0.31038 76179.9n -0.31038 76180.0n 0.31139 76309.9n 0.31139 76310.0n 0.10559 76439.9n 0.10559 76440.0n 0.47556 76569.9n 0.47556 76570.0n -0.14927 76699.9n -0.14927 76700.0n 0.26419 76829.9n 0.26419 76830.0n 0.55006 76959.9n 0.55006 76960.0n 0.73600 77089.9n 0.73600 77090.0n 0.55066 77219.9n 0.55066 77220.0n 0.43581 77349.9n 0.43581 77350.0n 0.56449 77479.9n 0.56449 77480.0n 0.24079 77609.9n 0.24079 77610.0n 1.36668 77739.9n 1.36668 77740.0n 0.21498 77869.9n 0.21498 77870.0n 0.17082 77999.9n 0.17082 78000.0n 0.48508 78129.9n 0.48508 78130.0n 0.86030 78259.9n 0.86030 78260.0n 0.57742 78389.9n 0.57742 78390.0n 0.79287 78519.9n 0.79287 78520.0n 0.60090 78649.9n 0.60090 78650.0n 0.23371 78779.9n 0.23371 78780.0n 0.12484 78909.9n 0.12484 78910.0n 0.48351 79039.9n 0.48351 79040.0n 0.52272 79169.9n 0.52272 79170.0n 0.10421 79299.9n 0.10421 79300.0n 0.26187 79429.9n 0.26187 79430.0n 0.26993 79559.9n 0.26993 79560.0n 0.61195 79689.9n 0.61195 79690.0n 0.55435 79819.9n 0.55435 79820.0n 0.15028 79949.9n 0.15028 79950.0n 0.68626 80079.9n 0.68626 80080.0n 0.46500 80209.9n 0.46500 80210.0n 0.34619 80339.9n 0.34619 80340.0n 0.41172 80469.9n 0.41172 80470.0n 0.70707 80599.9n 0.70707 80600.0n 0.65136 80729.9n 0.65136 80730.0n 0.60081 80859.9n 0.60081 80860.0n 0.71496 80989.9n 0.71496 80990.0n 0.09082 81119.9n 0.09082 81120.0n 1.38855 81249.9n 1.38855 81250.0n 1.21890 81379.9n 1.21890 81380.0n 1.28851 81509.9n 1.28851 81510.0n 1.24585 81639.9n 1.24585 81640.0n -0.15208 81769.9n -0.15208 81770.0n 0.58159 81899.9n 0.58159 81900.0n 0.75662 82029.9n 0.75662 82030.0n -0.49277 82159.9n -0.49277 82160.0n -0.19260 82289.9n -0.19260 82290.0n 1.27962 82419.9n 1.27962 82420.0n 0.44267 82549.9n 0.44267 82550.0n 0.04400 82679.9n 0.04400 82680.0n 1.04710 82809.9n 1.04710 82810.0n 0.19758 82939.9n 0.19758 82940.0n 0.60264 83069.9n 0.60264 83070.0n -0.04029 83199.9n -0.04029 83200.0n 0.36851 83329.9n 0.36851 83330.0n 0.18248 83459.9n 0.18248 83460.0n -0.19808 83589.9n -0.19808 83590.0n -0.39872 83719.9n -0.39872 83720.0n 0.71881 83849.9n 0.71881 83850.0n -0.46004 83979.9n -0.46004 83980.0n 1.19303 84109.9n 1.19303 84110.0n 0.06458 84239.9n 0.06458 84240.0n 0.10559 84369.9n 0.10559 84370.0n 0.17082 84499.9n 0.17082 84500.0n 0.69502 84629.9n 0.69502 84630.0n 0.31139 84759.9n 0.31139 84760.0n 0.55006 84889.9n 0.55006 84890.0n 0.52079 85019.9n 0.52079 85020.0n 0.69969 85149.9n 0.69969 85150.0n 0.88832 85279.9n 0.88832 85280.0n 0.96459 85409.9n 0.96459 85410.0n 0.35630 85539.9n 0.35630 85540.0n 0.53141 85669.9n 0.53141 85670.0n 1.07007 85799.9n 1.07007 85800.0n 0.27076 85929.9n 0.27076 85930.0n -0.14927 86059.9n -0.14927 86060.0n 0.20119 86189.9n 0.20119 86190.0n -0.04662 86319.9n -0.04662 86320.0n 0.70685 86449.9n 0.70685 86450.0n 0.47556 86579.9n 0.47556 86580.0n 0.21498 86709.9n 0.21498 86710.0n 0.43581 86839.9n 0.43581 86840.0n 0.73600 86969.9n 0.73600 86970.0n 0.27643 87099.9n 0.27643 87100.0n 0.56449 87229.9n 0.56449 87230.0n 0.55066 87359.9n 0.55066 87360.0n 1.36668 87489.9n 1.36668 87490.0n -0.31038 87619.9n -0.31038 87620.0n 0.26419 87749.9n 0.26419 87750.0n 0.24079 87879.9n 0.24079 87880.0n 1.07007 88009.9n 1.07007 88010.0n 0.55066 88139.9n 0.55066 88140.0n 0.47556 88269.9n 0.47556 88270.0n -0.04662 88399.9n -0.04662 88400.0n 0.52079 88529.9n 0.52079 88530.0n 0.10559 88659.9n 0.10559 88660.0n 0.27076 88789.9n 0.27076 88790.0n 0.73600 88919.9n 0.73600 88920.0n 0.21498 89049.9n 0.21498 89050.0n 0.56449 89179.9n 0.56449 89180.0n 0.96459 89309.9n 0.96459 89310.0n 0.69969 89439.9n 0.69969 89440.0n 1.36668 89569.9n 1.36668 89570.0n 0.53141 89699.9n 0.53141 89700.0n 0.26419 89829.9n 0.26419 89830.0n 0.88832 89959.9n 0.88832 89960.0n 0.55006 90089.9n 0.55006 90090.0n 0.24079 90219.9n 0.24079 90220.0n 0.70685 90349.9n 0.70685 90350.0n 0.35630 90479.9n 0.35630 90480.0n 0.69502 90609.9n 0.69502 90610.0n 0.43581 90739.9n 0.43581 90740.0n 0.20119 90869.9n 0.20119 90870.0n -0.31038 90999.9n -0.31038 91000.0n -0.14927 91129.9n -0.14927 91130.0n 0.17082 91259.9n 0.17082 91260.0n 0.27643 91389.9n 0.27643 91390.0n 0.31139 91519.9n 0.31139 91520.0n 0.53141 91649.9n 0.53141 91650.0n 0.73600 91779.9n 0.73600 91780.0n 0.31139 91909.9n 0.31139 91910.0n 0.24079 92039.9n 0.24079 92040.0n 0.88832 92169.9n 0.88832 92170.0n 0.56449 92299.9n 0.56449 92300.0n 0.27076 92429.9n 0.27076 92430.0n 0.10559 92559.9n 0.10559 92560.0n 0.27643 92689.9n 0.27643 92690.0n 0.20119 92819.9n 0.20119 92820.0n 0.70685 92949.9n 0.70685 92950.0n 0.55066 93079.9n 0.55066 93080.0n -0.04662 93209.9n -0.04662 93210.0n 1.36668 93339.9n 1.36668 93340.0n 0.55006 93469.9n 0.55006 93470.0n 0.47556 93599.9n 0.47556 93600.0n 1.07007 93729.9n 1.07007 93730.0n 0.26419 93859.9n 0.26419 93860.0n 0.21498 93989.9n 0.21498 93990.0n 0.69502 94119.9n 0.69502 94120.0n -0.14927 94249.9n -0.14927 94250.0n -0.31038 94379.9n -0.31038 94380.0n 0.96459 94509.9n 0.96459 94510.0n 0.52079 94639.9n 0.52079 94640.0n 0.17082 94769.9n 0.17082 94770.0n 0.35630 94899.9n 0.35630 94900.0n 0.43581 95029.9n 0.43581 95030.0n 0.69969 95159.9n 0.69969 95160.0n 0.26419 95289.9n 0.26419 95290.0n 0.73600 95419.9n 0.73600 95420.0n 0.31139 95549.9n 0.31139 95550.0n 0.27643 95679.9n 0.27643 95680.0n 0.55006 95809.9n 0.55006 95810.0n 1.36668 95939.9n 1.36668 95940.0n -0.04662 96069.9n -0.04662 96070.0n 0.47556 96199.9n 0.47556 96200.0n -0.14927 96329.9n -0.14927 96330.0n 0.27076 96459.9n 0.27076 96460.0n 0.43581 96589.9n 0.43581 96590.0n 0.88832 96719.9n 0.88832 96720.0n 1.07007 96849.9n 1.07007 96850.0n 0.20119 96979.9n 0.20119 96980.0n 0.69502 97109.9n 0.69502 97110.0n 0.21498 97239.9n 0.21498 97240.0n 0.55066 97369.9n 0.55066 97370.0n 0.10559 97499.9n 0.10559 97500.0n 0.52079 97629.9n 0.52079 97630.0n -0.31038 97759.9n -0.31038 97760.0n 0.56449 97889.9n 0.56449 97890.0n 0.17082 98019.9n 0.17082 98020.0n 0.24079 98149.9n 0.24079 98150.0n 0.70685 98279.9n 0.70685 98280.0n 0.35630 98409.9n 0.35630 98410.0n 0.69969 98539.9n 0.69969 98540.0n 0.96459 98669.9n 0.96459 98670.0n 0.53141 98799.9n 0.53141 98800.0n 1.07007 98929.9n 1.07007 98930.0n 0.24079 99059.9n 0.24079 99060.0n 0.52079 99189.9n 0.52079 99190.0n 0.96459 99319.9n 0.96459 99320.0n 0.56449 99449.9n 0.56449 99450.0n -0.31038 99579.9n -0.31038 99580.0n -0.14927 99709.9n -0.14927 99710.0n 0.17082 99839.9n 0.17082 99840.0n 0.21498 99969.9n 0.21498 99970.0n 0.31139 100099.9n 0.31139 100100.0n 0.55006 100229.9n 0.55006 100230.0n 0.43581 100359.9n 0.43581 100360.0n 0.20119 100489.9n 0.20119 100490.0n 0.27643 100619.9n 0.27643 100620.0n 0.73600 100749.9n 0.73600 100750.0n 0.53141 100879.9n 0.53141 100880.0n 0.69502 101009.9n 0.69502 101010.0n -0.04662 101139.9n -0.04662 101140.0n 0.27076 101269.9n 0.27076 101270.0n 1.36668 101399.9n 1.36668 101400.0n 0.47556 101529.9n 0.47556 101530.0n 0.26419 101659.9n 0.26419 101660.0n 0.55066 101789.9n 0.55066 101790.0n 0.69969 101919.9n 0.69969 101920.0n 0.35630 102049.9n 0.35630 102050.0n 0.10559 102179.9n 0.10559 102180.0n 0.70685 102309.9n 0.70685 102310.0n 0.88832 102439.9n 0.88832 102440.0n 0.20119 102569.9n 0.20119 102570.0n 0.43581 102699.9n 0.43581 102700.0n 0.96459 102829.9n 0.96459 102830.0n 0.53141 102959.9n 0.53141 102960.0n 0.88832 103089.9n 0.88832 103090.0n 0.70685 103219.9n 0.70685 103220.0n 0.55006 103349.9n 0.55006 103350.0n 0.10559 103479.9n 0.10559 103480.0n 1.36668 103609.9n 1.36668 103610.0n 1.07007 103739.9n 1.07007 103740.0n 0.35630 103869.9n 0.35630 103870.0n 0.24079 103999.9n 0.24079 104000.0n 0.55066 104129.9n 0.55066 104130.0n -0.14927 104259.9n -0.14927 104260.0n 0.21498 104389.9n 0.21498 104390.0n 0.17082 104519.9n 0.17082 104520.0n 0.31139 104649.9n 0.31139 104650.0n 0.27643 104779.9n 0.27643 104780.0n 0.56449 104909.9n 0.56449 104910.0n 0.27076 105039.9n 0.27076 105040.0n 0.47556 105169.9n 0.47556 105170.0n -0.31038 105299.9n -0.31038 105300.0n -0.04662 105429.9n -0.04662 105430.0n 0.26419 105559.9n 0.26419 105560.0n 0.52079 105689.9n 0.52079 105690.0n 0.73600 105819.9n 0.73600 105820.0n 0.69502 105949.9n 0.69502 105950.0n 0.69969 106079.9n 0.69969 106080.0n 0.48508 106209.9n 0.48508 106210.0n 0.86030 106339.9n 0.86030 106340.0n 0.57742 106469.9n 0.57742 106470.0n 0.79287 106599.9n 0.79287 106600.0n 0.60090 106729.9n 0.60090 106730.0n 0.23371 106859.9n 0.23371 106860.0n 0.12484 106989.9n 0.12484 106990.0n 0.48351 107119.9n 0.48351 107120.0n 0.52272 107249.9n 0.52272 107250.0n 0.10421 107379.9n 0.10421 107380.0n 0.26187 107509.9n 0.26187 107510.0n 0.26993 107639.9n 0.26993 107640.0n 0.61195 107769.9n 0.61195 107770.0n 0.55435 107899.9n 0.55435 107900.0n 0.15028 108029.9n 0.15028 108030.0n 0.68626 108159.9n 0.68626 108160.0n 0.46500 108289.9n 0.46500 108290.0n 0.34619 108419.9n 0.34619 108420.0n 0.41172 108549.9n 0.41172 108550.0n 0.70707 108679.9n 0.70707 108680.0n 0.65136 108809.9n 0.65136 108810.0n 0.60081 108939.9n 0.60081 108940.0n 0.71496 109069.9n 0.71496 109070.0n 0.09082 109199.9n 0.09082 109200.0n 1.38855 109329.9n 1.38855 109330.0n 1.21890 109459.9n 1.21890 109460.0n 1.28851 109589.9n 1.28851 109590.0n 1.24585 109719.9n 1.24585 109720.0n -0.15208 109849.9n -0.15208 109850.0n 0.58159 109979.9n 0.58159 109980.0n 0.75662 110109.9n 0.75662 110110.0n -0.49277 110239.9n -0.49277 110240.0n -0.19260 110369.9n -0.19260 110370.0n 1.27962 110499.9n 1.27962 110500.0n 0.44267 110629.9n 0.44267 110630.0n 0.04400 110759.9n 0.04400 110760.0n 1.04710 110889.9n 1.04710 110890.0n 0.19758 111019.9n 0.19758 111020.0n 0.60264 111149.9n 0.60264 111150.0n -0.04029 111279.9n -0.04029 111280.0n 0.36851 111409.9n 0.36851 111410.0n 0.18248 111539.9n 0.18248 111540.0n -0.19808 111669.9n -0.19808 111670.0n -0.39872 111799.9n -0.39872 111800.0n 0.71881 111929.9n 0.71881 111930.0n -0.46004 112059.9n -0.46004 112060.0n 1.19303 112189.9n 1.19303 112190.0n 0.06458 112319.9n 0.06458 112320.0n -0.31038 112449.9n -0.31038 112450.0n 0.21498 112579.9n 0.21498 112580.0n -0.14927 112709.9n -0.14927 112710.0n 0.24079 112839.9n 0.24079 112840.0n 0.17082 112969.9n 0.17082 112970.0n 0.31139 113099.9n 0.31139 113100.0n 0.20119 113229.9n 0.20119 113230.0n 1.36668 113359.9n 1.36668 113360.0n 0.55006 113489.9n 0.55006 113490.0n 0.55066 113619.9n 0.55066 113620.0n 0.73600 113749.9n 0.73600 113750.0n 0.69969 113879.9n 0.69969 113880.0n -0.04662 114009.9n -0.04662 114010.0n 0.69502 114139.9n 0.69502 114140.0n 0.56449 114269.9n 0.56449 114270.0n 1.07007 114399.9n 1.07007 114400.0n 0.35630 114529.9n 0.35630 114530.0n 0.70685 114659.9n 0.70685 114660.0n 0.43581 114789.9n 0.43581 114790.0n 0.26419 114919.9n 0.26419 114920.0n 0.27076 115049.9n 0.27076 115050.0n 0.27643 115179.9n 0.27643 115180.0n 0.88832 115309.9n 0.88832 115310.0n 0.10559 115439.9n 0.10559 115440.0n 0.47556 115569.9n 0.47556 115570.0n 0.53141 115699.9n 0.53141 115700.0n 0.96459 115829.9n 0.96459 115830.0n 0.52079 115959.9n 0.52079 115960.0n -0.31038 116089.9n -0.31038 116090.0n 0.56449 116219.9n 0.56449 116220.0n 0.88832 116349.9n 0.88832 116350.0n 0.69969 116479.9n 0.69969 116480.0n -0.14927 116609.9n -0.14927 116610.0n 0.52079 116739.9n 0.52079 116740.0n 0.27643 116869.9n 0.27643 116870.0n 0.43581 116999.9n 0.43581 117000.0n -0.04662 117129.9n -0.04662 117130.0n 0.55006 117259.9n 0.55006 117260.0n 0.96459 117389.9n 0.96459 117390.0n 0.10559 117519.9n 0.10559 117520.0n 0.26419 117649.9n 0.26419 117650.0n 0.55066 117779.9n 0.55066 117780.0n 0.27076 117909.9n 0.27076 117910.0n 1.07007 118039.9n 1.07007 118040.0n 0.31139 118169.9n 0.31139 118170.0n 0.70685 118299.9n 0.70685 118300.0n 0.35630 118429.9n 0.35630 118430.0n 0.21498 118559.9n 0.21498 118560.0n 0.73600 118689.9n 0.73600 118690.0n 0.17082 118819.9n 0.17082 118820.0n 0.69502 118949.9n 0.69502 118950.0n 0.20119 119079.9n 0.20119 119080.0n 1.36668 119209.9n 1.36668 119210.0n 0.24079 119339.9n 0.24079 119340.0n 0.47556 119469.9n 0.47556 119470.0n 0.53141 119599.9n 0.53141 119600.0n 0.73600 119729.9n 0.73600 119730.0n 0.96459 119859.9n 0.96459 119860.0n 0.27076 119989.9n 0.27076 119990.0n 0.53141 120119.9n 0.53141 120120.0n 0.55066 120249.9n 0.55066 120250.0n 0.17082 120379.9n 0.17082 120380.0n 1.36668 120509.9n 1.36668 120510.0n 0.27643 120639.9n 0.27643 120640.0n 0.20119 120769.9n 0.20119 120770.0n 0.55006 120899.9n 0.55006 120900.0n 0.31139 121029.9n 0.31139 121030.0n 1.07007 121159.9n 1.07007 121160.0n 0.35630 121289.9n 0.35630 121290.0n 0.70685 121419.9n 0.70685 121420.0n 0.10559 121549.9n 0.10559 121550.0n 0.26419 121679.9n 0.26419 121680.0n 0.56449 121809.9n 0.56449 121810.0n -0.04662 121939.9n -0.04662 121940.0n -0.31038 122069.9n -0.31038 122070.0n 0.47556 122199.9n 0.47556 122200.0n 0.52079 122329.9n 0.52079 122330.0n 0.24079 122459.9n 0.24079 122460.0n 0.43581 122589.9n 0.43581 122590.0n 0.69969 122719.9n 0.69969 122720.0n 0.88832 122849.9n 0.88832 122850.0n 0.21498 122979.9n 0.21498 122980.0n -0.14927 123109.9n -0.14927 123110.0n 0.69502 123239.9n 0.69502 123240.0n -0.14927 123369.9n -0.14927 123370.0n 0.55066 123499.9n 0.55066 123500.0n 0.27643 123629.9n 0.27643 123630.0n 0.52079 123759.9n 0.52079 123760.0n -0.04662 123889.9n -0.04662 123890.0n 0.17082 124019.9n 0.17082 124020.0n 0.26419 124149.9n 0.26419 124150.0n 0.10559 124279.9n 0.10559 124280.0n 0.73600 124409.9n 0.73600 124410.0n 0.70685 124539.9n 0.70685 124540.0n 0.20119 124669.9n 0.20119 124670.0n 0.27076 124799.9n 0.27076 124800.0n 0.21498 124929.9n 0.21498 124930.0n 0.69969 125059.9n 0.69969 125060.0n 0.88832 125189.9n 0.88832 125190.0n 0.47556 125319.9n 0.47556 125320.0n -0.31038 125449.9n -0.31038 125450.0n 0.69502 125579.9n 0.69502 125580.0n 0.35630 125709.9n 0.35630 125710.0n 0.24079 125839.9n 0.24079 125840.0n 0.31139 125969.9n 0.31139 125970.0n 0.96459 126099.9n 0.96459 126100.0n 1.36668 126229.9n 1.36668 126230.0n 0.43581 126359.9n 0.43581 126360.0n 1.07007 126489.9n 1.07007 126490.0n 0.53141 126619.9n 0.53141 126620.0n 0.56449 126749.9n 0.56449 126750.0n 0.55006 126879.9n 0.55006 126880.0n 0.47556 127009.9n 0.47556 127010.0n 0.88832 127139.9n 0.88832 127140.0n 0.10559 127269.9n 0.10559 127270.0n 0.24079 127399.9n 0.24079 127400.0n 0.17082 127529.9n 0.17082 127530.0n 0.69502 127659.9n 0.69502 127660.0n 1.07007 127789.9n 1.07007 127790.0n -0.31038 127919.9n -0.31038 127920.0n 0.73600 128049.9n 0.73600 128050.0n 0.56449 128179.9n 0.56449 128180.0n 1.36668 128309.9n 1.36668 128310.0n 0.55066 128439.9n 0.55066 128440.0n 0.52079 128569.9n 0.52079 128570.0n 0.21498 128699.9n 0.21498 128700.0n 0.53141 128829.9n 0.53141 128830.0n 0.96459 128959.9n 0.96459 128960.0n 0.35630 129089.9n 0.35630 129090.0n 0.27643 129219.9n 0.27643 129220.0n 0.31139 129349.9n 0.31139 129350.0n 0.26419 129479.9n 0.26419 129480.0n 0.27076 129609.9n 0.27076 129610.0n 0.55006 129739.9n 0.55006 129740.0n 0.20119 129869.9n 0.20119 129870.0n 0.70685 129999.9n 0.70685 130000.0n -0.04662 130129.9n -0.04662 130130.0n 0.69969 130259.9n 0.69969 130260.0n 0.43581 130389.9n 0.43581 130390.0n -0.14927 130519.9n -0.14927 130520.0n 0.69502 130649.9n 0.69502 130650.0n 0.24079 130779.9n 0.24079 130780.0n 0.31139 130909.9n 0.31139 130910.0n 0.27643 131039.9n 0.27643 131040.0n 0.21498 131169.9n 0.21498 131170.0n 0.20119 131299.9n 0.20119 131300.0n 0.69969 131429.9n 0.69969 131430.0n -0.04662 131559.9n -0.04662 131560.0n 0.17082 131689.9n 0.17082 131690.0n 0.55066 131819.9n 0.55066 131820.0n 0.55006 131949.9n 0.55006 131950.0n 0.47556 132079.9n 0.47556 132080.0n 0.35630 132209.9n 0.35630 132210.0n 0.27076 132339.9n 0.27076 132340.0n 1.07007 132469.9n 1.07007 132470.0n -0.31038 132599.9n -0.31038 132600.0n 0.43581 132729.9n 0.43581 132730.0n 0.52079 132859.9n 0.52079 132860.0n 1.36668 132989.9n 1.36668 132990.0n 0.88832 133119.9n 0.88832 133120.0n 0.53141 133249.9n 0.53141 133250.0n 0.26419 133379.9n 0.26419 133380.0n -0.14927 133509.9n -0.14927 133510.0n 0.10559 133639.9n 0.10559 133640.0n 0.56449 133769.9n 0.56449 133770.0n 0.96459 133899.9n 0.96459 133900.0n 0.73600 134029.9n 0.73600 134030.0n 0.70685 134159.9n 0.70685 134160.0n 0.48508 134289.9n 0.48508 134290.0n 0.86030 134419.9n 0.86030 134420.0n 0.57742 134549.9n 0.57742 134550.0n 0.79287 134679.9n 0.79287 134680.0n 0.60090 134809.9n 0.60090 134810.0n 0.23371 134939.9n 0.23371 134940.0n 0.12484 135069.9n 0.12484 135070.0n 0.48351 135199.9n 0.48351 135200.0n 0.52272 135329.9n 0.52272 135330.0n 0.10421 135459.9n 0.10421 135460.0n 0.26187 135589.9n 0.26187 135590.0n 0.26993 135719.9n 0.26993 135720.0n 0.61195 135849.9n 0.61195 135850.0n 0.55435 135979.9n 0.55435 135980.0n 0.15028 136109.9n 0.15028 136110.0n 0.68626 136239.9n 0.68626 136240.0n 0.46500 136369.9n 0.46500 136370.0n 0.34619 136499.9n 0.34619 136500.0n 0.41172 136629.9n 0.41172 136630.0n 0.70707 136759.9n 0.70707 136760.0n 0.65136 136889.9n 0.65136 136890.0n 0.60081 137019.9n 0.60081 137020.0n 0.71496 137149.9n 0.71496 137150.0n 0.09082 137279.9n 0.09082 137280.0n 1.38855 137409.9n 1.38855 137410.0n 1.21890 137539.9n 1.21890 137540.0n 1.28851 137669.9n 1.28851 137670.0n 1.24585 137799.9n 1.24585 137800.0n -0.15208 137929.9n -0.15208 137930.0n 0.58159 138059.9n 0.58159 138060.0n 0.75662 138189.9n 0.75662 138190.0n -0.49277 138319.9n -0.49277 138320.0n -0.19260 138449.9n -0.19260 138450.0n 1.27962 138579.9n 1.27962 138580.0n 0.44267 138709.9n 0.44267 138710.0n 0.04400 138839.9n 0.04400 138840.0n 1.04710 138969.9n 1.04710 138970.0n 0.19758 139099.9n 0.19758 139100.0n 0.60264 139229.9n 0.60264 139230.0n -0.04029 139359.9n -0.04029 139360.0n 0.36851 139489.9n 0.36851 139490.0n 0.18248 139619.9n 0.18248 139620.0n -0.19808 139749.9n -0.19808 139750.0n -0.39872 139879.9n -0.39872 139880.0n 0.71881 140009.9n 0.71881 140010.0n -0.46004 140139.9n -0.46004 140140.0n 1.19303 140269.9n 1.19303 140270.0n 0.06458 140399.9n 0.06458 140400.0n 0.52079 140529.9n 0.52079 140530.0n 0.88832 140659.9n 0.88832 140660.0n 0.35630 140789.9n 0.35630 140790.0n 0.69502 140919.9n 0.69502 140920.0n 0.27643 141049.9n 0.27643 141050.0n 0.17082 141179.9n 0.17082 141180.0n -0.14927 141309.9n -0.14927 141310.0n 0.56449 141439.9n 0.56449 141440.0n 0.43581 141569.9n 0.43581 141570.0n 0.21498 141699.9n 0.21498 141700.0n 0.31139 141829.9n 0.31139 141830.0n 0.27076 141959.9n 0.27076 141960.0n -0.31038 142089.9n -0.31038 142090.0n -0.04662 142219.9n -0.04662 142220.0n 0.10559 142349.9n 0.10559 142350.0n 0.53141 142479.9n 0.53141 142480.0n 1.36668 142609.9n 1.36668 142610.0n 0.73600 142739.9n 0.73600 142740.0n 0.55006 142869.9n 0.55006 142870.0n 0.96459 142999.9n 0.96459 143000.0n 0.55066 143129.9n 0.55066 143130.0n 0.70685 143259.9n 0.70685 143260.0n 0.26419 143389.9n 0.26419 143390.0n 0.47556 143519.9n 0.47556 143520.0n 0.69969 143649.9n 0.69969 143650.0n 1.07007 143779.9n 1.07007 143780.0n 0.24079 143909.9n 0.24079 143910.0n 0.20119 144039.9n 0.20119 144040.0n 0.47556 144169.9n 0.47556 144170.0n 0.69969 144299.9n 0.69969 144300.0n 0.27076 144429.9n 0.27076 144430.0n 0.55006 144559.9n 0.55006 144560.0n 0.35630 144689.9n 0.35630 144690.0n 0.27643 144819.9n 0.27643 144820.0n 1.07007 144949.9n 1.07007 144950.0n 0.73600 145079.9n 0.73600 145080.0n 0.88832 145209.9n 0.88832 145210.0n 0.55066 145339.9n 0.55066 145340.0n 0.20119 145469.9n 0.20119 145470.0n 0.69502 145599.9n 0.69502 145600.0n 0.96459 145729.9n 0.96459 145730.0n 0.17082 145859.9n 0.17082 145860.0n 1.36668 145989.9n 1.36668 145990.0n 0.26419 146119.9n 0.26419 146120.0n 0.31139 146249.9n 0.31139 146250.0n 0.52079 146379.9n 0.52079 146380.0n 0.53141 146509.9n 0.53141 146510.0n 0.21498 146639.9n 0.21498 146640.0n 0.10559 146769.9n 0.10559 146770.0n 0.24079 146899.9n 0.24079 146900.0n -0.04662 147029.9n -0.04662 147030.0n -0.14927 147159.9n -0.14927 147160.0n -0.31038 147289.9n -0.31038 147290.0n 0.70685 147419.9n 0.70685 147420.0n 0.43581 147549.9n 0.43581 147550.0n 0.56449 147679.9n 0.56449 147680.0n 0.73600 147809.9n 0.73600 147810.0n 0.55066 147939.9n 0.55066 147940.0n 0.69969 148069.9n 0.69969 148070.0n 1.07007 148199.9n 1.07007 148200.0n 0.70685 148329.9n 0.70685 148330.0n 0.55006 148459.9n 0.55006 148460.0n -0.31038 148589.9n -0.31038 148590.0n -0.04662 148719.9n -0.04662 148720.0n 0.24079 148849.9n 0.24079 148850.0n 0.47556 148979.9n 0.47556 148980.0n 0.26419 149109.9n 0.26419 149110.0n 0.35630 149239.9n 0.35630 149240.0n 0.53141 149369.9n 0.53141 149370.0n 0.56449 149499.9n 0.56449 149500.0n 0.21498 149629.9n 0.21498 149630.0n 0.69502 149759.9n 0.69502 149760.0n 0.27076 149889.9n 0.27076 149890.0n 0.10559 150019.9n 0.10559 150020.0n 1.36668 150149.9n 1.36668 150150.0n 0.27643 150279.9n 0.27643 150280.0n -0.14927 150409.9n -0.14927 150410.0n 0.52079 150539.9n 0.52079 150540.0n 0.20119 150669.9n 0.20119 150670.0n 0.43581 150799.9n 0.43581 150800.0n 0.17082 150929.9n 0.17082 150930.0n 0.96459 151059.9n 0.96459 151060.0n 0.88832 151189.9n 0.88832 151190.0n 0.31139 151319.9n 0.31139 151320.0n 0.47556 151449.9n 0.47556 151450.0n 0.31139 151579.9n 0.31139 151580.0n 0.35630 151709.9n 0.35630 151710.0n 0.21498 151839.9n 0.21498 151840.0n 0.53141 151969.9n 0.53141 151970.0n 0.43581 152099.9n 0.43581 152100.0n 0.10559 152229.9n 0.10559 152230.0n 0.52079 152359.9n 0.52079 152360.0n -0.14927 152489.9n -0.14927 152490.0n 0.69969 152619.9n 0.69969 152620.0n 1.36668 152749.9n 1.36668 152750.0n 0.88832 152879.9n 0.88832 152880.0n -0.04662 153009.9n -0.04662 153010.0n 0.70685 153139.9n 0.70685 153140.0n -0.31038 153269.9n -0.31038 153270.0n 0.17082 153399.9n 0.17082 153400.0n 0.96459 153529.9n 0.96459 153530.0n 0.56449 153659.9n 0.56449 153660.0n 1.07007 153789.9n 1.07007 153790.0n 0.26419 153919.9n 0.26419 153920.0n 0.24079 154049.9n 0.24079 154050.0n 0.55006 154179.9n 0.55006 154180.0n 0.55066 154309.9n 0.55066 154310.0n 0.27643 154439.9n 0.27643 154440.0n 0.69502 154569.9n 0.69502 154570.0n 0.73600 154699.9n 0.73600 154700.0n 0.27076 154829.9n 0.27076 154830.0n 0.20119 154959.9n 0.20119 154960.0n 0.21498 155089.9n 0.21498 155090.0n 0.55066 155219.9n 0.55066 155220.0n -0.14927 155349.9n -0.14927 155350.0n 0.10559 155479.9n 0.10559 155480.0n 0.27076 155609.9n 0.27076 155610.0n 0.27643 155739.9n 0.27643 155740.0n 0.55006 155869.9n 0.55006 155870.0n 0.31139 155999.9n 0.31139 156000.0n 0.20119 156129.9n 0.20119 156130.0n 0.96459 156259.9n 0.96459 156260.0n 0.35630 156389.9n 0.35630 156390.0n 0.17082 156519.9n 0.17082 156520.0n 0.70685 156649.9n 0.70685 156650.0n 0.24079 156779.9n 0.24079 156780.0n 0.69502 156909.9n 0.69502 156910.0n 0.69969 157039.9n 0.69969 157040.0n 1.07007 157169.9n 1.07007 157170.0n -0.31038 157299.9n -0.31038 157300.0n -0.04662 157429.9n -0.04662 157430.0n 0.88832 157559.9n 0.88832 157560.0n 0.73600 157689.9n 0.73600 157690.0n 0.53141 157819.9n 0.53141 157820.0n 0.43581 157949.9n 0.43581 157950.0n 0.52079 158079.9n 0.52079 158080.0n 0.47556 158209.9n 0.47556 158210.0n 0.56449 158339.9n 0.56449 158340.0n 0.26419 158469.9n 0.26419 158470.0n 1.36668 158599.9n 1.36668 158600.0n 0.73600 158729.9n 0.73600 158730.0n 0.17082 158859.9n 0.17082 158860.0n 1.36668 158989.9n 1.36668 158990.0n 0.43581 159119.9n 0.43581 159120.0n 0.88832 159249.9n 0.88832 159250.0n 0.20119 159379.9n 0.20119 159380.0n 0.24079 159509.9n 0.24079 159510.0n 0.26419 159639.9n 0.26419 159640.0n 0.10559 159769.9n 0.10559 159770.0n -0.31038 159899.9n -0.31038 159900.0n 0.31139 160029.9n 0.31139 160030.0n 0.27076 160159.9n 0.27076 160160.0n 0.27643 160289.9n 0.27643 160290.0n 0.35630 160419.9n 0.35630 160420.0n 0.52079 160549.9n 0.52079 160550.0n 0.55066 160679.9n 0.55066 160680.0n 0.56449 160809.9n 0.56449 160810.0n 1.07007 160939.9n 1.07007 160940.0n 0.69502 161069.9n 0.69502 161070.0n 0.53141 161199.9n 0.53141 161200.0n 0.96459 161329.9n 0.96459 161330.0n -0.14927 161459.9n -0.14927 161460.0n 0.55006 161589.9n 0.55006 161590.0n 0.69969 161719.9n 0.69969 161720.0n 0.21498 161849.9n 0.21498 161850.0n 0.47556 161979.9n 0.47556 161980.0n 0.70685 162109.9n 0.70685 162110.0n -0.04662 162239.9n -0.04662 162240.0n 0.48508 162369.9n 0.48508 162370.0n 0.86030 162499.9n 0.86030 162500.0n 0.57742 162629.9n 0.57742 162630.0n 0.79287 162759.9n 0.79287 162760.0n 0.60090 162889.9n 0.60090 162890.0n 0.23371 163019.9n 0.23371 163020.0n 0.12484 163149.9n 0.12484 163150.0n 0.48351 163279.9n 0.48351 163280.0n 0.52272 163409.9n 0.52272 163410.0n 0.10421 163539.9n 0.10421 163540.0n 0.26187 163669.9n 0.26187 163670.0n 0.26993 163799.9n 0.26993 163800.0n 0.61195 163929.9n 0.61195 163930.0n 0.55435 164059.9n 0.55435 164060.0n 0.15028 164189.9n 0.15028 164190.0n 0.68626 164319.9n 0.68626 164320.0n 0.46500 164449.9n 0.46500 164450.0n 0.34619 164579.9n 0.34619 164580.0n 0.41172 164709.9n 0.41172 164710.0n 0.70707 164839.9n 0.70707 164840.0n 0.65136 164969.9n 0.65136 164970.0n 0.60081 165099.9n 0.60081 165100.0n 0.71496 165229.9n 0.71496 165230.0n 0.09082 165359.9n 0.09082 165360.0n 1.38855 165489.9n 1.38855 165490.0n 1.21890 165619.9n 1.21890 165620.0n 1.28851 165749.9n 1.28851 165750.0n 1.24585 165879.9n 1.24585 165880.0n -0.15208 166009.9n -0.15208 166010.0n 0.58159 166139.9n 0.58159 166140.0n 0.75662 166269.9n 0.75662 166270.0n -0.49277 166399.9n -0.49277 166400.0n -0.19260 166529.9n -0.19260 166530.0n 1.27962 166659.9n 1.27962 166660.0n 0.44267 166789.9n 0.44267 166790.0n 0.04400 166919.9n 0.04400 166920.0n 1.04710 167049.9n 1.04710 167050.0n 0.19758 167179.9n 0.19758 167180.0n 0.60264 167309.9n 0.60264 167310.0n -0.04029 167439.9n -0.04029 167440.0n 0.36851 167569.9n 0.36851 167570.0n 0.18248 167699.9n 0.18248 167700.0n -0.19808 167829.9n -0.19808 167830.0n -0.39872 167959.9n -0.39872 167960.0n 0.71881 168089.9n 0.71881 168090.0n -0.46004 168219.9n -0.46004 168220.0n 1.19303 168349.9n 1.19303 168350.0n 0.06458)
Vxn0 a_xn0 0 PWL(0.0n 0.79881 129.9n 0.79881 130.0n 0.30031 259.9n 0.30031 260.0n 0.44934 389.9n 0.44934 390.0n 0.89441 519.9n 0.89441 520.0n 0.73581 649.9n 0.73581 650.0n 0.26400 779.9n 0.26400 780.0n 0.29315 909.9n 0.29315 910.0n 0.68861 1039.9n 0.68861 1040.0n 0.78502 1169.9n 0.78502 1170.0n 0.03541 1299.9n 0.03541 1300.0n 0.56419 1429.9n 0.56419 1430.0n -0.36668 1559.9n -0.36668 1560.0n 0.46859 1689.9n 0.46859 1690.0n 0.82918 1819.9n 0.82918 1820.0n 0.44994 1949.9n 0.44994 1950.0n 0.52444 2079.9n 0.52444 2080.0n 1.31038 2209.9n 1.31038 2210.0n 0.64370 2339.9n 0.64370 2340.0n 0.43551 2469.9n 0.43551 2470.0n 1.14927 2599.9n 1.14927 2600.0n 0.72924 2729.9n 0.72924 2730.0n 1.04662 2859.9n 1.04662 2860.0n 0.30498 2989.9n 0.30498 2990.0n 0.75921 3119.9n 0.75921 3120.0n 0.47921 3249.9n 0.47921 3250.0n 0.11168 3379.9n 0.11168 3380.0n 0.72357 3509.9n 0.72357 3510.0n -0.07007 3639.9n -0.07007 3640.0n 1.31038 3769.9n 1.31038 3770.0n 0.44934 3899.9n 0.44934 3900.0n 1.04662 4029.9n 1.04662 4030.0n 0.72924 4159.9n 0.72924 4160.0n 0.30031 4289.9n 0.30031 4290.0n 0.44994 4419.9n 0.44994 4420.0n 0.79881 4549.9n 0.79881 4550.0n 1.14927 4679.9n 1.14927 4680.0n 0.47921 4809.9n 0.47921 4810.0n 0.82918 4939.9n 0.82918 4940.0n 0.89441 5069.9n 0.89441 5070.0n 0.64370 5199.9n 0.64370 5200.0n 0.43551 5329.9n 0.43551 5330.0n 0.26400 5459.9n 0.26400 5460.0n -0.36668 5589.9n -0.36668 5590.0n 0.46859 5719.9n 0.46859 5720.0n 0.30498 5849.9n 0.30498 5850.0n -0.07007 5979.9n -0.07007 5980.0n 0.03541 6109.9n 0.03541 6110.0n 0.78502 6239.9n 0.78502 6240.0n 0.73581 6369.9n 0.73581 6370.0n 0.75921 6499.9n 0.75921 6500.0n 0.52444 6629.9n 0.52444 6630.0n 0.56419 6759.9n 0.56419 6760.0n 0.11168 6889.9n 0.11168 6890.0n 0.29315 7019.9n 0.29315 7020.0n 0.72357 7149.9n 0.72357 7150.0n 0.68861 7279.9n 0.68861 7280.0n 0.89441 7409.9n 0.89441 7410.0n 1.04662 7539.9n 1.04662 7540.0n 0.46859 7669.9n 0.46859 7670.0n 0.68861 7799.9n 0.68861 7800.0n 0.11168 7929.9n 0.11168 7930.0n 0.03541 8059.9n 0.03541 8060.0n 1.31038 8189.9n 1.31038 8190.0n -0.07007 8319.9n -0.07007 8320.0n 0.82918 8449.9n 0.82918 8450.0n 1.14927 8579.9n 1.14927 8580.0n 0.30498 8709.9n 0.30498 8710.0n 0.29315 8839.9n 0.29315 8840.0n 0.44994 8969.9n 0.44994 8970.0n 0.72357 9099.9n 0.72357 9100.0n 0.64370 9229.9n 0.64370 9230.0n -0.36668 9359.9n -0.36668 9360.0n 0.72924 9489.9n 0.72924 9490.0n 0.52444 9619.9n 0.52444 9620.0n 0.75921 9749.9n 0.75921 9750.0n 0.78502 9879.9n 0.78502 9880.0n 0.79881 10009.9n 0.79881 10010.0n 0.56419 10139.9n 0.56419 10140.0n 0.30031 10269.9n 0.30031 10270.0n 0.26400 10399.9n 0.26400 10400.0n 0.44934 10529.9n 0.44934 10530.0n 0.43551 10659.9n 0.43551 10660.0n 0.73581 10789.9n 0.73581 10790.0n 0.47921 10919.9n 0.47921 10920.0n 0.29315 11049.9n 0.29315 11050.0n -0.07007 11179.9n -0.07007 11180.0n 0.89441 11309.9n 0.89441 11310.0n 0.82918 11439.9n 0.82918 11440.0n 0.47921 11569.9n 0.47921 11570.0n 0.79881 11699.9n 0.79881 11700.0n 0.30498 11829.9n 0.30498 11830.0n 0.72357 11959.9n 0.72357 11960.0n 0.44934 12089.9n 0.44934 12090.0n 0.72924 12219.9n 0.72924 12220.0n 0.75921 12349.9n 0.75921 12350.0n 0.78502 12479.9n 0.78502 12480.0n 0.11168 12609.9n 0.11168 12610.0n 0.44994 12739.9n 0.44994 12740.0n 0.26400 12869.9n 0.26400 12870.0n 0.64370 12999.9n 0.64370 13000.0n 1.31038 13129.9n 1.31038 13130.0n 0.03541 13259.9n 0.03541 13260.0n 0.46859 13389.9n 0.46859 13390.0n 0.56419 13519.9n 0.56419 13520.0n -0.36668 13649.9n -0.36668 13650.0n 0.68861 13779.9n 0.68861 13780.0n 1.14927 13909.9n 1.14927 13910.0n 1.04662 14039.9n 1.04662 14040.0n 0.43551 14169.9n 0.43551 14170.0n 0.30031 14299.9n 0.30031 14300.0n 0.73581 14429.9n 0.73581 14430.0n 0.52444 14559.9n 0.52444 14560.0n 1.31038 14689.9n 1.31038 14690.0n 0.56419 14819.9n 0.56419 14820.0n 0.11168 14949.9n 0.11168 14950.0n 0.26400 15079.9n 0.26400 15080.0n 0.52444 15209.9n 0.52444 15210.0n 0.72357 15339.9n 0.72357 15340.0n 0.46859 15469.9n 0.46859 15470.0n 0.30031 15599.9n 0.30031 15600.0n 0.72924 15729.9n 0.72924 15730.0n 0.43551 15859.9n 0.43551 15860.0n 1.04662 15989.9n 1.04662 15990.0n 0.79881 16119.9n 0.79881 16120.0n -0.07007 16249.9n -0.07007 16250.0n 0.89441 16379.9n 0.89441 16380.0n 0.68861 16509.9n 0.68861 16510.0n 0.47921 16639.9n 0.47921 16640.0n 0.44994 16769.9n 0.44994 16770.0n 0.73581 16899.9n 0.73581 16900.0n -0.36668 17029.9n -0.36668 17030.0n 0.30498 17159.9n 0.30498 17160.0n 0.75921 17289.9n 0.75921 17290.0n 0.64370 17419.9n 0.64370 17420.0n 0.82918 17549.9n 0.82918 17550.0n 1.14927 17679.9n 1.14927 17680.0n 0.44934 17809.9n 0.44934 17810.0n 0.29315 17939.9n 0.29315 17940.0n 0.03541 18069.9n 0.03541 18070.0n 0.78502 18199.9n 0.78502 18200.0n 0.79881 18329.9n 0.79881 18330.0n 0.89441 18459.9n 0.89441 18460.0n 0.26400 18589.9n 0.26400 18590.0n 0.75921 18719.9n 0.75921 18720.0n 0.29315 18849.9n 0.29315 18850.0n 0.44994 18979.9n 0.44994 18980.0n 0.46859 19109.9n 0.46859 19110.0n 0.11168 19239.9n 0.11168 19240.0n 1.14927 19369.9n 1.14927 19370.0n 0.30498 19499.9n 0.30498 19500.0n 0.43551 19629.9n 0.43551 19630.0n -0.07007 19759.9n -0.07007 19760.0n 0.52444 19889.9n 0.52444 19890.0n 0.56419 20019.9n 0.56419 20020.0n 0.73581 20149.9n 0.73581 20150.0n 0.30031 20279.9n 0.30031 20280.0n 0.82918 20409.9n 0.82918 20410.0n 0.72357 20539.9n 0.72357 20540.0n 0.68861 20669.9n 0.68861 20670.0n 0.03541 20799.9n 0.03541 20800.0n 1.31038 20929.9n 1.31038 20930.0n 0.72924 21059.9n 0.72924 21060.0n 0.47921 21189.9n 0.47921 21190.0n 1.04662 21319.9n 1.04662 21320.0n 0.44934 21449.9n 0.44934 21450.0n 0.64370 21579.9n 0.64370 21580.0n -0.36668 21709.9n -0.36668 21710.0n 0.78502 21839.9n 0.78502 21840.0n 0.51492 21969.9n 0.51492 21970.0n 0.13970 22099.9n 0.13970 22100.0n 0.42258 22229.9n 0.42258 22230.0n 0.20713 22359.9n 0.20713 22360.0n 0.39910 22489.9n 0.39910 22490.0n 0.76629 22619.9n 0.76629 22620.0n 0.87516 22749.9n 0.87516 22750.0n 0.51649 22879.9n 0.51649 22880.0n 0.47728 23009.9n 0.47728 23010.0n 0.89579 23139.9n 0.89579 23140.0n 0.73813 23269.9n 0.73813 23270.0n 0.73007 23399.9n 0.73007 23400.0n 0.38805 23529.9n 0.38805 23530.0n 0.44565 23659.9n 0.44565 23660.0n 0.84972 23789.9n 0.84972 23790.0n 0.31374 23919.9n 0.31374 23920.0n 0.53500 24049.9n 0.53500 24050.0n 0.65381 24179.9n 0.65381 24180.0n 0.58828 24309.9n 0.58828 24310.0n 0.29293 24439.9n 0.29293 24440.0n 0.34864 24569.9n 0.34864 24570.0n 0.39919 24699.9n 0.39919 24700.0n 0.28504 24829.9n 0.28504 24830.0n 0.90918 24959.9n 0.90918 24960.0n -0.38855 25089.9n -0.38855 25090.0n -0.21890 25219.9n -0.21890 25220.0n -0.28851 25349.9n -0.28851 25350.0n -0.24585 25479.9n -0.24585 25480.0n 1.15208 25609.9n 1.15208 25610.0n 0.41841 25739.9n 0.41841 25740.0n 0.24338 25869.9n 0.24338 25870.0n 1.49277 25999.9n 1.49277 26000.0n 1.19260 26129.9n 1.19260 26130.0n -0.27962 26259.9n -0.27962 26260.0n 0.55733 26389.9n 0.55733 26390.0n 0.95600 26519.9n 0.95600 26520.0n -0.04710 26649.9n -0.04710 26650.0n 0.80242 26779.9n 0.80242 26780.0n 0.39736 26909.9n 0.39736 26910.0n 1.04029 27039.9n 1.04029 27040.0n 0.63149 27169.9n 0.63149 27170.0n 0.81752 27299.9n 0.81752 27300.0n 1.19808 27429.9n 1.19808 27430.0n 1.39872 27559.9n 1.39872 27560.0n 0.28119 27689.9n 0.28119 27690.0n 1.46004 27819.9n 1.46004 27820.0n -0.19303 27949.9n -0.19303 27950.0n 0.93542 28079.9n 0.93542 28080.0n 0.44994 28209.9n 0.44994 28210.0n 0.75921 28339.9n 0.75921 28340.0n 0.73581 28469.9n 0.73581 28470.0n 0.72924 28599.9n 0.72924 28600.0n 0.46859 28729.9n 0.46859 28730.0n 0.30031 28859.9n 0.30031 28860.0n 0.72357 28989.9n 0.72357 28990.0n 0.78502 29119.9n 0.78502 29120.0n 0.82918 29249.9n 0.82918 29250.0n 0.30498 29379.9n 0.30498 29380.0n 0.56419 29509.9n 0.56419 29510.0n 0.89441 29639.9n 0.89441 29640.0n 0.68861 29769.9n 0.68861 29770.0n 0.11168 29899.9n 0.11168 29900.0n 0.79881 30029.9n 0.79881 30030.0n 0.03541 30159.9n 0.03541 30160.0n 1.31038 30289.9n 1.31038 30290.0n 0.52444 30419.9n 0.52444 30420.0n -0.36668 30549.9n -0.36668 30550.0n -0.07007 30679.9n -0.07007 30680.0n 1.04662 30809.9n 1.04662 30810.0n 1.14927 30939.9n 1.14927 30940.0n 0.44934 31069.9n 0.44934 31070.0n 0.29315 31199.9n 0.29315 31200.0n 0.43551 31329.9n 0.43551 31330.0n 0.47921 31459.9n 0.47921 31460.0n 0.64370 31589.9n 0.64370 31590.0n 0.26400 31719.9n 0.26400 31720.0n 0.72357 31849.9n 0.72357 31850.0n 0.82918 31979.9n 0.82918 31980.0n -0.36668 32109.9n -0.36668 32110.0n 0.73581 32239.9n 0.73581 32240.0n 0.47921 32369.9n 0.47921 32370.0n 0.44994 32499.9n 0.44994 32500.0n 0.78502 32629.9n 0.78502 32630.0n 0.43551 32759.9n 0.43551 32760.0n 0.44934 32889.9n 0.44934 32890.0n 0.79881 33019.9n 0.79881 33020.0n 0.75921 33149.9n 0.75921 33150.0n 1.14927 33279.9n 1.14927 33280.0n 0.11168 33409.9n 0.11168 33410.0n 0.68861 33539.9n 0.68861 33540.0n 0.64370 33669.9n 0.64370 33670.0n 1.31038 33799.9n 1.31038 33800.0n 0.26400 33929.9n 0.26400 33930.0n -0.07007 34059.9n -0.07007 34060.0n 0.72924 34189.9n 0.72924 34190.0n 0.03541 34319.9n 0.03541 34320.0n 0.46859 34449.9n 0.46859 34450.0n 0.56419 34579.9n 0.56419 34580.0n 0.89441 34709.9n 0.89441 34710.0n 1.04662 34839.9n 1.04662 34840.0n 0.30498 34969.9n 0.30498 34970.0n 0.30031 35099.9n 0.30031 35100.0n 0.29315 35229.9n 0.29315 35230.0n 0.52444 35359.9n 0.52444 35360.0n 0.78502 35489.9n 0.78502 35490.0n 1.31038 35619.9n 1.31038 35620.0n 0.46859 35749.9n 0.46859 35750.0n 0.43551 35879.9n 0.43551 35880.0n 1.14927 36009.9n 1.14927 36010.0n 1.04662 36139.9n 1.04662 36140.0n 0.44934 36269.9n 0.44934 36270.0n 0.47921 36399.9n 0.47921 36400.0n 0.75921 36529.9n 0.75921 36530.0n 0.64370 36659.9n 0.64370 36660.0n 0.72357 36789.9n 0.72357 36790.0n 0.72924 36919.9n 0.72924 36920.0n 0.52444 37049.9n 0.52444 37050.0n 0.68861 37179.9n 0.68861 37180.0n 0.30031 37309.9n 0.30031 37310.0n 0.89441 37439.9n 0.89441 37440.0n -0.36668 37569.9n -0.36668 37570.0n 0.11168 37699.9n 0.11168 37700.0n 0.26400 37829.9n 0.26400 37830.0n 0.29315 37959.9n 0.29315 37960.0n 0.44994 38089.9n 0.44994 38090.0n 0.30498 38219.9n 0.30498 38220.0n -0.07007 38349.9n -0.07007 38350.0n 0.03541 38479.9n 0.03541 38480.0n 0.56419 38609.9n 0.56419 38610.0n 0.82918 38739.9n 0.82918 38740.0n 0.73581 38869.9n 0.73581 38870.0n 0.79881 38999.9n 0.79881 39000.0n 0.03541 39129.9n 0.03541 39130.0n -0.07007 39259.9n -0.07007 39260.0n 0.46859 39389.9n 0.46859 39390.0n 0.72357 39519.9n 0.72357 39520.0n 0.44934 39649.9n 0.44934 39650.0n 0.73581 39779.9n 0.73581 39780.0n 0.43551 39909.9n 0.43551 39910.0n 0.26400 40039.9n 0.26400 40040.0n 0.44994 40169.9n 0.44994 40170.0n 0.68861 40299.9n 0.68861 40300.0n 0.29315 40429.9n 0.29315 40430.0n 1.31038 40559.9n 1.31038 40560.0n 0.30031 40689.9n 0.30031 40690.0n 0.64370 40819.9n 0.64370 40820.0n -0.36668 40949.9n -0.36668 40950.0n 0.30498 41079.9n 0.30498 41080.0n 0.11168 41209.9n 0.11168 41210.0n 1.04662 41339.9n 1.04662 41340.0n 0.79881 41469.9n 0.79881 41470.0n 0.78502 41599.9n 0.78502 41600.0n 0.56419 41729.9n 0.56419 41730.0n 1.14927 41859.9n 1.14927 41860.0n 0.47921 41989.9n 0.47921 41990.0n 0.82918 42119.9n 0.82918 42120.0n 0.72924 42249.9n 0.72924 42250.0n 0.52444 42379.9n 0.52444 42380.0n 0.75921 42509.9n 0.75921 42510.0n 0.89441 42639.9n 0.89441 42640.0n 0.72924 42769.9n 0.72924 42770.0n 0.68861 42899.9n 0.68861 42900.0n 0.47921 43029.9n 0.47921 43030.0n 0.64370 43159.9n 0.64370 43160.0n 0.43551 43289.9n 0.43551 43290.0n 0.79881 43419.9n 0.79881 43420.0n 0.29315 43549.9n 0.29315 43550.0n 0.72357 43679.9n 0.72357 43680.0n 0.89441 43809.9n 0.89441 43810.0n 0.56419 43939.9n 0.56419 43940.0n 0.75921 44069.9n 0.75921 44070.0n 0.30031 44199.9n 0.30031 44200.0n 0.44934 44329.9n 0.44934 44330.0n -0.07007 44459.9n -0.07007 44460.0n 1.31038 44589.9n 1.31038 44590.0n 0.46859 44719.9n 0.46859 44720.0n 0.44994 44849.9n 0.44994 44850.0n 0.78502 44979.9n 0.78502 44980.0n 1.04662 45109.9n 1.04662 45110.0n 0.73581 45239.9n 0.73581 45240.0n 0.11168 45369.9n 0.11168 45370.0n 0.03541 45499.9n 0.03541 45500.0n 0.82918 45629.9n 0.82918 45630.0n 0.30498 45759.9n 0.30498 45760.0n 1.14927 45889.9n 1.14927 45890.0n -0.36668 46019.9n -0.36668 46020.0n 0.26400 46149.9n 0.26400 46150.0n 0.52444 46279.9n 0.52444 46280.0n 0.30031 46409.9n 0.30031 46410.0n 0.43551 46539.9n 0.43551 46540.0n 0.47921 46669.9n 0.47921 46670.0n 0.30498 46799.9n 0.30498 46800.0n 0.75921 46929.9n 0.75921 46930.0n 0.82918 47059.9n 0.82918 47060.0n 0.89441 47189.9n 0.89441 47190.0n 0.72924 47319.9n 0.72924 47320.0n 0.11168 47449.9n 0.11168 47450.0n 0.72357 47579.9n 0.72357 47580.0n 0.46859 47709.9n 0.46859 47710.0n 0.29315 47839.9n 0.29315 47840.0n 0.68861 47969.9n 0.68861 47970.0n 0.79881 48099.9n 0.79881 48100.0n -0.36668 48229.9n -0.36668 48230.0n 0.78502 48359.9n 0.78502 48360.0n 0.44994 48489.9n 0.44994 48490.0n 0.03541 48619.9n 0.03541 48620.0n 0.44934 48749.9n 0.44934 48750.0n 0.73581 48879.9n 0.73581 48880.0n 1.31038 49009.9n 1.31038 49010.0n 0.26400 49139.9n 0.26400 49140.0n 0.52444 49269.9n 0.52444 49270.0n 1.04662 49399.9n 1.04662 49400.0n 0.56419 49529.9n 0.56419 49530.0n 0.64370 49659.9n 0.64370 49660.0n -0.07007 49789.9n -0.07007 49790.0n 1.14927 49919.9n 1.14927 49920.0n 0.51492 50049.9n 0.51492 50050.0n 0.13970 50179.9n 0.13970 50180.0n 0.42258 50309.9n 0.42258 50310.0n 0.20713 50439.9n 0.20713 50440.0n 0.39910 50569.9n 0.39910 50570.0n 0.76629 50699.9n 0.76629 50700.0n 0.87516 50829.9n 0.87516 50830.0n 0.51649 50959.9n 0.51649 50960.0n 0.47728 51089.9n 0.47728 51090.0n 0.89579 51219.9n 0.89579 51220.0n 0.73813 51349.9n 0.73813 51350.0n 0.73007 51479.9n 0.73007 51480.0n 0.38805 51609.9n 0.38805 51610.0n 0.44565 51739.9n 0.44565 51740.0n 0.84972 51869.9n 0.84972 51870.0n 0.31374 51999.9n 0.31374 52000.0n 0.53500 52129.9n 0.53500 52130.0n 0.65381 52259.9n 0.65381 52260.0n 0.58828 52389.9n 0.58828 52390.0n 0.29293 52519.9n 0.29293 52520.0n 0.34864 52649.9n 0.34864 52650.0n 0.39919 52779.9n 0.39919 52780.0n 0.28504 52909.9n 0.28504 52910.0n 0.90918 53039.9n 0.90918 53040.0n -0.38855 53169.9n -0.38855 53170.0n -0.21890 53299.9n -0.21890 53300.0n -0.28851 53429.9n -0.28851 53430.0n -0.24585 53559.9n -0.24585 53560.0n 1.15208 53689.9n 1.15208 53690.0n 0.41841 53819.9n 0.41841 53820.0n 0.24338 53949.9n 0.24338 53950.0n 1.49277 54079.9n 1.49277 54080.0n 1.19260 54209.9n 1.19260 54210.0n -0.27962 54339.9n -0.27962 54340.0n 0.55733 54469.9n 0.55733 54470.0n 0.95600 54599.9n 0.95600 54600.0n -0.04710 54729.9n -0.04710 54730.0n 0.80242 54859.9n 0.80242 54860.0n 0.39736 54989.9n 0.39736 54990.0n 1.04029 55119.9n 1.04029 55120.0n 0.63149 55249.9n 0.63149 55250.0n 0.81752 55379.9n 0.81752 55380.0n 1.19808 55509.9n 1.19808 55510.0n 1.39872 55639.9n 1.39872 55640.0n 0.28119 55769.9n 0.28119 55770.0n 1.46004 55899.9n 1.46004 55900.0n -0.19303 56029.9n -0.19303 56030.0n 0.93542 56159.9n 0.93542 56160.0n 0.78502 56289.9n 0.78502 56290.0n 0.89441 56419.9n 0.89441 56420.0n 0.72357 56549.9n 0.72357 56550.0n 1.31038 56679.9n 1.31038 56680.0n 0.75921 56809.9n 0.75921 56810.0n -0.36668 56939.9n -0.36668 56940.0n 0.52444 57069.9n 0.52444 57070.0n 0.11168 57199.9n 0.11168 57200.0n 0.72924 57329.9n 0.72924 57330.0n 0.44994 57459.9n 0.44994 57460.0n 0.44934 57589.9n 0.44934 57590.0n 0.68861 57719.9n 0.68861 57720.0n 0.47921 57849.9n 0.47921 57850.0n 0.30498 57979.9n 0.30498 57980.0n 0.43551 58109.9n 0.43551 58110.0n 0.64370 58239.9n 0.64370 58240.0n 0.46859 58369.9n 0.46859 58370.0n -0.07007 58499.9n -0.07007 58500.0n 0.73581 58629.9n 0.73581 58630.0n 1.04662 58759.9n 1.04662 58760.0n 1.14927 58889.9n 1.14927 58890.0n 0.56419 59019.9n 0.56419 59020.0n 0.79881 59149.9n 0.79881 59150.0n 0.29315 59279.9n 0.29315 59280.0n 0.26400 59409.9n 0.26400 59410.0n 0.03541 59539.9n 0.03541 59540.0n 0.82918 59669.9n 0.82918 59670.0n 0.30031 59799.9n 0.30031 59800.0n 0.26400 59929.9n 0.26400 59930.0n 0.43551 60059.9n 0.43551 60060.0n 1.04662 60189.9n 1.04662 60190.0n 0.78502 60319.9n 0.78502 60320.0n 0.47921 60449.9n 0.47921 60450.0n 1.31038 60579.9n 1.31038 60580.0n 0.73581 60709.9n 0.73581 60710.0n 0.68861 60839.9n 0.68861 60840.0n 0.52444 60969.9n 0.52444 60970.0n 0.72357 61099.9n 0.72357 61100.0n 0.64370 61229.9n 0.64370 61230.0n 0.30031 61359.9n 0.30031 61360.0n 0.44994 61489.9n 0.44994 61490.0n 0.72924 61619.9n 0.72924 61620.0n 0.11168 61749.9n 0.11168 61750.0n 0.75921 61879.9n 0.75921 61880.0n 0.82918 62009.9n 0.82918 62010.0n -0.07007 62139.9n -0.07007 62140.0n 0.56419 62269.9n 0.56419 62270.0n -0.36668 62399.9n -0.36668 62400.0n 0.29315 62529.9n 0.29315 62530.0n 0.30498 62659.9n 0.30498 62660.0n 0.79881 62789.9n 0.79881 62790.0n 0.46859 62919.9n 0.46859 62920.0n 0.89441 63049.9n 0.89441 63050.0n 0.03541 63179.9n 0.03541 63180.0n 1.14927 63309.9n 1.14927 63310.0n 0.44934 63439.9n 0.44934 63440.0n -0.36668 63569.9n -0.36668 63570.0n 0.78502 63699.9n 0.78502 63700.0n 0.79881 63829.9n 0.79881 63830.0n 1.31038 63959.9n 1.31038 63960.0n 0.11168 64089.9n 0.11168 64090.0n 0.26400 64219.9n 0.26400 64220.0n 1.04662 64349.9n 1.04662 64350.0n 0.89441 64479.9n 0.89441 64480.0n 0.75921 64609.9n 0.75921 64610.0n 0.72924 64739.9n 0.72924 64740.0n 0.52444 64869.9n 0.52444 64870.0n 0.43551 64999.9n 0.43551 65000.0n 0.30031 65129.9n 0.30031 65130.0n 0.73581 65259.9n 0.73581 65260.0n 1.14927 65389.9n 1.14927 65390.0n -0.07007 65519.9n -0.07007 65520.0n 0.30498 65649.9n 0.30498 65650.0n 0.44994 65779.9n 0.44994 65780.0n 0.47921 65909.9n 0.47921 65910.0n 0.03541 66039.9n 0.03541 66040.0n 0.29315 66169.9n 0.29315 66170.0n 0.56419 66299.9n 0.56419 66300.0n 0.82918 66429.9n 0.82918 66430.0n 0.68861 66559.9n 0.68861 66560.0n 0.72357 66689.9n 0.72357 66690.0n 0.44934 66819.9n 0.44934 66820.0n 0.46859 66949.9n 0.46859 66950.0n 0.64370 67079.9n 0.64370 67080.0n 1.04662 67209.9n 1.04662 67210.0n 0.44994 67339.9n 0.44994 67340.0n 1.14927 67469.9n 1.14927 67470.0n 0.30031 67599.9n 0.30031 67600.0n 0.30498 67729.9n 0.30498 67730.0n 0.46859 67859.9n 0.46859 67860.0n 0.29315 67989.9n 0.29315 67990.0n 0.56419 68119.9n 0.56419 68120.0n 0.82918 68249.9n 0.82918 68250.0n 0.72924 68379.9n 0.72924 68380.0n 0.11168 68509.9n 0.11168 68510.0n 0.44934 68639.9n 0.44934 68640.0n 0.64370 68769.9n 0.64370 68770.0n -0.36668 68899.9n -0.36668 68900.0n 0.73581 69029.9n 0.73581 69030.0n 0.68861 69159.9n 0.68861 69160.0n 0.89441 69289.9n 0.89441 69290.0n 0.79881 69419.9n 0.79881 69420.0n 0.72357 69549.9n 0.72357 69550.0n 0.78502 69679.9n 0.78502 69680.0n 0.26400 69809.9n 0.26400 69810.0n 0.52444 69939.9n 0.52444 69940.0n 0.43551 70069.9n 0.43551 70070.0n -0.07007 70199.9n -0.07007 70200.0n 1.31038 70329.9n 1.31038 70330.0n 0.03541 70459.9n 0.03541 70460.0n 0.47921 70589.9n 0.47921 70590.0n 0.75921 70719.9n 0.75921 70720.0n 0.46859 70849.9n 0.46859 70850.0n 0.30031 70979.9n 0.30031 70980.0n 0.44934 71109.9n 0.44934 71110.0n 0.29315 71239.9n 0.29315 71240.0n 0.75921 71369.9n 0.75921 71370.0n 0.64370 71499.9n 0.64370 71500.0n 0.56419 71629.9n 0.56419 71630.0n 1.04662 71759.9n 1.04662 71760.0n 0.52444 71889.9n 0.52444 71890.0n 0.03541 72019.9n 0.03541 72020.0n -0.07007 72149.9n -0.07007 72150.0n 0.79881 72279.9n 0.79881 72280.0n 1.31038 72409.9n 1.31038 72410.0n 0.47921 72539.9n 0.47921 72540.0n 0.73581 72669.9n 0.73581 72670.0n 0.44994 72799.9n 0.44994 72800.0n -0.36668 72929.9n -0.36668 72930.0n 0.26400 73059.9n 0.26400 73060.0n 0.78502 73189.9n 0.78502 73190.0n 0.43551 73319.9n 0.43551 73320.0n 0.89441 73449.9n 0.89441 73450.0n 0.72357 73579.9n 0.72357 73580.0n 0.82918 73709.9n 0.82918 73710.0n 0.11168 73839.9n 0.11168 73840.0n 0.30498 73969.9n 0.30498 73970.0n 0.72924 74099.9n 0.72924 74100.0n 1.14927 74229.9n 1.14927 74230.0n 0.68861 74359.9n 0.68861 74360.0n 0.29315 74489.9n 0.29315 74490.0n 0.30498 74619.9n 0.30498 74620.0n 1.04662 74749.9n 1.04662 74750.0n 0.03541 74879.9n 0.03541 74880.0n -0.07007 75009.9n -0.07007 75010.0n 0.64370 75139.9n 0.64370 75140.0n 0.30031 75269.9n 0.30031 75270.0n 0.72924 75399.9n 0.72924 75400.0n 0.79881 75529.9n 0.79881 75530.0n 0.46859 75659.9n 0.46859 75660.0n 0.11168 75789.9n 0.11168 75790.0n 0.47921 75919.9n 0.47921 75920.0n 0.72357 76049.9n 0.72357 76050.0n 1.31038 76179.9n 1.31038 76180.0n 0.68861 76309.9n 0.68861 76310.0n 0.89441 76439.9n 0.89441 76440.0n 0.52444 76569.9n 0.52444 76570.0n 1.14927 76699.9n 1.14927 76700.0n 0.73581 76829.9n 0.73581 76830.0n 0.44994 76959.9n 0.44994 76960.0n 0.26400 77089.9n 0.26400 77090.0n 0.44934 77219.9n 0.44934 77220.0n 0.56419 77349.9n 0.56419 77350.0n 0.43551 77479.9n 0.43551 77480.0n 0.75921 77609.9n 0.75921 77610.0n -0.36668 77739.9n -0.36668 77740.0n 0.78502 77869.9n 0.78502 77870.0n 0.82918 77999.9n 0.82918 78000.0n 0.51492 78129.9n 0.51492 78130.0n 0.13970 78259.9n 0.13970 78260.0n 0.42258 78389.9n 0.42258 78390.0n 0.20713 78519.9n 0.20713 78520.0n 0.39910 78649.9n 0.39910 78650.0n 0.76629 78779.9n 0.76629 78780.0n 0.87516 78909.9n 0.87516 78910.0n 0.51649 79039.9n 0.51649 79040.0n 0.47728 79169.9n 0.47728 79170.0n 0.89579 79299.9n 0.89579 79300.0n 0.73813 79429.9n 0.73813 79430.0n 0.73007 79559.9n 0.73007 79560.0n 0.38805 79689.9n 0.38805 79690.0n 0.44565 79819.9n 0.44565 79820.0n 0.84972 79949.9n 0.84972 79950.0n 0.31374 80079.9n 0.31374 80080.0n 0.53500 80209.9n 0.53500 80210.0n 0.65381 80339.9n 0.65381 80340.0n 0.58828 80469.9n 0.58828 80470.0n 0.29293 80599.9n 0.29293 80600.0n 0.34864 80729.9n 0.34864 80730.0n 0.39919 80859.9n 0.39919 80860.0n 0.28504 80989.9n 0.28504 80990.0n 0.90918 81119.9n 0.90918 81120.0n -0.38855 81249.9n -0.38855 81250.0n -0.21890 81379.9n -0.21890 81380.0n -0.28851 81509.9n -0.28851 81510.0n -0.24585 81639.9n -0.24585 81640.0n 1.15208 81769.9n 1.15208 81770.0n 0.41841 81899.9n 0.41841 81900.0n 0.24338 82029.9n 0.24338 82030.0n 1.49277 82159.9n 1.49277 82160.0n 1.19260 82289.9n 1.19260 82290.0n -0.27962 82419.9n -0.27962 82420.0n 0.55733 82549.9n 0.55733 82550.0n 0.95600 82679.9n 0.95600 82680.0n -0.04710 82809.9n -0.04710 82810.0n 0.80242 82939.9n 0.80242 82940.0n 0.39736 83069.9n 0.39736 83070.0n 1.04029 83199.9n 1.04029 83200.0n 0.63149 83329.9n 0.63149 83330.0n 0.81752 83459.9n 0.81752 83460.0n 1.19808 83589.9n 1.19808 83590.0n 1.39872 83719.9n 1.39872 83720.0n 0.28119 83849.9n 0.28119 83850.0n 1.46004 83979.9n 1.46004 83980.0n -0.19303 84109.9n -0.19303 84110.0n 0.93542 84239.9n 0.93542 84240.0n 0.89441 84369.9n 0.89441 84370.0n 0.82918 84499.9n 0.82918 84500.0n 0.30498 84629.9n 0.30498 84630.0n 0.68861 84759.9n 0.68861 84760.0n 0.44994 84889.9n 0.44994 84890.0n 0.47921 85019.9n 0.47921 85020.0n 0.30031 85149.9n 0.30031 85150.0n 0.11168 85279.9n 0.11168 85280.0n 0.03541 85409.9n 0.03541 85410.0n 0.64370 85539.9n 0.64370 85540.0n 0.46859 85669.9n 0.46859 85670.0n -0.07007 85799.9n -0.07007 85800.0n 0.72924 85929.9n 0.72924 85930.0n 1.14927 86059.9n 1.14927 86060.0n 0.79881 86189.9n 0.79881 86190.0n 1.04662 86319.9n 1.04662 86320.0n 0.29315 86449.9n 0.29315 86450.0n 0.52444 86579.9n 0.52444 86580.0n 0.78502 86709.9n 0.78502 86710.0n 0.56419 86839.9n 0.56419 86840.0n 0.26400 86969.9n 0.26400 86970.0n 0.72357 87099.9n 0.72357 87100.0n 0.43551 87229.9n 0.43551 87230.0n 0.44934 87359.9n 0.44934 87360.0n -0.36668 87489.9n -0.36668 87490.0n 1.31038 87619.9n 1.31038 87620.0n 0.73581 87749.9n 0.73581 87750.0n 0.75921 87879.9n 0.75921 87880.0n -0.07007 88009.9n -0.07007 88010.0n 0.44934 88139.9n 0.44934 88140.0n 0.52444 88269.9n 0.52444 88270.0n 1.04662 88399.9n 1.04662 88400.0n 0.47921 88529.9n 0.47921 88530.0n 0.89441 88659.9n 0.89441 88660.0n 0.72924 88789.9n 0.72924 88790.0n 0.26400 88919.9n 0.26400 88920.0n 0.78502 89049.9n 0.78502 89050.0n 0.43551 89179.9n 0.43551 89180.0n 0.03541 89309.9n 0.03541 89310.0n 0.30031 89439.9n 0.30031 89440.0n -0.36668 89569.9n -0.36668 89570.0n 0.46859 89699.9n 0.46859 89700.0n 0.73581 89829.9n 0.73581 89830.0n 0.11168 89959.9n 0.11168 89960.0n 0.44994 90089.9n 0.44994 90090.0n 0.75921 90219.9n 0.75921 90220.0n 0.29315 90349.9n 0.29315 90350.0n 0.64370 90479.9n 0.64370 90480.0n 0.30498 90609.9n 0.30498 90610.0n 0.56419 90739.9n 0.56419 90740.0n 0.79881 90869.9n 0.79881 90870.0n 1.31038 90999.9n 1.31038 91000.0n 1.14927 91129.9n 1.14927 91130.0n 0.82918 91259.9n 0.82918 91260.0n 0.72357 91389.9n 0.72357 91390.0n 0.68861 91519.9n 0.68861 91520.0n 0.46859 91649.9n 0.46859 91650.0n 0.26400 91779.9n 0.26400 91780.0n 0.68861 91909.9n 0.68861 91910.0n 0.75921 92039.9n 0.75921 92040.0n 0.11168 92169.9n 0.11168 92170.0n 0.43551 92299.9n 0.43551 92300.0n 0.72924 92429.9n 0.72924 92430.0n 0.89441 92559.9n 0.89441 92560.0n 0.72357 92689.9n 0.72357 92690.0n 0.79881 92819.9n 0.79881 92820.0n 0.29315 92949.9n 0.29315 92950.0n 0.44934 93079.9n 0.44934 93080.0n 1.04662 93209.9n 1.04662 93210.0n -0.36668 93339.9n -0.36668 93340.0n 0.44994 93469.9n 0.44994 93470.0n 0.52444 93599.9n 0.52444 93600.0n -0.07007 93729.9n -0.07007 93730.0n 0.73581 93859.9n 0.73581 93860.0n 0.78502 93989.9n 0.78502 93990.0n 0.30498 94119.9n 0.30498 94120.0n 1.14927 94249.9n 1.14927 94250.0n 1.31038 94379.9n 1.31038 94380.0n 0.03541 94509.9n 0.03541 94510.0n 0.47921 94639.9n 0.47921 94640.0n 0.82918 94769.9n 0.82918 94770.0n 0.64370 94899.9n 0.64370 94900.0n 0.56419 95029.9n 0.56419 95030.0n 0.30031 95159.9n 0.30031 95160.0n 0.73581 95289.9n 0.73581 95290.0n 0.26400 95419.9n 0.26400 95420.0n 0.68861 95549.9n 0.68861 95550.0n 0.72357 95679.9n 0.72357 95680.0n 0.44994 95809.9n 0.44994 95810.0n -0.36668 95939.9n -0.36668 95940.0n 1.04662 96069.9n 1.04662 96070.0n 0.52444 96199.9n 0.52444 96200.0n 1.14927 96329.9n 1.14927 96330.0n 0.72924 96459.9n 0.72924 96460.0n 0.56419 96589.9n 0.56419 96590.0n 0.11168 96719.9n 0.11168 96720.0n -0.07007 96849.9n -0.07007 96850.0n 0.79881 96979.9n 0.79881 96980.0n 0.30498 97109.9n 0.30498 97110.0n 0.78502 97239.9n 0.78502 97240.0n 0.44934 97369.9n 0.44934 97370.0n 0.89441 97499.9n 0.89441 97500.0n 0.47921 97629.9n 0.47921 97630.0n 1.31038 97759.9n 1.31038 97760.0n 0.43551 97889.9n 0.43551 97890.0n 0.82918 98019.9n 0.82918 98020.0n 0.75921 98149.9n 0.75921 98150.0n 0.29315 98279.9n 0.29315 98280.0n 0.64370 98409.9n 0.64370 98410.0n 0.30031 98539.9n 0.30031 98540.0n 0.03541 98669.9n 0.03541 98670.0n 0.46859 98799.9n 0.46859 98800.0n -0.07007 98929.9n -0.07007 98930.0n 0.75921 99059.9n 0.75921 99060.0n 0.47921 99189.9n 0.47921 99190.0n 0.03541 99319.9n 0.03541 99320.0n 0.43551 99449.9n 0.43551 99450.0n 1.31038 99579.9n 1.31038 99580.0n 1.14927 99709.9n 1.14927 99710.0n 0.82918 99839.9n 0.82918 99840.0n 0.78502 99969.9n 0.78502 99970.0n 0.68861 100099.9n 0.68861 100100.0n 0.44994 100229.9n 0.44994 100230.0n 0.56419 100359.9n 0.56419 100360.0n 0.79881 100489.9n 0.79881 100490.0n 0.72357 100619.9n 0.72357 100620.0n 0.26400 100749.9n 0.26400 100750.0n 0.46859 100879.9n 0.46859 100880.0n 0.30498 101009.9n 0.30498 101010.0n 1.04662 101139.9n 1.04662 101140.0n 0.72924 101269.9n 0.72924 101270.0n -0.36668 101399.9n -0.36668 101400.0n 0.52444 101529.9n 0.52444 101530.0n 0.73581 101659.9n 0.73581 101660.0n 0.44934 101789.9n 0.44934 101790.0n 0.30031 101919.9n 0.30031 101920.0n 0.64370 102049.9n 0.64370 102050.0n 0.89441 102179.9n 0.89441 102180.0n 0.29315 102309.9n 0.29315 102310.0n 0.11168 102439.9n 0.11168 102440.0n 0.79881 102569.9n 0.79881 102570.0n 0.56419 102699.9n 0.56419 102700.0n 0.03541 102829.9n 0.03541 102830.0n 0.46859 102959.9n 0.46859 102960.0n 0.11168 103089.9n 0.11168 103090.0n 0.29315 103219.9n 0.29315 103220.0n 0.44994 103349.9n 0.44994 103350.0n 0.89441 103479.9n 0.89441 103480.0n -0.36668 103609.9n -0.36668 103610.0n -0.07007 103739.9n -0.07007 103740.0n 0.64370 103869.9n 0.64370 103870.0n 0.75921 103999.9n 0.75921 104000.0n 0.44934 104129.9n 0.44934 104130.0n 1.14927 104259.9n 1.14927 104260.0n 0.78502 104389.9n 0.78502 104390.0n 0.82918 104519.9n 0.82918 104520.0n 0.68861 104649.9n 0.68861 104650.0n 0.72357 104779.9n 0.72357 104780.0n 0.43551 104909.9n 0.43551 104910.0n 0.72924 105039.9n 0.72924 105040.0n 0.52444 105169.9n 0.52444 105170.0n 1.31038 105299.9n 1.31038 105300.0n 1.04662 105429.9n 1.04662 105430.0n 0.73581 105559.9n 0.73581 105560.0n 0.47921 105689.9n 0.47921 105690.0n 0.26400 105819.9n 0.26400 105820.0n 0.30498 105949.9n 0.30498 105950.0n 0.30031 106079.9n 0.30031 106080.0n 0.51492 106209.9n 0.51492 106210.0n 0.13970 106339.9n 0.13970 106340.0n 0.42258 106469.9n 0.42258 106470.0n 0.20713 106599.9n 0.20713 106600.0n 0.39910 106729.9n 0.39910 106730.0n 0.76629 106859.9n 0.76629 106860.0n 0.87516 106989.9n 0.87516 106990.0n 0.51649 107119.9n 0.51649 107120.0n 0.47728 107249.9n 0.47728 107250.0n 0.89579 107379.9n 0.89579 107380.0n 0.73813 107509.9n 0.73813 107510.0n 0.73007 107639.9n 0.73007 107640.0n 0.38805 107769.9n 0.38805 107770.0n 0.44565 107899.9n 0.44565 107900.0n 0.84972 108029.9n 0.84972 108030.0n 0.31374 108159.9n 0.31374 108160.0n 0.53500 108289.9n 0.53500 108290.0n 0.65381 108419.9n 0.65381 108420.0n 0.58828 108549.9n 0.58828 108550.0n 0.29293 108679.9n 0.29293 108680.0n 0.34864 108809.9n 0.34864 108810.0n 0.39919 108939.9n 0.39919 108940.0n 0.28504 109069.9n 0.28504 109070.0n 0.90918 109199.9n 0.90918 109200.0n -0.38855 109329.9n -0.38855 109330.0n -0.21890 109459.9n -0.21890 109460.0n -0.28851 109589.9n -0.28851 109590.0n -0.24585 109719.9n -0.24585 109720.0n 1.15208 109849.9n 1.15208 109850.0n 0.41841 109979.9n 0.41841 109980.0n 0.24338 110109.9n 0.24338 110110.0n 1.49277 110239.9n 1.49277 110240.0n 1.19260 110369.9n 1.19260 110370.0n -0.27962 110499.9n -0.27962 110500.0n 0.55733 110629.9n 0.55733 110630.0n 0.95600 110759.9n 0.95600 110760.0n -0.04710 110889.9n -0.04710 110890.0n 0.80242 111019.9n 0.80242 111020.0n 0.39736 111149.9n 0.39736 111150.0n 1.04029 111279.9n 1.04029 111280.0n 0.63149 111409.9n 0.63149 111410.0n 0.81752 111539.9n 0.81752 111540.0n 1.19808 111669.9n 1.19808 111670.0n 1.39872 111799.9n 1.39872 111800.0n 0.28119 111929.9n 0.28119 111930.0n 1.46004 112059.9n 1.46004 112060.0n -0.19303 112189.9n -0.19303 112190.0n 0.93542 112319.9n 0.93542 112320.0n 1.31038 112449.9n 1.31038 112450.0n 0.78502 112579.9n 0.78502 112580.0n 1.14927 112709.9n 1.14927 112710.0n 0.75921 112839.9n 0.75921 112840.0n 0.82918 112969.9n 0.82918 112970.0n 0.68861 113099.9n 0.68861 113100.0n 0.79881 113229.9n 0.79881 113230.0n -0.36668 113359.9n -0.36668 113360.0n 0.44994 113489.9n 0.44994 113490.0n 0.44934 113619.9n 0.44934 113620.0n 0.26400 113749.9n 0.26400 113750.0n 0.30031 113879.9n 0.30031 113880.0n 1.04662 114009.9n 1.04662 114010.0n 0.30498 114139.9n 0.30498 114140.0n 0.43551 114269.9n 0.43551 114270.0n -0.07007 114399.9n -0.07007 114400.0n 0.64370 114529.9n 0.64370 114530.0n 0.29315 114659.9n 0.29315 114660.0n 0.56419 114789.9n 0.56419 114790.0n 0.73581 114919.9n 0.73581 114920.0n 0.72924 115049.9n 0.72924 115050.0n 0.72357 115179.9n 0.72357 115180.0n 0.11168 115309.9n 0.11168 115310.0n 0.89441 115439.9n 0.89441 115440.0n 0.52444 115569.9n 0.52444 115570.0n 0.46859 115699.9n 0.46859 115700.0n 0.03541 115829.9n 0.03541 115830.0n 0.47921 115959.9n 0.47921 115960.0n 1.31038 116089.9n 1.31038 116090.0n 0.43551 116219.9n 0.43551 116220.0n 0.11168 116349.9n 0.11168 116350.0n 0.30031 116479.9n 0.30031 116480.0n 1.14927 116609.9n 1.14927 116610.0n 0.47921 116739.9n 0.47921 116740.0n 0.72357 116869.9n 0.72357 116870.0n 0.56419 116999.9n 0.56419 117000.0n 1.04662 117129.9n 1.04662 117130.0n 0.44994 117259.9n 0.44994 117260.0n 0.03541 117389.9n 0.03541 117390.0n 0.89441 117519.9n 0.89441 117520.0n 0.73581 117649.9n 0.73581 117650.0n 0.44934 117779.9n 0.44934 117780.0n 0.72924 117909.9n 0.72924 117910.0n -0.07007 118039.9n -0.07007 118040.0n 0.68861 118169.9n 0.68861 118170.0n 0.29315 118299.9n 0.29315 118300.0n 0.64370 118429.9n 0.64370 118430.0n 0.78502 118559.9n 0.78502 118560.0n 0.26400 118689.9n 0.26400 118690.0n 0.82918 118819.9n 0.82918 118820.0n 0.30498 118949.9n 0.30498 118950.0n 0.79881 119079.9n 0.79881 119080.0n -0.36668 119209.9n -0.36668 119210.0n 0.75921 119339.9n 0.75921 119340.0n 0.52444 119469.9n 0.52444 119470.0n 0.46859 119599.9n 0.46859 119600.0n 0.26400 119729.9n 0.26400 119730.0n 0.03541 119859.9n 0.03541 119860.0n 0.72924 119989.9n 0.72924 119990.0n 0.46859 120119.9n 0.46859 120120.0n 0.44934 120249.9n 0.44934 120250.0n 0.82918 120379.9n 0.82918 120380.0n -0.36668 120509.9n -0.36668 120510.0n 0.72357 120639.9n 0.72357 120640.0n 0.79881 120769.9n 0.79881 120770.0n 0.44994 120899.9n 0.44994 120900.0n 0.68861 121029.9n 0.68861 121030.0n -0.07007 121159.9n -0.07007 121160.0n 0.64370 121289.9n 0.64370 121290.0n 0.29315 121419.9n 0.29315 121420.0n 0.89441 121549.9n 0.89441 121550.0n 0.73581 121679.9n 0.73581 121680.0n 0.43551 121809.9n 0.43551 121810.0n 1.04662 121939.9n 1.04662 121940.0n 1.31038 122069.9n 1.31038 122070.0n 0.52444 122199.9n 0.52444 122200.0n 0.47921 122329.9n 0.47921 122330.0n 0.75921 122459.9n 0.75921 122460.0n 0.56419 122589.9n 0.56419 122590.0n 0.30031 122719.9n 0.30031 122720.0n 0.11168 122849.9n 0.11168 122850.0n 0.78502 122979.9n 0.78502 122980.0n 1.14927 123109.9n 1.14927 123110.0n 0.30498 123239.9n 0.30498 123240.0n 1.14927 123369.9n 1.14927 123370.0n 0.44934 123499.9n 0.44934 123500.0n 0.72357 123629.9n 0.72357 123630.0n 0.47921 123759.9n 0.47921 123760.0n 1.04662 123889.9n 1.04662 123890.0n 0.82918 124019.9n 0.82918 124020.0n 0.73581 124149.9n 0.73581 124150.0n 0.89441 124279.9n 0.89441 124280.0n 0.26400 124409.9n 0.26400 124410.0n 0.29315 124539.9n 0.29315 124540.0n 0.79881 124669.9n 0.79881 124670.0n 0.72924 124799.9n 0.72924 124800.0n 0.78502 124929.9n 0.78502 124930.0n 0.30031 125059.9n 0.30031 125060.0n 0.11168 125189.9n 0.11168 125190.0n 0.52444 125319.9n 0.52444 125320.0n 1.31038 125449.9n 1.31038 125450.0n 0.30498 125579.9n 0.30498 125580.0n 0.64370 125709.9n 0.64370 125710.0n 0.75921 125839.9n 0.75921 125840.0n 0.68861 125969.9n 0.68861 125970.0n 0.03541 126099.9n 0.03541 126100.0n -0.36668 126229.9n -0.36668 126230.0n 0.56419 126359.9n 0.56419 126360.0n -0.07007 126489.9n -0.07007 126490.0n 0.46859 126619.9n 0.46859 126620.0n 0.43551 126749.9n 0.43551 126750.0n 0.44994 126879.9n 0.44994 126880.0n 0.52444 127009.9n 0.52444 127010.0n 0.11168 127139.9n 0.11168 127140.0n 0.89441 127269.9n 0.89441 127270.0n 0.75921 127399.9n 0.75921 127400.0n 0.82918 127529.9n 0.82918 127530.0n 0.30498 127659.9n 0.30498 127660.0n -0.07007 127789.9n -0.07007 127790.0n 1.31038 127919.9n 1.31038 127920.0n 0.26400 128049.9n 0.26400 128050.0n 0.43551 128179.9n 0.43551 128180.0n -0.36668 128309.9n -0.36668 128310.0n 0.44934 128439.9n 0.44934 128440.0n 0.47921 128569.9n 0.47921 128570.0n 0.78502 128699.9n 0.78502 128700.0n 0.46859 128829.9n 0.46859 128830.0n 0.03541 128959.9n 0.03541 128960.0n 0.64370 129089.9n 0.64370 129090.0n 0.72357 129219.9n 0.72357 129220.0n 0.68861 129349.9n 0.68861 129350.0n 0.73581 129479.9n 0.73581 129480.0n 0.72924 129609.9n 0.72924 129610.0n 0.44994 129739.9n 0.44994 129740.0n 0.79881 129869.9n 0.79881 129870.0n 0.29315 129999.9n 0.29315 130000.0n 1.04662 130129.9n 1.04662 130130.0n 0.30031 130259.9n 0.30031 130260.0n 0.56419 130389.9n 0.56419 130390.0n 1.14927 130519.9n 1.14927 130520.0n 0.30498 130649.9n 0.30498 130650.0n 0.75921 130779.9n 0.75921 130780.0n 0.68861 130909.9n 0.68861 130910.0n 0.72357 131039.9n 0.72357 131040.0n 0.78502 131169.9n 0.78502 131170.0n 0.79881 131299.9n 0.79881 131300.0n 0.30031 131429.9n 0.30031 131430.0n 1.04662 131559.9n 1.04662 131560.0n 0.82918 131689.9n 0.82918 131690.0n 0.44934 131819.9n 0.44934 131820.0n 0.44994 131949.9n 0.44994 131950.0n 0.52444 132079.9n 0.52444 132080.0n 0.64370 132209.9n 0.64370 132210.0n 0.72924 132339.9n 0.72924 132340.0n -0.07007 132469.9n -0.07007 132470.0n 1.31038 132599.9n 1.31038 132600.0n 0.56419 132729.9n 0.56419 132730.0n 0.47921 132859.9n 0.47921 132860.0n -0.36668 132989.9n -0.36668 132990.0n 0.11168 133119.9n 0.11168 133120.0n 0.46859 133249.9n 0.46859 133250.0n 0.73581 133379.9n 0.73581 133380.0n 1.14927 133509.9n 1.14927 133510.0n 0.89441 133639.9n 0.89441 133640.0n 0.43551 133769.9n 0.43551 133770.0n 0.03541 133899.9n 0.03541 133900.0n 0.26400 134029.9n 0.26400 134030.0n 0.29315 134159.9n 0.29315 134160.0n 0.51492 134289.9n 0.51492 134290.0n 0.13970 134419.9n 0.13970 134420.0n 0.42258 134549.9n 0.42258 134550.0n 0.20713 134679.9n 0.20713 134680.0n 0.39910 134809.9n 0.39910 134810.0n 0.76629 134939.9n 0.76629 134940.0n 0.87516 135069.9n 0.87516 135070.0n 0.51649 135199.9n 0.51649 135200.0n 0.47728 135329.9n 0.47728 135330.0n 0.89579 135459.9n 0.89579 135460.0n 0.73813 135589.9n 0.73813 135590.0n 0.73007 135719.9n 0.73007 135720.0n 0.38805 135849.9n 0.38805 135850.0n 0.44565 135979.9n 0.44565 135980.0n 0.84972 136109.9n 0.84972 136110.0n 0.31374 136239.9n 0.31374 136240.0n 0.53500 136369.9n 0.53500 136370.0n 0.65381 136499.9n 0.65381 136500.0n 0.58828 136629.9n 0.58828 136630.0n 0.29293 136759.9n 0.29293 136760.0n 0.34864 136889.9n 0.34864 136890.0n 0.39919 137019.9n 0.39919 137020.0n 0.28504 137149.9n 0.28504 137150.0n 0.90918 137279.9n 0.90918 137280.0n -0.38855 137409.9n -0.38855 137410.0n -0.21890 137539.9n -0.21890 137540.0n -0.28851 137669.9n -0.28851 137670.0n -0.24585 137799.9n -0.24585 137800.0n 1.15208 137929.9n 1.15208 137930.0n 0.41841 138059.9n 0.41841 138060.0n 0.24338 138189.9n 0.24338 138190.0n 1.49277 138319.9n 1.49277 138320.0n 1.19260 138449.9n 1.19260 138450.0n -0.27962 138579.9n -0.27962 138580.0n 0.55733 138709.9n 0.55733 138710.0n 0.95600 138839.9n 0.95600 138840.0n -0.04710 138969.9n -0.04710 138970.0n 0.80242 139099.9n 0.80242 139100.0n 0.39736 139229.9n 0.39736 139230.0n 1.04029 139359.9n 1.04029 139360.0n 0.63149 139489.9n 0.63149 139490.0n 0.81752 139619.9n 0.81752 139620.0n 1.19808 139749.9n 1.19808 139750.0n 1.39872 139879.9n 1.39872 139880.0n 0.28119 140009.9n 0.28119 140010.0n 1.46004 140139.9n 1.46004 140140.0n -0.19303 140269.9n -0.19303 140270.0n 0.93542 140399.9n 0.93542 140400.0n 0.47921 140529.9n 0.47921 140530.0n 0.11168 140659.9n 0.11168 140660.0n 0.64370 140789.9n 0.64370 140790.0n 0.30498 140919.9n 0.30498 140920.0n 0.72357 141049.9n 0.72357 141050.0n 0.82918 141179.9n 0.82918 141180.0n 1.14927 141309.9n 1.14927 141310.0n 0.43551 141439.9n 0.43551 141440.0n 0.56419 141569.9n 0.56419 141570.0n 0.78502 141699.9n 0.78502 141700.0n 0.68861 141829.9n 0.68861 141830.0n 0.72924 141959.9n 0.72924 141960.0n 1.31038 142089.9n 1.31038 142090.0n 1.04662 142219.9n 1.04662 142220.0n 0.89441 142349.9n 0.89441 142350.0n 0.46859 142479.9n 0.46859 142480.0n -0.36668 142609.9n -0.36668 142610.0n 0.26400 142739.9n 0.26400 142740.0n 0.44994 142869.9n 0.44994 142870.0n 0.03541 142999.9n 0.03541 143000.0n 0.44934 143129.9n 0.44934 143130.0n 0.29315 143259.9n 0.29315 143260.0n 0.73581 143389.9n 0.73581 143390.0n 0.52444 143519.9n 0.52444 143520.0n 0.30031 143649.9n 0.30031 143650.0n -0.07007 143779.9n -0.07007 143780.0n 0.75921 143909.9n 0.75921 143910.0n 0.79881 144039.9n 0.79881 144040.0n 0.52444 144169.9n 0.52444 144170.0n 0.30031 144299.9n 0.30031 144300.0n 0.72924 144429.9n 0.72924 144430.0n 0.44994 144559.9n 0.44994 144560.0n 0.64370 144689.9n 0.64370 144690.0n 0.72357 144819.9n 0.72357 144820.0n -0.07007 144949.9n -0.07007 144950.0n 0.26400 145079.9n 0.26400 145080.0n 0.11168 145209.9n 0.11168 145210.0n 0.44934 145339.9n 0.44934 145340.0n 0.79881 145469.9n 0.79881 145470.0n 0.30498 145599.9n 0.30498 145600.0n 0.03541 145729.9n 0.03541 145730.0n 0.82918 145859.9n 0.82918 145860.0n -0.36668 145989.9n -0.36668 145990.0n 0.73581 146119.9n 0.73581 146120.0n 0.68861 146249.9n 0.68861 146250.0n 0.47921 146379.9n 0.47921 146380.0n 0.46859 146509.9n 0.46859 146510.0n 0.78502 146639.9n 0.78502 146640.0n 0.89441 146769.9n 0.89441 146770.0n 0.75921 146899.9n 0.75921 146900.0n 1.04662 147029.9n 1.04662 147030.0n 1.14927 147159.9n 1.14927 147160.0n 1.31038 147289.9n 1.31038 147290.0n 0.29315 147419.9n 0.29315 147420.0n 0.56419 147549.9n 0.56419 147550.0n 0.43551 147679.9n 0.43551 147680.0n 0.26400 147809.9n 0.26400 147810.0n 0.44934 147939.9n 0.44934 147940.0n 0.30031 148069.9n 0.30031 148070.0n -0.07007 148199.9n -0.07007 148200.0n 0.29315 148329.9n 0.29315 148330.0n 0.44994 148459.9n 0.44994 148460.0n 1.31038 148589.9n 1.31038 148590.0n 1.04662 148719.9n 1.04662 148720.0n 0.75921 148849.9n 0.75921 148850.0n 0.52444 148979.9n 0.52444 148980.0n 0.73581 149109.9n 0.73581 149110.0n 0.64370 149239.9n 0.64370 149240.0n 0.46859 149369.9n 0.46859 149370.0n 0.43551 149499.9n 0.43551 149500.0n 0.78502 149629.9n 0.78502 149630.0n 0.30498 149759.9n 0.30498 149760.0n 0.72924 149889.9n 0.72924 149890.0n 0.89441 150019.9n 0.89441 150020.0n -0.36668 150149.9n -0.36668 150150.0n 0.72357 150279.9n 0.72357 150280.0n 1.14927 150409.9n 1.14927 150410.0n 0.47921 150539.9n 0.47921 150540.0n 0.79881 150669.9n 0.79881 150670.0n 0.56419 150799.9n 0.56419 150800.0n 0.82918 150929.9n 0.82918 150930.0n 0.03541 151059.9n 0.03541 151060.0n 0.11168 151189.9n 0.11168 151190.0n 0.68861 151319.9n 0.68861 151320.0n 0.52444 151449.9n 0.52444 151450.0n 0.68861 151579.9n 0.68861 151580.0n 0.64370 151709.9n 0.64370 151710.0n 0.78502 151839.9n 0.78502 151840.0n 0.46859 151969.9n 0.46859 151970.0n 0.56419 152099.9n 0.56419 152100.0n 0.89441 152229.9n 0.89441 152230.0n 0.47921 152359.9n 0.47921 152360.0n 1.14927 152489.9n 1.14927 152490.0n 0.30031 152619.9n 0.30031 152620.0n -0.36668 152749.9n -0.36668 152750.0n 0.11168 152879.9n 0.11168 152880.0n 1.04662 153009.9n 1.04662 153010.0n 0.29315 153139.9n 0.29315 153140.0n 1.31038 153269.9n 1.31038 153270.0n 0.82918 153399.9n 0.82918 153400.0n 0.03541 153529.9n 0.03541 153530.0n 0.43551 153659.9n 0.43551 153660.0n -0.07007 153789.9n -0.07007 153790.0n 0.73581 153919.9n 0.73581 153920.0n 0.75921 154049.9n 0.75921 154050.0n 0.44994 154179.9n 0.44994 154180.0n 0.44934 154309.9n 0.44934 154310.0n 0.72357 154439.9n 0.72357 154440.0n 0.30498 154569.9n 0.30498 154570.0n 0.26400 154699.9n 0.26400 154700.0n 0.72924 154829.9n 0.72924 154830.0n 0.79881 154959.9n 0.79881 154960.0n 0.78502 155089.9n 0.78502 155090.0n 0.44934 155219.9n 0.44934 155220.0n 1.14927 155349.9n 1.14927 155350.0n 0.89441 155479.9n 0.89441 155480.0n 0.72924 155609.9n 0.72924 155610.0n 0.72357 155739.9n 0.72357 155740.0n 0.44994 155869.9n 0.44994 155870.0n 0.68861 155999.9n 0.68861 156000.0n 0.79881 156129.9n 0.79881 156130.0n 0.03541 156259.9n 0.03541 156260.0n 0.64370 156389.9n 0.64370 156390.0n 0.82918 156519.9n 0.82918 156520.0n 0.29315 156649.9n 0.29315 156650.0n 0.75921 156779.9n 0.75921 156780.0n 0.30498 156909.9n 0.30498 156910.0n 0.30031 157039.9n 0.30031 157040.0n -0.07007 157169.9n -0.07007 157170.0n 1.31038 157299.9n 1.31038 157300.0n 1.04662 157429.9n 1.04662 157430.0n 0.11168 157559.9n 0.11168 157560.0n 0.26400 157689.9n 0.26400 157690.0n 0.46859 157819.9n 0.46859 157820.0n 0.56419 157949.9n 0.56419 157950.0n 0.47921 158079.9n 0.47921 158080.0n 0.52444 158209.9n 0.52444 158210.0n 0.43551 158339.9n 0.43551 158340.0n 0.73581 158469.9n 0.73581 158470.0n -0.36668 158599.9n -0.36668 158600.0n 0.26400 158729.9n 0.26400 158730.0n 0.82918 158859.9n 0.82918 158860.0n -0.36668 158989.9n -0.36668 158990.0n 0.56419 159119.9n 0.56419 159120.0n 0.11168 159249.9n 0.11168 159250.0n 0.79881 159379.9n 0.79881 159380.0n 0.75921 159509.9n 0.75921 159510.0n 0.73581 159639.9n 0.73581 159640.0n 0.89441 159769.9n 0.89441 159770.0n 1.31038 159899.9n 1.31038 159900.0n 0.68861 160029.9n 0.68861 160030.0n 0.72924 160159.9n 0.72924 160160.0n 0.72357 160289.9n 0.72357 160290.0n 0.64370 160419.9n 0.64370 160420.0n 0.47921 160549.9n 0.47921 160550.0n 0.44934 160679.9n 0.44934 160680.0n 0.43551 160809.9n 0.43551 160810.0n -0.07007 160939.9n -0.07007 160940.0n 0.30498 161069.9n 0.30498 161070.0n 0.46859 161199.9n 0.46859 161200.0n 0.03541 161329.9n 0.03541 161330.0n 1.14927 161459.9n 1.14927 161460.0n 0.44994 161589.9n 0.44994 161590.0n 0.30031 161719.9n 0.30031 161720.0n 0.78502 161849.9n 0.78502 161850.0n 0.52444 161979.9n 0.52444 161980.0n 0.29315 162109.9n 0.29315 162110.0n 1.04662 162239.9n 1.04662 162240.0n 0.51492 162369.9n 0.51492 162370.0n 0.13970 162499.9n 0.13970 162500.0n 0.42258 162629.9n 0.42258 162630.0n 0.20713 162759.9n 0.20713 162760.0n 0.39910 162889.9n 0.39910 162890.0n 0.76629 163019.9n 0.76629 163020.0n 0.87516 163149.9n 0.87516 163150.0n 0.51649 163279.9n 0.51649 163280.0n 0.47728 163409.9n 0.47728 163410.0n 0.89579 163539.9n 0.89579 163540.0n 0.73813 163669.9n 0.73813 163670.0n 0.73007 163799.9n 0.73007 163800.0n 0.38805 163929.9n 0.38805 163930.0n 0.44565 164059.9n 0.44565 164060.0n 0.84972 164189.9n 0.84972 164190.0n 0.31374 164319.9n 0.31374 164320.0n 0.53500 164449.9n 0.53500 164450.0n 0.65381 164579.9n 0.65381 164580.0n 0.58828 164709.9n 0.58828 164710.0n 0.29293 164839.9n 0.29293 164840.0n 0.34864 164969.9n 0.34864 164970.0n 0.39919 165099.9n 0.39919 165100.0n 0.28504 165229.9n 0.28504 165230.0n 0.90918 165359.9n 0.90918 165360.0n -0.38855 165489.9n -0.38855 165490.0n -0.21890 165619.9n -0.21890 165620.0n -0.28851 165749.9n -0.28851 165750.0n -0.24585 165879.9n -0.24585 165880.0n 1.15208 166009.9n 1.15208 166010.0n 0.41841 166139.9n 0.41841 166140.0n 0.24338 166269.9n 0.24338 166270.0n 1.49277 166399.9n 1.49277 166400.0n 1.19260 166529.9n 1.19260 166530.0n -0.27962 166659.9n -0.27962 166660.0n 0.55733 166789.9n 0.55733 166790.0n 0.95600 166919.9n 0.95600 166920.0n -0.04710 167049.9n -0.04710 167050.0n 0.80242 167179.9n 0.80242 167180.0n 0.39736 167309.9n 0.39736 167310.0n 1.04029 167439.9n 1.04029 167440.0n 0.63149 167569.9n 0.63149 167570.0n 0.81752 167699.9n 0.81752 167700.0n 1.19808 167829.9n 1.19808 167830.0n 1.39872 167959.9n 1.39872 167960.0n 0.28119 168089.9n 0.28119 168090.0n 1.46004 168219.9n 1.46004 168220.0n -0.19303 168349.9n -0.19303 168350.0n 0.93542)
Vxp1 a_xp1 0 PWL(0.0n 0.25911 129.9n 0.25911 130.0n 1.23180 259.9n 1.23180 260.0n 0.76415 389.9n 0.76415 390.0n 1.11225 519.9n 1.11225 520.0n -0.15161 649.9n -0.15161 650.0n 0.23835 779.9n 0.23835 780.0n 0.33171 909.9n 0.33171 910.0n 0.70122 1039.9n 0.70122 1040.0n 0.65842 1169.9n 0.65842 1170.0n -0.33158 1299.9n -0.33158 1300.0n 0.67130 1429.9n 0.67130 1430.0n 0.13226 1559.9n 0.13226 1560.0n -0.21828 1689.9n -0.21828 1690.0n 0.66096 1819.9n 0.66096 1820.0n 0.63482 1949.9n 0.63482 1950.0n -0.37792 2079.9n -0.37792 2080.0n 0.28700 2209.9n 0.28700 2210.0n 0.42554 2339.9n 0.42554 2340.0n 0.28189 2469.9n 0.28189 2470.0n 1.17517 2599.9n 1.17517 2600.0n 1.27694 2729.9n 1.27694 2730.0n 1.18224 2859.9n 1.18224 2860.0n 0.48458 2989.9n 0.48458 2990.0n 0.56595 3119.9n 0.56595 3120.0n 0.34013 3249.9n 0.34013 3250.0n -0.08309 3379.9n -0.08309 3380.0n -0.23386 3509.9n -0.23386 3510.0n 1.28574 3639.9n 1.28574 3640.0n 0.28700 3769.9n 0.28700 3770.0n 0.76415 3899.9n 0.76415 3900.0n 1.18224 4029.9n 1.18224 4030.0n 1.27694 4159.9n 1.27694 4160.0n 1.23180 4289.9n 1.23180 4290.0n 0.63482 4419.9n 0.63482 4420.0n 0.25911 4549.9n 0.25911 4550.0n 1.17517 4679.9n 1.17517 4680.0n 0.34013 4809.9n 0.34013 4810.0n 0.66096 4939.9n 0.66096 4940.0n 1.11225 5069.9n 1.11225 5070.0n 0.42554 5199.9n 0.42554 5200.0n 0.28189 5329.9n 0.28189 5330.0n 0.23835 5459.9n 0.23835 5460.0n 0.13226 5589.9n 0.13226 5590.0n -0.21828 5719.9n -0.21828 5720.0n 0.48458 5849.9n 0.48458 5850.0n 1.28574 5979.9n 1.28574 5980.0n -0.33158 6109.9n -0.33158 6110.0n 0.65842 6239.9n 0.65842 6240.0n -0.15161 6369.9n -0.15161 6370.0n 0.56595 6499.9n 0.56595 6500.0n -0.37792 6629.9n -0.37792 6630.0n 0.67130 6759.9n 0.67130 6760.0n -0.08309 6889.9n -0.08309 6890.0n 0.33171 7019.9n 0.33171 7020.0n -0.23386 7149.9n -0.23386 7150.0n 0.70122 7279.9n 0.70122 7280.0n 1.11225 7409.9n 1.11225 7410.0n 1.18224 7539.9n 1.18224 7540.0n -0.21828 7669.9n -0.21828 7670.0n 0.70122 7799.9n 0.70122 7800.0n -0.08309 7929.9n -0.08309 7930.0n -0.33158 8059.9n -0.33158 8060.0n 0.28700 8189.9n 0.28700 8190.0n 1.28574 8319.9n 1.28574 8320.0n 0.66096 8449.9n 0.66096 8450.0n 1.17517 8579.9n 1.17517 8580.0n 0.48458 8709.9n 0.48458 8710.0n 0.33171 8839.9n 0.33171 8840.0n 0.63482 8969.9n 0.63482 8970.0n -0.23386 9099.9n -0.23386 9100.0n 0.42554 9229.9n 0.42554 9230.0n 0.13226 9359.9n 0.13226 9360.0n 1.27694 9489.9n 1.27694 9490.0n -0.37792 9619.9n -0.37792 9620.0n 0.56595 9749.9n 0.56595 9750.0n 0.65842 9879.9n 0.65842 9880.0n 0.25911 10009.9n 0.25911 10010.0n 0.67130 10139.9n 0.67130 10140.0n 1.23180 10269.9n 1.23180 10270.0n 0.23835 10399.9n 0.23835 10400.0n 0.76415 10529.9n 0.76415 10530.0n 0.28189 10659.9n 0.28189 10660.0n -0.15161 10789.9n -0.15161 10790.0n 0.34013 10919.9n 0.34013 10920.0n 0.33171 11049.9n 0.33171 11050.0n 1.28574 11179.9n 1.28574 11180.0n 1.11225 11309.9n 1.11225 11310.0n 0.66096 11439.9n 0.66096 11440.0n 0.34013 11569.9n 0.34013 11570.0n 0.25911 11699.9n 0.25911 11700.0n 0.48458 11829.9n 0.48458 11830.0n -0.23386 11959.9n -0.23386 11960.0n 0.76415 12089.9n 0.76415 12090.0n 1.27694 12219.9n 1.27694 12220.0n 0.56595 12349.9n 0.56595 12350.0n 0.65842 12479.9n 0.65842 12480.0n -0.08309 12609.9n -0.08309 12610.0n 0.63482 12739.9n 0.63482 12740.0n 0.23835 12869.9n 0.23835 12870.0n 0.42554 12999.9n 0.42554 13000.0n 0.28700 13129.9n 0.28700 13130.0n -0.33158 13259.9n -0.33158 13260.0n -0.21828 13389.9n -0.21828 13390.0n 0.67130 13519.9n 0.67130 13520.0n 0.13226 13649.9n 0.13226 13650.0n 0.70122 13779.9n 0.70122 13780.0n 1.17517 13909.9n 1.17517 13910.0n 1.18224 14039.9n 1.18224 14040.0n 0.28189 14169.9n 0.28189 14170.0n 1.23180 14299.9n 1.23180 14300.0n -0.15161 14429.9n -0.15161 14430.0n -0.37792 14559.9n -0.37792 14560.0n 0.28700 14689.9n 0.28700 14690.0n 0.67130 14819.9n 0.67130 14820.0n -0.08309 14949.9n -0.08309 14950.0n 0.23835 15079.9n 0.23835 15080.0n -0.37792 15209.9n -0.37792 15210.0n -0.23386 15339.9n -0.23386 15340.0n -0.21828 15469.9n -0.21828 15470.0n 1.23180 15599.9n 1.23180 15600.0n 1.27694 15729.9n 1.27694 15730.0n 0.28189 15859.9n 0.28189 15860.0n 1.18224 15989.9n 1.18224 15990.0n 0.25911 16119.9n 0.25911 16120.0n 1.28574 16249.9n 1.28574 16250.0n 1.11225 16379.9n 1.11225 16380.0n 0.70122 16509.9n 0.70122 16510.0n 0.34013 16639.9n 0.34013 16640.0n 0.63482 16769.9n 0.63482 16770.0n -0.15161 16899.9n -0.15161 16900.0n 0.13226 17029.9n 0.13226 17030.0n 0.48458 17159.9n 0.48458 17160.0n 0.56595 17289.9n 0.56595 17290.0n 0.42554 17419.9n 0.42554 17420.0n 0.66096 17549.9n 0.66096 17550.0n 1.17517 17679.9n 1.17517 17680.0n 0.76415 17809.9n 0.76415 17810.0n 0.33171 17939.9n 0.33171 17940.0n -0.33158 18069.9n -0.33158 18070.0n 0.65842 18199.9n 0.65842 18200.0n 0.25911 18329.9n 0.25911 18330.0n 1.11225 18459.9n 1.11225 18460.0n 0.23835 18589.9n 0.23835 18590.0n 0.56595 18719.9n 0.56595 18720.0n 0.33171 18849.9n 0.33171 18850.0n 0.63482 18979.9n 0.63482 18980.0n -0.21828 19109.9n -0.21828 19110.0n -0.08309 19239.9n -0.08309 19240.0n 1.17517 19369.9n 1.17517 19370.0n 0.48458 19499.9n 0.48458 19500.0n 0.28189 19629.9n 0.28189 19630.0n 1.28574 19759.9n 1.28574 19760.0n -0.37792 19889.9n -0.37792 19890.0n 0.67130 20019.9n 0.67130 20020.0n -0.15161 20149.9n -0.15161 20150.0n 1.23180 20279.9n 1.23180 20280.0n 0.66096 20409.9n 0.66096 20410.0n -0.23386 20539.9n -0.23386 20540.0n 0.70122 20669.9n 0.70122 20670.0n -0.33158 20799.9n -0.33158 20800.0n 0.28700 20929.9n 0.28700 20930.0n 1.27694 21059.9n 1.27694 21060.0n 0.34013 21189.9n 0.34013 21190.0n 1.18224 21319.9n 1.18224 21320.0n 0.76415 21449.9n 0.76415 21450.0n 0.42554 21579.9n 0.42554 21580.0n 0.13226 21709.9n 0.13226 21710.0n 0.65842 21839.9n 0.65842 21840.0n 0.29915 21969.9n 0.29915 21970.0n 0.40313 22099.9n 0.40313 22100.0n 0.36576 22229.9n 0.36576 22230.0n 0.33730 22359.9n 0.33730 22360.0n 0.38385 22489.9n 0.38385 22490.0n 0.59706 22619.9n 0.59706 22620.0n 0.62307 22749.9n 0.62307 22750.0n 0.67018 22879.9n 0.67018 22880.0n 0.70540 23009.9n 0.70540 23010.0n 0.53582 23139.9n 0.53582 23140.0n 0.33357 23269.9n 0.33357 23270.0n 0.52885 23399.9n 0.52885 23400.0n 0.74383 23529.9n 0.74383 23530.0n 0.78409 23659.9n 0.78409 23660.0n 0.51936 23789.9n 0.51936 23790.0n 0.50532 23919.9n 0.50532 23920.0n 0.68189 24049.9n 0.68189 24050.0n 0.79862 24179.9n 0.79862 24180.0n 0.35050 24309.9n 0.35050 24310.0n 0.16858 24439.9n 0.16858 24440.0n 0.55253 24569.9n 0.55253 24570.0n 0.60823 24699.9n 0.60823 24700.0n 0.63611 24829.9n 0.63611 24830.0n 0.41197 24959.9n 0.41197 24960.0n 0.59247 25089.9n 0.59247 25090.0n 1.20712 25219.9n 1.20712 25220.0n 0.87402 25349.9n 0.87402 25350.0n -0.10545 25479.9n -0.10545 25480.0n -0.25282 25609.9n -0.25282 25610.0n -0.37666 25739.9n -0.37666 25740.0n 1.43391 25869.9n 1.43391 25870.0n 0.37511 25999.9n 0.37511 26000.0n 0.35780 26129.9n 0.35780 26130.0n 1.04281 26259.9n 1.04281 26260.0n 1.30757 26389.9n 1.30757 26390.0n -0.27950 26519.9n -0.27950 26520.0n 0.10137 26649.9n 0.10137 26650.0n 1.20727 26779.9n 1.20727 26780.0n 1.40210 26909.9n 1.40210 26910.0n 1.03003 27039.9n 1.03003 27040.0n -0.27250 27169.9n -0.27250 27170.0n -0.24444 27299.9n -0.24444 27300.0n 0.81835 27429.9n 0.81835 27430.0n 0.11792 27559.9n 0.11792 27560.0n -0.41822 27689.9n -0.41822 27690.0n 0.75242 27819.9n 0.75242 27820.0n 0.57354 27949.9n 0.57354 27950.0n 1.22124 28079.9n 1.22124 28080.0n 0.63482 28209.9n 0.63482 28210.0n 0.56595 28339.9n 0.56595 28340.0n -0.15161 28469.9n -0.15161 28470.0n 1.27694 28599.9n 1.27694 28600.0n -0.21828 28729.9n -0.21828 28730.0n 1.23180 28859.9n 1.23180 28860.0n -0.23386 28989.9n -0.23386 28990.0n 0.65842 29119.9n 0.65842 29120.0n 0.66096 29249.9n 0.66096 29250.0n 0.48458 29379.9n 0.48458 29380.0n 0.67130 29509.9n 0.67130 29510.0n 1.11225 29639.9n 1.11225 29640.0n 0.70122 29769.9n 0.70122 29770.0n -0.08309 29899.9n -0.08309 29900.0n 0.25911 30029.9n 0.25911 30030.0n -0.33158 30159.9n -0.33158 30160.0n 0.28700 30289.9n 0.28700 30290.0n -0.37792 30419.9n -0.37792 30420.0n 0.13226 30549.9n 0.13226 30550.0n 1.28574 30679.9n 1.28574 30680.0n 1.18224 30809.9n 1.18224 30810.0n 1.17517 30939.9n 1.17517 30940.0n 0.76415 31069.9n 0.76415 31070.0n 0.33171 31199.9n 0.33171 31200.0n 0.28189 31329.9n 0.28189 31330.0n 0.34013 31459.9n 0.34013 31460.0n 0.42554 31589.9n 0.42554 31590.0n 0.23835 31719.9n 0.23835 31720.0n -0.23386 31849.9n -0.23386 31850.0n 0.66096 31979.9n 0.66096 31980.0n 0.13226 32109.9n 0.13226 32110.0n -0.15161 32239.9n -0.15161 32240.0n 0.34013 32369.9n 0.34013 32370.0n 0.63482 32499.9n 0.63482 32500.0n 0.65842 32629.9n 0.65842 32630.0n 0.28189 32759.9n 0.28189 32760.0n 0.76415 32889.9n 0.76415 32890.0n 0.25911 33019.9n 0.25911 33020.0n 0.56595 33149.9n 0.56595 33150.0n 1.17517 33279.9n 1.17517 33280.0n -0.08309 33409.9n -0.08309 33410.0n 0.70122 33539.9n 0.70122 33540.0n 0.42554 33669.9n 0.42554 33670.0n 0.28700 33799.9n 0.28700 33800.0n 0.23835 33929.9n 0.23835 33930.0n 1.28574 34059.9n 1.28574 34060.0n 1.27694 34189.9n 1.27694 34190.0n -0.33158 34319.9n -0.33158 34320.0n -0.21828 34449.9n -0.21828 34450.0n 0.67130 34579.9n 0.67130 34580.0n 1.11225 34709.9n 1.11225 34710.0n 1.18224 34839.9n 1.18224 34840.0n 0.48458 34969.9n 0.48458 34970.0n 1.23180 35099.9n 1.23180 35100.0n 0.33171 35229.9n 0.33171 35230.0n -0.37792 35359.9n -0.37792 35360.0n 0.65842 35489.9n 0.65842 35490.0n 0.28700 35619.9n 0.28700 35620.0n -0.21828 35749.9n -0.21828 35750.0n 0.28189 35879.9n 0.28189 35880.0n 1.17517 36009.9n 1.17517 36010.0n 1.18224 36139.9n 1.18224 36140.0n 0.76415 36269.9n 0.76415 36270.0n 0.34013 36399.9n 0.34013 36400.0n 0.56595 36529.9n 0.56595 36530.0n 0.42554 36659.9n 0.42554 36660.0n -0.23386 36789.9n -0.23386 36790.0n 1.27694 36919.9n 1.27694 36920.0n -0.37792 37049.9n -0.37792 37050.0n 0.70122 37179.9n 0.70122 37180.0n 1.23180 37309.9n 1.23180 37310.0n 1.11225 37439.9n 1.11225 37440.0n 0.13226 37569.9n 0.13226 37570.0n -0.08309 37699.9n -0.08309 37700.0n 0.23835 37829.9n 0.23835 37830.0n 0.33171 37959.9n 0.33171 37960.0n 0.63482 38089.9n 0.63482 38090.0n 0.48458 38219.9n 0.48458 38220.0n 1.28574 38349.9n 1.28574 38350.0n -0.33158 38479.9n -0.33158 38480.0n 0.67130 38609.9n 0.67130 38610.0n 0.66096 38739.9n 0.66096 38740.0n -0.15161 38869.9n -0.15161 38870.0n 0.25911 38999.9n 0.25911 39000.0n -0.33158 39129.9n -0.33158 39130.0n 1.28574 39259.9n 1.28574 39260.0n -0.21828 39389.9n -0.21828 39390.0n -0.23386 39519.9n -0.23386 39520.0n 0.76415 39649.9n 0.76415 39650.0n -0.15161 39779.9n -0.15161 39780.0n 0.28189 39909.9n 0.28189 39910.0n 0.23835 40039.9n 0.23835 40040.0n 0.63482 40169.9n 0.63482 40170.0n 0.70122 40299.9n 0.70122 40300.0n 0.33171 40429.9n 0.33171 40430.0n 0.28700 40559.9n 0.28700 40560.0n 1.23180 40689.9n 1.23180 40690.0n 0.42554 40819.9n 0.42554 40820.0n 0.13226 40949.9n 0.13226 40950.0n 0.48458 41079.9n 0.48458 41080.0n -0.08309 41209.9n -0.08309 41210.0n 1.18224 41339.9n 1.18224 41340.0n 0.25911 41469.9n 0.25911 41470.0n 0.65842 41599.9n 0.65842 41600.0n 0.67130 41729.9n 0.67130 41730.0n 1.17517 41859.9n 1.17517 41860.0n 0.34013 41989.9n 0.34013 41990.0n 0.66096 42119.9n 0.66096 42120.0n 1.27694 42249.9n 1.27694 42250.0n -0.37792 42379.9n -0.37792 42380.0n 0.56595 42509.9n 0.56595 42510.0n 1.11225 42639.9n 1.11225 42640.0n 1.27694 42769.9n 1.27694 42770.0n 0.70122 42899.9n 0.70122 42900.0n 0.34013 43029.9n 0.34013 43030.0n 0.42554 43159.9n 0.42554 43160.0n 0.28189 43289.9n 0.28189 43290.0n 0.25911 43419.9n 0.25911 43420.0n 0.33171 43549.9n 0.33171 43550.0n -0.23386 43679.9n -0.23386 43680.0n 1.11225 43809.9n 1.11225 43810.0n 0.67130 43939.9n 0.67130 43940.0n 0.56595 44069.9n 0.56595 44070.0n 1.23180 44199.9n 1.23180 44200.0n 0.76415 44329.9n 0.76415 44330.0n 1.28574 44459.9n 1.28574 44460.0n 0.28700 44589.9n 0.28700 44590.0n -0.21828 44719.9n -0.21828 44720.0n 0.63482 44849.9n 0.63482 44850.0n 0.65842 44979.9n 0.65842 44980.0n 1.18224 45109.9n 1.18224 45110.0n -0.15161 45239.9n -0.15161 45240.0n -0.08309 45369.9n -0.08309 45370.0n -0.33158 45499.9n -0.33158 45500.0n 0.66096 45629.9n 0.66096 45630.0n 0.48458 45759.9n 0.48458 45760.0n 1.17517 45889.9n 1.17517 45890.0n 0.13226 46019.9n 0.13226 46020.0n 0.23835 46149.9n 0.23835 46150.0n -0.37792 46279.9n -0.37792 46280.0n 1.23180 46409.9n 1.23180 46410.0n 0.28189 46539.9n 0.28189 46540.0n 0.34013 46669.9n 0.34013 46670.0n 0.48458 46799.9n 0.48458 46800.0n 0.56595 46929.9n 0.56595 46930.0n 0.66096 47059.9n 0.66096 47060.0n 1.11225 47189.9n 1.11225 47190.0n 1.27694 47319.9n 1.27694 47320.0n -0.08309 47449.9n -0.08309 47450.0n -0.23386 47579.9n -0.23386 47580.0n -0.21828 47709.9n -0.21828 47710.0n 0.33171 47839.9n 0.33171 47840.0n 0.70122 47969.9n 0.70122 47970.0n 0.25911 48099.9n 0.25911 48100.0n 0.13226 48229.9n 0.13226 48230.0n 0.65842 48359.9n 0.65842 48360.0n 0.63482 48489.9n 0.63482 48490.0n -0.33158 48619.9n -0.33158 48620.0n 0.76415 48749.9n 0.76415 48750.0n -0.15161 48879.9n -0.15161 48880.0n 0.28700 49009.9n 0.28700 49010.0n 0.23835 49139.9n 0.23835 49140.0n -0.37792 49269.9n -0.37792 49270.0n 1.18224 49399.9n 1.18224 49400.0n 0.67130 49529.9n 0.67130 49530.0n 0.42554 49659.9n 0.42554 49660.0n 1.28574 49789.9n 1.28574 49790.0n 1.17517 49919.9n 1.17517 49920.0n 0.29915 50049.9n 0.29915 50050.0n 0.40313 50179.9n 0.40313 50180.0n 0.36576 50309.9n 0.36576 50310.0n 0.33730 50439.9n 0.33730 50440.0n 0.38385 50569.9n 0.38385 50570.0n 0.59706 50699.9n 0.59706 50700.0n 0.62307 50829.9n 0.62307 50830.0n 0.67018 50959.9n 0.67018 50960.0n 0.70540 51089.9n 0.70540 51090.0n 0.53582 51219.9n 0.53582 51220.0n 0.33357 51349.9n 0.33357 51350.0n 0.52885 51479.9n 0.52885 51480.0n 0.74383 51609.9n 0.74383 51610.0n 0.78409 51739.9n 0.78409 51740.0n 0.51936 51869.9n 0.51936 51870.0n 0.50532 51999.9n 0.50532 52000.0n 0.68189 52129.9n 0.68189 52130.0n 0.79862 52259.9n 0.79862 52260.0n 0.35050 52389.9n 0.35050 52390.0n 0.16858 52519.9n 0.16858 52520.0n 0.55253 52649.9n 0.55253 52650.0n 0.60823 52779.9n 0.60823 52780.0n 0.63611 52909.9n 0.63611 52910.0n 0.41197 53039.9n 0.41197 53040.0n 0.59247 53169.9n 0.59247 53170.0n 1.20712 53299.9n 1.20712 53300.0n 0.87402 53429.9n 0.87402 53430.0n -0.10545 53559.9n -0.10545 53560.0n -0.25282 53689.9n -0.25282 53690.0n -0.37666 53819.9n -0.37666 53820.0n 1.43391 53949.9n 1.43391 53950.0n 0.37511 54079.9n 0.37511 54080.0n 0.35780 54209.9n 0.35780 54210.0n 1.04281 54339.9n 1.04281 54340.0n 1.30757 54469.9n 1.30757 54470.0n -0.27950 54599.9n -0.27950 54600.0n 0.10137 54729.9n 0.10137 54730.0n 1.20727 54859.9n 1.20727 54860.0n 1.40210 54989.9n 1.40210 54990.0n 1.03003 55119.9n 1.03003 55120.0n -0.27250 55249.9n -0.27250 55250.0n -0.24444 55379.9n -0.24444 55380.0n 0.81835 55509.9n 0.81835 55510.0n 0.11792 55639.9n 0.11792 55640.0n -0.41822 55769.9n -0.41822 55770.0n 0.75242 55899.9n 0.75242 55900.0n 0.57354 56029.9n 0.57354 56030.0n 1.22124 56159.9n 1.22124 56160.0n 0.65842 56289.9n 0.65842 56290.0n 1.11225 56419.9n 1.11225 56420.0n -0.23386 56549.9n -0.23386 56550.0n 0.28700 56679.9n 0.28700 56680.0n 0.56595 56809.9n 0.56595 56810.0n 0.13226 56939.9n 0.13226 56940.0n -0.37792 57069.9n -0.37792 57070.0n -0.08309 57199.9n -0.08309 57200.0n 1.27694 57329.9n 1.27694 57330.0n 0.63482 57459.9n 0.63482 57460.0n 0.76415 57589.9n 0.76415 57590.0n 0.70122 57719.9n 0.70122 57720.0n 0.34013 57849.9n 0.34013 57850.0n 0.48458 57979.9n 0.48458 57980.0n 0.28189 58109.9n 0.28189 58110.0n 0.42554 58239.9n 0.42554 58240.0n -0.21828 58369.9n -0.21828 58370.0n 1.28574 58499.9n 1.28574 58500.0n -0.15161 58629.9n -0.15161 58630.0n 1.18224 58759.9n 1.18224 58760.0n 1.17517 58889.9n 1.17517 58890.0n 0.67130 59019.9n 0.67130 59020.0n 0.25911 59149.9n 0.25911 59150.0n 0.33171 59279.9n 0.33171 59280.0n 0.23835 59409.9n 0.23835 59410.0n -0.33158 59539.9n -0.33158 59540.0n 0.66096 59669.9n 0.66096 59670.0n 1.23180 59799.9n 1.23180 59800.0n 0.23835 59929.9n 0.23835 59930.0n 0.28189 60059.9n 0.28189 60060.0n 1.18224 60189.9n 1.18224 60190.0n 0.65842 60319.9n 0.65842 60320.0n 0.34013 60449.9n 0.34013 60450.0n 0.28700 60579.9n 0.28700 60580.0n -0.15161 60709.9n -0.15161 60710.0n 0.70122 60839.9n 0.70122 60840.0n -0.37792 60969.9n -0.37792 60970.0n -0.23386 61099.9n -0.23386 61100.0n 0.42554 61229.9n 0.42554 61230.0n 1.23180 61359.9n 1.23180 61360.0n 0.63482 61489.9n 0.63482 61490.0n 1.27694 61619.9n 1.27694 61620.0n -0.08309 61749.9n -0.08309 61750.0n 0.56595 61879.9n 0.56595 61880.0n 0.66096 62009.9n 0.66096 62010.0n 1.28574 62139.9n 1.28574 62140.0n 0.67130 62269.9n 0.67130 62270.0n 0.13226 62399.9n 0.13226 62400.0n 0.33171 62529.9n 0.33171 62530.0n 0.48458 62659.9n 0.48458 62660.0n 0.25911 62789.9n 0.25911 62790.0n -0.21828 62919.9n -0.21828 62920.0n 1.11225 63049.9n 1.11225 63050.0n -0.33158 63179.9n -0.33158 63180.0n 1.17517 63309.9n 1.17517 63310.0n 0.76415 63439.9n 0.76415 63440.0n 0.13226 63569.9n 0.13226 63570.0n 0.65842 63699.9n 0.65842 63700.0n 0.25911 63829.9n 0.25911 63830.0n 0.28700 63959.9n 0.28700 63960.0n -0.08309 64089.9n -0.08309 64090.0n 0.23835 64219.9n 0.23835 64220.0n 1.18224 64349.9n 1.18224 64350.0n 1.11225 64479.9n 1.11225 64480.0n 0.56595 64609.9n 0.56595 64610.0n 1.27694 64739.9n 1.27694 64740.0n -0.37792 64869.9n -0.37792 64870.0n 0.28189 64999.9n 0.28189 65000.0n 1.23180 65129.9n 1.23180 65130.0n -0.15161 65259.9n -0.15161 65260.0n 1.17517 65389.9n 1.17517 65390.0n 1.28574 65519.9n 1.28574 65520.0n 0.48458 65649.9n 0.48458 65650.0n 0.63482 65779.9n 0.63482 65780.0n 0.34013 65909.9n 0.34013 65910.0n -0.33158 66039.9n -0.33158 66040.0n 0.33171 66169.9n 0.33171 66170.0n 0.67130 66299.9n 0.67130 66300.0n 0.66096 66429.9n 0.66096 66430.0n 0.70122 66559.9n 0.70122 66560.0n -0.23386 66689.9n -0.23386 66690.0n 0.76415 66819.9n 0.76415 66820.0n -0.21828 66949.9n -0.21828 66950.0n 0.42554 67079.9n 0.42554 67080.0n 1.18224 67209.9n 1.18224 67210.0n 0.63482 67339.9n 0.63482 67340.0n 1.17517 67469.9n 1.17517 67470.0n 1.23180 67599.9n 1.23180 67600.0n 0.48458 67729.9n 0.48458 67730.0n -0.21828 67859.9n -0.21828 67860.0n 0.33171 67989.9n 0.33171 67990.0n 0.67130 68119.9n 0.67130 68120.0n 0.66096 68249.9n 0.66096 68250.0n 1.27694 68379.9n 1.27694 68380.0n -0.08309 68509.9n -0.08309 68510.0n 0.76415 68639.9n 0.76415 68640.0n 0.42554 68769.9n 0.42554 68770.0n 0.13226 68899.9n 0.13226 68900.0n -0.15161 69029.9n -0.15161 69030.0n 0.70122 69159.9n 0.70122 69160.0n 1.11225 69289.9n 1.11225 69290.0n 0.25911 69419.9n 0.25911 69420.0n -0.23386 69549.9n -0.23386 69550.0n 0.65842 69679.9n 0.65842 69680.0n 0.23835 69809.9n 0.23835 69810.0n -0.37792 69939.9n -0.37792 69940.0n 0.28189 70069.9n 0.28189 70070.0n 1.28574 70199.9n 1.28574 70200.0n 0.28700 70329.9n 0.28700 70330.0n -0.33158 70459.9n -0.33158 70460.0n 0.34013 70589.9n 0.34013 70590.0n 0.56595 70719.9n 0.56595 70720.0n -0.21828 70849.9n -0.21828 70850.0n 1.23180 70979.9n 1.23180 70980.0n 0.76415 71109.9n 0.76415 71110.0n 0.33171 71239.9n 0.33171 71240.0n 0.56595 71369.9n 0.56595 71370.0n 0.42554 71499.9n 0.42554 71500.0n 0.67130 71629.9n 0.67130 71630.0n 1.18224 71759.9n 1.18224 71760.0n -0.37792 71889.9n -0.37792 71890.0n -0.33158 72019.9n -0.33158 72020.0n 1.28574 72149.9n 1.28574 72150.0n 0.25911 72279.9n 0.25911 72280.0n 0.28700 72409.9n 0.28700 72410.0n 0.34013 72539.9n 0.34013 72540.0n -0.15161 72669.9n -0.15161 72670.0n 0.63482 72799.9n 0.63482 72800.0n 0.13226 72929.9n 0.13226 72930.0n 0.23835 73059.9n 0.23835 73060.0n 0.65842 73189.9n 0.65842 73190.0n 0.28189 73319.9n 0.28189 73320.0n 1.11225 73449.9n 1.11225 73450.0n -0.23386 73579.9n -0.23386 73580.0n 0.66096 73709.9n 0.66096 73710.0n -0.08309 73839.9n -0.08309 73840.0n 0.48458 73969.9n 0.48458 73970.0n 1.27694 74099.9n 1.27694 74100.0n 1.17517 74229.9n 1.17517 74230.0n 0.70122 74359.9n 0.70122 74360.0n 0.33171 74489.9n 0.33171 74490.0n 0.48458 74619.9n 0.48458 74620.0n 1.18224 74749.9n 1.18224 74750.0n -0.33158 74879.9n -0.33158 74880.0n 1.28574 75009.9n 1.28574 75010.0n 0.42554 75139.9n 0.42554 75140.0n 1.23180 75269.9n 1.23180 75270.0n 1.27694 75399.9n 1.27694 75400.0n 0.25911 75529.9n 0.25911 75530.0n -0.21828 75659.9n -0.21828 75660.0n -0.08309 75789.9n -0.08309 75790.0n 0.34013 75919.9n 0.34013 75920.0n -0.23386 76049.9n -0.23386 76050.0n 0.28700 76179.9n 0.28700 76180.0n 0.70122 76309.9n 0.70122 76310.0n 1.11225 76439.9n 1.11225 76440.0n -0.37792 76569.9n -0.37792 76570.0n 1.17517 76699.9n 1.17517 76700.0n -0.15161 76829.9n -0.15161 76830.0n 0.63482 76959.9n 0.63482 76960.0n 0.23835 77089.9n 0.23835 77090.0n 0.76415 77219.9n 0.76415 77220.0n 0.67130 77349.9n 0.67130 77350.0n 0.28189 77479.9n 0.28189 77480.0n 0.56595 77609.9n 0.56595 77610.0n 0.13226 77739.9n 0.13226 77740.0n 0.65842 77869.9n 0.65842 77870.0n 0.66096 77999.9n 0.66096 78000.0n 0.29915 78129.9n 0.29915 78130.0n 0.40313 78259.9n 0.40313 78260.0n 0.36576 78389.9n 0.36576 78390.0n 0.33730 78519.9n 0.33730 78520.0n 0.38385 78649.9n 0.38385 78650.0n 0.59706 78779.9n 0.59706 78780.0n 0.62307 78909.9n 0.62307 78910.0n 0.67018 79039.9n 0.67018 79040.0n 0.70540 79169.9n 0.70540 79170.0n 0.53582 79299.9n 0.53582 79300.0n 0.33357 79429.9n 0.33357 79430.0n 0.52885 79559.9n 0.52885 79560.0n 0.74383 79689.9n 0.74383 79690.0n 0.78409 79819.9n 0.78409 79820.0n 0.51936 79949.9n 0.51936 79950.0n 0.50532 80079.9n 0.50532 80080.0n 0.68189 80209.9n 0.68189 80210.0n 0.79862 80339.9n 0.79862 80340.0n 0.35050 80469.9n 0.35050 80470.0n 0.16858 80599.9n 0.16858 80600.0n 0.55253 80729.9n 0.55253 80730.0n 0.60823 80859.9n 0.60823 80860.0n 0.63611 80989.9n 0.63611 80990.0n 0.41197 81119.9n 0.41197 81120.0n 0.59247 81249.9n 0.59247 81250.0n 1.20712 81379.9n 1.20712 81380.0n 0.87402 81509.9n 0.87402 81510.0n -0.10545 81639.9n -0.10545 81640.0n -0.25282 81769.9n -0.25282 81770.0n -0.37666 81899.9n -0.37666 81900.0n 1.43391 82029.9n 1.43391 82030.0n 0.37511 82159.9n 0.37511 82160.0n 0.35780 82289.9n 0.35780 82290.0n 1.04281 82419.9n 1.04281 82420.0n 1.30757 82549.9n 1.30757 82550.0n -0.27950 82679.9n -0.27950 82680.0n 0.10137 82809.9n 0.10137 82810.0n 1.20727 82939.9n 1.20727 82940.0n 1.40210 83069.9n 1.40210 83070.0n 1.03003 83199.9n 1.03003 83200.0n -0.27250 83329.9n -0.27250 83330.0n -0.24444 83459.9n -0.24444 83460.0n 0.81835 83589.9n 0.81835 83590.0n 0.11792 83719.9n 0.11792 83720.0n -0.41822 83849.9n -0.41822 83850.0n 0.75242 83979.9n 0.75242 83980.0n 0.57354 84109.9n 0.57354 84110.0n 1.22124 84239.9n 1.22124 84240.0n 1.11225 84369.9n 1.11225 84370.0n 0.66096 84499.9n 0.66096 84500.0n 0.48458 84629.9n 0.48458 84630.0n 0.70122 84759.9n 0.70122 84760.0n 0.63482 84889.9n 0.63482 84890.0n 0.34013 85019.9n 0.34013 85020.0n 1.23180 85149.9n 1.23180 85150.0n -0.08309 85279.9n -0.08309 85280.0n -0.33158 85409.9n -0.33158 85410.0n 0.42554 85539.9n 0.42554 85540.0n -0.21828 85669.9n -0.21828 85670.0n 1.28574 85799.9n 1.28574 85800.0n 1.27694 85929.9n 1.27694 85930.0n 1.17517 86059.9n 1.17517 86060.0n 0.25911 86189.9n 0.25911 86190.0n 1.18224 86319.9n 1.18224 86320.0n 0.33171 86449.9n 0.33171 86450.0n -0.37792 86579.9n -0.37792 86580.0n 0.65842 86709.9n 0.65842 86710.0n 0.67130 86839.9n 0.67130 86840.0n 0.23835 86969.9n 0.23835 86970.0n -0.23386 87099.9n -0.23386 87100.0n 0.28189 87229.9n 0.28189 87230.0n 0.76415 87359.9n 0.76415 87360.0n 0.13226 87489.9n 0.13226 87490.0n 0.28700 87619.9n 0.28700 87620.0n -0.15161 87749.9n -0.15161 87750.0n 0.56595 87879.9n 0.56595 87880.0n 1.28574 88009.9n 1.28574 88010.0n 0.76415 88139.9n 0.76415 88140.0n -0.37792 88269.9n -0.37792 88270.0n 1.18224 88399.9n 1.18224 88400.0n 0.34013 88529.9n 0.34013 88530.0n 1.11225 88659.9n 1.11225 88660.0n 1.27694 88789.9n 1.27694 88790.0n 0.23835 88919.9n 0.23835 88920.0n 0.65842 89049.9n 0.65842 89050.0n 0.28189 89179.9n 0.28189 89180.0n -0.33158 89309.9n -0.33158 89310.0n 1.23180 89439.9n 1.23180 89440.0n 0.13226 89569.9n 0.13226 89570.0n -0.21828 89699.9n -0.21828 89700.0n -0.15161 89829.9n -0.15161 89830.0n -0.08309 89959.9n -0.08309 89960.0n 0.63482 90089.9n 0.63482 90090.0n 0.56595 90219.9n 0.56595 90220.0n 0.33171 90349.9n 0.33171 90350.0n 0.42554 90479.9n 0.42554 90480.0n 0.48458 90609.9n 0.48458 90610.0n 0.67130 90739.9n 0.67130 90740.0n 0.25911 90869.9n 0.25911 90870.0n 0.28700 90999.9n 0.28700 91000.0n 1.17517 91129.9n 1.17517 91130.0n 0.66096 91259.9n 0.66096 91260.0n -0.23386 91389.9n -0.23386 91390.0n 0.70122 91519.9n 0.70122 91520.0n -0.21828 91649.9n -0.21828 91650.0n 0.23835 91779.9n 0.23835 91780.0n 0.70122 91909.9n 0.70122 91910.0n 0.56595 92039.9n 0.56595 92040.0n -0.08309 92169.9n -0.08309 92170.0n 0.28189 92299.9n 0.28189 92300.0n 1.27694 92429.9n 1.27694 92430.0n 1.11225 92559.9n 1.11225 92560.0n -0.23386 92689.9n -0.23386 92690.0n 0.25911 92819.9n 0.25911 92820.0n 0.33171 92949.9n 0.33171 92950.0n 0.76415 93079.9n 0.76415 93080.0n 1.18224 93209.9n 1.18224 93210.0n 0.13226 93339.9n 0.13226 93340.0n 0.63482 93469.9n 0.63482 93470.0n -0.37792 93599.9n -0.37792 93600.0n 1.28574 93729.9n 1.28574 93730.0n -0.15161 93859.9n -0.15161 93860.0n 0.65842 93989.9n 0.65842 93990.0n 0.48458 94119.9n 0.48458 94120.0n 1.17517 94249.9n 1.17517 94250.0n 0.28700 94379.9n 0.28700 94380.0n -0.33158 94509.9n -0.33158 94510.0n 0.34013 94639.9n 0.34013 94640.0n 0.66096 94769.9n 0.66096 94770.0n 0.42554 94899.9n 0.42554 94900.0n 0.67130 95029.9n 0.67130 95030.0n 1.23180 95159.9n 1.23180 95160.0n -0.15161 95289.9n -0.15161 95290.0n 0.23835 95419.9n 0.23835 95420.0n 0.70122 95549.9n 0.70122 95550.0n -0.23386 95679.9n -0.23386 95680.0n 0.63482 95809.9n 0.63482 95810.0n 0.13226 95939.9n 0.13226 95940.0n 1.18224 96069.9n 1.18224 96070.0n -0.37792 96199.9n -0.37792 96200.0n 1.17517 96329.9n 1.17517 96330.0n 1.27694 96459.9n 1.27694 96460.0n 0.67130 96589.9n 0.67130 96590.0n -0.08309 96719.9n -0.08309 96720.0n 1.28574 96849.9n 1.28574 96850.0n 0.25911 96979.9n 0.25911 96980.0n 0.48458 97109.9n 0.48458 97110.0n 0.65842 97239.9n 0.65842 97240.0n 0.76415 97369.9n 0.76415 97370.0n 1.11225 97499.9n 1.11225 97500.0n 0.34013 97629.9n 0.34013 97630.0n 0.28700 97759.9n 0.28700 97760.0n 0.28189 97889.9n 0.28189 97890.0n 0.66096 98019.9n 0.66096 98020.0n 0.56595 98149.9n 0.56595 98150.0n 0.33171 98279.9n 0.33171 98280.0n 0.42554 98409.9n 0.42554 98410.0n 1.23180 98539.9n 1.23180 98540.0n -0.33158 98669.9n -0.33158 98670.0n -0.21828 98799.9n -0.21828 98800.0n 1.28574 98929.9n 1.28574 98930.0n 0.56595 99059.9n 0.56595 99060.0n 0.34013 99189.9n 0.34013 99190.0n -0.33158 99319.9n -0.33158 99320.0n 0.28189 99449.9n 0.28189 99450.0n 0.28700 99579.9n 0.28700 99580.0n 1.17517 99709.9n 1.17517 99710.0n 0.66096 99839.9n 0.66096 99840.0n 0.65842 99969.9n 0.65842 99970.0n 0.70122 100099.9n 0.70122 100100.0n 0.63482 100229.9n 0.63482 100230.0n 0.67130 100359.9n 0.67130 100360.0n 0.25911 100489.9n 0.25911 100490.0n -0.23386 100619.9n -0.23386 100620.0n 0.23835 100749.9n 0.23835 100750.0n -0.21828 100879.9n -0.21828 100880.0n 0.48458 101009.9n 0.48458 101010.0n 1.18224 101139.9n 1.18224 101140.0n 1.27694 101269.9n 1.27694 101270.0n 0.13226 101399.9n 0.13226 101400.0n -0.37792 101529.9n -0.37792 101530.0n -0.15161 101659.9n -0.15161 101660.0n 0.76415 101789.9n 0.76415 101790.0n 1.23180 101919.9n 1.23180 101920.0n 0.42554 102049.9n 0.42554 102050.0n 1.11225 102179.9n 1.11225 102180.0n 0.33171 102309.9n 0.33171 102310.0n -0.08309 102439.9n -0.08309 102440.0n 0.25911 102569.9n 0.25911 102570.0n 0.67130 102699.9n 0.67130 102700.0n -0.33158 102829.9n -0.33158 102830.0n -0.21828 102959.9n -0.21828 102960.0n -0.08309 103089.9n -0.08309 103090.0n 0.33171 103219.9n 0.33171 103220.0n 0.63482 103349.9n 0.63482 103350.0n 1.11225 103479.9n 1.11225 103480.0n 0.13226 103609.9n 0.13226 103610.0n 1.28574 103739.9n 1.28574 103740.0n 0.42554 103869.9n 0.42554 103870.0n 0.56595 103999.9n 0.56595 104000.0n 0.76415 104129.9n 0.76415 104130.0n 1.17517 104259.9n 1.17517 104260.0n 0.65842 104389.9n 0.65842 104390.0n 0.66096 104519.9n 0.66096 104520.0n 0.70122 104649.9n 0.70122 104650.0n -0.23386 104779.9n -0.23386 104780.0n 0.28189 104909.9n 0.28189 104910.0n 1.27694 105039.9n 1.27694 105040.0n -0.37792 105169.9n -0.37792 105170.0n 0.28700 105299.9n 0.28700 105300.0n 1.18224 105429.9n 1.18224 105430.0n -0.15161 105559.9n -0.15161 105560.0n 0.34013 105689.9n 0.34013 105690.0n 0.23835 105819.9n 0.23835 105820.0n 0.48458 105949.9n 0.48458 105950.0n 1.23180 106079.9n 1.23180 106080.0n 0.29915 106209.9n 0.29915 106210.0n 0.40313 106339.9n 0.40313 106340.0n 0.36576 106469.9n 0.36576 106470.0n 0.33730 106599.9n 0.33730 106600.0n 0.38385 106729.9n 0.38385 106730.0n 0.59706 106859.9n 0.59706 106860.0n 0.62307 106989.9n 0.62307 106990.0n 0.67018 107119.9n 0.67018 107120.0n 0.70540 107249.9n 0.70540 107250.0n 0.53582 107379.9n 0.53582 107380.0n 0.33357 107509.9n 0.33357 107510.0n 0.52885 107639.9n 0.52885 107640.0n 0.74383 107769.9n 0.74383 107770.0n 0.78409 107899.9n 0.78409 107900.0n 0.51936 108029.9n 0.51936 108030.0n 0.50532 108159.9n 0.50532 108160.0n 0.68189 108289.9n 0.68189 108290.0n 0.79862 108419.9n 0.79862 108420.0n 0.35050 108549.9n 0.35050 108550.0n 0.16858 108679.9n 0.16858 108680.0n 0.55253 108809.9n 0.55253 108810.0n 0.60823 108939.9n 0.60823 108940.0n 0.63611 109069.9n 0.63611 109070.0n 0.41197 109199.9n 0.41197 109200.0n 0.59247 109329.9n 0.59247 109330.0n 1.20712 109459.9n 1.20712 109460.0n 0.87402 109589.9n 0.87402 109590.0n -0.10545 109719.9n -0.10545 109720.0n -0.25282 109849.9n -0.25282 109850.0n -0.37666 109979.9n -0.37666 109980.0n 1.43391 110109.9n 1.43391 110110.0n 0.37511 110239.9n 0.37511 110240.0n 0.35780 110369.9n 0.35780 110370.0n 1.04281 110499.9n 1.04281 110500.0n 1.30757 110629.9n 1.30757 110630.0n -0.27950 110759.9n -0.27950 110760.0n 0.10137 110889.9n 0.10137 110890.0n 1.20727 111019.9n 1.20727 111020.0n 1.40210 111149.9n 1.40210 111150.0n 1.03003 111279.9n 1.03003 111280.0n -0.27250 111409.9n -0.27250 111410.0n -0.24444 111539.9n -0.24444 111540.0n 0.81835 111669.9n 0.81835 111670.0n 0.11792 111799.9n 0.11792 111800.0n -0.41822 111929.9n -0.41822 111930.0n 0.75242 112059.9n 0.75242 112060.0n 0.57354 112189.9n 0.57354 112190.0n 1.22124 112319.9n 1.22124 112320.0n 0.28700 112449.9n 0.28700 112450.0n 0.65842 112579.9n 0.65842 112580.0n 1.17517 112709.9n 1.17517 112710.0n 0.56595 112839.9n 0.56595 112840.0n 0.66096 112969.9n 0.66096 112970.0n 0.70122 113099.9n 0.70122 113100.0n 0.25911 113229.9n 0.25911 113230.0n 0.13226 113359.9n 0.13226 113360.0n 0.63482 113489.9n 0.63482 113490.0n 0.76415 113619.9n 0.76415 113620.0n 0.23835 113749.9n 0.23835 113750.0n 1.23180 113879.9n 1.23180 113880.0n 1.18224 114009.9n 1.18224 114010.0n 0.48458 114139.9n 0.48458 114140.0n 0.28189 114269.9n 0.28189 114270.0n 1.28574 114399.9n 1.28574 114400.0n 0.42554 114529.9n 0.42554 114530.0n 0.33171 114659.9n 0.33171 114660.0n 0.67130 114789.9n 0.67130 114790.0n -0.15161 114919.9n -0.15161 114920.0n 1.27694 115049.9n 1.27694 115050.0n -0.23386 115179.9n -0.23386 115180.0n -0.08309 115309.9n -0.08309 115310.0n 1.11225 115439.9n 1.11225 115440.0n -0.37792 115569.9n -0.37792 115570.0n -0.21828 115699.9n -0.21828 115700.0n -0.33158 115829.9n -0.33158 115830.0n 0.34013 115959.9n 0.34013 115960.0n 0.28700 116089.9n 0.28700 116090.0n 0.28189 116219.9n 0.28189 116220.0n -0.08309 116349.9n -0.08309 116350.0n 1.23180 116479.9n 1.23180 116480.0n 1.17517 116609.9n 1.17517 116610.0n 0.34013 116739.9n 0.34013 116740.0n -0.23386 116869.9n -0.23386 116870.0n 0.67130 116999.9n 0.67130 117000.0n 1.18224 117129.9n 1.18224 117130.0n 0.63482 117259.9n 0.63482 117260.0n -0.33158 117389.9n -0.33158 117390.0n 1.11225 117519.9n 1.11225 117520.0n -0.15161 117649.9n -0.15161 117650.0n 0.76415 117779.9n 0.76415 117780.0n 1.27694 117909.9n 1.27694 117910.0n 1.28574 118039.9n 1.28574 118040.0n 0.70122 118169.9n 0.70122 118170.0n 0.33171 118299.9n 0.33171 118300.0n 0.42554 118429.9n 0.42554 118430.0n 0.65842 118559.9n 0.65842 118560.0n 0.23835 118689.9n 0.23835 118690.0n 0.66096 118819.9n 0.66096 118820.0n 0.48458 118949.9n 0.48458 118950.0n 0.25911 119079.9n 0.25911 119080.0n 0.13226 119209.9n 0.13226 119210.0n 0.56595 119339.9n 0.56595 119340.0n -0.37792 119469.9n -0.37792 119470.0n -0.21828 119599.9n -0.21828 119600.0n 0.23835 119729.9n 0.23835 119730.0n -0.33158 119859.9n -0.33158 119860.0n 1.27694 119989.9n 1.27694 119990.0n -0.21828 120119.9n -0.21828 120120.0n 0.76415 120249.9n 0.76415 120250.0n 0.66096 120379.9n 0.66096 120380.0n 0.13226 120509.9n 0.13226 120510.0n -0.23386 120639.9n -0.23386 120640.0n 0.25911 120769.9n 0.25911 120770.0n 0.63482 120899.9n 0.63482 120900.0n 0.70122 121029.9n 0.70122 121030.0n 1.28574 121159.9n 1.28574 121160.0n 0.42554 121289.9n 0.42554 121290.0n 0.33171 121419.9n 0.33171 121420.0n 1.11225 121549.9n 1.11225 121550.0n -0.15161 121679.9n -0.15161 121680.0n 0.28189 121809.9n 0.28189 121810.0n 1.18224 121939.9n 1.18224 121940.0n 0.28700 122069.9n 0.28700 122070.0n -0.37792 122199.9n -0.37792 122200.0n 0.34013 122329.9n 0.34013 122330.0n 0.56595 122459.9n 0.56595 122460.0n 0.67130 122589.9n 0.67130 122590.0n 1.23180 122719.9n 1.23180 122720.0n -0.08309 122849.9n -0.08309 122850.0n 0.65842 122979.9n 0.65842 122980.0n 1.17517 123109.9n 1.17517 123110.0n 0.48458 123239.9n 0.48458 123240.0n 1.17517 123369.9n 1.17517 123370.0n 0.76415 123499.9n 0.76415 123500.0n -0.23386 123629.9n -0.23386 123630.0n 0.34013 123759.9n 0.34013 123760.0n 1.18224 123889.9n 1.18224 123890.0n 0.66096 124019.9n 0.66096 124020.0n -0.15161 124149.9n -0.15161 124150.0n 1.11225 124279.9n 1.11225 124280.0n 0.23835 124409.9n 0.23835 124410.0n 0.33171 124539.9n 0.33171 124540.0n 0.25911 124669.9n 0.25911 124670.0n 1.27694 124799.9n 1.27694 124800.0n 0.65842 124929.9n 0.65842 124930.0n 1.23180 125059.9n 1.23180 125060.0n -0.08309 125189.9n -0.08309 125190.0n -0.37792 125319.9n -0.37792 125320.0n 0.28700 125449.9n 0.28700 125450.0n 0.48458 125579.9n 0.48458 125580.0n 0.42554 125709.9n 0.42554 125710.0n 0.56595 125839.9n 0.56595 125840.0n 0.70122 125969.9n 0.70122 125970.0n -0.33158 126099.9n -0.33158 126100.0n 0.13226 126229.9n 0.13226 126230.0n 0.67130 126359.9n 0.67130 126360.0n 1.28574 126489.9n 1.28574 126490.0n -0.21828 126619.9n -0.21828 126620.0n 0.28189 126749.9n 0.28189 126750.0n 0.63482 126879.9n 0.63482 126880.0n -0.37792 127009.9n -0.37792 127010.0n -0.08309 127139.9n -0.08309 127140.0n 1.11225 127269.9n 1.11225 127270.0n 0.56595 127399.9n 0.56595 127400.0n 0.66096 127529.9n 0.66096 127530.0n 0.48458 127659.9n 0.48458 127660.0n 1.28574 127789.9n 1.28574 127790.0n 0.28700 127919.9n 0.28700 127920.0n 0.23835 128049.9n 0.23835 128050.0n 0.28189 128179.9n 0.28189 128180.0n 0.13226 128309.9n 0.13226 128310.0n 0.76415 128439.9n 0.76415 128440.0n 0.34013 128569.9n 0.34013 128570.0n 0.65842 128699.9n 0.65842 128700.0n -0.21828 128829.9n -0.21828 128830.0n -0.33158 128959.9n -0.33158 128960.0n 0.42554 129089.9n 0.42554 129090.0n -0.23386 129219.9n -0.23386 129220.0n 0.70122 129349.9n 0.70122 129350.0n -0.15161 129479.9n -0.15161 129480.0n 1.27694 129609.9n 1.27694 129610.0n 0.63482 129739.9n 0.63482 129740.0n 0.25911 129869.9n 0.25911 129870.0n 0.33171 129999.9n 0.33171 130000.0n 1.18224 130129.9n 1.18224 130130.0n 1.23180 130259.9n 1.23180 130260.0n 0.67130 130389.9n 0.67130 130390.0n 1.17517 130519.9n 1.17517 130520.0n 0.48458 130649.9n 0.48458 130650.0n 0.56595 130779.9n 0.56595 130780.0n 0.70122 130909.9n 0.70122 130910.0n -0.23386 131039.9n -0.23386 131040.0n 0.65842 131169.9n 0.65842 131170.0n 0.25911 131299.9n 0.25911 131300.0n 1.23180 131429.9n 1.23180 131430.0n 1.18224 131559.9n 1.18224 131560.0n 0.66096 131689.9n 0.66096 131690.0n 0.76415 131819.9n 0.76415 131820.0n 0.63482 131949.9n 0.63482 131950.0n -0.37792 132079.9n -0.37792 132080.0n 0.42554 132209.9n 0.42554 132210.0n 1.27694 132339.9n 1.27694 132340.0n 1.28574 132469.9n 1.28574 132470.0n 0.28700 132599.9n 0.28700 132600.0n 0.67130 132729.9n 0.67130 132730.0n 0.34013 132859.9n 0.34013 132860.0n 0.13226 132989.9n 0.13226 132990.0n -0.08309 133119.9n -0.08309 133120.0n -0.21828 133249.9n -0.21828 133250.0n -0.15161 133379.9n -0.15161 133380.0n 1.17517 133509.9n 1.17517 133510.0n 1.11225 133639.9n 1.11225 133640.0n 0.28189 133769.9n 0.28189 133770.0n -0.33158 133899.9n -0.33158 133900.0n 0.23835 134029.9n 0.23835 134030.0n 0.33171 134159.9n 0.33171 134160.0n 0.29915 134289.9n 0.29915 134290.0n 0.40313 134419.9n 0.40313 134420.0n 0.36576 134549.9n 0.36576 134550.0n 0.33730 134679.9n 0.33730 134680.0n 0.38385 134809.9n 0.38385 134810.0n 0.59706 134939.9n 0.59706 134940.0n 0.62307 135069.9n 0.62307 135070.0n 0.67018 135199.9n 0.67018 135200.0n 0.70540 135329.9n 0.70540 135330.0n 0.53582 135459.9n 0.53582 135460.0n 0.33357 135589.9n 0.33357 135590.0n 0.52885 135719.9n 0.52885 135720.0n 0.74383 135849.9n 0.74383 135850.0n 0.78409 135979.9n 0.78409 135980.0n 0.51936 136109.9n 0.51936 136110.0n 0.50532 136239.9n 0.50532 136240.0n 0.68189 136369.9n 0.68189 136370.0n 0.79862 136499.9n 0.79862 136500.0n 0.35050 136629.9n 0.35050 136630.0n 0.16858 136759.9n 0.16858 136760.0n 0.55253 136889.9n 0.55253 136890.0n 0.60823 137019.9n 0.60823 137020.0n 0.63611 137149.9n 0.63611 137150.0n 0.41197 137279.9n 0.41197 137280.0n 0.59247 137409.9n 0.59247 137410.0n 1.20712 137539.9n 1.20712 137540.0n 0.87402 137669.9n 0.87402 137670.0n -0.10545 137799.9n -0.10545 137800.0n -0.25282 137929.9n -0.25282 137930.0n -0.37666 138059.9n -0.37666 138060.0n 1.43391 138189.9n 1.43391 138190.0n 0.37511 138319.9n 0.37511 138320.0n 0.35780 138449.9n 0.35780 138450.0n 1.04281 138579.9n 1.04281 138580.0n 1.30757 138709.9n 1.30757 138710.0n -0.27950 138839.9n -0.27950 138840.0n 0.10137 138969.9n 0.10137 138970.0n 1.20727 139099.9n 1.20727 139100.0n 1.40210 139229.9n 1.40210 139230.0n 1.03003 139359.9n 1.03003 139360.0n -0.27250 139489.9n -0.27250 139490.0n -0.24444 139619.9n -0.24444 139620.0n 0.81835 139749.9n 0.81835 139750.0n 0.11792 139879.9n 0.11792 139880.0n -0.41822 140009.9n -0.41822 140010.0n 0.75242 140139.9n 0.75242 140140.0n 0.57354 140269.9n 0.57354 140270.0n 1.22124 140399.9n 1.22124 140400.0n 0.34013 140529.9n 0.34013 140530.0n -0.08309 140659.9n -0.08309 140660.0n 0.42554 140789.9n 0.42554 140790.0n 0.48458 140919.9n 0.48458 140920.0n -0.23386 141049.9n -0.23386 141050.0n 0.66096 141179.9n 0.66096 141180.0n 1.17517 141309.9n 1.17517 141310.0n 0.28189 141439.9n 0.28189 141440.0n 0.67130 141569.9n 0.67130 141570.0n 0.65842 141699.9n 0.65842 141700.0n 0.70122 141829.9n 0.70122 141830.0n 1.27694 141959.9n 1.27694 141960.0n 0.28700 142089.9n 0.28700 142090.0n 1.18224 142219.9n 1.18224 142220.0n 1.11225 142349.9n 1.11225 142350.0n -0.21828 142479.9n -0.21828 142480.0n 0.13226 142609.9n 0.13226 142610.0n 0.23835 142739.9n 0.23835 142740.0n 0.63482 142869.9n 0.63482 142870.0n -0.33158 142999.9n -0.33158 143000.0n 0.76415 143129.9n 0.76415 143130.0n 0.33171 143259.9n 0.33171 143260.0n -0.15161 143389.9n -0.15161 143390.0n -0.37792 143519.9n -0.37792 143520.0n 1.23180 143649.9n 1.23180 143650.0n 1.28574 143779.9n 1.28574 143780.0n 0.56595 143909.9n 0.56595 143910.0n 0.25911 144039.9n 0.25911 144040.0n -0.37792 144169.9n -0.37792 144170.0n 1.23180 144299.9n 1.23180 144300.0n 1.27694 144429.9n 1.27694 144430.0n 0.63482 144559.9n 0.63482 144560.0n 0.42554 144689.9n 0.42554 144690.0n -0.23386 144819.9n -0.23386 144820.0n 1.28574 144949.9n 1.28574 144950.0n 0.23835 145079.9n 0.23835 145080.0n -0.08309 145209.9n -0.08309 145210.0n 0.76415 145339.9n 0.76415 145340.0n 0.25911 145469.9n 0.25911 145470.0n 0.48458 145599.9n 0.48458 145600.0n -0.33158 145729.9n -0.33158 145730.0n 0.66096 145859.9n 0.66096 145860.0n 0.13226 145989.9n 0.13226 145990.0n -0.15161 146119.9n -0.15161 146120.0n 0.70122 146249.9n 0.70122 146250.0n 0.34013 146379.9n 0.34013 146380.0n -0.21828 146509.9n -0.21828 146510.0n 0.65842 146639.9n 0.65842 146640.0n 1.11225 146769.9n 1.11225 146770.0n 0.56595 146899.9n 0.56595 146900.0n 1.18224 147029.9n 1.18224 147030.0n 1.17517 147159.9n 1.17517 147160.0n 0.28700 147289.9n 0.28700 147290.0n 0.33171 147419.9n 0.33171 147420.0n 0.67130 147549.9n 0.67130 147550.0n 0.28189 147679.9n 0.28189 147680.0n 0.23835 147809.9n 0.23835 147810.0n 0.76415 147939.9n 0.76415 147940.0n 1.23180 148069.9n 1.23180 148070.0n 1.28574 148199.9n 1.28574 148200.0n 0.33171 148329.9n 0.33171 148330.0n 0.63482 148459.9n 0.63482 148460.0n 0.28700 148589.9n 0.28700 148590.0n 1.18224 148719.9n 1.18224 148720.0n 0.56595 148849.9n 0.56595 148850.0n -0.37792 148979.9n -0.37792 148980.0n -0.15161 149109.9n -0.15161 149110.0n 0.42554 149239.9n 0.42554 149240.0n -0.21828 149369.9n -0.21828 149370.0n 0.28189 149499.9n 0.28189 149500.0n 0.65842 149629.9n 0.65842 149630.0n 0.48458 149759.9n 0.48458 149760.0n 1.27694 149889.9n 1.27694 149890.0n 1.11225 150019.9n 1.11225 150020.0n 0.13226 150149.9n 0.13226 150150.0n -0.23386 150279.9n -0.23386 150280.0n 1.17517 150409.9n 1.17517 150410.0n 0.34013 150539.9n 0.34013 150540.0n 0.25911 150669.9n 0.25911 150670.0n 0.67130 150799.9n 0.67130 150800.0n 0.66096 150929.9n 0.66096 150930.0n -0.33158 151059.9n -0.33158 151060.0n -0.08309 151189.9n -0.08309 151190.0n 0.70122 151319.9n 0.70122 151320.0n -0.37792 151449.9n -0.37792 151450.0n 0.70122 151579.9n 0.70122 151580.0n 0.42554 151709.9n 0.42554 151710.0n 0.65842 151839.9n 0.65842 151840.0n -0.21828 151969.9n -0.21828 151970.0n 0.67130 152099.9n 0.67130 152100.0n 1.11225 152229.9n 1.11225 152230.0n 0.34013 152359.9n 0.34013 152360.0n 1.17517 152489.9n 1.17517 152490.0n 1.23180 152619.9n 1.23180 152620.0n 0.13226 152749.9n 0.13226 152750.0n -0.08309 152879.9n -0.08309 152880.0n 1.18224 153009.9n 1.18224 153010.0n 0.33171 153139.9n 0.33171 153140.0n 0.28700 153269.9n 0.28700 153270.0n 0.66096 153399.9n 0.66096 153400.0n -0.33158 153529.9n -0.33158 153530.0n 0.28189 153659.9n 0.28189 153660.0n 1.28574 153789.9n 1.28574 153790.0n -0.15161 153919.9n -0.15161 153920.0n 0.56595 154049.9n 0.56595 154050.0n 0.63482 154179.9n 0.63482 154180.0n 0.76415 154309.9n 0.76415 154310.0n -0.23386 154439.9n -0.23386 154440.0n 0.48458 154569.9n 0.48458 154570.0n 0.23835 154699.9n 0.23835 154700.0n 1.27694 154829.9n 1.27694 154830.0n 0.25911 154959.9n 0.25911 154960.0n 0.65842 155089.9n 0.65842 155090.0n 0.76415 155219.9n 0.76415 155220.0n 1.17517 155349.9n 1.17517 155350.0n 1.11225 155479.9n 1.11225 155480.0n 1.27694 155609.9n 1.27694 155610.0n -0.23386 155739.9n -0.23386 155740.0n 0.63482 155869.9n 0.63482 155870.0n 0.70122 155999.9n 0.70122 156000.0n 0.25911 156129.9n 0.25911 156130.0n -0.33158 156259.9n -0.33158 156260.0n 0.42554 156389.9n 0.42554 156390.0n 0.66096 156519.9n 0.66096 156520.0n 0.33171 156649.9n 0.33171 156650.0n 0.56595 156779.9n 0.56595 156780.0n 0.48458 156909.9n 0.48458 156910.0n 1.23180 157039.9n 1.23180 157040.0n 1.28574 157169.9n 1.28574 157170.0n 0.28700 157299.9n 0.28700 157300.0n 1.18224 157429.9n 1.18224 157430.0n -0.08309 157559.9n -0.08309 157560.0n 0.23835 157689.9n 0.23835 157690.0n -0.21828 157819.9n -0.21828 157820.0n 0.67130 157949.9n 0.67130 157950.0n 0.34013 158079.9n 0.34013 158080.0n -0.37792 158209.9n -0.37792 158210.0n 0.28189 158339.9n 0.28189 158340.0n -0.15161 158469.9n -0.15161 158470.0n 0.13226 158599.9n 0.13226 158600.0n 0.23835 158729.9n 0.23835 158730.0n 0.66096 158859.9n 0.66096 158860.0n 0.13226 158989.9n 0.13226 158990.0n 0.67130 159119.9n 0.67130 159120.0n -0.08309 159249.9n -0.08309 159250.0n 0.25911 159379.9n 0.25911 159380.0n 0.56595 159509.9n 0.56595 159510.0n -0.15161 159639.9n -0.15161 159640.0n 1.11225 159769.9n 1.11225 159770.0n 0.28700 159899.9n 0.28700 159900.0n 0.70122 160029.9n 0.70122 160030.0n 1.27694 160159.9n 1.27694 160160.0n -0.23386 160289.9n -0.23386 160290.0n 0.42554 160419.9n 0.42554 160420.0n 0.34013 160549.9n 0.34013 160550.0n 0.76415 160679.9n 0.76415 160680.0n 0.28189 160809.9n 0.28189 160810.0n 1.28574 160939.9n 1.28574 160940.0n 0.48458 161069.9n 0.48458 161070.0n -0.21828 161199.9n -0.21828 161200.0n -0.33158 161329.9n -0.33158 161330.0n 1.17517 161459.9n 1.17517 161460.0n 0.63482 161589.9n 0.63482 161590.0n 1.23180 161719.9n 1.23180 161720.0n 0.65842 161849.9n 0.65842 161850.0n -0.37792 161979.9n -0.37792 161980.0n 0.33171 162109.9n 0.33171 162110.0n 1.18224 162239.9n 1.18224 162240.0n 0.29915 162369.9n 0.29915 162370.0n 0.40313 162499.9n 0.40313 162500.0n 0.36576 162629.9n 0.36576 162630.0n 0.33730 162759.9n 0.33730 162760.0n 0.38385 162889.9n 0.38385 162890.0n 0.59706 163019.9n 0.59706 163020.0n 0.62307 163149.9n 0.62307 163150.0n 0.67018 163279.9n 0.67018 163280.0n 0.70540 163409.9n 0.70540 163410.0n 0.53582 163539.9n 0.53582 163540.0n 0.33357 163669.9n 0.33357 163670.0n 0.52885 163799.9n 0.52885 163800.0n 0.74383 163929.9n 0.74383 163930.0n 0.78409 164059.9n 0.78409 164060.0n 0.51936 164189.9n 0.51936 164190.0n 0.50532 164319.9n 0.50532 164320.0n 0.68189 164449.9n 0.68189 164450.0n 0.79862 164579.9n 0.79862 164580.0n 0.35050 164709.9n 0.35050 164710.0n 0.16858 164839.9n 0.16858 164840.0n 0.55253 164969.9n 0.55253 164970.0n 0.60823 165099.9n 0.60823 165100.0n 0.63611 165229.9n 0.63611 165230.0n 0.41197 165359.9n 0.41197 165360.0n 0.59247 165489.9n 0.59247 165490.0n 1.20712 165619.9n 1.20712 165620.0n 0.87402 165749.9n 0.87402 165750.0n -0.10545 165879.9n -0.10545 165880.0n -0.25282 166009.9n -0.25282 166010.0n -0.37666 166139.9n -0.37666 166140.0n 1.43391 166269.9n 1.43391 166270.0n 0.37511 166399.9n 0.37511 166400.0n 0.35780 166529.9n 0.35780 166530.0n 1.04281 166659.9n 1.04281 166660.0n 1.30757 166789.9n 1.30757 166790.0n -0.27950 166919.9n -0.27950 166920.0n 0.10137 167049.9n 0.10137 167050.0n 1.20727 167179.9n 1.20727 167180.0n 1.40210 167309.9n 1.40210 167310.0n 1.03003 167439.9n 1.03003 167440.0n -0.27250 167569.9n -0.27250 167570.0n -0.24444 167699.9n -0.24444 167700.0n 0.81835 167829.9n 0.81835 167830.0n 0.11792 167959.9n 0.11792 167960.0n -0.41822 168089.9n -0.41822 168090.0n 0.75242 168219.9n 0.75242 168220.0n 0.57354 168349.9n 0.57354 168350.0n 1.22124)
Vxn1 a_xn1 0 PWL(0.0n 0.74089 129.9n 0.74089 130.0n -0.23180 259.9n -0.23180 260.0n 0.23585 389.9n 0.23585 390.0n -0.11225 519.9n -0.11225 520.0n 1.15161 649.9n 1.15161 650.0n 0.76165 779.9n 0.76165 780.0n 0.66829 909.9n 0.66829 910.0n 0.29878 1039.9n 0.29878 1040.0n 0.34158 1169.9n 0.34158 1170.0n 1.33158 1299.9n 1.33158 1300.0n 0.32870 1429.9n 0.32870 1430.0n 0.86774 1559.9n 0.86774 1560.0n 1.21828 1689.9n 1.21828 1690.0n 0.33904 1819.9n 0.33904 1820.0n 0.36518 1949.9n 0.36518 1950.0n 1.37792 2079.9n 1.37792 2080.0n 0.71300 2209.9n 0.71300 2210.0n 0.57446 2339.9n 0.57446 2340.0n 0.71811 2469.9n 0.71811 2470.0n -0.17517 2599.9n -0.17517 2600.0n -0.27694 2729.9n -0.27694 2730.0n -0.18224 2859.9n -0.18224 2860.0n 0.51542 2989.9n 0.51542 2990.0n 0.43405 3119.9n 0.43405 3120.0n 0.65987 3249.9n 0.65987 3250.0n 1.08309 3379.9n 1.08309 3380.0n 1.23386 3509.9n 1.23386 3510.0n -0.28574 3639.9n -0.28574 3640.0n 0.71300 3769.9n 0.71300 3770.0n 0.23585 3899.9n 0.23585 3900.0n -0.18224 4029.9n -0.18224 4030.0n -0.27694 4159.9n -0.27694 4160.0n -0.23180 4289.9n -0.23180 4290.0n 0.36518 4419.9n 0.36518 4420.0n 0.74089 4549.9n 0.74089 4550.0n -0.17517 4679.9n -0.17517 4680.0n 0.65987 4809.9n 0.65987 4810.0n 0.33904 4939.9n 0.33904 4940.0n -0.11225 5069.9n -0.11225 5070.0n 0.57446 5199.9n 0.57446 5200.0n 0.71811 5329.9n 0.71811 5330.0n 0.76165 5459.9n 0.76165 5460.0n 0.86774 5589.9n 0.86774 5590.0n 1.21828 5719.9n 1.21828 5720.0n 0.51542 5849.9n 0.51542 5850.0n -0.28574 5979.9n -0.28574 5980.0n 1.33158 6109.9n 1.33158 6110.0n 0.34158 6239.9n 0.34158 6240.0n 1.15161 6369.9n 1.15161 6370.0n 0.43405 6499.9n 0.43405 6500.0n 1.37792 6629.9n 1.37792 6630.0n 0.32870 6759.9n 0.32870 6760.0n 1.08309 6889.9n 1.08309 6890.0n 0.66829 7019.9n 0.66829 7020.0n 1.23386 7149.9n 1.23386 7150.0n 0.29878 7279.9n 0.29878 7280.0n -0.11225 7409.9n -0.11225 7410.0n -0.18224 7539.9n -0.18224 7540.0n 1.21828 7669.9n 1.21828 7670.0n 0.29878 7799.9n 0.29878 7800.0n 1.08309 7929.9n 1.08309 7930.0n 1.33158 8059.9n 1.33158 8060.0n 0.71300 8189.9n 0.71300 8190.0n -0.28574 8319.9n -0.28574 8320.0n 0.33904 8449.9n 0.33904 8450.0n -0.17517 8579.9n -0.17517 8580.0n 0.51542 8709.9n 0.51542 8710.0n 0.66829 8839.9n 0.66829 8840.0n 0.36518 8969.9n 0.36518 8970.0n 1.23386 9099.9n 1.23386 9100.0n 0.57446 9229.9n 0.57446 9230.0n 0.86774 9359.9n 0.86774 9360.0n -0.27694 9489.9n -0.27694 9490.0n 1.37792 9619.9n 1.37792 9620.0n 0.43405 9749.9n 0.43405 9750.0n 0.34158 9879.9n 0.34158 9880.0n 0.74089 10009.9n 0.74089 10010.0n 0.32870 10139.9n 0.32870 10140.0n -0.23180 10269.9n -0.23180 10270.0n 0.76165 10399.9n 0.76165 10400.0n 0.23585 10529.9n 0.23585 10530.0n 0.71811 10659.9n 0.71811 10660.0n 1.15161 10789.9n 1.15161 10790.0n 0.65987 10919.9n 0.65987 10920.0n 0.66829 11049.9n 0.66829 11050.0n -0.28574 11179.9n -0.28574 11180.0n -0.11225 11309.9n -0.11225 11310.0n 0.33904 11439.9n 0.33904 11440.0n 0.65987 11569.9n 0.65987 11570.0n 0.74089 11699.9n 0.74089 11700.0n 0.51542 11829.9n 0.51542 11830.0n 1.23386 11959.9n 1.23386 11960.0n 0.23585 12089.9n 0.23585 12090.0n -0.27694 12219.9n -0.27694 12220.0n 0.43405 12349.9n 0.43405 12350.0n 0.34158 12479.9n 0.34158 12480.0n 1.08309 12609.9n 1.08309 12610.0n 0.36518 12739.9n 0.36518 12740.0n 0.76165 12869.9n 0.76165 12870.0n 0.57446 12999.9n 0.57446 13000.0n 0.71300 13129.9n 0.71300 13130.0n 1.33158 13259.9n 1.33158 13260.0n 1.21828 13389.9n 1.21828 13390.0n 0.32870 13519.9n 0.32870 13520.0n 0.86774 13649.9n 0.86774 13650.0n 0.29878 13779.9n 0.29878 13780.0n -0.17517 13909.9n -0.17517 13910.0n -0.18224 14039.9n -0.18224 14040.0n 0.71811 14169.9n 0.71811 14170.0n -0.23180 14299.9n -0.23180 14300.0n 1.15161 14429.9n 1.15161 14430.0n 1.37792 14559.9n 1.37792 14560.0n 0.71300 14689.9n 0.71300 14690.0n 0.32870 14819.9n 0.32870 14820.0n 1.08309 14949.9n 1.08309 14950.0n 0.76165 15079.9n 0.76165 15080.0n 1.37792 15209.9n 1.37792 15210.0n 1.23386 15339.9n 1.23386 15340.0n 1.21828 15469.9n 1.21828 15470.0n -0.23180 15599.9n -0.23180 15600.0n -0.27694 15729.9n -0.27694 15730.0n 0.71811 15859.9n 0.71811 15860.0n -0.18224 15989.9n -0.18224 15990.0n 0.74089 16119.9n 0.74089 16120.0n -0.28574 16249.9n -0.28574 16250.0n -0.11225 16379.9n -0.11225 16380.0n 0.29878 16509.9n 0.29878 16510.0n 0.65987 16639.9n 0.65987 16640.0n 0.36518 16769.9n 0.36518 16770.0n 1.15161 16899.9n 1.15161 16900.0n 0.86774 17029.9n 0.86774 17030.0n 0.51542 17159.9n 0.51542 17160.0n 0.43405 17289.9n 0.43405 17290.0n 0.57446 17419.9n 0.57446 17420.0n 0.33904 17549.9n 0.33904 17550.0n -0.17517 17679.9n -0.17517 17680.0n 0.23585 17809.9n 0.23585 17810.0n 0.66829 17939.9n 0.66829 17940.0n 1.33158 18069.9n 1.33158 18070.0n 0.34158 18199.9n 0.34158 18200.0n 0.74089 18329.9n 0.74089 18330.0n -0.11225 18459.9n -0.11225 18460.0n 0.76165 18589.9n 0.76165 18590.0n 0.43405 18719.9n 0.43405 18720.0n 0.66829 18849.9n 0.66829 18850.0n 0.36518 18979.9n 0.36518 18980.0n 1.21828 19109.9n 1.21828 19110.0n 1.08309 19239.9n 1.08309 19240.0n -0.17517 19369.9n -0.17517 19370.0n 0.51542 19499.9n 0.51542 19500.0n 0.71811 19629.9n 0.71811 19630.0n -0.28574 19759.9n -0.28574 19760.0n 1.37792 19889.9n 1.37792 19890.0n 0.32870 20019.9n 0.32870 20020.0n 1.15161 20149.9n 1.15161 20150.0n -0.23180 20279.9n -0.23180 20280.0n 0.33904 20409.9n 0.33904 20410.0n 1.23386 20539.9n 1.23386 20540.0n 0.29878 20669.9n 0.29878 20670.0n 1.33158 20799.9n 1.33158 20800.0n 0.71300 20929.9n 0.71300 20930.0n -0.27694 21059.9n -0.27694 21060.0n 0.65987 21189.9n 0.65987 21190.0n -0.18224 21319.9n -0.18224 21320.0n 0.23585 21449.9n 0.23585 21450.0n 0.57446 21579.9n 0.57446 21580.0n 0.86774 21709.9n 0.86774 21710.0n 0.34158 21839.9n 0.34158 21840.0n 0.70085 21969.9n 0.70085 21970.0n 0.59687 22099.9n 0.59687 22100.0n 0.63424 22229.9n 0.63424 22230.0n 0.66270 22359.9n 0.66270 22360.0n 0.61615 22489.9n 0.61615 22490.0n 0.40294 22619.9n 0.40294 22620.0n 0.37693 22749.9n 0.37693 22750.0n 0.32982 22879.9n 0.32982 22880.0n 0.29460 23009.9n 0.29460 23010.0n 0.46418 23139.9n 0.46418 23140.0n 0.66643 23269.9n 0.66643 23270.0n 0.47115 23399.9n 0.47115 23400.0n 0.25617 23529.9n 0.25617 23530.0n 0.21591 23659.9n 0.21591 23660.0n 0.48064 23789.9n 0.48064 23790.0n 0.49468 23919.9n 0.49468 23920.0n 0.31811 24049.9n 0.31811 24050.0n 0.20138 24179.9n 0.20138 24180.0n 0.64950 24309.9n 0.64950 24310.0n 0.83142 24439.9n 0.83142 24440.0n 0.44747 24569.9n 0.44747 24570.0n 0.39177 24699.9n 0.39177 24700.0n 0.36389 24829.9n 0.36389 24830.0n 0.58803 24959.9n 0.58803 24960.0n 0.40753 25089.9n 0.40753 25090.0n -0.20712 25219.9n -0.20712 25220.0n 0.12598 25349.9n 0.12598 25350.0n 1.10545 25479.9n 1.10545 25480.0n 1.25282 25609.9n 1.25282 25610.0n 1.37666 25739.9n 1.37666 25740.0n -0.43391 25869.9n -0.43391 25870.0n 0.62489 25999.9n 0.62489 26000.0n 0.64220 26129.9n 0.64220 26130.0n -0.04281 26259.9n -0.04281 26260.0n -0.30757 26389.9n -0.30757 26390.0n 1.27950 26519.9n 1.27950 26520.0n 0.89863 26649.9n 0.89863 26650.0n -0.20727 26779.9n -0.20727 26780.0n -0.40210 26909.9n -0.40210 26910.0n -0.03003 27039.9n -0.03003 27040.0n 1.27250 27169.9n 1.27250 27170.0n 1.24444 27299.9n 1.24444 27300.0n 0.18165 27429.9n 0.18165 27430.0n 0.88208 27559.9n 0.88208 27560.0n 1.41822 27689.9n 1.41822 27690.0n 0.24758 27819.9n 0.24758 27820.0n 0.42646 27949.9n 0.42646 27950.0n -0.22124 28079.9n -0.22124 28080.0n 0.36518 28209.9n 0.36518 28210.0n 0.43405 28339.9n 0.43405 28340.0n 1.15161 28469.9n 1.15161 28470.0n -0.27694 28599.9n -0.27694 28600.0n 1.21828 28729.9n 1.21828 28730.0n -0.23180 28859.9n -0.23180 28860.0n 1.23386 28989.9n 1.23386 28990.0n 0.34158 29119.9n 0.34158 29120.0n 0.33904 29249.9n 0.33904 29250.0n 0.51542 29379.9n 0.51542 29380.0n 0.32870 29509.9n 0.32870 29510.0n -0.11225 29639.9n -0.11225 29640.0n 0.29878 29769.9n 0.29878 29770.0n 1.08309 29899.9n 1.08309 29900.0n 0.74089 30029.9n 0.74089 30030.0n 1.33158 30159.9n 1.33158 30160.0n 0.71300 30289.9n 0.71300 30290.0n 1.37792 30419.9n 1.37792 30420.0n 0.86774 30549.9n 0.86774 30550.0n -0.28574 30679.9n -0.28574 30680.0n -0.18224 30809.9n -0.18224 30810.0n -0.17517 30939.9n -0.17517 30940.0n 0.23585 31069.9n 0.23585 31070.0n 0.66829 31199.9n 0.66829 31200.0n 0.71811 31329.9n 0.71811 31330.0n 0.65987 31459.9n 0.65987 31460.0n 0.57446 31589.9n 0.57446 31590.0n 0.76165 31719.9n 0.76165 31720.0n 1.23386 31849.9n 1.23386 31850.0n 0.33904 31979.9n 0.33904 31980.0n 0.86774 32109.9n 0.86774 32110.0n 1.15161 32239.9n 1.15161 32240.0n 0.65987 32369.9n 0.65987 32370.0n 0.36518 32499.9n 0.36518 32500.0n 0.34158 32629.9n 0.34158 32630.0n 0.71811 32759.9n 0.71811 32760.0n 0.23585 32889.9n 0.23585 32890.0n 0.74089 33019.9n 0.74089 33020.0n 0.43405 33149.9n 0.43405 33150.0n -0.17517 33279.9n -0.17517 33280.0n 1.08309 33409.9n 1.08309 33410.0n 0.29878 33539.9n 0.29878 33540.0n 0.57446 33669.9n 0.57446 33670.0n 0.71300 33799.9n 0.71300 33800.0n 0.76165 33929.9n 0.76165 33930.0n -0.28574 34059.9n -0.28574 34060.0n -0.27694 34189.9n -0.27694 34190.0n 1.33158 34319.9n 1.33158 34320.0n 1.21828 34449.9n 1.21828 34450.0n 0.32870 34579.9n 0.32870 34580.0n -0.11225 34709.9n -0.11225 34710.0n -0.18224 34839.9n -0.18224 34840.0n 0.51542 34969.9n 0.51542 34970.0n -0.23180 35099.9n -0.23180 35100.0n 0.66829 35229.9n 0.66829 35230.0n 1.37792 35359.9n 1.37792 35360.0n 0.34158 35489.9n 0.34158 35490.0n 0.71300 35619.9n 0.71300 35620.0n 1.21828 35749.9n 1.21828 35750.0n 0.71811 35879.9n 0.71811 35880.0n -0.17517 36009.9n -0.17517 36010.0n -0.18224 36139.9n -0.18224 36140.0n 0.23585 36269.9n 0.23585 36270.0n 0.65987 36399.9n 0.65987 36400.0n 0.43405 36529.9n 0.43405 36530.0n 0.57446 36659.9n 0.57446 36660.0n 1.23386 36789.9n 1.23386 36790.0n -0.27694 36919.9n -0.27694 36920.0n 1.37792 37049.9n 1.37792 37050.0n 0.29878 37179.9n 0.29878 37180.0n -0.23180 37309.9n -0.23180 37310.0n -0.11225 37439.9n -0.11225 37440.0n 0.86774 37569.9n 0.86774 37570.0n 1.08309 37699.9n 1.08309 37700.0n 0.76165 37829.9n 0.76165 37830.0n 0.66829 37959.9n 0.66829 37960.0n 0.36518 38089.9n 0.36518 38090.0n 0.51542 38219.9n 0.51542 38220.0n -0.28574 38349.9n -0.28574 38350.0n 1.33158 38479.9n 1.33158 38480.0n 0.32870 38609.9n 0.32870 38610.0n 0.33904 38739.9n 0.33904 38740.0n 1.15161 38869.9n 1.15161 38870.0n 0.74089 38999.9n 0.74089 39000.0n 1.33158 39129.9n 1.33158 39130.0n -0.28574 39259.9n -0.28574 39260.0n 1.21828 39389.9n 1.21828 39390.0n 1.23386 39519.9n 1.23386 39520.0n 0.23585 39649.9n 0.23585 39650.0n 1.15161 39779.9n 1.15161 39780.0n 0.71811 39909.9n 0.71811 39910.0n 0.76165 40039.9n 0.76165 40040.0n 0.36518 40169.9n 0.36518 40170.0n 0.29878 40299.9n 0.29878 40300.0n 0.66829 40429.9n 0.66829 40430.0n 0.71300 40559.9n 0.71300 40560.0n -0.23180 40689.9n -0.23180 40690.0n 0.57446 40819.9n 0.57446 40820.0n 0.86774 40949.9n 0.86774 40950.0n 0.51542 41079.9n 0.51542 41080.0n 1.08309 41209.9n 1.08309 41210.0n -0.18224 41339.9n -0.18224 41340.0n 0.74089 41469.9n 0.74089 41470.0n 0.34158 41599.9n 0.34158 41600.0n 0.32870 41729.9n 0.32870 41730.0n -0.17517 41859.9n -0.17517 41860.0n 0.65987 41989.9n 0.65987 41990.0n 0.33904 42119.9n 0.33904 42120.0n -0.27694 42249.9n -0.27694 42250.0n 1.37792 42379.9n 1.37792 42380.0n 0.43405 42509.9n 0.43405 42510.0n -0.11225 42639.9n -0.11225 42640.0n -0.27694 42769.9n -0.27694 42770.0n 0.29878 42899.9n 0.29878 42900.0n 0.65987 43029.9n 0.65987 43030.0n 0.57446 43159.9n 0.57446 43160.0n 0.71811 43289.9n 0.71811 43290.0n 0.74089 43419.9n 0.74089 43420.0n 0.66829 43549.9n 0.66829 43550.0n 1.23386 43679.9n 1.23386 43680.0n -0.11225 43809.9n -0.11225 43810.0n 0.32870 43939.9n 0.32870 43940.0n 0.43405 44069.9n 0.43405 44070.0n -0.23180 44199.9n -0.23180 44200.0n 0.23585 44329.9n 0.23585 44330.0n -0.28574 44459.9n -0.28574 44460.0n 0.71300 44589.9n 0.71300 44590.0n 1.21828 44719.9n 1.21828 44720.0n 0.36518 44849.9n 0.36518 44850.0n 0.34158 44979.9n 0.34158 44980.0n -0.18224 45109.9n -0.18224 45110.0n 1.15161 45239.9n 1.15161 45240.0n 1.08309 45369.9n 1.08309 45370.0n 1.33158 45499.9n 1.33158 45500.0n 0.33904 45629.9n 0.33904 45630.0n 0.51542 45759.9n 0.51542 45760.0n -0.17517 45889.9n -0.17517 45890.0n 0.86774 46019.9n 0.86774 46020.0n 0.76165 46149.9n 0.76165 46150.0n 1.37792 46279.9n 1.37792 46280.0n -0.23180 46409.9n -0.23180 46410.0n 0.71811 46539.9n 0.71811 46540.0n 0.65987 46669.9n 0.65987 46670.0n 0.51542 46799.9n 0.51542 46800.0n 0.43405 46929.9n 0.43405 46930.0n 0.33904 47059.9n 0.33904 47060.0n -0.11225 47189.9n -0.11225 47190.0n -0.27694 47319.9n -0.27694 47320.0n 1.08309 47449.9n 1.08309 47450.0n 1.23386 47579.9n 1.23386 47580.0n 1.21828 47709.9n 1.21828 47710.0n 0.66829 47839.9n 0.66829 47840.0n 0.29878 47969.9n 0.29878 47970.0n 0.74089 48099.9n 0.74089 48100.0n 0.86774 48229.9n 0.86774 48230.0n 0.34158 48359.9n 0.34158 48360.0n 0.36518 48489.9n 0.36518 48490.0n 1.33158 48619.9n 1.33158 48620.0n 0.23585 48749.9n 0.23585 48750.0n 1.15161 48879.9n 1.15161 48880.0n 0.71300 49009.9n 0.71300 49010.0n 0.76165 49139.9n 0.76165 49140.0n 1.37792 49269.9n 1.37792 49270.0n -0.18224 49399.9n -0.18224 49400.0n 0.32870 49529.9n 0.32870 49530.0n 0.57446 49659.9n 0.57446 49660.0n -0.28574 49789.9n -0.28574 49790.0n -0.17517 49919.9n -0.17517 49920.0n 0.70085 50049.9n 0.70085 50050.0n 0.59687 50179.9n 0.59687 50180.0n 0.63424 50309.9n 0.63424 50310.0n 0.66270 50439.9n 0.66270 50440.0n 0.61615 50569.9n 0.61615 50570.0n 0.40294 50699.9n 0.40294 50700.0n 0.37693 50829.9n 0.37693 50830.0n 0.32982 50959.9n 0.32982 50960.0n 0.29460 51089.9n 0.29460 51090.0n 0.46418 51219.9n 0.46418 51220.0n 0.66643 51349.9n 0.66643 51350.0n 0.47115 51479.9n 0.47115 51480.0n 0.25617 51609.9n 0.25617 51610.0n 0.21591 51739.9n 0.21591 51740.0n 0.48064 51869.9n 0.48064 51870.0n 0.49468 51999.9n 0.49468 52000.0n 0.31811 52129.9n 0.31811 52130.0n 0.20138 52259.9n 0.20138 52260.0n 0.64950 52389.9n 0.64950 52390.0n 0.83142 52519.9n 0.83142 52520.0n 0.44747 52649.9n 0.44747 52650.0n 0.39177 52779.9n 0.39177 52780.0n 0.36389 52909.9n 0.36389 52910.0n 0.58803 53039.9n 0.58803 53040.0n 0.40753 53169.9n 0.40753 53170.0n -0.20712 53299.9n -0.20712 53300.0n 0.12598 53429.9n 0.12598 53430.0n 1.10545 53559.9n 1.10545 53560.0n 1.25282 53689.9n 1.25282 53690.0n 1.37666 53819.9n 1.37666 53820.0n -0.43391 53949.9n -0.43391 53950.0n 0.62489 54079.9n 0.62489 54080.0n 0.64220 54209.9n 0.64220 54210.0n -0.04281 54339.9n -0.04281 54340.0n -0.30757 54469.9n -0.30757 54470.0n 1.27950 54599.9n 1.27950 54600.0n 0.89863 54729.9n 0.89863 54730.0n -0.20727 54859.9n -0.20727 54860.0n -0.40210 54989.9n -0.40210 54990.0n -0.03003 55119.9n -0.03003 55120.0n 1.27250 55249.9n 1.27250 55250.0n 1.24444 55379.9n 1.24444 55380.0n 0.18165 55509.9n 0.18165 55510.0n 0.88208 55639.9n 0.88208 55640.0n 1.41822 55769.9n 1.41822 55770.0n 0.24758 55899.9n 0.24758 55900.0n 0.42646 56029.9n 0.42646 56030.0n -0.22124 56159.9n -0.22124 56160.0n 0.34158 56289.9n 0.34158 56290.0n -0.11225 56419.9n -0.11225 56420.0n 1.23386 56549.9n 1.23386 56550.0n 0.71300 56679.9n 0.71300 56680.0n 0.43405 56809.9n 0.43405 56810.0n 0.86774 56939.9n 0.86774 56940.0n 1.37792 57069.9n 1.37792 57070.0n 1.08309 57199.9n 1.08309 57200.0n -0.27694 57329.9n -0.27694 57330.0n 0.36518 57459.9n 0.36518 57460.0n 0.23585 57589.9n 0.23585 57590.0n 0.29878 57719.9n 0.29878 57720.0n 0.65987 57849.9n 0.65987 57850.0n 0.51542 57979.9n 0.51542 57980.0n 0.71811 58109.9n 0.71811 58110.0n 0.57446 58239.9n 0.57446 58240.0n 1.21828 58369.9n 1.21828 58370.0n -0.28574 58499.9n -0.28574 58500.0n 1.15161 58629.9n 1.15161 58630.0n -0.18224 58759.9n -0.18224 58760.0n -0.17517 58889.9n -0.17517 58890.0n 0.32870 59019.9n 0.32870 59020.0n 0.74089 59149.9n 0.74089 59150.0n 0.66829 59279.9n 0.66829 59280.0n 0.76165 59409.9n 0.76165 59410.0n 1.33158 59539.9n 1.33158 59540.0n 0.33904 59669.9n 0.33904 59670.0n -0.23180 59799.9n -0.23180 59800.0n 0.76165 59929.9n 0.76165 59930.0n 0.71811 60059.9n 0.71811 60060.0n -0.18224 60189.9n -0.18224 60190.0n 0.34158 60319.9n 0.34158 60320.0n 0.65987 60449.9n 0.65987 60450.0n 0.71300 60579.9n 0.71300 60580.0n 1.15161 60709.9n 1.15161 60710.0n 0.29878 60839.9n 0.29878 60840.0n 1.37792 60969.9n 1.37792 60970.0n 1.23386 61099.9n 1.23386 61100.0n 0.57446 61229.9n 0.57446 61230.0n -0.23180 61359.9n -0.23180 61360.0n 0.36518 61489.9n 0.36518 61490.0n -0.27694 61619.9n -0.27694 61620.0n 1.08309 61749.9n 1.08309 61750.0n 0.43405 61879.9n 0.43405 61880.0n 0.33904 62009.9n 0.33904 62010.0n -0.28574 62139.9n -0.28574 62140.0n 0.32870 62269.9n 0.32870 62270.0n 0.86774 62399.9n 0.86774 62400.0n 0.66829 62529.9n 0.66829 62530.0n 0.51542 62659.9n 0.51542 62660.0n 0.74089 62789.9n 0.74089 62790.0n 1.21828 62919.9n 1.21828 62920.0n -0.11225 63049.9n -0.11225 63050.0n 1.33158 63179.9n 1.33158 63180.0n -0.17517 63309.9n -0.17517 63310.0n 0.23585 63439.9n 0.23585 63440.0n 0.86774 63569.9n 0.86774 63570.0n 0.34158 63699.9n 0.34158 63700.0n 0.74089 63829.9n 0.74089 63830.0n 0.71300 63959.9n 0.71300 63960.0n 1.08309 64089.9n 1.08309 64090.0n 0.76165 64219.9n 0.76165 64220.0n -0.18224 64349.9n -0.18224 64350.0n -0.11225 64479.9n -0.11225 64480.0n 0.43405 64609.9n 0.43405 64610.0n -0.27694 64739.9n -0.27694 64740.0n 1.37792 64869.9n 1.37792 64870.0n 0.71811 64999.9n 0.71811 65000.0n -0.23180 65129.9n -0.23180 65130.0n 1.15161 65259.9n 1.15161 65260.0n -0.17517 65389.9n -0.17517 65390.0n -0.28574 65519.9n -0.28574 65520.0n 0.51542 65649.9n 0.51542 65650.0n 0.36518 65779.9n 0.36518 65780.0n 0.65987 65909.9n 0.65987 65910.0n 1.33158 66039.9n 1.33158 66040.0n 0.66829 66169.9n 0.66829 66170.0n 0.32870 66299.9n 0.32870 66300.0n 0.33904 66429.9n 0.33904 66430.0n 0.29878 66559.9n 0.29878 66560.0n 1.23386 66689.9n 1.23386 66690.0n 0.23585 66819.9n 0.23585 66820.0n 1.21828 66949.9n 1.21828 66950.0n 0.57446 67079.9n 0.57446 67080.0n -0.18224 67209.9n -0.18224 67210.0n 0.36518 67339.9n 0.36518 67340.0n -0.17517 67469.9n -0.17517 67470.0n -0.23180 67599.9n -0.23180 67600.0n 0.51542 67729.9n 0.51542 67730.0n 1.21828 67859.9n 1.21828 67860.0n 0.66829 67989.9n 0.66829 67990.0n 0.32870 68119.9n 0.32870 68120.0n 0.33904 68249.9n 0.33904 68250.0n -0.27694 68379.9n -0.27694 68380.0n 1.08309 68509.9n 1.08309 68510.0n 0.23585 68639.9n 0.23585 68640.0n 0.57446 68769.9n 0.57446 68770.0n 0.86774 68899.9n 0.86774 68900.0n 1.15161 69029.9n 1.15161 69030.0n 0.29878 69159.9n 0.29878 69160.0n -0.11225 69289.9n -0.11225 69290.0n 0.74089 69419.9n 0.74089 69420.0n 1.23386 69549.9n 1.23386 69550.0n 0.34158 69679.9n 0.34158 69680.0n 0.76165 69809.9n 0.76165 69810.0n 1.37792 69939.9n 1.37792 69940.0n 0.71811 70069.9n 0.71811 70070.0n -0.28574 70199.9n -0.28574 70200.0n 0.71300 70329.9n 0.71300 70330.0n 1.33158 70459.9n 1.33158 70460.0n 0.65987 70589.9n 0.65987 70590.0n 0.43405 70719.9n 0.43405 70720.0n 1.21828 70849.9n 1.21828 70850.0n -0.23180 70979.9n -0.23180 70980.0n 0.23585 71109.9n 0.23585 71110.0n 0.66829 71239.9n 0.66829 71240.0n 0.43405 71369.9n 0.43405 71370.0n 0.57446 71499.9n 0.57446 71500.0n 0.32870 71629.9n 0.32870 71630.0n -0.18224 71759.9n -0.18224 71760.0n 1.37792 71889.9n 1.37792 71890.0n 1.33158 72019.9n 1.33158 72020.0n -0.28574 72149.9n -0.28574 72150.0n 0.74089 72279.9n 0.74089 72280.0n 0.71300 72409.9n 0.71300 72410.0n 0.65987 72539.9n 0.65987 72540.0n 1.15161 72669.9n 1.15161 72670.0n 0.36518 72799.9n 0.36518 72800.0n 0.86774 72929.9n 0.86774 72930.0n 0.76165 73059.9n 0.76165 73060.0n 0.34158 73189.9n 0.34158 73190.0n 0.71811 73319.9n 0.71811 73320.0n -0.11225 73449.9n -0.11225 73450.0n 1.23386 73579.9n 1.23386 73580.0n 0.33904 73709.9n 0.33904 73710.0n 1.08309 73839.9n 1.08309 73840.0n 0.51542 73969.9n 0.51542 73970.0n -0.27694 74099.9n -0.27694 74100.0n -0.17517 74229.9n -0.17517 74230.0n 0.29878 74359.9n 0.29878 74360.0n 0.66829 74489.9n 0.66829 74490.0n 0.51542 74619.9n 0.51542 74620.0n -0.18224 74749.9n -0.18224 74750.0n 1.33158 74879.9n 1.33158 74880.0n -0.28574 75009.9n -0.28574 75010.0n 0.57446 75139.9n 0.57446 75140.0n -0.23180 75269.9n -0.23180 75270.0n -0.27694 75399.9n -0.27694 75400.0n 0.74089 75529.9n 0.74089 75530.0n 1.21828 75659.9n 1.21828 75660.0n 1.08309 75789.9n 1.08309 75790.0n 0.65987 75919.9n 0.65987 75920.0n 1.23386 76049.9n 1.23386 76050.0n 0.71300 76179.9n 0.71300 76180.0n 0.29878 76309.9n 0.29878 76310.0n -0.11225 76439.9n -0.11225 76440.0n 1.37792 76569.9n 1.37792 76570.0n -0.17517 76699.9n -0.17517 76700.0n 1.15161 76829.9n 1.15161 76830.0n 0.36518 76959.9n 0.36518 76960.0n 0.76165 77089.9n 0.76165 77090.0n 0.23585 77219.9n 0.23585 77220.0n 0.32870 77349.9n 0.32870 77350.0n 0.71811 77479.9n 0.71811 77480.0n 0.43405 77609.9n 0.43405 77610.0n 0.86774 77739.9n 0.86774 77740.0n 0.34158 77869.9n 0.34158 77870.0n 0.33904 77999.9n 0.33904 78000.0n 0.70085 78129.9n 0.70085 78130.0n 0.59687 78259.9n 0.59687 78260.0n 0.63424 78389.9n 0.63424 78390.0n 0.66270 78519.9n 0.66270 78520.0n 0.61615 78649.9n 0.61615 78650.0n 0.40294 78779.9n 0.40294 78780.0n 0.37693 78909.9n 0.37693 78910.0n 0.32982 79039.9n 0.32982 79040.0n 0.29460 79169.9n 0.29460 79170.0n 0.46418 79299.9n 0.46418 79300.0n 0.66643 79429.9n 0.66643 79430.0n 0.47115 79559.9n 0.47115 79560.0n 0.25617 79689.9n 0.25617 79690.0n 0.21591 79819.9n 0.21591 79820.0n 0.48064 79949.9n 0.48064 79950.0n 0.49468 80079.9n 0.49468 80080.0n 0.31811 80209.9n 0.31811 80210.0n 0.20138 80339.9n 0.20138 80340.0n 0.64950 80469.9n 0.64950 80470.0n 0.83142 80599.9n 0.83142 80600.0n 0.44747 80729.9n 0.44747 80730.0n 0.39177 80859.9n 0.39177 80860.0n 0.36389 80989.9n 0.36389 80990.0n 0.58803 81119.9n 0.58803 81120.0n 0.40753 81249.9n 0.40753 81250.0n -0.20712 81379.9n -0.20712 81380.0n 0.12598 81509.9n 0.12598 81510.0n 1.10545 81639.9n 1.10545 81640.0n 1.25282 81769.9n 1.25282 81770.0n 1.37666 81899.9n 1.37666 81900.0n -0.43391 82029.9n -0.43391 82030.0n 0.62489 82159.9n 0.62489 82160.0n 0.64220 82289.9n 0.64220 82290.0n -0.04281 82419.9n -0.04281 82420.0n -0.30757 82549.9n -0.30757 82550.0n 1.27950 82679.9n 1.27950 82680.0n 0.89863 82809.9n 0.89863 82810.0n -0.20727 82939.9n -0.20727 82940.0n -0.40210 83069.9n -0.40210 83070.0n -0.03003 83199.9n -0.03003 83200.0n 1.27250 83329.9n 1.27250 83330.0n 1.24444 83459.9n 1.24444 83460.0n 0.18165 83589.9n 0.18165 83590.0n 0.88208 83719.9n 0.88208 83720.0n 1.41822 83849.9n 1.41822 83850.0n 0.24758 83979.9n 0.24758 83980.0n 0.42646 84109.9n 0.42646 84110.0n -0.22124 84239.9n -0.22124 84240.0n -0.11225 84369.9n -0.11225 84370.0n 0.33904 84499.9n 0.33904 84500.0n 0.51542 84629.9n 0.51542 84630.0n 0.29878 84759.9n 0.29878 84760.0n 0.36518 84889.9n 0.36518 84890.0n 0.65987 85019.9n 0.65987 85020.0n -0.23180 85149.9n -0.23180 85150.0n 1.08309 85279.9n 1.08309 85280.0n 1.33158 85409.9n 1.33158 85410.0n 0.57446 85539.9n 0.57446 85540.0n 1.21828 85669.9n 1.21828 85670.0n -0.28574 85799.9n -0.28574 85800.0n -0.27694 85929.9n -0.27694 85930.0n -0.17517 86059.9n -0.17517 86060.0n 0.74089 86189.9n 0.74089 86190.0n -0.18224 86319.9n -0.18224 86320.0n 0.66829 86449.9n 0.66829 86450.0n 1.37792 86579.9n 1.37792 86580.0n 0.34158 86709.9n 0.34158 86710.0n 0.32870 86839.9n 0.32870 86840.0n 0.76165 86969.9n 0.76165 86970.0n 1.23386 87099.9n 1.23386 87100.0n 0.71811 87229.9n 0.71811 87230.0n 0.23585 87359.9n 0.23585 87360.0n 0.86774 87489.9n 0.86774 87490.0n 0.71300 87619.9n 0.71300 87620.0n 1.15161 87749.9n 1.15161 87750.0n 0.43405 87879.9n 0.43405 87880.0n -0.28574 88009.9n -0.28574 88010.0n 0.23585 88139.9n 0.23585 88140.0n 1.37792 88269.9n 1.37792 88270.0n -0.18224 88399.9n -0.18224 88400.0n 0.65987 88529.9n 0.65987 88530.0n -0.11225 88659.9n -0.11225 88660.0n -0.27694 88789.9n -0.27694 88790.0n 0.76165 88919.9n 0.76165 88920.0n 0.34158 89049.9n 0.34158 89050.0n 0.71811 89179.9n 0.71811 89180.0n 1.33158 89309.9n 1.33158 89310.0n -0.23180 89439.9n -0.23180 89440.0n 0.86774 89569.9n 0.86774 89570.0n 1.21828 89699.9n 1.21828 89700.0n 1.15161 89829.9n 1.15161 89830.0n 1.08309 89959.9n 1.08309 89960.0n 0.36518 90089.9n 0.36518 90090.0n 0.43405 90219.9n 0.43405 90220.0n 0.66829 90349.9n 0.66829 90350.0n 0.57446 90479.9n 0.57446 90480.0n 0.51542 90609.9n 0.51542 90610.0n 0.32870 90739.9n 0.32870 90740.0n 0.74089 90869.9n 0.74089 90870.0n 0.71300 90999.9n 0.71300 91000.0n -0.17517 91129.9n -0.17517 91130.0n 0.33904 91259.9n 0.33904 91260.0n 1.23386 91389.9n 1.23386 91390.0n 0.29878 91519.9n 0.29878 91520.0n 1.21828 91649.9n 1.21828 91650.0n 0.76165 91779.9n 0.76165 91780.0n 0.29878 91909.9n 0.29878 91910.0n 0.43405 92039.9n 0.43405 92040.0n 1.08309 92169.9n 1.08309 92170.0n 0.71811 92299.9n 0.71811 92300.0n -0.27694 92429.9n -0.27694 92430.0n -0.11225 92559.9n -0.11225 92560.0n 1.23386 92689.9n 1.23386 92690.0n 0.74089 92819.9n 0.74089 92820.0n 0.66829 92949.9n 0.66829 92950.0n 0.23585 93079.9n 0.23585 93080.0n -0.18224 93209.9n -0.18224 93210.0n 0.86774 93339.9n 0.86774 93340.0n 0.36518 93469.9n 0.36518 93470.0n 1.37792 93599.9n 1.37792 93600.0n -0.28574 93729.9n -0.28574 93730.0n 1.15161 93859.9n 1.15161 93860.0n 0.34158 93989.9n 0.34158 93990.0n 0.51542 94119.9n 0.51542 94120.0n -0.17517 94249.9n -0.17517 94250.0n 0.71300 94379.9n 0.71300 94380.0n 1.33158 94509.9n 1.33158 94510.0n 0.65987 94639.9n 0.65987 94640.0n 0.33904 94769.9n 0.33904 94770.0n 0.57446 94899.9n 0.57446 94900.0n 0.32870 95029.9n 0.32870 95030.0n -0.23180 95159.9n -0.23180 95160.0n 1.15161 95289.9n 1.15161 95290.0n 0.76165 95419.9n 0.76165 95420.0n 0.29878 95549.9n 0.29878 95550.0n 1.23386 95679.9n 1.23386 95680.0n 0.36518 95809.9n 0.36518 95810.0n 0.86774 95939.9n 0.86774 95940.0n -0.18224 96069.9n -0.18224 96070.0n 1.37792 96199.9n 1.37792 96200.0n -0.17517 96329.9n -0.17517 96330.0n -0.27694 96459.9n -0.27694 96460.0n 0.32870 96589.9n 0.32870 96590.0n 1.08309 96719.9n 1.08309 96720.0n -0.28574 96849.9n -0.28574 96850.0n 0.74089 96979.9n 0.74089 96980.0n 0.51542 97109.9n 0.51542 97110.0n 0.34158 97239.9n 0.34158 97240.0n 0.23585 97369.9n 0.23585 97370.0n -0.11225 97499.9n -0.11225 97500.0n 0.65987 97629.9n 0.65987 97630.0n 0.71300 97759.9n 0.71300 97760.0n 0.71811 97889.9n 0.71811 97890.0n 0.33904 98019.9n 0.33904 98020.0n 0.43405 98149.9n 0.43405 98150.0n 0.66829 98279.9n 0.66829 98280.0n 0.57446 98409.9n 0.57446 98410.0n -0.23180 98539.9n -0.23180 98540.0n 1.33158 98669.9n 1.33158 98670.0n 1.21828 98799.9n 1.21828 98800.0n -0.28574 98929.9n -0.28574 98930.0n 0.43405 99059.9n 0.43405 99060.0n 0.65987 99189.9n 0.65987 99190.0n 1.33158 99319.9n 1.33158 99320.0n 0.71811 99449.9n 0.71811 99450.0n 0.71300 99579.9n 0.71300 99580.0n -0.17517 99709.9n -0.17517 99710.0n 0.33904 99839.9n 0.33904 99840.0n 0.34158 99969.9n 0.34158 99970.0n 0.29878 100099.9n 0.29878 100100.0n 0.36518 100229.9n 0.36518 100230.0n 0.32870 100359.9n 0.32870 100360.0n 0.74089 100489.9n 0.74089 100490.0n 1.23386 100619.9n 1.23386 100620.0n 0.76165 100749.9n 0.76165 100750.0n 1.21828 100879.9n 1.21828 100880.0n 0.51542 101009.9n 0.51542 101010.0n -0.18224 101139.9n -0.18224 101140.0n -0.27694 101269.9n -0.27694 101270.0n 0.86774 101399.9n 0.86774 101400.0n 1.37792 101529.9n 1.37792 101530.0n 1.15161 101659.9n 1.15161 101660.0n 0.23585 101789.9n 0.23585 101790.0n -0.23180 101919.9n -0.23180 101920.0n 0.57446 102049.9n 0.57446 102050.0n -0.11225 102179.9n -0.11225 102180.0n 0.66829 102309.9n 0.66829 102310.0n 1.08309 102439.9n 1.08309 102440.0n 0.74089 102569.9n 0.74089 102570.0n 0.32870 102699.9n 0.32870 102700.0n 1.33158 102829.9n 1.33158 102830.0n 1.21828 102959.9n 1.21828 102960.0n 1.08309 103089.9n 1.08309 103090.0n 0.66829 103219.9n 0.66829 103220.0n 0.36518 103349.9n 0.36518 103350.0n -0.11225 103479.9n -0.11225 103480.0n 0.86774 103609.9n 0.86774 103610.0n -0.28574 103739.9n -0.28574 103740.0n 0.57446 103869.9n 0.57446 103870.0n 0.43405 103999.9n 0.43405 104000.0n 0.23585 104129.9n 0.23585 104130.0n -0.17517 104259.9n -0.17517 104260.0n 0.34158 104389.9n 0.34158 104390.0n 0.33904 104519.9n 0.33904 104520.0n 0.29878 104649.9n 0.29878 104650.0n 1.23386 104779.9n 1.23386 104780.0n 0.71811 104909.9n 0.71811 104910.0n -0.27694 105039.9n -0.27694 105040.0n 1.37792 105169.9n 1.37792 105170.0n 0.71300 105299.9n 0.71300 105300.0n -0.18224 105429.9n -0.18224 105430.0n 1.15161 105559.9n 1.15161 105560.0n 0.65987 105689.9n 0.65987 105690.0n 0.76165 105819.9n 0.76165 105820.0n 0.51542 105949.9n 0.51542 105950.0n -0.23180 106079.9n -0.23180 106080.0n 0.70085 106209.9n 0.70085 106210.0n 0.59687 106339.9n 0.59687 106340.0n 0.63424 106469.9n 0.63424 106470.0n 0.66270 106599.9n 0.66270 106600.0n 0.61615 106729.9n 0.61615 106730.0n 0.40294 106859.9n 0.40294 106860.0n 0.37693 106989.9n 0.37693 106990.0n 0.32982 107119.9n 0.32982 107120.0n 0.29460 107249.9n 0.29460 107250.0n 0.46418 107379.9n 0.46418 107380.0n 0.66643 107509.9n 0.66643 107510.0n 0.47115 107639.9n 0.47115 107640.0n 0.25617 107769.9n 0.25617 107770.0n 0.21591 107899.9n 0.21591 107900.0n 0.48064 108029.9n 0.48064 108030.0n 0.49468 108159.9n 0.49468 108160.0n 0.31811 108289.9n 0.31811 108290.0n 0.20138 108419.9n 0.20138 108420.0n 0.64950 108549.9n 0.64950 108550.0n 0.83142 108679.9n 0.83142 108680.0n 0.44747 108809.9n 0.44747 108810.0n 0.39177 108939.9n 0.39177 108940.0n 0.36389 109069.9n 0.36389 109070.0n 0.58803 109199.9n 0.58803 109200.0n 0.40753 109329.9n 0.40753 109330.0n -0.20712 109459.9n -0.20712 109460.0n 0.12598 109589.9n 0.12598 109590.0n 1.10545 109719.9n 1.10545 109720.0n 1.25282 109849.9n 1.25282 109850.0n 1.37666 109979.9n 1.37666 109980.0n -0.43391 110109.9n -0.43391 110110.0n 0.62489 110239.9n 0.62489 110240.0n 0.64220 110369.9n 0.64220 110370.0n -0.04281 110499.9n -0.04281 110500.0n -0.30757 110629.9n -0.30757 110630.0n 1.27950 110759.9n 1.27950 110760.0n 0.89863 110889.9n 0.89863 110890.0n -0.20727 111019.9n -0.20727 111020.0n -0.40210 111149.9n -0.40210 111150.0n -0.03003 111279.9n -0.03003 111280.0n 1.27250 111409.9n 1.27250 111410.0n 1.24444 111539.9n 1.24444 111540.0n 0.18165 111669.9n 0.18165 111670.0n 0.88208 111799.9n 0.88208 111800.0n 1.41822 111929.9n 1.41822 111930.0n 0.24758 112059.9n 0.24758 112060.0n 0.42646 112189.9n 0.42646 112190.0n -0.22124 112319.9n -0.22124 112320.0n 0.71300 112449.9n 0.71300 112450.0n 0.34158 112579.9n 0.34158 112580.0n -0.17517 112709.9n -0.17517 112710.0n 0.43405 112839.9n 0.43405 112840.0n 0.33904 112969.9n 0.33904 112970.0n 0.29878 113099.9n 0.29878 113100.0n 0.74089 113229.9n 0.74089 113230.0n 0.86774 113359.9n 0.86774 113360.0n 0.36518 113489.9n 0.36518 113490.0n 0.23585 113619.9n 0.23585 113620.0n 0.76165 113749.9n 0.76165 113750.0n -0.23180 113879.9n -0.23180 113880.0n -0.18224 114009.9n -0.18224 114010.0n 0.51542 114139.9n 0.51542 114140.0n 0.71811 114269.9n 0.71811 114270.0n -0.28574 114399.9n -0.28574 114400.0n 0.57446 114529.9n 0.57446 114530.0n 0.66829 114659.9n 0.66829 114660.0n 0.32870 114789.9n 0.32870 114790.0n 1.15161 114919.9n 1.15161 114920.0n -0.27694 115049.9n -0.27694 115050.0n 1.23386 115179.9n 1.23386 115180.0n 1.08309 115309.9n 1.08309 115310.0n -0.11225 115439.9n -0.11225 115440.0n 1.37792 115569.9n 1.37792 115570.0n 1.21828 115699.9n 1.21828 115700.0n 1.33158 115829.9n 1.33158 115830.0n 0.65987 115959.9n 0.65987 115960.0n 0.71300 116089.9n 0.71300 116090.0n 0.71811 116219.9n 0.71811 116220.0n 1.08309 116349.9n 1.08309 116350.0n -0.23180 116479.9n -0.23180 116480.0n -0.17517 116609.9n -0.17517 116610.0n 0.65987 116739.9n 0.65987 116740.0n 1.23386 116869.9n 1.23386 116870.0n 0.32870 116999.9n 0.32870 117000.0n -0.18224 117129.9n -0.18224 117130.0n 0.36518 117259.9n 0.36518 117260.0n 1.33158 117389.9n 1.33158 117390.0n -0.11225 117519.9n -0.11225 117520.0n 1.15161 117649.9n 1.15161 117650.0n 0.23585 117779.9n 0.23585 117780.0n -0.27694 117909.9n -0.27694 117910.0n -0.28574 118039.9n -0.28574 118040.0n 0.29878 118169.9n 0.29878 118170.0n 0.66829 118299.9n 0.66829 118300.0n 0.57446 118429.9n 0.57446 118430.0n 0.34158 118559.9n 0.34158 118560.0n 0.76165 118689.9n 0.76165 118690.0n 0.33904 118819.9n 0.33904 118820.0n 0.51542 118949.9n 0.51542 118950.0n 0.74089 119079.9n 0.74089 119080.0n 0.86774 119209.9n 0.86774 119210.0n 0.43405 119339.9n 0.43405 119340.0n 1.37792 119469.9n 1.37792 119470.0n 1.21828 119599.9n 1.21828 119600.0n 0.76165 119729.9n 0.76165 119730.0n 1.33158 119859.9n 1.33158 119860.0n -0.27694 119989.9n -0.27694 119990.0n 1.21828 120119.9n 1.21828 120120.0n 0.23585 120249.9n 0.23585 120250.0n 0.33904 120379.9n 0.33904 120380.0n 0.86774 120509.9n 0.86774 120510.0n 1.23386 120639.9n 1.23386 120640.0n 0.74089 120769.9n 0.74089 120770.0n 0.36518 120899.9n 0.36518 120900.0n 0.29878 121029.9n 0.29878 121030.0n -0.28574 121159.9n -0.28574 121160.0n 0.57446 121289.9n 0.57446 121290.0n 0.66829 121419.9n 0.66829 121420.0n -0.11225 121549.9n -0.11225 121550.0n 1.15161 121679.9n 1.15161 121680.0n 0.71811 121809.9n 0.71811 121810.0n -0.18224 121939.9n -0.18224 121940.0n 0.71300 122069.9n 0.71300 122070.0n 1.37792 122199.9n 1.37792 122200.0n 0.65987 122329.9n 0.65987 122330.0n 0.43405 122459.9n 0.43405 122460.0n 0.32870 122589.9n 0.32870 122590.0n -0.23180 122719.9n -0.23180 122720.0n 1.08309 122849.9n 1.08309 122850.0n 0.34158 122979.9n 0.34158 122980.0n -0.17517 123109.9n -0.17517 123110.0n 0.51542 123239.9n 0.51542 123240.0n -0.17517 123369.9n -0.17517 123370.0n 0.23585 123499.9n 0.23585 123500.0n 1.23386 123629.9n 1.23386 123630.0n 0.65987 123759.9n 0.65987 123760.0n -0.18224 123889.9n -0.18224 123890.0n 0.33904 124019.9n 0.33904 124020.0n 1.15161 124149.9n 1.15161 124150.0n -0.11225 124279.9n -0.11225 124280.0n 0.76165 124409.9n 0.76165 124410.0n 0.66829 124539.9n 0.66829 124540.0n 0.74089 124669.9n 0.74089 124670.0n -0.27694 124799.9n -0.27694 124800.0n 0.34158 124929.9n 0.34158 124930.0n -0.23180 125059.9n -0.23180 125060.0n 1.08309 125189.9n 1.08309 125190.0n 1.37792 125319.9n 1.37792 125320.0n 0.71300 125449.9n 0.71300 125450.0n 0.51542 125579.9n 0.51542 125580.0n 0.57446 125709.9n 0.57446 125710.0n 0.43405 125839.9n 0.43405 125840.0n 0.29878 125969.9n 0.29878 125970.0n 1.33158 126099.9n 1.33158 126100.0n 0.86774 126229.9n 0.86774 126230.0n 0.32870 126359.9n 0.32870 126360.0n -0.28574 126489.9n -0.28574 126490.0n 1.21828 126619.9n 1.21828 126620.0n 0.71811 126749.9n 0.71811 126750.0n 0.36518 126879.9n 0.36518 126880.0n 1.37792 127009.9n 1.37792 127010.0n 1.08309 127139.9n 1.08309 127140.0n -0.11225 127269.9n -0.11225 127270.0n 0.43405 127399.9n 0.43405 127400.0n 0.33904 127529.9n 0.33904 127530.0n 0.51542 127659.9n 0.51542 127660.0n -0.28574 127789.9n -0.28574 127790.0n 0.71300 127919.9n 0.71300 127920.0n 0.76165 128049.9n 0.76165 128050.0n 0.71811 128179.9n 0.71811 128180.0n 0.86774 128309.9n 0.86774 128310.0n 0.23585 128439.9n 0.23585 128440.0n 0.65987 128569.9n 0.65987 128570.0n 0.34158 128699.9n 0.34158 128700.0n 1.21828 128829.9n 1.21828 128830.0n 1.33158 128959.9n 1.33158 128960.0n 0.57446 129089.9n 0.57446 129090.0n 1.23386 129219.9n 1.23386 129220.0n 0.29878 129349.9n 0.29878 129350.0n 1.15161 129479.9n 1.15161 129480.0n -0.27694 129609.9n -0.27694 129610.0n 0.36518 129739.9n 0.36518 129740.0n 0.74089 129869.9n 0.74089 129870.0n 0.66829 129999.9n 0.66829 130000.0n -0.18224 130129.9n -0.18224 130130.0n -0.23180 130259.9n -0.23180 130260.0n 0.32870 130389.9n 0.32870 130390.0n -0.17517 130519.9n -0.17517 130520.0n 0.51542 130649.9n 0.51542 130650.0n 0.43405 130779.9n 0.43405 130780.0n 0.29878 130909.9n 0.29878 130910.0n 1.23386 131039.9n 1.23386 131040.0n 0.34158 131169.9n 0.34158 131170.0n 0.74089 131299.9n 0.74089 131300.0n -0.23180 131429.9n -0.23180 131430.0n -0.18224 131559.9n -0.18224 131560.0n 0.33904 131689.9n 0.33904 131690.0n 0.23585 131819.9n 0.23585 131820.0n 0.36518 131949.9n 0.36518 131950.0n 1.37792 132079.9n 1.37792 132080.0n 0.57446 132209.9n 0.57446 132210.0n -0.27694 132339.9n -0.27694 132340.0n -0.28574 132469.9n -0.28574 132470.0n 0.71300 132599.9n 0.71300 132600.0n 0.32870 132729.9n 0.32870 132730.0n 0.65987 132859.9n 0.65987 132860.0n 0.86774 132989.9n 0.86774 132990.0n 1.08309 133119.9n 1.08309 133120.0n 1.21828 133249.9n 1.21828 133250.0n 1.15161 133379.9n 1.15161 133380.0n -0.17517 133509.9n -0.17517 133510.0n -0.11225 133639.9n -0.11225 133640.0n 0.71811 133769.9n 0.71811 133770.0n 1.33158 133899.9n 1.33158 133900.0n 0.76165 134029.9n 0.76165 134030.0n 0.66829 134159.9n 0.66829 134160.0n 0.70085 134289.9n 0.70085 134290.0n 0.59687 134419.9n 0.59687 134420.0n 0.63424 134549.9n 0.63424 134550.0n 0.66270 134679.9n 0.66270 134680.0n 0.61615 134809.9n 0.61615 134810.0n 0.40294 134939.9n 0.40294 134940.0n 0.37693 135069.9n 0.37693 135070.0n 0.32982 135199.9n 0.32982 135200.0n 0.29460 135329.9n 0.29460 135330.0n 0.46418 135459.9n 0.46418 135460.0n 0.66643 135589.9n 0.66643 135590.0n 0.47115 135719.9n 0.47115 135720.0n 0.25617 135849.9n 0.25617 135850.0n 0.21591 135979.9n 0.21591 135980.0n 0.48064 136109.9n 0.48064 136110.0n 0.49468 136239.9n 0.49468 136240.0n 0.31811 136369.9n 0.31811 136370.0n 0.20138 136499.9n 0.20138 136500.0n 0.64950 136629.9n 0.64950 136630.0n 0.83142 136759.9n 0.83142 136760.0n 0.44747 136889.9n 0.44747 136890.0n 0.39177 137019.9n 0.39177 137020.0n 0.36389 137149.9n 0.36389 137150.0n 0.58803 137279.9n 0.58803 137280.0n 0.40753 137409.9n 0.40753 137410.0n -0.20712 137539.9n -0.20712 137540.0n 0.12598 137669.9n 0.12598 137670.0n 1.10545 137799.9n 1.10545 137800.0n 1.25282 137929.9n 1.25282 137930.0n 1.37666 138059.9n 1.37666 138060.0n -0.43391 138189.9n -0.43391 138190.0n 0.62489 138319.9n 0.62489 138320.0n 0.64220 138449.9n 0.64220 138450.0n -0.04281 138579.9n -0.04281 138580.0n -0.30757 138709.9n -0.30757 138710.0n 1.27950 138839.9n 1.27950 138840.0n 0.89863 138969.9n 0.89863 138970.0n -0.20727 139099.9n -0.20727 139100.0n -0.40210 139229.9n -0.40210 139230.0n -0.03003 139359.9n -0.03003 139360.0n 1.27250 139489.9n 1.27250 139490.0n 1.24444 139619.9n 1.24444 139620.0n 0.18165 139749.9n 0.18165 139750.0n 0.88208 139879.9n 0.88208 139880.0n 1.41822 140009.9n 1.41822 140010.0n 0.24758 140139.9n 0.24758 140140.0n 0.42646 140269.9n 0.42646 140270.0n -0.22124 140399.9n -0.22124 140400.0n 0.65987 140529.9n 0.65987 140530.0n 1.08309 140659.9n 1.08309 140660.0n 0.57446 140789.9n 0.57446 140790.0n 0.51542 140919.9n 0.51542 140920.0n 1.23386 141049.9n 1.23386 141050.0n 0.33904 141179.9n 0.33904 141180.0n -0.17517 141309.9n -0.17517 141310.0n 0.71811 141439.9n 0.71811 141440.0n 0.32870 141569.9n 0.32870 141570.0n 0.34158 141699.9n 0.34158 141700.0n 0.29878 141829.9n 0.29878 141830.0n -0.27694 141959.9n -0.27694 141960.0n 0.71300 142089.9n 0.71300 142090.0n -0.18224 142219.9n -0.18224 142220.0n -0.11225 142349.9n -0.11225 142350.0n 1.21828 142479.9n 1.21828 142480.0n 0.86774 142609.9n 0.86774 142610.0n 0.76165 142739.9n 0.76165 142740.0n 0.36518 142869.9n 0.36518 142870.0n 1.33158 142999.9n 1.33158 143000.0n 0.23585 143129.9n 0.23585 143130.0n 0.66829 143259.9n 0.66829 143260.0n 1.15161 143389.9n 1.15161 143390.0n 1.37792 143519.9n 1.37792 143520.0n -0.23180 143649.9n -0.23180 143650.0n -0.28574 143779.9n -0.28574 143780.0n 0.43405 143909.9n 0.43405 143910.0n 0.74089 144039.9n 0.74089 144040.0n 1.37792 144169.9n 1.37792 144170.0n -0.23180 144299.9n -0.23180 144300.0n -0.27694 144429.9n -0.27694 144430.0n 0.36518 144559.9n 0.36518 144560.0n 0.57446 144689.9n 0.57446 144690.0n 1.23386 144819.9n 1.23386 144820.0n -0.28574 144949.9n -0.28574 144950.0n 0.76165 145079.9n 0.76165 145080.0n 1.08309 145209.9n 1.08309 145210.0n 0.23585 145339.9n 0.23585 145340.0n 0.74089 145469.9n 0.74089 145470.0n 0.51542 145599.9n 0.51542 145600.0n 1.33158 145729.9n 1.33158 145730.0n 0.33904 145859.9n 0.33904 145860.0n 0.86774 145989.9n 0.86774 145990.0n 1.15161 146119.9n 1.15161 146120.0n 0.29878 146249.9n 0.29878 146250.0n 0.65987 146379.9n 0.65987 146380.0n 1.21828 146509.9n 1.21828 146510.0n 0.34158 146639.9n 0.34158 146640.0n -0.11225 146769.9n -0.11225 146770.0n 0.43405 146899.9n 0.43405 146900.0n -0.18224 147029.9n -0.18224 147030.0n -0.17517 147159.9n -0.17517 147160.0n 0.71300 147289.9n 0.71300 147290.0n 0.66829 147419.9n 0.66829 147420.0n 0.32870 147549.9n 0.32870 147550.0n 0.71811 147679.9n 0.71811 147680.0n 0.76165 147809.9n 0.76165 147810.0n 0.23585 147939.9n 0.23585 147940.0n -0.23180 148069.9n -0.23180 148070.0n -0.28574 148199.9n -0.28574 148200.0n 0.66829 148329.9n 0.66829 148330.0n 0.36518 148459.9n 0.36518 148460.0n 0.71300 148589.9n 0.71300 148590.0n -0.18224 148719.9n -0.18224 148720.0n 0.43405 148849.9n 0.43405 148850.0n 1.37792 148979.9n 1.37792 148980.0n 1.15161 149109.9n 1.15161 149110.0n 0.57446 149239.9n 0.57446 149240.0n 1.21828 149369.9n 1.21828 149370.0n 0.71811 149499.9n 0.71811 149500.0n 0.34158 149629.9n 0.34158 149630.0n 0.51542 149759.9n 0.51542 149760.0n -0.27694 149889.9n -0.27694 149890.0n -0.11225 150019.9n -0.11225 150020.0n 0.86774 150149.9n 0.86774 150150.0n 1.23386 150279.9n 1.23386 150280.0n -0.17517 150409.9n -0.17517 150410.0n 0.65987 150539.9n 0.65987 150540.0n 0.74089 150669.9n 0.74089 150670.0n 0.32870 150799.9n 0.32870 150800.0n 0.33904 150929.9n 0.33904 150930.0n 1.33158 151059.9n 1.33158 151060.0n 1.08309 151189.9n 1.08309 151190.0n 0.29878 151319.9n 0.29878 151320.0n 1.37792 151449.9n 1.37792 151450.0n 0.29878 151579.9n 0.29878 151580.0n 0.57446 151709.9n 0.57446 151710.0n 0.34158 151839.9n 0.34158 151840.0n 1.21828 151969.9n 1.21828 151970.0n 0.32870 152099.9n 0.32870 152100.0n -0.11225 152229.9n -0.11225 152230.0n 0.65987 152359.9n 0.65987 152360.0n -0.17517 152489.9n -0.17517 152490.0n -0.23180 152619.9n -0.23180 152620.0n 0.86774 152749.9n 0.86774 152750.0n 1.08309 152879.9n 1.08309 152880.0n -0.18224 153009.9n -0.18224 153010.0n 0.66829 153139.9n 0.66829 153140.0n 0.71300 153269.9n 0.71300 153270.0n 0.33904 153399.9n 0.33904 153400.0n 1.33158 153529.9n 1.33158 153530.0n 0.71811 153659.9n 0.71811 153660.0n -0.28574 153789.9n -0.28574 153790.0n 1.15161 153919.9n 1.15161 153920.0n 0.43405 154049.9n 0.43405 154050.0n 0.36518 154179.9n 0.36518 154180.0n 0.23585 154309.9n 0.23585 154310.0n 1.23386 154439.9n 1.23386 154440.0n 0.51542 154569.9n 0.51542 154570.0n 0.76165 154699.9n 0.76165 154700.0n -0.27694 154829.9n -0.27694 154830.0n 0.74089 154959.9n 0.74089 154960.0n 0.34158 155089.9n 0.34158 155090.0n 0.23585 155219.9n 0.23585 155220.0n -0.17517 155349.9n -0.17517 155350.0n -0.11225 155479.9n -0.11225 155480.0n -0.27694 155609.9n -0.27694 155610.0n 1.23386 155739.9n 1.23386 155740.0n 0.36518 155869.9n 0.36518 155870.0n 0.29878 155999.9n 0.29878 156000.0n 0.74089 156129.9n 0.74089 156130.0n 1.33158 156259.9n 1.33158 156260.0n 0.57446 156389.9n 0.57446 156390.0n 0.33904 156519.9n 0.33904 156520.0n 0.66829 156649.9n 0.66829 156650.0n 0.43405 156779.9n 0.43405 156780.0n 0.51542 156909.9n 0.51542 156910.0n -0.23180 157039.9n -0.23180 157040.0n -0.28574 157169.9n -0.28574 157170.0n 0.71300 157299.9n 0.71300 157300.0n -0.18224 157429.9n -0.18224 157430.0n 1.08309 157559.9n 1.08309 157560.0n 0.76165 157689.9n 0.76165 157690.0n 1.21828 157819.9n 1.21828 157820.0n 0.32870 157949.9n 0.32870 157950.0n 0.65987 158079.9n 0.65987 158080.0n 1.37792 158209.9n 1.37792 158210.0n 0.71811 158339.9n 0.71811 158340.0n 1.15161 158469.9n 1.15161 158470.0n 0.86774 158599.9n 0.86774 158600.0n 0.76165 158729.9n 0.76165 158730.0n 0.33904 158859.9n 0.33904 158860.0n 0.86774 158989.9n 0.86774 158990.0n 0.32870 159119.9n 0.32870 159120.0n 1.08309 159249.9n 1.08309 159250.0n 0.74089 159379.9n 0.74089 159380.0n 0.43405 159509.9n 0.43405 159510.0n 1.15161 159639.9n 1.15161 159640.0n -0.11225 159769.9n -0.11225 159770.0n 0.71300 159899.9n 0.71300 159900.0n 0.29878 160029.9n 0.29878 160030.0n -0.27694 160159.9n -0.27694 160160.0n 1.23386 160289.9n 1.23386 160290.0n 0.57446 160419.9n 0.57446 160420.0n 0.65987 160549.9n 0.65987 160550.0n 0.23585 160679.9n 0.23585 160680.0n 0.71811 160809.9n 0.71811 160810.0n -0.28574 160939.9n -0.28574 160940.0n 0.51542 161069.9n 0.51542 161070.0n 1.21828 161199.9n 1.21828 161200.0n 1.33158 161329.9n 1.33158 161330.0n -0.17517 161459.9n -0.17517 161460.0n 0.36518 161589.9n 0.36518 161590.0n -0.23180 161719.9n -0.23180 161720.0n 0.34158 161849.9n 0.34158 161850.0n 1.37792 161979.9n 1.37792 161980.0n 0.66829 162109.9n 0.66829 162110.0n -0.18224 162239.9n -0.18224 162240.0n 0.70085 162369.9n 0.70085 162370.0n 0.59687 162499.9n 0.59687 162500.0n 0.63424 162629.9n 0.63424 162630.0n 0.66270 162759.9n 0.66270 162760.0n 0.61615 162889.9n 0.61615 162890.0n 0.40294 163019.9n 0.40294 163020.0n 0.37693 163149.9n 0.37693 163150.0n 0.32982 163279.9n 0.32982 163280.0n 0.29460 163409.9n 0.29460 163410.0n 0.46418 163539.9n 0.46418 163540.0n 0.66643 163669.9n 0.66643 163670.0n 0.47115 163799.9n 0.47115 163800.0n 0.25617 163929.9n 0.25617 163930.0n 0.21591 164059.9n 0.21591 164060.0n 0.48064 164189.9n 0.48064 164190.0n 0.49468 164319.9n 0.49468 164320.0n 0.31811 164449.9n 0.31811 164450.0n 0.20138 164579.9n 0.20138 164580.0n 0.64950 164709.9n 0.64950 164710.0n 0.83142 164839.9n 0.83142 164840.0n 0.44747 164969.9n 0.44747 164970.0n 0.39177 165099.9n 0.39177 165100.0n 0.36389 165229.9n 0.36389 165230.0n 0.58803 165359.9n 0.58803 165360.0n 0.40753 165489.9n 0.40753 165490.0n -0.20712 165619.9n -0.20712 165620.0n 0.12598 165749.9n 0.12598 165750.0n 1.10545 165879.9n 1.10545 165880.0n 1.25282 166009.9n 1.25282 166010.0n 1.37666 166139.9n 1.37666 166140.0n -0.43391 166269.9n -0.43391 166270.0n 0.62489 166399.9n 0.62489 166400.0n 0.64220 166529.9n 0.64220 166530.0n -0.04281 166659.9n -0.04281 166660.0n -0.30757 166789.9n -0.30757 166790.0n 1.27950 166919.9n 1.27950 166920.0n 0.89863 167049.9n 0.89863 167050.0n -0.20727 167179.9n -0.20727 167180.0n -0.40210 167309.9n -0.40210 167310.0n -0.03003 167439.9n -0.03003 167440.0n 1.27250 167569.9n 1.27250 167570.0n 1.24444 167699.9n 1.24444 167700.0n 0.18165 167829.9n 0.18165 167830.0n 0.88208 167959.9n 0.88208 167960.0n 1.41822 168089.9n 1.41822 168090.0n 0.24758 168219.9n 0.24758 168220.0n 0.42646 168349.9n 0.42646 168350.0n -0.22124)
Vxp2 a_xp2 0 PWL(0.0n 0.80000 129.9n 0.80000 130.0n 0.80000 259.9n 0.80000 260.0n 0.80000 389.9n 0.80000 390.0n 0.80000 519.9n 0.80000 520.0n 0.80000 649.9n 0.80000 650.0n 0.80000 779.9n 0.80000 780.0n 0.80000 909.9n 0.80000 910.0n 0.80000 1039.9n 0.80000 1040.0n 0.80000 1169.9n 0.80000 1170.0n 0.80000 1299.9n 0.80000 1300.0n 0.80000 1429.9n 0.80000 1430.0n 0.80000 1559.9n 0.80000 1560.0n 0.80000 1689.9n 0.80000 1690.0n 0.80000 1819.9n 0.80000 1820.0n 0.80000 1949.9n 0.80000 1950.0n 0.80000 2079.9n 0.80000 2080.0n 0.80000 2209.9n 0.80000 2210.0n 0.80000 2339.9n 0.80000 2340.0n 0.80000 2469.9n 0.80000 2470.0n 0.80000 2599.9n 0.80000 2600.0n 0.80000 2729.9n 0.80000 2730.0n 0.80000 2859.9n 0.80000 2860.0n 0.80000 2989.9n 0.80000 2990.0n 0.80000 3119.9n 0.80000 3120.0n 0.80000 3249.9n 0.80000 3250.0n 0.80000 3379.9n 0.80000 3380.0n 0.80000 3509.9n 0.80000 3510.0n 0.80000 3639.9n 0.80000 3640.0n 0.80000 3769.9n 0.80000 3770.0n 0.80000 3899.9n 0.80000 3900.0n 0.80000 4029.9n 0.80000 4030.0n 0.80000 4159.9n 0.80000 4160.0n 0.80000 4289.9n 0.80000 4290.0n 0.80000 4419.9n 0.80000 4420.0n 0.80000 4549.9n 0.80000 4550.0n 0.80000 4679.9n 0.80000 4680.0n 0.80000 4809.9n 0.80000 4810.0n 0.80000 4939.9n 0.80000 4940.0n 0.80000 5069.9n 0.80000 5070.0n 0.80000 5199.9n 0.80000 5200.0n 0.80000 5329.9n 0.80000 5330.0n 0.80000 5459.9n 0.80000 5460.0n 0.80000 5589.9n 0.80000 5590.0n 0.80000 5719.9n 0.80000 5720.0n 0.80000 5849.9n 0.80000 5850.0n 0.80000 5979.9n 0.80000 5980.0n 0.80000 6109.9n 0.80000 6110.0n 0.80000 6239.9n 0.80000 6240.0n 0.80000 6369.9n 0.80000 6370.0n 0.80000 6499.9n 0.80000 6500.0n 0.80000 6629.9n 0.80000 6630.0n 0.80000 6759.9n 0.80000 6760.0n 0.80000 6889.9n 0.80000 6890.0n 0.80000 7019.9n 0.80000 7020.0n 0.80000 7149.9n 0.80000 7150.0n 0.80000 7279.9n 0.80000 7280.0n 0.80000 7409.9n 0.80000 7410.0n 0.80000 7539.9n 0.80000 7540.0n 0.80000 7669.9n 0.80000 7670.0n 0.80000 7799.9n 0.80000 7800.0n 0.80000 7929.9n 0.80000 7930.0n 0.80000 8059.9n 0.80000 8060.0n 0.80000 8189.9n 0.80000 8190.0n 0.80000 8319.9n 0.80000 8320.0n 0.80000 8449.9n 0.80000 8450.0n 0.80000 8579.9n 0.80000 8580.0n 0.80000 8709.9n 0.80000 8710.0n 0.80000 8839.9n 0.80000 8840.0n 0.80000 8969.9n 0.80000 8970.0n 0.80000 9099.9n 0.80000 9100.0n 0.80000 9229.9n 0.80000 9230.0n 0.80000 9359.9n 0.80000 9360.0n 0.80000 9489.9n 0.80000 9490.0n 0.80000 9619.9n 0.80000 9620.0n 0.80000 9749.9n 0.80000 9750.0n 0.80000 9879.9n 0.80000 9880.0n 0.80000 10009.9n 0.80000 10010.0n 0.80000 10139.9n 0.80000 10140.0n 0.80000 10269.9n 0.80000 10270.0n 0.80000 10399.9n 0.80000 10400.0n 0.80000 10529.9n 0.80000 10530.0n 0.80000 10659.9n 0.80000 10660.0n 0.80000 10789.9n 0.80000 10790.0n 0.80000 10919.9n 0.80000 10920.0n 0.80000 11049.9n 0.80000 11050.0n 0.80000 11179.9n 0.80000 11180.0n 0.80000 11309.9n 0.80000 11310.0n 0.80000 11439.9n 0.80000 11440.0n 0.80000 11569.9n 0.80000 11570.0n 0.80000 11699.9n 0.80000 11700.0n 0.80000 11829.9n 0.80000 11830.0n 0.80000 11959.9n 0.80000 11960.0n 0.80000 12089.9n 0.80000 12090.0n 0.80000 12219.9n 0.80000 12220.0n 0.80000 12349.9n 0.80000 12350.0n 0.80000 12479.9n 0.80000 12480.0n 0.80000 12609.9n 0.80000 12610.0n 0.80000 12739.9n 0.80000 12740.0n 0.80000 12869.9n 0.80000 12870.0n 0.80000 12999.9n 0.80000 13000.0n 0.80000 13129.9n 0.80000 13130.0n 0.80000 13259.9n 0.80000 13260.0n 0.80000 13389.9n 0.80000 13390.0n 0.80000 13519.9n 0.80000 13520.0n 0.80000 13649.9n 0.80000 13650.0n 0.80000 13779.9n 0.80000 13780.0n 0.80000 13909.9n 0.80000 13910.0n 0.80000 14039.9n 0.80000 14040.0n 0.80000 14169.9n 0.80000 14170.0n 0.80000 14299.9n 0.80000 14300.0n 0.80000 14429.9n 0.80000 14430.0n 0.80000 14559.9n 0.80000 14560.0n 0.80000 14689.9n 0.80000 14690.0n 0.80000 14819.9n 0.80000 14820.0n 0.80000 14949.9n 0.80000 14950.0n 0.80000 15079.9n 0.80000 15080.0n 0.80000 15209.9n 0.80000 15210.0n 0.80000 15339.9n 0.80000 15340.0n 0.80000 15469.9n 0.80000 15470.0n 0.80000 15599.9n 0.80000 15600.0n 0.80000 15729.9n 0.80000 15730.0n 0.80000 15859.9n 0.80000 15860.0n 0.80000 15989.9n 0.80000 15990.0n 0.80000 16119.9n 0.80000 16120.0n 0.80000 16249.9n 0.80000 16250.0n 0.80000 16379.9n 0.80000 16380.0n 0.80000 16509.9n 0.80000 16510.0n 0.80000 16639.9n 0.80000 16640.0n 0.80000 16769.9n 0.80000 16770.0n 0.80000 16899.9n 0.80000 16900.0n 0.80000 17029.9n 0.80000 17030.0n 0.80000 17159.9n 0.80000 17160.0n 0.80000 17289.9n 0.80000 17290.0n 0.80000 17419.9n 0.80000 17420.0n 0.80000 17549.9n 0.80000 17550.0n 0.80000 17679.9n 0.80000 17680.0n 0.80000 17809.9n 0.80000 17810.0n 0.80000 17939.9n 0.80000 17940.0n 0.80000 18069.9n 0.80000 18070.0n 0.80000 18199.9n 0.80000 18200.0n 0.80000 18329.9n 0.80000 18330.0n 0.80000 18459.9n 0.80000 18460.0n 0.80000 18589.9n 0.80000 18590.0n 0.80000 18719.9n 0.80000 18720.0n 0.80000 18849.9n 0.80000 18850.0n 0.80000 18979.9n 0.80000 18980.0n 0.80000 19109.9n 0.80000 19110.0n 0.80000 19239.9n 0.80000 19240.0n 0.80000 19369.9n 0.80000 19370.0n 0.80000 19499.9n 0.80000 19500.0n 0.80000 19629.9n 0.80000 19630.0n 0.80000 19759.9n 0.80000 19760.0n 0.80000 19889.9n 0.80000 19890.0n 0.80000 20019.9n 0.80000 20020.0n 0.80000 20149.9n 0.80000 20150.0n 0.80000 20279.9n 0.80000 20280.0n 0.80000 20409.9n 0.80000 20410.0n 0.80000 20539.9n 0.80000 20540.0n 0.80000 20669.9n 0.80000 20670.0n 0.80000 20799.9n 0.80000 20800.0n 0.80000 20929.9n 0.80000 20930.0n 0.80000 21059.9n 0.80000 21060.0n 0.80000 21189.9n 0.80000 21190.0n 0.80000 21319.9n 0.80000 21320.0n 0.80000 21449.9n 0.80000 21450.0n 0.80000 21579.9n 0.80000 21580.0n 0.80000 21709.9n 0.80000 21710.0n 0.80000 21839.9n 0.80000 21840.0n 0.80000 21969.9n 0.80000 21970.0n 0.80000 22099.9n 0.80000 22100.0n 0.80000 22229.9n 0.80000 22230.0n 0.80000 22359.9n 0.80000 22360.0n 0.80000 22489.9n 0.80000 22490.0n 0.80000 22619.9n 0.80000 22620.0n 0.80000 22749.9n 0.80000 22750.0n 0.80000 22879.9n 0.80000 22880.0n 0.80000 23009.9n 0.80000 23010.0n 0.80000 23139.9n 0.80000 23140.0n 0.80000 23269.9n 0.80000 23270.0n 0.80000 23399.9n 0.80000 23400.0n 0.80000 23529.9n 0.80000 23530.0n 0.80000 23659.9n 0.80000 23660.0n 0.80000 23789.9n 0.80000 23790.0n 0.80000 23919.9n 0.80000 23920.0n 0.80000 24049.9n 0.80000 24050.0n 0.80000 24179.9n 0.80000 24180.0n 0.80000 24309.9n 0.80000 24310.0n 0.80000 24439.9n 0.80000 24440.0n 0.80000 24569.9n 0.80000 24570.0n 0.80000 24699.9n 0.80000 24700.0n 0.80000 24829.9n 0.80000 24830.0n 0.80000 24959.9n 0.80000 24960.0n 0.80000 25089.9n 0.80000 25090.0n 0.80000 25219.9n 0.80000 25220.0n 0.80000 25349.9n 0.80000 25350.0n 0.80000 25479.9n 0.80000 25480.0n 0.80000 25609.9n 0.80000 25610.0n 0.80000 25739.9n 0.80000 25740.0n 0.80000 25869.9n 0.80000 25870.0n 0.80000 25999.9n 0.80000 26000.0n 0.80000 26129.9n 0.80000 26130.0n 0.80000 26259.9n 0.80000 26260.0n 0.80000 26389.9n 0.80000 26390.0n 0.80000 26519.9n 0.80000 26520.0n 0.80000 26649.9n 0.80000 26650.0n 0.80000 26779.9n 0.80000 26780.0n 0.80000 26909.9n 0.80000 26910.0n 0.80000 27039.9n 0.80000 27040.0n 0.80000 27169.9n 0.80000 27170.0n 0.80000 27299.9n 0.80000 27300.0n 0.80000 27429.9n 0.80000 27430.0n 0.80000 27559.9n 0.80000 27560.0n 0.80000 27689.9n 0.80000 27690.0n 0.80000 27819.9n 0.80000 27820.0n 0.80000 27949.9n 0.80000 27950.0n 0.80000 28079.9n 0.80000 28080.0n 0.80000 28209.9n 0.80000 28210.0n 0.80000 28339.9n 0.80000 28340.0n 0.80000 28469.9n 0.80000 28470.0n 0.80000 28599.9n 0.80000 28600.0n 0.80000 28729.9n 0.80000 28730.0n 0.80000 28859.9n 0.80000 28860.0n 0.80000 28989.9n 0.80000 28990.0n 0.80000 29119.9n 0.80000 29120.0n 0.80000 29249.9n 0.80000 29250.0n 0.80000 29379.9n 0.80000 29380.0n 0.80000 29509.9n 0.80000 29510.0n 0.80000 29639.9n 0.80000 29640.0n 0.80000 29769.9n 0.80000 29770.0n 0.80000 29899.9n 0.80000 29900.0n 0.80000 30029.9n 0.80000 30030.0n 0.80000 30159.9n 0.80000 30160.0n 0.80000 30289.9n 0.80000 30290.0n 0.80000 30419.9n 0.80000 30420.0n 0.80000 30549.9n 0.80000 30550.0n 0.80000 30679.9n 0.80000 30680.0n 0.80000 30809.9n 0.80000 30810.0n 0.80000 30939.9n 0.80000 30940.0n 0.80000 31069.9n 0.80000 31070.0n 0.80000 31199.9n 0.80000 31200.0n 0.80000 31329.9n 0.80000 31330.0n 0.80000 31459.9n 0.80000 31460.0n 0.80000 31589.9n 0.80000 31590.0n 0.80000 31719.9n 0.80000 31720.0n 0.80000 31849.9n 0.80000 31850.0n 0.80000 31979.9n 0.80000 31980.0n 0.80000 32109.9n 0.80000 32110.0n 0.80000 32239.9n 0.80000 32240.0n 0.80000 32369.9n 0.80000 32370.0n 0.80000 32499.9n 0.80000 32500.0n 0.80000 32629.9n 0.80000 32630.0n 0.80000 32759.9n 0.80000 32760.0n 0.80000 32889.9n 0.80000 32890.0n 0.80000 33019.9n 0.80000 33020.0n 0.80000 33149.9n 0.80000 33150.0n 0.80000 33279.9n 0.80000 33280.0n 0.80000 33409.9n 0.80000 33410.0n 0.80000 33539.9n 0.80000 33540.0n 0.80000 33669.9n 0.80000 33670.0n 0.80000 33799.9n 0.80000 33800.0n 0.80000 33929.9n 0.80000 33930.0n 0.80000 34059.9n 0.80000 34060.0n 0.80000 34189.9n 0.80000 34190.0n 0.80000 34319.9n 0.80000 34320.0n 0.80000 34449.9n 0.80000 34450.0n 0.80000 34579.9n 0.80000 34580.0n 0.80000 34709.9n 0.80000 34710.0n 0.80000 34839.9n 0.80000 34840.0n 0.80000 34969.9n 0.80000 34970.0n 0.80000 35099.9n 0.80000 35100.0n 0.80000 35229.9n 0.80000 35230.0n 0.80000 35359.9n 0.80000 35360.0n 0.80000 35489.9n 0.80000 35490.0n 0.80000 35619.9n 0.80000 35620.0n 0.80000 35749.9n 0.80000 35750.0n 0.80000 35879.9n 0.80000 35880.0n 0.80000 36009.9n 0.80000 36010.0n 0.80000 36139.9n 0.80000 36140.0n 0.80000 36269.9n 0.80000 36270.0n 0.80000 36399.9n 0.80000 36400.0n 0.80000 36529.9n 0.80000 36530.0n 0.80000 36659.9n 0.80000 36660.0n 0.80000 36789.9n 0.80000 36790.0n 0.80000 36919.9n 0.80000 36920.0n 0.80000 37049.9n 0.80000 37050.0n 0.80000 37179.9n 0.80000 37180.0n 0.80000 37309.9n 0.80000 37310.0n 0.80000 37439.9n 0.80000 37440.0n 0.80000 37569.9n 0.80000 37570.0n 0.80000 37699.9n 0.80000 37700.0n 0.80000 37829.9n 0.80000 37830.0n 0.80000 37959.9n 0.80000 37960.0n 0.80000 38089.9n 0.80000 38090.0n 0.80000 38219.9n 0.80000 38220.0n 0.80000 38349.9n 0.80000 38350.0n 0.80000 38479.9n 0.80000 38480.0n 0.80000 38609.9n 0.80000 38610.0n 0.80000 38739.9n 0.80000 38740.0n 0.80000 38869.9n 0.80000 38870.0n 0.80000 38999.9n 0.80000 39000.0n 0.80000 39129.9n 0.80000 39130.0n 0.80000 39259.9n 0.80000 39260.0n 0.80000 39389.9n 0.80000 39390.0n 0.80000 39519.9n 0.80000 39520.0n 0.80000 39649.9n 0.80000 39650.0n 0.80000 39779.9n 0.80000 39780.0n 0.80000 39909.9n 0.80000 39910.0n 0.80000 40039.9n 0.80000 40040.0n 0.80000 40169.9n 0.80000 40170.0n 0.80000 40299.9n 0.80000 40300.0n 0.80000 40429.9n 0.80000 40430.0n 0.80000 40559.9n 0.80000 40560.0n 0.80000 40689.9n 0.80000 40690.0n 0.80000 40819.9n 0.80000 40820.0n 0.80000 40949.9n 0.80000 40950.0n 0.80000 41079.9n 0.80000 41080.0n 0.80000 41209.9n 0.80000 41210.0n 0.80000 41339.9n 0.80000 41340.0n 0.80000 41469.9n 0.80000 41470.0n 0.80000 41599.9n 0.80000 41600.0n 0.80000 41729.9n 0.80000 41730.0n 0.80000 41859.9n 0.80000 41860.0n 0.80000 41989.9n 0.80000 41990.0n 0.80000 42119.9n 0.80000 42120.0n 0.80000 42249.9n 0.80000 42250.0n 0.80000 42379.9n 0.80000 42380.0n 0.80000 42509.9n 0.80000 42510.0n 0.80000 42639.9n 0.80000 42640.0n 0.80000 42769.9n 0.80000 42770.0n 0.80000 42899.9n 0.80000 42900.0n 0.80000 43029.9n 0.80000 43030.0n 0.80000 43159.9n 0.80000 43160.0n 0.80000 43289.9n 0.80000 43290.0n 0.80000 43419.9n 0.80000 43420.0n 0.80000 43549.9n 0.80000 43550.0n 0.80000 43679.9n 0.80000 43680.0n 0.80000 43809.9n 0.80000 43810.0n 0.80000 43939.9n 0.80000 43940.0n 0.80000 44069.9n 0.80000 44070.0n 0.80000 44199.9n 0.80000 44200.0n 0.80000 44329.9n 0.80000 44330.0n 0.80000 44459.9n 0.80000 44460.0n 0.80000 44589.9n 0.80000 44590.0n 0.80000 44719.9n 0.80000 44720.0n 0.80000 44849.9n 0.80000 44850.0n 0.80000 44979.9n 0.80000 44980.0n 0.80000 45109.9n 0.80000 45110.0n 0.80000 45239.9n 0.80000 45240.0n 0.80000 45369.9n 0.80000 45370.0n 0.80000 45499.9n 0.80000 45500.0n 0.80000 45629.9n 0.80000 45630.0n 0.80000 45759.9n 0.80000 45760.0n 0.80000 45889.9n 0.80000 45890.0n 0.80000 46019.9n 0.80000 46020.0n 0.80000 46149.9n 0.80000 46150.0n 0.80000 46279.9n 0.80000 46280.0n 0.80000 46409.9n 0.80000 46410.0n 0.80000 46539.9n 0.80000 46540.0n 0.80000 46669.9n 0.80000 46670.0n 0.80000 46799.9n 0.80000 46800.0n 0.80000 46929.9n 0.80000 46930.0n 0.80000 47059.9n 0.80000 47060.0n 0.80000 47189.9n 0.80000 47190.0n 0.80000 47319.9n 0.80000 47320.0n 0.80000 47449.9n 0.80000 47450.0n 0.80000 47579.9n 0.80000 47580.0n 0.80000 47709.9n 0.80000 47710.0n 0.80000 47839.9n 0.80000 47840.0n 0.80000 47969.9n 0.80000 47970.0n 0.80000 48099.9n 0.80000 48100.0n 0.80000 48229.9n 0.80000 48230.0n 0.80000 48359.9n 0.80000 48360.0n 0.80000 48489.9n 0.80000 48490.0n 0.80000 48619.9n 0.80000 48620.0n 0.80000 48749.9n 0.80000 48750.0n 0.80000 48879.9n 0.80000 48880.0n 0.80000 49009.9n 0.80000 49010.0n 0.80000 49139.9n 0.80000 49140.0n 0.80000 49269.9n 0.80000 49270.0n 0.80000 49399.9n 0.80000 49400.0n 0.80000 49529.9n 0.80000 49530.0n 0.80000 49659.9n 0.80000 49660.0n 0.80000 49789.9n 0.80000 49790.0n 0.80000 49919.9n 0.80000 49920.0n 0.80000 50049.9n 0.80000 50050.0n 0.80000 50179.9n 0.80000 50180.0n 0.80000 50309.9n 0.80000 50310.0n 0.80000 50439.9n 0.80000 50440.0n 0.80000 50569.9n 0.80000 50570.0n 0.80000 50699.9n 0.80000 50700.0n 0.80000 50829.9n 0.80000 50830.0n 0.80000 50959.9n 0.80000 50960.0n 0.80000 51089.9n 0.80000 51090.0n 0.80000 51219.9n 0.80000 51220.0n 0.80000 51349.9n 0.80000 51350.0n 0.80000 51479.9n 0.80000 51480.0n 0.80000 51609.9n 0.80000 51610.0n 0.80000 51739.9n 0.80000 51740.0n 0.80000 51869.9n 0.80000 51870.0n 0.80000 51999.9n 0.80000 52000.0n 0.80000 52129.9n 0.80000 52130.0n 0.80000 52259.9n 0.80000 52260.0n 0.80000 52389.9n 0.80000 52390.0n 0.80000 52519.9n 0.80000 52520.0n 0.80000 52649.9n 0.80000 52650.0n 0.80000 52779.9n 0.80000 52780.0n 0.80000 52909.9n 0.80000 52910.0n 0.80000 53039.9n 0.80000 53040.0n 0.80000 53169.9n 0.80000 53170.0n 0.80000 53299.9n 0.80000 53300.0n 0.80000 53429.9n 0.80000 53430.0n 0.80000 53559.9n 0.80000 53560.0n 0.80000 53689.9n 0.80000 53690.0n 0.80000 53819.9n 0.80000 53820.0n 0.80000 53949.9n 0.80000 53950.0n 0.80000 54079.9n 0.80000 54080.0n 0.80000 54209.9n 0.80000 54210.0n 0.80000 54339.9n 0.80000 54340.0n 0.80000 54469.9n 0.80000 54470.0n 0.80000 54599.9n 0.80000 54600.0n 0.80000 54729.9n 0.80000 54730.0n 0.80000 54859.9n 0.80000 54860.0n 0.80000 54989.9n 0.80000 54990.0n 0.80000 55119.9n 0.80000 55120.0n 0.80000 55249.9n 0.80000 55250.0n 0.80000 55379.9n 0.80000 55380.0n 0.80000 55509.9n 0.80000 55510.0n 0.80000 55639.9n 0.80000 55640.0n 0.80000 55769.9n 0.80000 55770.0n 0.80000 55899.9n 0.80000 55900.0n 0.80000 56029.9n 0.80000 56030.0n 0.80000 56159.9n 0.80000 56160.0n 0.80000 56289.9n 0.80000 56290.0n 0.80000 56419.9n 0.80000 56420.0n 0.80000 56549.9n 0.80000 56550.0n 0.80000 56679.9n 0.80000 56680.0n 0.80000 56809.9n 0.80000 56810.0n 0.80000 56939.9n 0.80000 56940.0n 0.80000 57069.9n 0.80000 57070.0n 0.80000 57199.9n 0.80000 57200.0n 0.80000 57329.9n 0.80000 57330.0n 0.80000 57459.9n 0.80000 57460.0n 0.80000 57589.9n 0.80000 57590.0n 0.80000 57719.9n 0.80000 57720.0n 0.80000 57849.9n 0.80000 57850.0n 0.80000 57979.9n 0.80000 57980.0n 0.80000 58109.9n 0.80000 58110.0n 0.80000 58239.9n 0.80000 58240.0n 0.80000 58369.9n 0.80000 58370.0n 0.80000 58499.9n 0.80000 58500.0n 0.80000 58629.9n 0.80000 58630.0n 0.80000 58759.9n 0.80000 58760.0n 0.80000 58889.9n 0.80000 58890.0n 0.80000 59019.9n 0.80000 59020.0n 0.80000 59149.9n 0.80000 59150.0n 0.80000 59279.9n 0.80000 59280.0n 0.80000 59409.9n 0.80000 59410.0n 0.80000 59539.9n 0.80000 59540.0n 0.80000 59669.9n 0.80000 59670.0n 0.80000 59799.9n 0.80000 59800.0n 0.80000 59929.9n 0.80000 59930.0n 0.80000 60059.9n 0.80000 60060.0n 0.80000 60189.9n 0.80000 60190.0n 0.80000 60319.9n 0.80000 60320.0n 0.80000 60449.9n 0.80000 60450.0n 0.80000 60579.9n 0.80000 60580.0n 0.80000 60709.9n 0.80000 60710.0n 0.80000 60839.9n 0.80000 60840.0n 0.80000 60969.9n 0.80000 60970.0n 0.80000 61099.9n 0.80000 61100.0n 0.80000 61229.9n 0.80000 61230.0n 0.80000 61359.9n 0.80000 61360.0n 0.80000 61489.9n 0.80000 61490.0n 0.80000 61619.9n 0.80000 61620.0n 0.80000 61749.9n 0.80000 61750.0n 0.80000 61879.9n 0.80000 61880.0n 0.80000 62009.9n 0.80000 62010.0n 0.80000 62139.9n 0.80000 62140.0n 0.80000 62269.9n 0.80000 62270.0n 0.80000 62399.9n 0.80000 62400.0n 0.80000 62529.9n 0.80000 62530.0n 0.80000 62659.9n 0.80000 62660.0n 0.80000 62789.9n 0.80000 62790.0n 0.80000 62919.9n 0.80000 62920.0n 0.80000 63049.9n 0.80000 63050.0n 0.80000 63179.9n 0.80000 63180.0n 0.80000 63309.9n 0.80000 63310.0n 0.80000 63439.9n 0.80000 63440.0n 0.80000 63569.9n 0.80000 63570.0n 0.80000 63699.9n 0.80000 63700.0n 0.80000 63829.9n 0.80000 63830.0n 0.80000 63959.9n 0.80000 63960.0n 0.80000 64089.9n 0.80000 64090.0n 0.80000 64219.9n 0.80000 64220.0n 0.80000 64349.9n 0.80000 64350.0n 0.80000 64479.9n 0.80000 64480.0n 0.80000 64609.9n 0.80000 64610.0n 0.80000 64739.9n 0.80000 64740.0n 0.80000 64869.9n 0.80000 64870.0n 0.80000 64999.9n 0.80000 65000.0n 0.80000 65129.9n 0.80000 65130.0n 0.80000 65259.9n 0.80000 65260.0n 0.80000 65389.9n 0.80000 65390.0n 0.80000 65519.9n 0.80000 65520.0n 0.80000 65649.9n 0.80000 65650.0n 0.80000 65779.9n 0.80000 65780.0n 0.80000 65909.9n 0.80000 65910.0n 0.80000 66039.9n 0.80000 66040.0n 0.80000 66169.9n 0.80000 66170.0n 0.80000 66299.9n 0.80000 66300.0n 0.80000 66429.9n 0.80000 66430.0n 0.80000 66559.9n 0.80000 66560.0n 0.80000 66689.9n 0.80000 66690.0n 0.80000 66819.9n 0.80000 66820.0n 0.80000 66949.9n 0.80000 66950.0n 0.80000 67079.9n 0.80000 67080.0n 0.80000 67209.9n 0.80000 67210.0n 0.80000 67339.9n 0.80000 67340.0n 0.80000 67469.9n 0.80000 67470.0n 0.80000 67599.9n 0.80000 67600.0n 0.80000 67729.9n 0.80000 67730.0n 0.80000 67859.9n 0.80000 67860.0n 0.80000 67989.9n 0.80000 67990.0n 0.80000 68119.9n 0.80000 68120.0n 0.80000 68249.9n 0.80000 68250.0n 0.80000 68379.9n 0.80000 68380.0n 0.80000 68509.9n 0.80000 68510.0n 0.80000 68639.9n 0.80000 68640.0n 0.80000 68769.9n 0.80000 68770.0n 0.80000 68899.9n 0.80000 68900.0n 0.80000 69029.9n 0.80000 69030.0n 0.80000 69159.9n 0.80000 69160.0n 0.80000 69289.9n 0.80000 69290.0n 0.80000 69419.9n 0.80000 69420.0n 0.80000 69549.9n 0.80000 69550.0n 0.80000 69679.9n 0.80000 69680.0n 0.80000 69809.9n 0.80000 69810.0n 0.80000 69939.9n 0.80000 69940.0n 0.80000 70069.9n 0.80000 70070.0n 0.80000 70199.9n 0.80000 70200.0n 0.80000 70329.9n 0.80000 70330.0n 0.80000 70459.9n 0.80000 70460.0n 0.80000 70589.9n 0.80000 70590.0n 0.80000 70719.9n 0.80000 70720.0n 0.80000 70849.9n 0.80000 70850.0n 0.80000 70979.9n 0.80000 70980.0n 0.80000 71109.9n 0.80000 71110.0n 0.80000 71239.9n 0.80000 71240.0n 0.80000 71369.9n 0.80000 71370.0n 0.80000 71499.9n 0.80000 71500.0n 0.80000 71629.9n 0.80000 71630.0n 0.80000 71759.9n 0.80000 71760.0n 0.80000 71889.9n 0.80000 71890.0n 0.80000 72019.9n 0.80000 72020.0n 0.80000 72149.9n 0.80000 72150.0n 0.80000 72279.9n 0.80000 72280.0n 0.80000 72409.9n 0.80000 72410.0n 0.80000 72539.9n 0.80000 72540.0n 0.80000 72669.9n 0.80000 72670.0n 0.80000 72799.9n 0.80000 72800.0n 0.80000 72929.9n 0.80000 72930.0n 0.80000 73059.9n 0.80000 73060.0n 0.80000 73189.9n 0.80000 73190.0n 0.80000 73319.9n 0.80000 73320.0n 0.80000 73449.9n 0.80000 73450.0n 0.80000 73579.9n 0.80000 73580.0n 0.80000 73709.9n 0.80000 73710.0n 0.80000 73839.9n 0.80000 73840.0n 0.80000 73969.9n 0.80000 73970.0n 0.80000 74099.9n 0.80000 74100.0n 0.80000 74229.9n 0.80000 74230.0n 0.80000 74359.9n 0.80000 74360.0n 0.80000 74489.9n 0.80000 74490.0n 0.80000 74619.9n 0.80000 74620.0n 0.80000 74749.9n 0.80000 74750.0n 0.80000 74879.9n 0.80000 74880.0n 0.80000 75009.9n 0.80000 75010.0n 0.80000 75139.9n 0.80000 75140.0n 0.80000 75269.9n 0.80000 75270.0n 0.80000 75399.9n 0.80000 75400.0n 0.80000 75529.9n 0.80000 75530.0n 0.80000 75659.9n 0.80000 75660.0n 0.80000 75789.9n 0.80000 75790.0n 0.80000 75919.9n 0.80000 75920.0n 0.80000 76049.9n 0.80000 76050.0n 0.80000 76179.9n 0.80000 76180.0n 0.80000 76309.9n 0.80000 76310.0n 0.80000 76439.9n 0.80000 76440.0n 0.80000 76569.9n 0.80000 76570.0n 0.80000 76699.9n 0.80000 76700.0n 0.80000 76829.9n 0.80000 76830.0n 0.80000 76959.9n 0.80000 76960.0n 0.80000 77089.9n 0.80000 77090.0n 0.80000 77219.9n 0.80000 77220.0n 0.80000 77349.9n 0.80000 77350.0n 0.80000 77479.9n 0.80000 77480.0n 0.80000 77609.9n 0.80000 77610.0n 0.80000 77739.9n 0.80000 77740.0n 0.80000 77869.9n 0.80000 77870.0n 0.80000 77999.9n 0.80000 78000.0n 0.80000 78129.9n 0.80000 78130.0n 0.80000 78259.9n 0.80000 78260.0n 0.80000 78389.9n 0.80000 78390.0n 0.80000 78519.9n 0.80000 78520.0n 0.80000 78649.9n 0.80000 78650.0n 0.80000 78779.9n 0.80000 78780.0n 0.80000 78909.9n 0.80000 78910.0n 0.80000 79039.9n 0.80000 79040.0n 0.80000 79169.9n 0.80000 79170.0n 0.80000 79299.9n 0.80000 79300.0n 0.80000 79429.9n 0.80000 79430.0n 0.80000 79559.9n 0.80000 79560.0n 0.80000 79689.9n 0.80000 79690.0n 0.80000 79819.9n 0.80000 79820.0n 0.80000 79949.9n 0.80000 79950.0n 0.80000 80079.9n 0.80000 80080.0n 0.80000 80209.9n 0.80000 80210.0n 0.80000 80339.9n 0.80000 80340.0n 0.80000 80469.9n 0.80000 80470.0n 0.80000 80599.9n 0.80000 80600.0n 0.80000 80729.9n 0.80000 80730.0n 0.80000 80859.9n 0.80000 80860.0n 0.80000 80989.9n 0.80000 80990.0n 0.80000 81119.9n 0.80000 81120.0n 0.80000 81249.9n 0.80000 81250.0n 0.80000 81379.9n 0.80000 81380.0n 0.80000 81509.9n 0.80000 81510.0n 0.80000 81639.9n 0.80000 81640.0n 0.80000 81769.9n 0.80000 81770.0n 0.80000 81899.9n 0.80000 81900.0n 0.80000 82029.9n 0.80000 82030.0n 0.80000 82159.9n 0.80000 82160.0n 0.80000 82289.9n 0.80000 82290.0n 0.80000 82419.9n 0.80000 82420.0n 0.80000 82549.9n 0.80000 82550.0n 0.80000 82679.9n 0.80000 82680.0n 0.80000 82809.9n 0.80000 82810.0n 0.80000 82939.9n 0.80000 82940.0n 0.80000 83069.9n 0.80000 83070.0n 0.80000 83199.9n 0.80000 83200.0n 0.80000 83329.9n 0.80000 83330.0n 0.80000 83459.9n 0.80000 83460.0n 0.80000 83589.9n 0.80000 83590.0n 0.80000 83719.9n 0.80000 83720.0n 0.80000 83849.9n 0.80000 83850.0n 0.80000 83979.9n 0.80000 83980.0n 0.80000 84109.9n 0.80000 84110.0n 0.80000 84239.9n 0.80000 84240.0n 0.80000 84369.9n 0.80000 84370.0n 0.80000 84499.9n 0.80000 84500.0n 0.80000 84629.9n 0.80000 84630.0n 0.80000 84759.9n 0.80000 84760.0n 0.80000 84889.9n 0.80000 84890.0n 0.80000 85019.9n 0.80000 85020.0n 0.80000 85149.9n 0.80000 85150.0n 0.80000 85279.9n 0.80000 85280.0n 0.80000 85409.9n 0.80000 85410.0n 0.80000 85539.9n 0.80000 85540.0n 0.80000 85669.9n 0.80000 85670.0n 0.80000 85799.9n 0.80000 85800.0n 0.80000 85929.9n 0.80000 85930.0n 0.80000 86059.9n 0.80000 86060.0n 0.80000 86189.9n 0.80000 86190.0n 0.80000 86319.9n 0.80000 86320.0n 0.80000 86449.9n 0.80000 86450.0n 0.80000 86579.9n 0.80000 86580.0n 0.80000 86709.9n 0.80000 86710.0n 0.80000 86839.9n 0.80000 86840.0n 0.80000 86969.9n 0.80000 86970.0n 0.80000 87099.9n 0.80000 87100.0n 0.80000 87229.9n 0.80000 87230.0n 0.80000 87359.9n 0.80000 87360.0n 0.80000 87489.9n 0.80000 87490.0n 0.80000 87619.9n 0.80000 87620.0n 0.80000 87749.9n 0.80000 87750.0n 0.80000 87879.9n 0.80000 87880.0n 0.80000 88009.9n 0.80000 88010.0n 0.80000 88139.9n 0.80000 88140.0n 0.80000 88269.9n 0.80000 88270.0n 0.80000 88399.9n 0.80000 88400.0n 0.80000 88529.9n 0.80000 88530.0n 0.80000 88659.9n 0.80000 88660.0n 0.80000 88789.9n 0.80000 88790.0n 0.80000 88919.9n 0.80000 88920.0n 0.80000 89049.9n 0.80000 89050.0n 0.80000 89179.9n 0.80000 89180.0n 0.80000 89309.9n 0.80000 89310.0n 0.80000 89439.9n 0.80000 89440.0n 0.80000 89569.9n 0.80000 89570.0n 0.80000 89699.9n 0.80000 89700.0n 0.80000 89829.9n 0.80000 89830.0n 0.80000 89959.9n 0.80000 89960.0n 0.80000 90089.9n 0.80000 90090.0n 0.80000 90219.9n 0.80000 90220.0n 0.80000 90349.9n 0.80000 90350.0n 0.80000 90479.9n 0.80000 90480.0n 0.80000 90609.9n 0.80000 90610.0n 0.80000 90739.9n 0.80000 90740.0n 0.80000 90869.9n 0.80000 90870.0n 0.80000 90999.9n 0.80000 91000.0n 0.80000 91129.9n 0.80000 91130.0n 0.80000 91259.9n 0.80000 91260.0n 0.80000 91389.9n 0.80000 91390.0n 0.80000 91519.9n 0.80000 91520.0n 0.80000 91649.9n 0.80000 91650.0n 0.80000 91779.9n 0.80000 91780.0n 0.80000 91909.9n 0.80000 91910.0n 0.80000 92039.9n 0.80000 92040.0n 0.80000 92169.9n 0.80000 92170.0n 0.80000 92299.9n 0.80000 92300.0n 0.80000 92429.9n 0.80000 92430.0n 0.80000 92559.9n 0.80000 92560.0n 0.80000 92689.9n 0.80000 92690.0n 0.80000 92819.9n 0.80000 92820.0n 0.80000 92949.9n 0.80000 92950.0n 0.80000 93079.9n 0.80000 93080.0n 0.80000 93209.9n 0.80000 93210.0n 0.80000 93339.9n 0.80000 93340.0n 0.80000 93469.9n 0.80000 93470.0n 0.80000 93599.9n 0.80000 93600.0n 0.80000 93729.9n 0.80000 93730.0n 0.80000 93859.9n 0.80000 93860.0n 0.80000 93989.9n 0.80000 93990.0n 0.80000 94119.9n 0.80000 94120.0n 0.80000 94249.9n 0.80000 94250.0n 0.80000 94379.9n 0.80000 94380.0n 0.80000 94509.9n 0.80000 94510.0n 0.80000 94639.9n 0.80000 94640.0n 0.80000 94769.9n 0.80000 94770.0n 0.80000 94899.9n 0.80000 94900.0n 0.80000 95029.9n 0.80000 95030.0n 0.80000 95159.9n 0.80000 95160.0n 0.80000 95289.9n 0.80000 95290.0n 0.80000 95419.9n 0.80000 95420.0n 0.80000 95549.9n 0.80000 95550.0n 0.80000 95679.9n 0.80000 95680.0n 0.80000 95809.9n 0.80000 95810.0n 0.80000 95939.9n 0.80000 95940.0n 0.80000 96069.9n 0.80000 96070.0n 0.80000 96199.9n 0.80000 96200.0n 0.80000 96329.9n 0.80000 96330.0n 0.80000 96459.9n 0.80000 96460.0n 0.80000 96589.9n 0.80000 96590.0n 0.80000 96719.9n 0.80000 96720.0n 0.80000 96849.9n 0.80000 96850.0n 0.80000 96979.9n 0.80000 96980.0n 0.80000 97109.9n 0.80000 97110.0n 0.80000 97239.9n 0.80000 97240.0n 0.80000 97369.9n 0.80000 97370.0n 0.80000 97499.9n 0.80000 97500.0n 0.80000 97629.9n 0.80000 97630.0n 0.80000 97759.9n 0.80000 97760.0n 0.80000 97889.9n 0.80000 97890.0n 0.80000 98019.9n 0.80000 98020.0n 0.80000 98149.9n 0.80000 98150.0n 0.80000 98279.9n 0.80000 98280.0n 0.80000 98409.9n 0.80000 98410.0n 0.80000 98539.9n 0.80000 98540.0n 0.80000 98669.9n 0.80000 98670.0n 0.80000 98799.9n 0.80000 98800.0n 0.80000 98929.9n 0.80000 98930.0n 0.80000 99059.9n 0.80000 99060.0n 0.80000 99189.9n 0.80000 99190.0n 0.80000 99319.9n 0.80000 99320.0n 0.80000 99449.9n 0.80000 99450.0n 0.80000 99579.9n 0.80000 99580.0n 0.80000 99709.9n 0.80000 99710.0n 0.80000 99839.9n 0.80000 99840.0n 0.80000 99969.9n 0.80000 99970.0n 0.80000 100099.9n 0.80000 100100.0n 0.80000 100229.9n 0.80000 100230.0n 0.80000 100359.9n 0.80000 100360.0n 0.80000 100489.9n 0.80000 100490.0n 0.80000 100619.9n 0.80000 100620.0n 0.80000 100749.9n 0.80000 100750.0n 0.80000 100879.9n 0.80000 100880.0n 0.80000 101009.9n 0.80000 101010.0n 0.80000 101139.9n 0.80000 101140.0n 0.80000 101269.9n 0.80000 101270.0n 0.80000 101399.9n 0.80000 101400.0n 0.80000 101529.9n 0.80000 101530.0n 0.80000 101659.9n 0.80000 101660.0n 0.80000 101789.9n 0.80000 101790.0n 0.80000 101919.9n 0.80000 101920.0n 0.80000 102049.9n 0.80000 102050.0n 0.80000 102179.9n 0.80000 102180.0n 0.80000 102309.9n 0.80000 102310.0n 0.80000 102439.9n 0.80000 102440.0n 0.80000 102569.9n 0.80000 102570.0n 0.80000 102699.9n 0.80000 102700.0n 0.80000 102829.9n 0.80000 102830.0n 0.80000 102959.9n 0.80000 102960.0n 0.80000 103089.9n 0.80000 103090.0n 0.80000 103219.9n 0.80000 103220.0n 0.80000 103349.9n 0.80000 103350.0n 0.80000 103479.9n 0.80000 103480.0n 0.80000 103609.9n 0.80000 103610.0n 0.80000 103739.9n 0.80000 103740.0n 0.80000 103869.9n 0.80000 103870.0n 0.80000 103999.9n 0.80000 104000.0n 0.80000 104129.9n 0.80000 104130.0n 0.80000 104259.9n 0.80000 104260.0n 0.80000 104389.9n 0.80000 104390.0n 0.80000 104519.9n 0.80000 104520.0n 0.80000 104649.9n 0.80000 104650.0n 0.80000 104779.9n 0.80000 104780.0n 0.80000 104909.9n 0.80000 104910.0n 0.80000 105039.9n 0.80000 105040.0n 0.80000 105169.9n 0.80000 105170.0n 0.80000 105299.9n 0.80000 105300.0n 0.80000 105429.9n 0.80000 105430.0n 0.80000 105559.9n 0.80000 105560.0n 0.80000 105689.9n 0.80000 105690.0n 0.80000 105819.9n 0.80000 105820.0n 0.80000 105949.9n 0.80000 105950.0n 0.80000 106079.9n 0.80000 106080.0n 0.80000 106209.9n 0.80000 106210.0n 0.80000 106339.9n 0.80000 106340.0n 0.80000 106469.9n 0.80000 106470.0n 0.80000 106599.9n 0.80000 106600.0n 0.80000 106729.9n 0.80000 106730.0n 0.80000 106859.9n 0.80000 106860.0n 0.80000 106989.9n 0.80000 106990.0n 0.80000 107119.9n 0.80000 107120.0n 0.80000 107249.9n 0.80000 107250.0n 0.80000 107379.9n 0.80000 107380.0n 0.80000 107509.9n 0.80000 107510.0n 0.80000 107639.9n 0.80000 107640.0n 0.80000 107769.9n 0.80000 107770.0n 0.80000 107899.9n 0.80000 107900.0n 0.80000 108029.9n 0.80000 108030.0n 0.80000 108159.9n 0.80000 108160.0n 0.80000 108289.9n 0.80000 108290.0n 0.80000 108419.9n 0.80000 108420.0n 0.80000 108549.9n 0.80000 108550.0n 0.80000 108679.9n 0.80000 108680.0n 0.80000 108809.9n 0.80000 108810.0n 0.80000 108939.9n 0.80000 108940.0n 0.80000 109069.9n 0.80000 109070.0n 0.80000 109199.9n 0.80000 109200.0n 0.80000 109329.9n 0.80000 109330.0n 0.80000 109459.9n 0.80000 109460.0n 0.80000 109589.9n 0.80000 109590.0n 0.80000 109719.9n 0.80000 109720.0n 0.80000 109849.9n 0.80000 109850.0n 0.80000 109979.9n 0.80000 109980.0n 0.80000 110109.9n 0.80000 110110.0n 0.80000 110239.9n 0.80000 110240.0n 0.80000 110369.9n 0.80000 110370.0n 0.80000 110499.9n 0.80000 110500.0n 0.80000 110629.9n 0.80000 110630.0n 0.80000 110759.9n 0.80000 110760.0n 0.80000 110889.9n 0.80000 110890.0n 0.80000 111019.9n 0.80000 111020.0n 0.80000 111149.9n 0.80000 111150.0n 0.80000 111279.9n 0.80000 111280.0n 0.80000 111409.9n 0.80000 111410.0n 0.80000 111539.9n 0.80000 111540.0n 0.80000 111669.9n 0.80000 111670.0n 0.80000 111799.9n 0.80000 111800.0n 0.80000 111929.9n 0.80000 111930.0n 0.80000 112059.9n 0.80000 112060.0n 0.80000 112189.9n 0.80000 112190.0n 0.80000 112319.9n 0.80000 112320.0n 0.80000 112449.9n 0.80000 112450.0n 0.80000 112579.9n 0.80000 112580.0n 0.80000 112709.9n 0.80000 112710.0n 0.80000 112839.9n 0.80000 112840.0n 0.80000 112969.9n 0.80000 112970.0n 0.80000 113099.9n 0.80000 113100.0n 0.80000 113229.9n 0.80000 113230.0n 0.80000 113359.9n 0.80000 113360.0n 0.80000 113489.9n 0.80000 113490.0n 0.80000 113619.9n 0.80000 113620.0n 0.80000 113749.9n 0.80000 113750.0n 0.80000 113879.9n 0.80000 113880.0n 0.80000 114009.9n 0.80000 114010.0n 0.80000 114139.9n 0.80000 114140.0n 0.80000 114269.9n 0.80000 114270.0n 0.80000 114399.9n 0.80000 114400.0n 0.80000 114529.9n 0.80000 114530.0n 0.80000 114659.9n 0.80000 114660.0n 0.80000 114789.9n 0.80000 114790.0n 0.80000 114919.9n 0.80000 114920.0n 0.80000 115049.9n 0.80000 115050.0n 0.80000 115179.9n 0.80000 115180.0n 0.80000 115309.9n 0.80000 115310.0n 0.80000 115439.9n 0.80000 115440.0n 0.80000 115569.9n 0.80000 115570.0n 0.80000 115699.9n 0.80000 115700.0n 0.80000 115829.9n 0.80000 115830.0n 0.80000 115959.9n 0.80000 115960.0n 0.80000 116089.9n 0.80000 116090.0n 0.80000 116219.9n 0.80000 116220.0n 0.80000 116349.9n 0.80000 116350.0n 0.80000 116479.9n 0.80000 116480.0n 0.80000 116609.9n 0.80000 116610.0n 0.80000 116739.9n 0.80000 116740.0n 0.80000 116869.9n 0.80000 116870.0n 0.80000 116999.9n 0.80000 117000.0n 0.80000 117129.9n 0.80000 117130.0n 0.80000 117259.9n 0.80000 117260.0n 0.80000 117389.9n 0.80000 117390.0n 0.80000 117519.9n 0.80000 117520.0n 0.80000 117649.9n 0.80000 117650.0n 0.80000 117779.9n 0.80000 117780.0n 0.80000 117909.9n 0.80000 117910.0n 0.80000 118039.9n 0.80000 118040.0n 0.80000 118169.9n 0.80000 118170.0n 0.80000 118299.9n 0.80000 118300.0n 0.80000 118429.9n 0.80000 118430.0n 0.80000 118559.9n 0.80000 118560.0n 0.80000 118689.9n 0.80000 118690.0n 0.80000 118819.9n 0.80000 118820.0n 0.80000 118949.9n 0.80000 118950.0n 0.80000 119079.9n 0.80000 119080.0n 0.80000 119209.9n 0.80000 119210.0n 0.80000 119339.9n 0.80000 119340.0n 0.80000 119469.9n 0.80000 119470.0n 0.80000 119599.9n 0.80000 119600.0n 0.80000 119729.9n 0.80000 119730.0n 0.80000 119859.9n 0.80000 119860.0n 0.80000 119989.9n 0.80000 119990.0n 0.80000 120119.9n 0.80000 120120.0n 0.80000 120249.9n 0.80000 120250.0n 0.80000 120379.9n 0.80000 120380.0n 0.80000 120509.9n 0.80000 120510.0n 0.80000 120639.9n 0.80000 120640.0n 0.80000 120769.9n 0.80000 120770.0n 0.80000 120899.9n 0.80000 120900.0n 0.80000 121029.9n 0.80000 121030.0n 0.80000 121159.9n 0.80000 121160.0n 0.80000 121289.9n 0.80000 121290.0n 0.80000 121419.9n 0.80000 121420.0n 0.80000 121549.9n 0.80000 121550.0n 0.80000 121679.9n 0.80000 121680.0n 0.80000 121809.9n 0.80000 121810.0n 0.80000 121939.9n 0.80000 121940.0n 0.80000 122069.9n 0.80000 122070.0n 0.80000 122199.9n 0.80000 122200.0n 0.80000 122329.9n 0.80000 122330.0n 0.80000 122459.9n 0.80000 122460.0n 0.80000 122589.9n 0.80000 122590.0n 0.80000 122719.9n 0.80000 122720.0n 0.80000 122849.9n 0.80000 122850.0n 0.80000 122979.9n 0.80000 122980.0n 0.80000 123109.9n 0.80000 123110.0n 0.80000 123239.9n 0.80000 123240.0n 0.80000 123369.9n 0.80000 123370.0n 0.80000 123499.9n 0.80000 123500.0n 0.80000 123629.9n 0.80000 123630.0n 0.80000 123759.9n 0.80000 123760.0n 0.80000 123889.9n 0.80000 123890.0n 0.80000 124019.9n 0.80000 124020.0n 0.80000 124149.9n 0.80000 124150.0n 0.80000 124279.9n 0.80000 124280.0n 0.80000 124409.9n 0.80000 124410.0n 0.80000 124539.9n 0.80000 124540.0n 0.80000 124669.9n 0.80000 124670.0n 0.80000 124799.9n 0.80000 124800.0n 0.80000 124929.9n 0.80000 124930.0n 0.80000 125059.9n 0.80000 125060.0n 0.80000 125189.9n 0.80000 125190.0n 0.80000 125319.9n 0.80000 125320.0n 0.80000 125449.9n 0.80000 125450.0n 0.80000 125579.9n 0.80000 125580.0n 0.80000 125709.9n 0.80000 125710.0n 0.80000 125839.9n 0.80000 125840.0n 0.80000 125969.9n 0.80000 125970.0n 0.80000 126099.9n 0.80000 126100.0n 0.80000 126229.9n 0.80000 126230.0n 0.80000 126359.9n 0.80000 126360.0n 0.80000 126489.9n 0.80000 126490.0n 0.80000 126619.9n 0.80000 126620.0n 0.80000 126749.9n 0.80000 126750.0n 0.80000 126879.9n 0.80000 126880.0n 0.80000 127009.9n 0.80000 127010.0n 0.80000 127139.9n 0.80000 127140.0n 0.80000 127269.9n 0.80000 127270.0n 0.80000 127399.9n 0.80000 127400.0n 0.80000 127529.9n 0.80000 127530.0n 0.80000 127659.9n 0.80000 127660.0n 0.80000 127789.9n 0.80000 127790.0n 0.80000 127919.9n 0.80000 127920.0n 0.80000 128049.9n 0.80000 128050.0n 0.80000 128179.9n 0.80000 128180.0n 0.80000 128309.9n 0.80000 128310.0n 0.80000 128439.9n 0.80000 128440.0n 0.80000 128569.9n 0.80000 128570.0n 0.80000 128699.9n 0.80000 128700.0n 0.80000 128829.9n 0.80000 128830.0n 0.80000 128959.9n 0.80000 128960.0n 0.80000 129089.9n 0.80000 129090.0n 0.80000 129219.9n 0.80000 129220.0n 0.80000 129349.9n 0.80000 129350.0n 0.80000 129479.9n 0.80000 129480.0n 0.80000 129609.9n 0.80000 129610.0n 0.80000 129739.9n 0.80000 129740.0n 0.80000 129869.9n 0.80000 129870.0n 0.80000 129999.9n 0.80000 130000.0n 0.80000 130129.9n 0.80000 130130.0n 0.80000 130259.9n 0.80000 130260.0n 0.80000 130389.9n 0.80000 130390.0n 0.80000 130519.9n 0.80000 130520.0n 0.80000 130649.9n 0.80000 130650.0n 0.80000 130779.9n 0.80000 130780.0n 0.80000 130909.9n 0.80000 130910.0n 0.80000 131039.9n 0.80000 131040.0n 0.80000 131169.9n 0.80000 131170.0n 0.80000 131299.9n 0.80000 131300.0n 0.80000 131429.9n 0.80000 131430.0n 0.80000 131559.9n 0.80000 131560.0n 0.80000 131689.9n 0.80000 131690.0n 0.80000 131819.9n 0.80000 131820.0n 0.80000 131949.9n 0.80000 131950.0n 0.80000 132079.9n 0.80000 132080.0n 0.80000 132209.9n 0.80000 132210.0n 0.80000 132339.9n 0.80000 132340.0n 0.80000 132469.9n 0.80000 132470.0n 0.80000 132599.9n 0.80000 132600.0n 0.80000 132729.9n 0.80000 132730.0n 0.80000 132859.9n 0.80000 132860.0n 0.80000 132989.9n 0.80000 132990.0n 0.80000 133119.9n 0.80000 133120.0n 0.80000 133249.9n 0.80000 133250.0n 0.80000 133379.9n 0.80000 133380.0n 0.80000 133509.9n 0.80000 133510.0n 0.80000 133639.9n 0.80000 133640.0n 0.80000 133769.9n 0.80000 133770.0n 0.80000 133899.9n 0.80000 133900.0n 0.80000 134029.9n 0.80000 134030.0n 0.80000 134159.9n 0.80000 134160.0n 0.80000 134289.9n 0.80000 134290.0n 0.80000 134419.9n 0.80000 134420.0n 0.80000 134549.9n 0.80000 134550.0n 0.80000 134679.9n 0.80000 134680.0n 0.80000 134809.9n 0.80000 134810.0n 0.80000 134939.9n 0.80000 134940.0n 0.80000 135069.9n 0.80000 135070.0n 0.80000 135199.9n 0.80000 135200.0n 0.80000 135329.9n 0.80000 135330.0n 0.80000 135459.9n 0.80000 135460.0n 0.80000 135589.9n 0.80000 135590.0n 0.80000 135719.9n 0.80000 135720.0n 0.80000 135849.9n 0.80000 135850.0n 0.80000 135979.9n 0.80000 135980.0n 0.80000 136109.9n 0.80000 136110.0n 0.80000 136239.9n 0.80000 136240.0n 0.80000 136369.9n 0.80000 136370.0n 0.80000 136499.9n 0.80000 136500.0n 0.80000 136629.9n 0.80000 136630.0n 0.80000 136759.9n 0.80000 136760.0n 0.80000 136889.9n 0.80000 136890.0n 0.80000 137019.9n 0.80000 137020.0n 0.80000 137149.9n 0.80000 137150.0n 0.80000 137279.9n 0.80000 137280.0n 0.80000 137409.9n 0.80000 137410.0n 0.80000 137539.9n 0.80000 137540.0n 0.80000 137669.9n 0.80000 137670.0n 0.80000 137799.9n 0.80000 137800.0n 0.80000 137929.9n 0.80000 137930.0n 0.80000 138059.9n 0.80000 138060.0n 0.80000 138189.9n 0.80000 138190.0n 0.80000 138319.9n 0.80000 138320.0n 0.80000 138449.9n 0.80000 138450.0n 0.80000 138579.9n 0.80000 138580.0n 0.80000 138709.9n 0.80000 138710.0n 0.80000 138839.9n 0.80000 138840.0n 0.80000 138969.9n 0.80000 138970.0n 0.80000 139099.9n 0.80000 139100.0n 0.80000 139229.9n 0.80000 139230.0n 0.80000 139359.9n 0.80000 139360.0n 0.80000 139489.9n 0.80000 139490.0n 0.80000 139619.9n 0.80000 139620.0n 0.80000 139749.9n 0.80000 139750.0n 0.80000 139879.9n 0.80000 139880.0n 0.80000 140009.9n 0.80000 140010.0n 0.80000 140139.9n 0.80000 140140.0n 0.80000 140269.9n 0.80000 140270.0n 0.80000 140399.9n 0.80000 140400.0n 0.80000 140529.9n 0.80000 140530.0n 0.80000 140659.9n 0.80000 140660.0n 0.80000 140789.9n 0.80000 140790.0n 0.80000 140919.9n 0.80000 140920.0n 0.80000 141049.9n 0.80000 141050.0n 0.80000 141179.9n 0.80000 141180.0n 0.80000 141309.9n 0.80000 141310.0n 0.80000 141439.9n 0.80000 141440.0n 0.80000 141569.9n 0.80000 141570.0n 0.80000 141699.9n 0.80000 141700.0n 0.80000 141829.9n 0.80000 141830.0n 0.80000 141959.9n 0.80000 141960.0n 0.80000 142089.9n 0.80000 142090.0n 0.80000 142219.9n 0.80000 142220.0n 0.80000 142349.9n 0.80000 142350.0n 0.80000 142479.9n 0.80000 142480.0n 0.80000 142609.9n 0.80000 142610.0n 0.80000 142739.9n 0.80000 142740.0n 0.80000 142869.9n 0.80000 142870.0n 0.80000 142999.9n 0.80000 143000.0n 0.80000 143129.9n 0.80000 143130.0n 0.80000 143259.9n 0.80000 143260.0n 0.80000 143389.9n 0.80000 143390.0n 0.80000 143519.9n 0.80000 143520.0n 0.80000 143649.9n 0.80000 143650.0n 0.80000 143779.9n 0.80000 143780.0n 0.80000 143909.9n 0.80000 143910.0n 0.80000 144039.9n 0.80000 144040.0n 0.80000 144169.9n 0.80000 144170.0n 0.80000 144299.9n 0.80000 144300.0n 0.80000 144429.9n 0.80000 144430.0n 0.80000 144559.9n 0.80000 144560.0n 0.80000 144689.9n 0.80000 144690.0n 0.80000 144819.9n 0.80000 144820.0n 0.80000 144949.9n 0.80000 144950.0n 0.80000 145079.9n 0.80000 145080.0n 0.80000 145209.9n 0.80000 145210.0n 0.80000 145339.9n 0.80000 145340.0n 0.80000 145469.9n 0.80000 145470.0n 0.80000 145599.9n 0.80000 145600.0n 0.80000 145729.9n 0.80000 145730.0n 0.80000 145859.9n 0.80000 145860.0n 0.80000 145989.9n 0.80000 145990.0n 0.80000 146119.9n 0.80000 146120.0n 0.80000 146249.9n 0.80000 146250.0n 0.80000 146379.9n 0.80000 146380.0n 0.80000 146509.9n 0.80000 146510.0n 0.80000 146639.9n 0.80000 146640.0n 0.80000 146769.9n 0.80000 146770.0n 0.80000 146899.9n 0.80000 146900.0n 0.80000 147029.9n 0.80000 147030.0n 0.80000 147159.9n 0.80000 147160.0n 0.80000 147289.9n 0.80000 147290.0n 0.80000 147419.9n 0.80000 147420.0n 0.80000 147549.9n 0.80000 147550.0n 0.80000 147679.9n 0.80000 147680.0n 0.80000 147809.9n 0.80000 147810.0n 0.80000 147939.9n 0.80000 147940.0n 0.80000 148069.9n 0.80000 148070.0n 0.80000 148199.9n 0.80000 148200.0n 0.80000 148329.9n 0.80000 148330.0n 0.80000 148459.9n 0.80000 148460.0n 0.80000 148589.9n 0.80000 148590.0n 0.80000 148719.9n 0.80000 148720.0n 0.80000 148849.9n 0.80000 148850.0n 0.80000 148979.9n 0.80000 148980.0n 0.80000 149109.9n 0.80000 149110.0n 0.80000 149239.9n 0.80000 149240.0n 0.80000 149369.9n 0.80000 149370.0n 0.80000 149499.9n 0.80000 149500.0n 0.80000 149629.9n 0.80000 149630.0n 0.80000 149759.9n 0.80000 149760.0n 0.80000 149889.9n 0.80000 149890.0n 0.80000 150019.9n 0.80000 150020.0n 0.80000 150149.9n 0.80000 150150.0n 0.80000 150279.9n 0.80000 150280.0n 0.80000 150409.9n 0.80000 150410.0n 0.80000 150539.9n 0.80000 150540.0n 0.80000 150669.9n 0.80000 150670.0n 0.80000 150799.9n 0.80000 150800.0n 0.80000 150929.9n 0.80000 150930.0n 0.80000 151059.9n 0.80000 151060.0n 0.80000 151189.9n 0.80000 151190.0n 0.80000 151319.9n 0.80000 151320.0n 0.80000 151449.9n 0.80000 151450.0n 0.80000 151579.9n 0.80000 151580.0n 0.80000 151709.9n 0.80000 151710.0n 0.80000 151839.9n 0.80000 151840.0n 0.80000 151969.9n 0.80000 151970.0n 0.80000 152099.9n 0.80000 152100.0n 0.80000 152229.9n 0.80000 152230.0n 0.80000 152359.9n 0.80000 152360.0n 0.80000 152489.9n 0.80000 152490.0n 0.80000 152619.9n 0.80000 152620.0n 0.80000 152749.9n 0.80000 152750.0n 0.80000 152879.9n 0.80000 152880.0n 0.80000 153009.9n 0.80000 153010.0n 0.80000 153139.9n 0.80000 153140.0n 0.80000 153269.9n 0.80000 153270.0n 0.80000 153399.9n 0.80000 153400.0n 0.80000 153529.9n 0.80000 153530.0n 0.80000 153659.9n 0.80000 153660.0n 0.80000 153789.9n 0.80000 153790.0n 0.80000 153919.9n 0.80000 153920.0n 0.80000 154049.9n 0.80000 154050.0n 0.80000 154179.9n 0.80000 154180.0n 0.80000 154309.9n 0.80000 154310.0n 0.80000 154439.9n 0.80000 154440.0n 0.80000 154569.9n 0.80000 154570.0n 0.80000 154699.9n 0.80000 154700.0n 0.80000 154829.9n 0.80000 154830.0n 0.80000 154959.9n 0.80000 154960.0n 0.80000 155089.9n 0.80000 155090.0n 0.80000 155219.9n 0.80000 155220.0n 0.80000 155349.9n 0.80000 155350.0n 0.80000 155479.9n 0.80000 155480.0n 0.80000 155609.9n 0.80000 155610.0n 0.80000 155739.9n 0.80000 155740.0n 0.80000 155869.9n 0.80000 155870.0n 0.80000 155999.9n 0.80000 156000.0n 0.80000 156129.9n 0.80000 156130.0n 0.80000 156259.9n 0.80000 156260.0n 0.80000 156389.9n 0.80000 156390.0n 0.80000 156519.9n 0.80000 156520.0n 0.80000 156649.9n 0.80000 156650.0n 0.80000 156779.9n 0.80000 156780.0n 0.80000 156909.9n 0.80000 156910.0n 0.80000 157039.9n 0.80000 157040.0n 0.80000 157169.9n 0.80000 157170.0n 0.80000 157299.9n 0.80000 157300.0n 0.80000 157429.9n 0.80000 157430.0n 0.80000 157559.9n 0.80000 157560.0n 0.80000 157689.9n 0.80000 157690.0n 0.80000 157819.9n 0.80000 157820.0n 0.80000 157949.9n 0.80000 157950.0n 0.80000 158079.9n 0.80000 158080.0n 0.80000 158209.9n 0.80000 158210.0n 0.80000 158339.9n 0.80000 158340.0n 0.80000 158469.9n 0.80000 158470.0n 0.80000 158599.9n 0.80000 158600.0n 0.80000 158729.9n 0.80000 158730.0n 0.80000 158859.9n 0.80000 158860.0n 0.80000 158989.9n 0.80000 158990.0n 0.80000 159119.9n 0.80000 159120.0n 0.80000 159249.9n 0.80000 159250.0n 0.80000 159379.9n 0.80000 159380.0n 0.80000 159509.9n 0.80000 159510.0n 0.80000 159639.9n 0.80000 159640.0n 0.80000 159769.9n 0.80000 159770.0n 0.80000 159899.9n 0.80000 159900.0n 0.80000 160029.9n 0.80000 160030.0n 0.80000 160159.9n 0.80000 160160.0n 0.80000 160289.9n 0.80000 160290.0n 0.80000 160419.9n 0.80000 160420.0n 0.80000 160549.9n 0.80000 160550.0n 0.80000 160679.9n 0.80000 160680.0n 0.80000 160809.9n 0.80000 160810.0n 0.80000 160939.9n 0.80000 160940.0n 0.80000 161069.9n 0.80000 161070.0n 0.80000 161199.9n 0.80000 161200.0n 0.80000 161329.9n 0.80000 161330.0n 0.80000 161459.9n 0.80000 161460.0n 0.80000 161589.9n 0.80000 161590.0n 0.80000 161719.9n 0.80000 161720.0n 0.80000 161849.9n 0.80000 161850.0n 0.80000 161979.9n 0.80000 161980.0n 0.80000 162109.9n 0.80000 162110.0n 0.80000 162239.9n 0.80000 162240.0n 0.80000 162369.9n 0.80000 162370.0n 0.80000 162499.9n 0.80000 162500.0n 0.80000 162629.9n 0.80000 162630.0n 0.80000 162759.9n 0.80000 162760.0n 0.80000 162889.9n 0.80000 162890.0n 0.80000 163019.9n 0.80000 163020.0n 0.80000 163149.9n 0.80000 163150.0n 0.80000 163279.9n 0.80000 163280.0n 0.80000 163409.9n 0.80000 163410.0n 0.80000 163539.9n 0.80000 163540.0n 0.80000 163669.9n 0.80000 163670.0n 0.80000 163799.9n 0.80000 163800.0n 0.80000 163929.9n 0.80000 163930.0n 0.80000 164059.9n 0.80000 164060.0n 0.80000 164189.9n 0.80000 164190.0n 0.80000 164319.9n 0.80000 164320.0n 0.80000 164449.9n 0.80000 164450.0n 0.80000 164579.9n 0.80000 164580.0n 0.80000 164709.9n 0.80000 164710.0n 0.80000 164839.9n 0.80000 164840.0n 0.80000 164969.9n 0.80000 164970.0n 0.80000 165099.9n 0.80000 165100.0n 0.80000 165229.9n 0.80000 165230.0n 0.80000 165359.9n 0.80000 165360.0n 0.80000 165489.9n 0.80000 165490.0n 0.80000 165619.9n 0.80000 165620.0n 0.80000 165749.9n 0.80000 165750.0n 0.80000 165879.9n 0.80000 165880.0n 0.80000 166009.9n 0.80000 166010.0n 0.80000 166139.9n 0.80000 166140.0n 0.80000 166269.9n 0.80000 166270.0n 0.80000 166399.9n 0.80000 166400.0n 0.80000 166529.9n 0.80000 166530.0n 0.80000 166659.9n 0.80000 166660.0n 0.80000 166789.9n 0.80000 166790.0n 0.80000 166919.9n 0.80000 166920.0n 0.80000 167049.9n 0.80000 167050.0n 0.80000 167179.9n 0.80000 167180.0n 0.80000 167309.9n 0.80000 167310.0n 0.80000 167439.9n 0.80000 167440.0n 0.80000 167569.9n 0.80000 167570.0n 0.80000 167699.9n 0.80000 167700.0n 0.80000 167829.9n 0.80000 167830.0n 0.80000 167959.9n 0.80000 167960.0n 0.80000 168089.9n 0.80000 168090.0n 0.80000 168219.9n 0.80000 168220.0n 0.80000 168349.9n 0.80000 168350.0n 0.80000)
Vxn2 a_xn2 0 PWL(0.0n 0.20000 129.9n 0.20000 130.0n 0.20000 259.9n 0.20000 260.0n 0.20000 389.9n 0.20000 390.0n 0.20000 519.9n 0.20000 520.0n 0.20000 649.9n 0.20000 650.0n 0.20000 779.9n 0.20000 780.0n 0.20000 909.9n 0.20000 910.0n 0.20000 1039.9n 0.20000 1040.0n 0.20000 1169.9n 0.20000 1170.0n 0.20000 1299.9n 0.20000 1300.0n 0.20000 1429.9n 0.20000 1430.0n 0.20000 1559.9n 0.20000 1560.0n 0.20000 1689.9n 0.20000 1690.0n 0.20000 1819.9n 0.20000 1820.0n 0.20000 1949.9n 0.20000 1950.0n 0.20000 2079.9n 0.20000 2080.0n 0.20000 2209.9n 0.20000 2210.0n 0.20000 2339.9n 0.20000 2340.0n 0.20000 2469.9n 0.20000 2470.0n 0.20000 2599.9n 0.20000 2600.0n 0.20000 2729.9n 0.20000 2730.0n 0.20000 2859.9n 0.20000 2860.0n 0.20000 2989.9n 0.20000 2990.0n 0.20000 3119.9n 0.20000 3120.0n 0.20000 3249.9n 0.20000 3250.0n 0.20000 3379.9n 0.20000 3380.0n 0.20000 3509.9n 0.20000 3510.0n 0.20000 3639.9n 0.20000 3640.0n 0.20000 3769.9n 0.20000 3770.0n 0.20000 3899.9n 0.20000 3900.0n 0.20000 4029.9n 0.20000 4030.0n 0.20000 4159.9n 0.20000 4160.0n 0.20000 4289.9n 0.20000 4290.0n 0.20000 4419.9n 0.20000 4420.0n 0.20000 4549.9n 0.20000 4550.0n 0.20000 4679.9n 0.20000 4680.0n 0.20000 4809.9n 0.20000 4810.0n 0.20000 4939.9n 0.20000 4940.0n 0.20000 5069.9n 0.20000 5070.0n 0.20000 5199.9n 0.20000 5200.0n 0.20000 5329.9n 0.20000 5330.0n 0.20000 5459.9n 0.20000 5460.0n 0.20000 5589.9n 0.20000 5590.0n 0.20000 5719.9n 0.20000 5720.0n 0.20000 5849.9n 0.20000 5850.0n 0.20000 5979.9n 0.20000 5980.0n 0.20000 6109.9n 0.20000 6110.0n 0.20000 6239.9n 0.20000 6240.0n 0.20000 6369.9n 0.20000 6370.0n 0.20000 6499.9n 0.20000 6500.0n 0.20000 6629.9n 0.20000 6630.0n 0.20000 6759.9n 0.20000 6760.0n 0.20000 6889.9n 0.20000 6890.0n 0.20000 7019.9n 0.20000 7020.0n 0.20000 7149.9n 0.20000 7150.0n 0.20000 7279.9n 0.20000 7280.0n 0.20000 7409.9n 0.20000 7410.0n 0.20000 7539.9n 0.20000 7540.0n 0.20000 7669.9n 0.20000 7670.0n 0.20000 7799.9n 0.20000 7800.0n 0.20000 7929.9n 0.20000 7930.0n 0.20000 8059.9n 0.20000 8060.0n 0.20000 8189.9n 0.20000 8190.0n 0.20000 8319.9n 0.20000 8320.0n 0.20000 8449.9n 0.20000 8450.0n 0.20000 8579.9n 0.20000 8580.0n 0.20000 8709.9n 0.20000 8710.0n 0.20000 8839.9n 0.20000 8840.0n 0.20000 8969.9n 0.20000 8970.0n 0.20000 9099.9n 0.20000 9100.0n 0.20000 9229.9n 0.20000 9230.0n 0.20000 9359.9n 0.20000 9360.0n 0.20000 9489.9n 0.20000 9490.0n 0.20000 9619.9n 0.20000 9620.0n 0.20000 9749.9n 0.20000 9750.0n 0.20000 9879.9n 0.20000 9880.0n 0.20000 10009.9n 0.20000 10010.0n 0.20000 10139.9n 0.20000 10140.0n 0.20000 10269.9n 0.20000 10270.0n 0.20000 10399.9n 0.20000 10400.0n 0.20000 10529.9n 0.20000 10530.0n 0.20000 10659.9n 0.20000 10660.0n 0.20000 10789.9n 0.20000 10790.0n 0.20000 10919.9n 0.20000 10920.0n 0.20000 11049.9n 0.20000 11050.0n 0.20000 11179.9n 0.20000 11180.0n 0.20000 11309.9n 0.20000 11310.0n 0.20000 11439.9n 0.20000 11440.0n 0.20000 11569.9n 0.20000 11570.0n 0.20000 11699.9n 0.20000 11700.0n 0.20000 11829.9n 0.20000 11830.0n 0.20000 11959.9n 0.20000 11960.0n 0.20000 12089.9n 0.20000 12090.0n 0.20000 12219.9n 0.20000 12220.0n 0.20000 12349.9n 0.20000 12350.0n 0.20000 12479.9n 0.20000 12480.0n 0.20000 12609.9n 0.20000 12610.0n 0.20000 12739.9n 0.20000 12740.0n 0.20000 12869.9n 0.20000 12870.0n 0.20000 12999.9n 0.20000 13000.0n 0.20000 13129.9n 0.20000 13130.0n 0.20000 13259.9n 0.20000 13260.0n 0.20000 13389.9n 0.20000 13390.0n 0.20000 13519.9n 0.20000 13520.0n 0.20000 13649.9n 0.20000 13650.0n 0.20000 13779.9n 0.20000 13780.0n 0.20000 13909.9n 0.20000 13910.0n 0.20000 14039.9n 0.20000 14040.0n 0.20000 14169.9n 0.20000 14170.0n 0.20000 14299.9n 0.20000 14300.0n 0.20000 14429.9n 0.20000 14430.0n 0.20000 14559.9n 0.20000 14560.0n 0.20000 14689.9n 0.20000 14690.0n 0.20000 14819.9n 0.20000 14820.0n 0.20000 14949.9n 0.20000 14950.0n 0.20000 15079.9n 0.20000 15080.0n 0.20000 15209.9n 0.20000 15210.0n 0.20000 15339.9n 0.20000 15340.0n 0.20000 15469.9n 0.20000 15470.0n 0.20000 15599.9n 0.20000 15600.0n 0.20000 15729.9n 0.20000 15730.0n 0.20000 15859.9n 0.20000 15860.0n 0.20000 15989.9n 0.20000 15990.0n 0.20000 16119.9n 0.20000 16120.0n 0.20000 16249.9n 0.20000 16250.0n 0.20000 16379.9n 0.20000 16380.0n 0.20000 16509.9n 0.20000 16510.0n 0.20000 16639.9n 0.20000 16640.0n 0.20000 16769.9n 0.20000 16770.0n 0.20000 16899.9n 0.20000 16900.0n 0.20000 17029.9n 0.20000 17030.0n 0.20000 17159.9n 0.20000 17160.0n 0.20000 17289.9n 0.20000 17290.0n 0.20000 17419.9n 0.20000 17420.0n 0.20000 17549.9n 0.20000 17550.0n 0.20000 17679.9n 0.20000 17680.0n 0.20000 17809.9n 0.20000 17810.0n 0.20000 17939.9n 0.20000 17940.0n 0.20000 18069.9n 0.20000 18070.0n 0.20000 18199.9n 0.20000 18200.0n 0.20000 18329.9n 0.20000 18330.0n 0.20000 18459.9n 0.20000 18460.0n 0.20000 18589.9n 0.20000 18590.0n 0.20000 18719.9n 0.20000 18720.0n 0.20000 18849.9n 0.20000 18850.0n 0.20000 18979.9n 0.20000 18980.0n 0.20000 19109.9n 0.20000 19110.0n 0.20000 19239.9n 0.20000 19240.0n 0.20000 19369.9n 0.20000 19370.0n 0.20000 19499.9n 0.20000 19500.0n 0.20000 19629.9n 0.20000 19630.0n 0.20000 19759.9n 0.20000 19760.0n 0.20000 19889.9n 0.20000 19890.0n 0.20000 20019.9n 0.20000 20020.0n 0.20000 20149.9n 0.20000 20150.0n 0.20000 20279.9n 0.20000 20280.0n 0.20000 20409.9n 0.20000 20410.0n 0.20000 20539.9n 0.20000 20540.0n 0.20000 20669.9n 0.20000 20670.0n 0.20000 20799.9n 0.20000 20800.0n 0.20000 20929.9n 0.20000 20930.0n 0.20000 21059.9n 0.20000 21060.0n 0.20000 21189.9n 0.20000 21190.0n 0.20000 21319.9n 0.20000 21320.0n 0.20000 21449.9n 0.20000 21450.0n 0.20000 21579.9n 0.20000 21580.0n 0.20000 21709.9n 0.20000 21710.0n 0.20000 21839.9n 0.20000 21840.0n 0.20000 21969.9n 0.20000 21970.0n 0.20000 22099.9n 0.20000 22100.0n 0.20000 22229.9n 0.20000 22230.0n 0.20000 22359.9n 0.20000 22360.0n 0.20000 22489.9n 0.20000 22490.0n 0.20000 22619.9n 0.20000 22620.0n 0.20000 22749.9n 0.20000 22750.0n 0.20000 22879.9n 0.20000 22880.0n 0.20000 23009.9n 0.20000 23010.0n 0.20000 23139.9n 0.20000 23140.0n 0.20000 23269.9n 0.20000 23270.0n 0.20000 23399.9n 0.20000 23400.0n 0.20000 23529.9n 0.20000 23530.0n 0.20000 23659.9n 0.20000 23660.0n 0.20000 23789.9n 0.20000 23790.0n 0.20000 23919.9n 0.20000 23920.0n 0.20000 24049.9n 0.20000 24050.0n 0.20000 24179.9n 0.20000 24180.0n 0.20000 24309.9n 0.20000 24310.0n 0.20000 24439.9n 0.20000 24440.0n 0.20000 24569.9n 0.20000 24570.0n 0.20000 24699.9n 0.20000 24700.0n 0.20000 24829.9n 0.20000 24830.0n 0.20000 24959.9n 0.20000 24960.0n 0.20000 25089.9n 0.20000 25090.0n 0.20000 25219.9n 0.20000 25220.0n 0.20000 25349.9n 0.20000 25350.0n 0.20000 25479.9n 0.20000 25480.0n 0.20000 25609.9n 0.20000 25610.0n 0.20000 25739.9n 0.20000 25740.0n 0.20000 25869.9n 0.20000 25870.0n 0.20000 25999.9n 0.20000 26000.0n 0.20000 26129.9n 0.20000 26130.0n 0.20000 26259.9n 0.20000 26260.0n 0.20000 26389.9n 0.20000 26390.0n 0.20000 26519.9n 0.20000 26520.0n 0.20000 26649.9n 0.20000 26650.0n 0.20000 26779.9n 0.20000 26780.0n 0.20000 26909.9n 0.20000 26910.0n 0.20000 27039.9n 0.20000 27040.0n 0.20000 27169.9n 0.20000 27170.0n 0.20000 27299.9n 0.20000 27300.0n 0.20000 27429.9n 0.20000 27430.0n 0.20000 27559.9n 0.20000 27560.0n 0.20000 27689.9n 0.20000 27690.0n 0.20000 27819.9n 0.20000 27820.0n 0.20000 27949.9n 0.20000 27950.0n 0.20000 28079.9n 0.20000 28080.0n 0.20000 28209.9n 0.20000 28210.0n 0.20000 28339.9n 0.20000 28340.0n 0.20000 28469.9n 0.20000 28470.0n 0.20000 28599.9n 0.20000 28600.0n 0.20000 28729.9n 0.20000 28730.0n 0.20000 28859.9n 0.20000 28860.0n 0.20000 28989.9n 0.20000 28990.0n 0.20000 29119.9n 0.20000 29120.0n 0.20000 29249.9n 0.20000 29250.0n 0.20000 29379.9n 0.20000 29380.0n 0.20000 29509.9n 0.20000 29510.0n 0.20000 29639.9n 0.20000 29640.0n 0.20000 29769.9n 0.20000 29770.0n 0.20000 29899.9n 0.20000 29900.0n 0.20000 30029.9n 0.20000 30030.0n 0.20000 30159.9n 0.20000 30160.0n 0.20000 30289.9n 0.20000 30290.0n 0.20000 30419.9n 0.20000 30420.0n 0.20000 30549.9n 0.20000 30550.0n 0.20000 30679.9n 0.20000 30680.0n 0.20000 30809.9n 0.20000 30810.0n 0.20000 30939.9n 0.20000 30940.0n 0.20000 31069.9n 0.20000 31070.0n 0.20000 31199.9n 0.20000 31200.0n 0.20000 31329.9n 0.20000 31330.0n 0.20000 31459.9n 0.20000 31460.0n 0.20000 31589.9n 0.20000 31590.0n 0.20000 31719.9n 0.20000 31720.0n 0.20000 31849.9n 0.20000 31850.0n 0.20000 31979.9n 0.20000 31980.0n 0.20000 32109.9n 0.20000 32110.0n 0.20000 32239.9n 0.20000 32240.0n 0.20000 32369.9n 0.20000 32370.0n 0.20000 32499.9n 0.20000 32500.0n 0.20000 32629.9n 0.20000 32630.0n 0.20000 32759.9n 0.20000 32760.0n 0.20000 32889.9n 0.20000 32890.0n 0.20000 33019.9n 0.20000 33020.0n 0.20000 33149.9n 0.20000 33150.0n 0.20000 33279.9n 0.20000 33280.0n 0.20000 33409.9n 0.20000 33410.0n 0.20000 33539.9n 0.20000 33540.0n 0.20000 33669.9n 0.20000 33670.0n 0.20000 33799.9n 0.20000 33800.0n 0.20000 33929.9n 0.20000 33930.0n 0.20000 34059.9n 0.20000 34060.0n 0.20000 34189.9n 0.20000 34190.0n 0.20000 34319.9n 0.20000 34320.0n 0.20000 34449.9n 0.20000 34450.0n 0.20000 34579.9n 0.20000 34580.0n 0.20000 34709.9n 0.20000 34710.0n 0.20000 34839.9n 0.20000 34840.0n 0.20000 34969.9n 0.20000 34970.0n 0.20000 35099.9n 0.20000 35100.0n 0.20000 35229.9n 0.20000 35230.0n 0.20000 35359.9n 0.20000 35360.0n 0.20000 35489.9n 0.20000 35490.0n 0.20000 35619.9n 0.20000 35620.0n 0.20000 35749.9n 0.20000 35750.0n 0.20000 35879.9n 0.20000 35880.0n 0.20000 36009.9n 0.20000 36010.0n 0.20000 36139.9n 0.20000 36140.0n 0.20000 36269.9n 0.20000 36270.0n 0.20000 36399.9n 0.20000 36400.0n 0.20000 36529.9n 0.20000 36530.0n 0.20000 36659.9n 0.20000 36660.0n 0.20000 36789.9n 0.20000 36790.0n 0.20000 36919.9n 0.20000 36920.0n 0.20000 37049.9n 0.20000 37050.0n 0.20000 37179.9n 0.20000 37180.0n 0.20000 37309.9n 0.20000 37310.0n 0.20000 37439.9n 0.20000 37440.0n 0.20000 37569.9n 0.20000 37570.0n 0.20000 37699.9n 0.20000 37700.0n 0.20000 37829.9n 0.20000 37830.0n 0.20000 37959.9n 0.20000 37960.0n 0.20000 38089.9n 0.20000 38090.0n 0.20000 38219.9n 0.20000 38220.0n 0.20000 38349.9n 0.20000 38350.0n 0.20000 38479.9n 0.20000 38480.0n 0.20000 38609.9n 0.20000 38610.0n 0.20000 38739.9n 0.20000 38740.0n 0.20000 38869.9n 0.20000 38870.0n 0.20000 38999.9n 0.20000 39000.0n 0.20000 39129.9n 0.20000 39130.0n 0.20000 39259.9n 0.20000 39260.0n 0.20000 39389.9n 0.20000 39390.0n 0.20000 39519.9n 0.20000 39520.0n 0.20000 39649.9n 0.20000 39650.0n 0.20000 39779.9n 0.20000 39780.0n 0.20000 39909.9n 0.20000 39910.0n 0.20000 40039.9n 0.20000 40040.0n 0.20000 40169.9n 0.20000 40170.0n 0.20000 40299.9n 0.20000 40300.0n 0.20000 40429.9n 0.20000 40430.0n 0.20000 40559.9n 0.20000 40560.0n 0.20000 40689.9n 0.20000 40690.0n 0.20000 40819.9n 0.20000 40820.0n 0.20000 40949.9n 0.20000 40950.0n 0.20000 41079.9n 0.20000 41080.0n 0.20000 41209.9n 0.20000 41210.0n 0.20000 41339.9n 0.20000 41340.0n 0.20000 41469.9n 0.20000 41470.0n 0.20000 41599.9n 0.20000 41600.0n 0.20000 41729.9n 0.20000 41730.0n 0.20000 41859.9n 0.20000 41860.0n 0.20000 41989.9n 0.20000 41990.0n 0.20000 42119.9n 0.20000 42120.0n 0.20000 42249.9n 0.20000 42250.0n 0.20000 42379.9n 0.20000 42380.0n 0.20000 42509.9n 0.20000 42510.0n 0.20000 42639.9n 0.20000 42640.0n 0.20000 42769.9n 0.20000 42770.0n 0.20000 42899.9n 0.20000 42900.0n 0.20000 43029.9n 0.20000 43030.0n 0.20000 43159.9n 0.20000 43160.0n 0.20000 43289.9n 0.20000 43290.0n 0.20000 43419.9n 0.20000 43420.0n 0.20000 43549.9n 0.20000 43550.0n 0.20000 43679.9n 0.20000 43680.0n 0.20000 43809.9n 0.20000 43810.0n 0.20000 43939.9n 0.20000 43940.0n 0.20000 44069.9n 0.20000 44070.0n 0.20000 44199.9n 0.20000 44200.0n 0.20000 44329.9n 0.20000 44330.0n 0.20000 44459.9n 0.20000 44460.0n 0.20000 44589.9n 0.20000 44590.0n 0.20000 44719.9n 0.20000 44720.0n 0.20000 44849.9n 0.20000 44850.0n 0.20000 44979.9n 0.20000 44980.0n 0.20000 45109.9n 0.20000 45110.0n 0.20000 45239.9n 0.20000 45240.0n 0.20000 45369.9n 0.20000 45370.0n 0.20000 45499.9n 0.20000 45500.0n 0.20000 45629.9n 0.20000 45630.0n 0.20000 45759.9n 0.20000 45760.0n 0.20000 45889.9n 0.20000 45890.0n 0.20000 46019.9n 0.20000 46020.0n 0.20000 46149.9n 0.20000 46150.0n 0.20000 46279.9n 0.20000 46280.0n 0.20000 46409.9n 0.20000 46410.0n 0.20000 46539.9n 0.20000 46540.0n 0.20000 46669.9n 0.20000 46670.0n 0.20000 46799.9n 0.20000 46800.0n 0.20000 46929.9n 0.20000 46930.0n 0.20000 47059.9n 0.20000 47060.0n 0.20000 47189.9n 0.20000 47190.0n 0.20000 47319.9n 0.20000 47320.0n 0.20000 47449.9n 0.20000 47450.0n 0.20000 47579.9n 0.20000 47580.0n 0.20000 47709.9n 0.20000 47710.0n 0.20000 47839.9n 0.20000 47840.0n 0.20000 47969.9n 0.20000 47970.0n 0.20000 48099.9n 0.20000 48100.0n 0.20000 48229.9n 0.20000 48230.0n 0.20000 48359.9n 0.20000 48360.0n 0.20000 48489.9n 0.20000 48490.0n 0.20000 48619.9n 0.20000 48620.0n 0.20000 48749.9n 0.20000 48750.0n 0.20000 48879.9n 0.20000 48880.0n 0.20000 49009.9n 0.20000 49010.0n 0.20000 49139.9n 0.20000 49140.0n 0.20000 49269.9n 0.20000 49270.0n 0.20000 49399.9n 0.20000 49400.0n 0.20000 49529.9n 0.20000 49530.0n 0.20000 49659.9n 0.20000 49660.0n 0.20000 49789.9n 0.20000 49790.0n 0.20000 49919.9n 0.20000 49920.0n 0.20000 50049.9n 0.20000 50050.0n 0.20000 50179.9n 0.20000 50180.0n 0.20000 50309.9n 0.20000 50310.0n 0.20000 50439.9n 0.20000 50440.0n 0.20000 50569.9n 0.20000 50570.0n 0.20000 50699.9n 0.20000 50700.0n 0.20000 50829.9n 0.20000 50830.0n 0.20000 50959.9n 0.20000 50960.0n 0.20000 51089.9n 0.20000 51090.0n 0.20000 51219.9n 0.20000 51220.0n 0.20000 51349.9n 0.20000 51350.0n 0.20000 51479.9n 0.20000 51480.0n 0.20000 51609.9n 0.20000 51610.0n 0.20000 51739.9n 0.20000 51740.0n 0.20000 51869.9n 0.20000 51870.0n 0.20000 51999.9n 0.20000 52000.0n 0.20000 52129.9n 0.20000 52130.0n 0.20000 52259.9n 0.20000 52260.0n 0.20000 52389.9n 0.20000 52390.0n 0.20000 52519.9n 0.20000 52520.0n 0.20000 52649.9n 0.20000 52650.0n 0.20000 52779.9n 0.20000 52780.0n 0.20000 52909.9n 0.20000 52910.0n 0.20000 53039.9n 0.20000 53040.0n 0.20000 53169.9n 0.20000 53170.0n 0.20000 53299.9n 0.20000 53300.0n 0.20000 53429.9n 0.20000 53430.0n 0.20000 53559.9n 0.20000 53560.0n 0.20000 53689.9n 0.20000 53690.0n 0.20000 53819.9n 0.20000 53820.0n 0.20000 53949.9n 0.20000 53950.0n 0.20000 54079.9n 0.20000 54080.0n 0.20000 54209.9n 0.20000 54210.0n 0.20000 54339.9n 0.20000 54340.0n 0.20000 54469.9n 0.20000 54470.0n 0.20000 54599.9n 0.20000 54600.0n 0.20000 54729.9n 0.20000 54730.0n 0.20000 54859.9n 0.20000 54860.0n 0.20000 54989.9n 0.20000 54990.0n 0.20000 55119.9n 0.20000 55120.0n 0.20000 55249.9n 0.20000 55250.0n 0.20000 55379.9n 0.20000 55380.0n 0.20000 55509.9n 0.20000 55510.0n 0.20000 55639.9n 0.20000 55640.0n 0.20000 55769.9n 0.20000 55770.0n 0.20000 55899.9n 0.20000 55900.0n 0.20000 56029.9n 0.20000 56030.0n 0.20000 56159.9n 0.20000 56160.0n 0.20000 56289.9n 0.20000 56290.0n 0.20000 56419.9n 0.20000 56420.0n 0.20000 56549.9n 0.20000 56550.0n 0.20000 56679.9n 0.20000 56680.0n 0.20000 56809.9n 0.20000 56810.0n 0.20000 56939.9n 0.20000 56940.0n 0.20000 57069.9n 0.20000 57070.0n 0.20000 57199.9n 0.20000 57200.0n 0.20000 57329.9n 0.20000 57330.0n 0.20000 57459.9n 0.20000 57460.0n 0.20000 57589.9n 0.20000 57590.0n 0.20000 57719.9n 0.20000 57720.0n 0.20000 57849.9n 0.20000 57850.0n 0.20000 57979.9n 0.20000 57980.0n 0.20000 58109.9n 0.20000 58110.0n 0.20000 58239.9n 0.20000 58240.0n 0.20000 58369.9n 0.20000 58370.0n 0.20000 58499.9n 0.20000 58500.0n 0.20000 58629.9n 0.20000 58630.0n 0.20000 58759.9n 0.20000 58760.0n 0.20000 58889.9n 0.20000 58890.0n 0.20000 59019.9n 0.20000 59020.0n 0.20000 59149.9n 0.20000 59150.0n 0.20000 59279.9n 0.20000 59280.0n 0.20000 59409.9n 0.20000 59410.0n 0.20000 59539.9n 0.20000 59540.0n 0.20000 59669.9n 0.20000 59670.0n 0.20000 59799.9n 0.20000 59800.0n 0.20000 59929.9n 0.20000 59930.0n 0.20000 60059.9n 0.20000 60060.0n 0.20000 60189.9n 0.20000 60190.0n 0.20000 60319.9n 0.20000 60320.0n 0.20000 60449.9n 0.20000 60450.0n 0.20000 60579.9n 0.20000 60580.0n 0.20000 60709.9n 0.20000 60710.0n 0.20000 60839.9n 0.20000 60840.0n 0.20000 60969.9n 0.20000 60970.0n 0.20000 61099.9n 0.20000 61100.0n 0.20000 61229.9n 0.20000 61230.0n 0.20000 61359.9n 0.20000 61360.0n 0.20000 61489.9n 0.20000 61490.0n 0.20000 61619.9n 0.20000 61620.0n 0.20000 61749.9n 0.20000 61750.0n 0.20000 61879.9n 0.20000 61880.0n 0.20000 62009.9n 0.20000 62010.0n 0.20000 62139.9n 0.20000 62140.0n 0.20000 62269.9n 0.20000 62270.0n 0.20000 62399.9n 0.20000 62400.0n 0.20000 62529.9n 0.20000 62530.0n 0.20000 62659.9n 0.20000 62660.0n 0.20000 62789.9n 0.20000 62790.0n 0.20000 62919.9n 0.20000 62920.0n 0.20000 63049.9n 0.20000 63050.0n 0.20000 63179.9n 0.20000 63180.0n 0.20000 63309.9n 0.20000 63310.0n 0.20000 63439.9n 0.20000 63440.0n 0.20000 63569.9n 0.20000 63570.0n 0.20000 63699.9n 0.20000 63700.0n 0.20000 63829.9n 0.20000 63830.0n 0.20000 63959.9n 0.20000 63960.0n 0.20000 64089.9n 0.20000 64090.0n 0.20000 64219.9n 0.20000 64220.0n 0.20000 64349.9n 0.20000 64350.0n 0.20000 64479.9n 0.20000 64480.0n 0.20000 64609.9n 0.20000 64610.0n 0.20000 64739.9n 0.20000 64740.0n 0.20000 64869.9n 0.20000 64870.0n 0.20000 64999.9n 0.20000 65000.0n 0.20000 65129.9n 0.20000 65130.0n 0.20000 65259.9n 0.20000 65260.0n 0.20000 65389.9n 0.20000 65390.0n 0.20000 65519.9n 0.20000 65520.0n 0.20000 65649.9n 0.20000 65650.0n 0.20000 65779.9n 0.20000 65780.0n 0.20000 65909.9n 0.20000 65910.0n 0.20000 66039.9n 0.20000 66040.0n 0.20000 66169.9n 0.20000 66170.0n 0.20000 66299.9n 0.20000 66300.0n 0.20000 66429.9n 0.20000 66430.0n 0.20000 66559.9n 0.20000 66560.0n 0.20000 66689.9n 0.20000 66690.0n 0.20000 66819.9n 0.20000 66820.0n 0.20000 66949.9n 0.20000 66950.0n 0.20000 67079.9n 0.20000 67080.0n 0.20000 67209.9n 0.20000 67210.0n 0.20000 67339.9n 0.20000 67340.0n 0.20000 67469.9n 0.20000 67470.0n 0.20000 67599.9n 0.20000 67600.0n 0.20000 67729.9n 0.20000 67730.0n 0.20000 67859.9n 0.20000 67860.0n 0.20000 67989.9n 0.20000 67990.0n 0.20000 68119.9n 0.20000 68120.0n 0.20000 68249.9n 0.20000 68250.0n 0.20000 68379.9n 0.20000 68380.0n 0.20000 68509.9n 0.20000 68510.0n 0.20000 68639.9n 0.20000 68640.0n 0.20000 68769.9n 0.20000 68770.0n 0.20000 68899.9n 0.20000 68900.0n 0.20000 69029.9n 0.20000 69030.0n 0.20000 69159.9n 0.20000 69160.0n 0.20000 69289.9n 0.20000 69290.0n 0.20000 69419.9n 0.20000 69420.0n 0.20000 69549.9n 0.20000 69550.0n 0.20000 69679.9n 0.20000 69680.0n 0.20000 69809.9n 0.20000 69810.0n 0.20000 69939.9n 0.20000 69940.0n 0.20000 70069.9n 0.20000 70070.0n 0.20000 70199.9n 0.20000 70200.0n 0.20000 70329.9n 0.20000 70330.0n 0.20000 70459.9n 0.20000 70460.0n 0.20000 70589.9n 0.20000 70590.0n 0.20000 70719.9n 0.20000 70720.0n 0.20000 70849.9n 0.20000 70850.0n 0.20000 70979.9n 0.20000 70980.0n 0.20000 71109.9n 0.20000 71110.0n 0.20000 71239.9n 0.20000 71240.0n 0.20000 71369.9n 0.20000 71370.0n 0.20000 71499.9n 0.20000 71500.0n 0.20000 71629.9n 0.20000 71630.0n 0.20000 71759.9n 0.20000 71760.0n 0.20000 71889.9n 0.20000 71890.0n 0.20000 72019.9n 0.20000 72020.0n 0.20000 72149.9n 0.20000 72150.0n 0.20000 72279.9n 0.20000 72280.0n 0.20000 72409.9n 0.20000 72410.0n 0.20000 72539.9n 0.20000 72540.0n 0.20000 72669.9n 0.20000 72670.0n 0.20000 72799.9n 0.20000 72800.0n 0.20000 72929.9n 0.20000 72930.0n 0.20000 73059.9n 0.20000 73060.0n 0.20000 73189.9n 0.20000 73190.0n 0.20000 73319.9n 0.20000 73320.0n 0.20000 73449.9n 0.20000 73450.0n 0.20000 73579.9n 0.20000 73580.0n 0.20000 73709.9n 0.20000 73710.0n 0.20000 73839.9n 0.20000 73840.0n 0.20000 73969.9n 0.20000 73970.0n 0.20000 74099.9n 0.20000 74100.0n 0.20000 74229.9n 0.20000 74230.0n 0.20000 74359.9n 0.20000 74360.0n 0.20000 74489.9n 0.20000 74490.0n 0.20000 74619.9n 0.20000 74620.0n 0.20000 74749.9n 0.20000 74750.0n 0.20000 74879.9n 0.20000 74880.0n 0.20000 75009.9n 0.20000 75010.0n 0.20000 75139.9n 0.20000 75140.0n 0.20000 75269.9n 0.20000 75270.0n 0.20000 75399.9n 0.20000 75400.0n 0.20000 75529.9n 0.20000 75530.0n 0.20000 75659.9n 0.20000 75660.0n 0.20000 75789.9n 0.20000 75790.0n 0.20000 75919.9n 0.20000 75920.0n 0.20000 76049.9n 0.20000 76050.0n 0.20000 76179.9n 0.20000 76180.0n 0.20000 76309.9n 0.20000 76310.0n 0.20000 76439.9n 0.20000 76440.0n 0.20000 76569.9n 0.20000 76570.0n 0.20000 76699.9n 0.20000 76700.0n 0.20000 76829.9n 0.20000 76830.0n 0.20000 76959.9n 0.20000 76960.0n 0.20000 77089.9n 0.20000 77090.0n 0.20000 77219.9n 0.20000 77220.0n 0.20000 77349.9n 0.20000 77350.0n 0.20000 77479.9n 0.20000 77480.0n 0.20000 77609.9n 0.20000 77610.0n 0.20000 77739.9n 0.20000 77740.0n 0.20000 77869.9n 0.20000 77870.0n 0.20000 77999.9n 0.20000 78000.0n 0.20000 78129.9n 0.20000 78130.0n 0.20000 78259.9n 0.20000 78260.0n 0.20000 78389.9n 0.20000 78390.0n 0.20000 78519.9n 0.20000 78520.0n 0.20000 78649.9n 0.20000 78650.0n 0.20000 78779.9n 0.20000 78780.0n 0.20000 78909.9n 0.20000 78910.0n 0.20000 79039.9n 0.20000 79040.0n 0.20000 79169.9n 0.20000 79170.0n 0.20000 79299.9n 0.20000 79300.0n 0.20000 79429.9n 0.20000 79430.0n 0.20000 79559.9n 0.20000 79560.0n 0.20000 79689.9n 0.20000 79690.0n 0.20000 79819.9n 0.20000 79820.0n 0.20000 79949.9n 0.20000 79950.0n 0.20000 80079.9n 0.20000 80080.0n 0.20000 80209.9n 0.20000 80210.0n 0.20000 80339.9n 0.20000 80340.0n 0.20000 80469.9n 0.20000 80470.0n 0.20000 80599.9n 0.20000 80600.0n 0.20000 80729.9n 0.20000 80730.0n 0.20000 80859.9n 0.20000 80860.0n 0.20000 80989.9n 0.20000 80990.0n 0.20000 81119.9n 0.20000 81120.0n 0.20000 81249.9n 0.20000 81250.0n 0.20000 81379.9n 0.20000 81380.0n 0.20000 81509.9n 0.20000 81510.0n 0.20000 81639.9n 0.20000 81640.0n 0.20000 81769.9n 0.20000 81770.0n 0.20000 81899.9n 0.20000 81900.0n 0.20000 82029.9n 0.20000 82030.0n 0.20000 82159.9n 0.20000 82160.0n 0.20000 82289.9n 0.20000 82290.0n 0.20000 82419.9n 0.20000 82420.0n 0.20000 82549.9n 0.20000 82550.0n 0.20000 82679.9n 0.20000 82680.0n 0.20000 82809.9n 0.20000 82810.0n 0.20000 82939.9n 0.20000 82940.0n 0.20000 83069.9n 0.20000 83070.0n 0.20000 83199.9n 0.20000 83200.0n 0.20000 83329.9n 0.20000 83330.0n 0.20000 83459.9n 0.20000 83460.0n 0.20000 83589.9n 0.20000 83590.0n 0.20000 83719.9n 0.20000 83720.0n 0.20000 83849.9n 0.20000 83850.0n 0.20000 83979.9n 0.20000 83980.0n 0.20000 84109.9n 0.20000 84110.0n 0.20000 84239.9n 0.20000 84240.0n 0.20000 84369.9n 0.20000 84370.0n 0.20000 84499.9n 0.20000 84500.0n 0.20000 84629.9n 0.20000 84630.0n 0.20000 84759.9n 0.20000 84760.0n 0.20000 84889.9n 0.20000 84890.0n 0.20000 85019.9n 0.20000 85020.0n 0.20000 85149.9n 0.20000 85150.0n 0.20000 85279.9n 0.20000 85280.0n 0.20000 85409.9n 0.20000 85410.0n 0.20000 85539.9n 0.20000 85540.0n 0.20000 85669.9n 0.20000 85670.0n 0.20000 85799.9n 0.20000 85800.0n 0.20000 85929.9n 0.20000 85930.0n 0.20000 86059.9n 0.20000 86060.0n 0.20000 86189.9n 0.20000 86190.0n 0.20000 86319.9n 0.20000 86320.0n 0.20000 86449.9n 0.20000 86450.0n 0.20000 86579.9n 0.20000 86580.0n 0.20000 86709.9n 0.20000 86710.0n 0.20000 86839.9n 0.20000 86840.0n 0.20000 86969.9n 0.20000 86970.0n 0.20000 87099.9n 0.20000 87100.0n 0.20000 87229.9n 0.20000 87230.0n 0.20000 87359.9n 0.20000 87360.0n 0.20000 87489.9n 0.20000 87490.0n 0.20000 87619.9n 0.20000 87620.0n 0.20000 87749.9n 0.20000 87750.0n 0.20000 87879.9n 0.20000 87880.0n 0.20000 88009.9n 0.20000 88010.0n 0.20000 88139.9n 0.20000 88140.0n 0.20000 88269.9n 0.20000 88270.0n 0.20000 88399.9n 0.20000 88400.0n 0.20000 88529.9n 0.20000 88530.0n 0.20000 88659.9n 0.20000 88660.0n 0.20000 88789.9n 0.20000 88790.0n 0.20000 88919.9n 0.20000 88920.0n 0.20000 89049.9n 0.20000 89050.0n 0.20000 89179.9n 0.20000 89180.0n 0.20000 89309.9n 0.20000 89310.0n 0.20000 89439.9n 0.20000 89440.0n 0.20000 89569.9n 0.20000 89570.0n 0.20000 89699.9n 0.20000 89700.0n 0.20000 89829.9n 0.20000 89830.0n 0.20000 89959.9n 0.20000 89960.0n 0.20000 90089.9n 0.20000 90090.0n 0.20000 90219.9n 0.20000 90220.0n 0.20000 90349.9n 0.20000 90350.0n 0.20000 90479.9n 0.20000 90480.0n 0.20000 90609.9n 0.20000 90610.0n 0.20000 90739.9n 0.20000 90740.0n 0.20000 90869.9n 0.20000 90870.0n 0.20000 90999.9n 0.20000 91000.0n 0.20000 91129.9n 0.20000 91130.0n 0.20000 91259.9n 0.20000 91260.0n 0.20000 91389.9n 0.20000 91390.0n 0.20000 91519.9n 0.20000 91520.0n 0.20000 91649.9n 0.20000 91650.0n 0.20000 91779.9n 0.20000 91780.0n 0.20000 91909.9n 0.20000 91910.0n 0.20000 92039.9n 0.20000 92040.0n 0.20000 92169.9n 0.20000 92170.0n 0.20000 92299.9n 0.20000 92300.0n 0.20000 92429.9n 0.20000 92430.0n 0.20000 92559.9n 0.20000 92560.0n 0.20000 92689.9n 0.20000 92690.0n 0.20000 92819.9n 0.20000 92820.0n 0.20000 92949.9n 0.20000 92950.0n 0.20000 93079.9n 0.20000 93080.0n 0.20000 93209.9n 0.20000 93210.0n 0.20000 93339.9n 0.20000 93340.0n 0.20000 93469.9n 0.20000 93470.0n 0.20000 93599.9n 0.20000 93600.0n 0.20000 93729.9n 0.20000 93730.0n 0.20000 93859.9n 0.20000 93860.0n 0.20000 93989.9n 0.20000 93990.0n 0.20000 94119.9n 0.20000 94120.0n 0.20000 94249.9n 0.20000 94250.0n 0.20000 94379.9n 0.20000 94380.0n 0.20000 94509.9n 0.20000 94510.0n 0.20000 94639.9n 0.20000 94640.0n 0.20000 94769.9n 0.20000 94770.0n 0.20000 94899.9n 0.20000 94900.0n 0.20000 95029.9n 0.20000 95030.0n 0.20000 95159.9n 0.20000 95160.0n 0.20000 95289.9n 0.20000 95290.0n 0.20000 95419.9n 0.20000 95420.0n 0.20000 95549.9n 0.20000 95550.0n 0.20000 95679.9n 0.20000 95680.0n 0.20000 95809.9n 0.20000 95810.0n 0.20000 95939.9n 0.20000 95940.0n 0.20000 96069.9n 0.20000 96070.0n 0.20000 96199.9n 0.20000 96200.0n 0.20000 96329.9n 0.20000 96330.0n 0.20000 96459.9n 0.20000 96460.0n 0.20000 96589.9n 0.20000 96590.0n 0.20000 96719.9n 0.20000 96720.0n 0.20000 96849.9n 0.20000 96850.0n 0.20000 96979.9n 0.20000 96980.0n 0.20000 97109.9n 0.20000 97110.0n 0.20000 97239.9n 0.20000 97240.0n 0.20000 97369.9n 0.20000 97370.0n 0.20000 97499.9n 0.20000 97500.0n 0.20000 97629.9n 0.20000 97630.0n 0.20000 97759.9n 0.20000 97760.0n 0.20000 97889.9n 0.20000 97890.0n 0.20000 98019.9n 0.20000 98020.0n 0.20000 98149.9n 0.20000 98150.0n 0.20000 98279.9n 0.20000 98280.0n 0.20000 98409.9n 0.20000 98410.0n 0.20000 98539.9n 0.20000 98540.0n 0.20000 98669.9n 0.20000 98670.0n 0.20000 98799.9n 0.20000 98800.0n 0.20000 98929.9n 0.20000 98930.0n 0.20000 99059.9n 0.20000 99060.0n 0.20000 99189.9n 0.20000 99190.0n 0.20000 99319.9n 0.20000 99320.0n 0.20000 99449.9n 0.20000 99450.0n 0.20000 99579.9n 0.20000 99580.0n 0.20000 99709.9n 0.20000 99710.0n 0.20000 99839.9n 0.20000 99840.0n 0.20000 99969.9n 0.20000 99970.0n 0.20000 100099.9n 0.20000 100100.0n 0.20000 100229.9n 0.20000 100230.0n 0.20000 100359.9n 0.20000 100360.0n 0.20000 100489.9n 0.20000 100490.0n 0.20000 100619.9n 0.20000 100620.0n 0.20000 100749.9n 0.20000 100750.0n 0.20000 100879.9n 0.20000 100880.0n 0.20000 101009.9n 0.20000 101010.0n 0.20000 101139.9n 0.20000 101140.0n 0.20000 101269.9n 0.20000 101270.0n 0.20000 101399.9n 0.20000 101400.0n 0.20000 101529.9n 0.20000 101530.0n 0.20000 101659.9n 0.20000 101660.0n 0.20000 101789.9n 0.20000 101790.0n 0.20000 101919.9n 0.20000 101920.0n 0.20000 102049.9n 0.20000 102050.0n 0.20000 102179.9n 0.20000 102180.0n 0.20000 102309.9n 0.20000 102310.0n 0.20000 102439.9n 0.20000 102440.0n 0.20000 102569.9n 0.20000 102570.0n 0.20000 102699.9n 0.20000 102700.0n 0.20000 102829.9n 0.20000 102830.0n 0.20000 102959.9n 0.20000 102960.0n 0.20000 103089.9n 0.20000 103090.0n 0.20000 103219.9n 0.20000 103220.0n 0.20000 103349.9n 0.20000 103350.0n 0.20000 103479.9n 0.20000 103480.0n 0.20000 103609.9n 0.20000 103610.0n 0.20000 103739.9n 0.20000 103740.0n 0.20000 103869.9n 0.20000 103870.0n 0.20000 103999.9n 0.20000 104000.0n 0.20000 104129.9n 0.20000 104130.0n 0.20000 104259.9n 0.20000 104260.0n 0.20000 104389.9n 0.20000 104390.0n 0.20000 104519.9n 0.20000 104520.0n 0.20000 104649.9n 0.20000 104650.0n 0.20000 104779.9n 0.20000 104780.0n 0.20000 104909.9n 0.20000 104910.0n 0.20000 105039.9n 0.20000 105040.0n 0.20000 105169.9n 0.20000 105170.0n 0.20000 105299.9n 0.20000 105300.0n 0.20000 105429.9n 0.20000 105430.0n 0.20000 105559.9n 0.20000 105560.0n 0.20000 105689.9n 0.20000 105690.0n 0.20000 105819.9n 0.20000 105820.0n 0.20000 105949.9n 0.20000 105950.0n 0.20000 106079.9n 0.20000 106080.0n 0.20000 106209.9n 0.20000 106210.0n 0.20000 106339.9n 0.20000 106340.0n 0.20000 106469.9n 0.20000 106470.0n 0.20000 106599.9n 0.20000 106600.0n 0.20000 106729.9n 0.20000 106730.0n 0.20000 106859.9n 0.20000 106860.0n 0.20000 106989.9n 0.20000 106990.0n 0.20000 107119.9n 0.20000 107120.0n 0.20000 107249.9n 0.20000 107250.0n 0.20000 107379.9n 0.20000 107380.0n 0.20000 107509.9n 0.20000 107510.0n 0.20000 107639.9n 0.20000 107640.0n 0.20000 107769.9n 0.20000 107770.0n 0.20000 107899.9n 0.20000 107900.0n 0.20000 108029.9n 0.20000 108030.0n 0.20000 108159.9n 0.20000 108160.0n 0.20000 108289.9n 0.20000 108290.0n 0.20000 108419.9n 0.20000 108420.0n 0.20000 108549.9n 0.20000 108550.0n 0.20000 108679.9n 0.20000 108680.0n 0.20000 108809.9n 0.20000 108810.0n 0.20000 108939.9n 0.20000 108940.0n 0.20000 109069.9n 0.20000 109070.0n 0.20000 109199.9n 0.20000 109200.0n 0.20000 109329.9n 0.20000 109330.0n 0.20000 109459.9n 0.20000 109460.0n 0.20000 109589.9n 0.20000 109590.0n 0.20000 109719.9n 0.20000 109720.0n 0.20000 109849.9n 0.20000 109850.0n 0.20000 109979.9n 0.20000 109980.0n 0.20000 110109.9n 0.20000 110110.0n 0.20000 110239.9n 0.20000 110240.0n 0.20000 110369.9n 0.20000 110370.0n 0.20000 110499.9n 0.20000 110500.0n 0.20000 110629.9n 0.20000 110630.0n 0.20000 110759.9n 0.20000 110760.0n 0.20000 110889.9n 0.20000 110890.0n 0.20000 111019.9n 0.20000 111020.0n 0.20000 111149.9n 0.20000 111150.0n 0.20000 111279.9n 0.20000 111280.0n 0.20000 111409.9n 0.20000 111410.0n 0.20000 111539.9n 0.20000 111540.0n 0.20000 111669.9n 0.20000 111670.0n 0.20000 111799.9n 0.20000 111800.0n 0.20000 111929.9n 0.20000 111930.0n 0.20000 112059.9n 0.20000 112060.0n 0.20000 112189.9n 0.20000 112190.0n 0.20000 112319.9n 0.20000 112320.0n 0.20000 112449.9n 0.20000 112450.0n 0.20000 112579.9n 0.20000 112580.0n 0.20000 112709.9n 0.20000 112710.0n 0.20000 112839.9n 0.20000 112840.0n 0.20000 112969.9n 0.20000 112970.0n 0.20000 113099.9n 0.20000 113100.0n 0.20000 113229.9n 0.20000 113230.0n 0.20000 113359.9n 0.20000 113360.0n 0.20000 113489.9n 0.20000 113490.0n 0.20000 113619.9n 0.20000 113620.0n 0.20000 113749.9n 0.20000 113750.0n 0.20000 113879.9n 0.20000 113880.0n 0.20000 114009.9n 0.20000 114010.0n 0.20000 114139.9n 0.20000 114140.0n 0.20000 114269.9n 0.20000 114270.0n 0.20000 114399.9n 0.20000 114400.0n 0.20000 114529.9n 0.20000 114530.0n 0.20000 114659.9n 0.20000 114660.0n 0.20000 114789.9n 0.20000 114790.0n 0.20000 114919.9n 0.20000 114920.0n 0.20000 115049.9n 0.20000 115050.0n 0.20000 115179.9n 0.20000 115180.0n 0.20000 115309.9n 0.20000 115310.0n 0.20000 115439.9n 0.20000 115440.0n 0.20000 115569.9n 0.20000 115570.0n 0.20000 115699.9n 0.20000 115700.0n 0.20000 115829.9n 0.20000 115830.0n 0.20000 115959.9n 0.20000 115960.0n 0.20000 116089.9n 0.20000 116090.0n 0.20000 116219.9n 0.20000 116220.0n 0.20000 116349.9n 0.20000 116350.0n 0.20000 116479.9n 0.20000 116480.0n 0.20000 116609.9n 0.20000 116610.0n 0.20000 116739.9n 0.20000 116740.0n 0.20000 116869.9n 0.20000 116870.0n 0.20000 116999.9n 0.20000 117000.0n 0.20000 117129.9n 0.20000 117130.0n 0.20000 117259.9n 0.20000 117260.0n 0.20000 117389.9n 0.20000 117390.0n 0.20000 117519.9n 0.20000 117520.0n 0.20000 117649.9n 0.20000 117650.0n 0.20000 117779.9n 0.20000 117780.0n 0.20000 117909.9n 0.20000 117910.0n 0.20000 118039.9n 0.20000 118040.0n 0.20000 118169.9n 0.20000 118170.0n 0.20000 118299.9n 0.20000 118300.0n 0.20000 118429.9n 0.20000 118430.0n 0.20000 118559.9n 0.20000 118560.0n 0.20000 118689.9n 0.20000 118690.0n 0.20000 118819.9n 0.20000 118820.0n 0.20000 118949.9n 0.20000 118950.0n 0.20000 119079.9n 0.20000 119080.0n 0.20000 119209.9n 0.20000 119210.0n 0.20000 119339.9n 0.20000 119340.0n 0.20000 119469.9n 0.20000 119470.0n 0.20000 119599.9n 0.20000 119600.0n 0.20000 119729.9n 0.20000 119730.0n 0.20000 119859.9n 0.20000 119860.0n 0.20000 119989.9n 0.20000 119990.0n 0.20000 120119.9n 0.20000 120120.0n 0.20000 120249.9n 0.20000 120250.0n 0.20000 120379.9n 0.20000 120380.0n 0.20000 120509.9n 0.20000 120510.0n 0.20000 120639.9n 0.20000 120640.0n 0.20000 120769.9n 0.20000 120770.0n 0.20000 120899.9n 0.20000 120900.0n 0.20000 121029.9n 0.20000 121030.0n 0.20000 121159.9n 0.20000 121160.0n 0.20000 121289.9n 0.20000 121290.0n 0.20000 121419.9n 0.20000 121420.0n 0.20000 121549.9n 0.20000 121550.0n 0.20000 121679.9n 0.20000 121680.0n 0.20000 121809.9n 0.20000 121810.0n 0.20000 121939.9n 0.20000 121940.0n 0.20000 122069.9n 0.20000 122070.0n 0.20000 122199.9n 0.20000 122200.0n 0.20000 122329.9n 0.20000 122330.0n 0.20000 122459.9n 0.20000 122460.0n 0.20000 122589.9n 0.20000 122590.0n 0.20000 122719.9n 0.20000 122720.0n 0.20000 122849.9n 0.20000 122850.0n 0.20000 122979.9n 0.20000 122980.0n 0.20000 123109.9n 0.20000 123110.0n 0.20000 123239.9n 0.20000 123240.0n 0.20000 123369.9n 0.20000 123370.0n 0.20000 123499.9n 0.20000 123500.0n 0.20000 123629.9n 0.20000 123630.0n 0.20000 123759.9n 0.20000 123760.0n 0.20000 123889.9n 0.20000 123890.0n 0.20000 124019.9n 0.20000 124020.0n 0.20000 124149.9n 0.20000 124150.0n 0.20000 124279.9n 0.20000 124280.0n 0.20000 124409.9n 0.20000 124410.0n 0.20000 124539.9n 0.20000 124540.0n 0.20000 124669.9n 0.20000 124670.0n 0.20000 124799.9n 0.20000 124800.0n 0.20000 124929.9n 0.20000 124930.0n 0.20000 125059.9n 0.20000 125060.0n 0.20000 125189.9n 0.20000 125190.0n 0.20000 125319.9n 0.20000 125320.0n 0.20000 125449.9n 0.20000 125450.0n 0.20000 125579.9n 0.20000 125580.0n 0.20000 125709.9n 0.20000 125710.0n 0.20000 125839.9n 0.20000 125840.0n 0.20000 125969.9n 0.20000 125970.0n 0.20000 126099.9n 0.20000 126100.0n 0.20000 126229.9n 0.20000 126230.0n 0.20000 126359.9n 0.20000 126360.0n 0.20000 126489.9n 0.20000 126490.0n 0.20000 126619.9n 0.20000 126620.0n 0.20000 126749.9n 0.20000 126750.0n 0.20000 126879.9n 0.20000 126880.0n 0.20000 127009.9n 0.20000 127010.0n 0.20000 127139.9n 0.20000 127140.0n 0.20000 127269.9n 0.20000 127270.0n 0.20000 127399.9n 0.20000 127400.0n 0.20000 127529.9n 0.20000 127530.0n 0.20000 127659.9n 0.20000 127660.0n 0.20000 127789.9n 0.20000 127790.0n 0.20000 127919.9n 0.20000 127920.0n 0.20000 128049.9n 0.20000 128050.0n 0.20000 128179.9n 0.20000 128180.0n 0.20000 128309.9n 0.20000 128310.0n 0.20000 128439.9n 0.20000 128440.0n 0.20000 128569.9n 0.20000 128570.0n 0.20000 128699.9n 0.20000 128700.0n 0.20000 128829.9n 0.20000 128830.0n 0.20000 128959.9n 0.20000 128960.0n 0.20000 129089.9n 0.20000 129090.0n 0.20000 129219.9n 0.20000 129220.0n 0.20000 129349.9n 0.20000 129350.0n 0.20000 129479.9n 0.20000 129480.0n 0.20000 129609.9n 0.20000 129610.0n 0.20000 129739.9n 0.20000 129740.0n 0.20000 129869.9n 0.20000 129870.0n 0.20000 129999.9n 0.20000 130000.0n 0.20000 130129.9n 0.20000 130130.0n 0.20000 130259.9n 0.20000 130260.0n 0.20000 130389.9n 0.20000 130390.0n 0.20000 130519.9n 0.20000 130520.0n 0.20000 130649.9n 0.20000 130650.0n 0.20000 130779.9n 0.20000 130780.0n 0.20000 130909.9n 0.20000 130910.0n 0.20000 131039.9n 0.20000 131040.0n 0.20000 131169.9n 0.20000 131170.0n 0.20000 131299.9n 0.20000 131300.0n 0.20000 131429.9n 0.20000 131430.0n 0.20000 131559.9n 0.20000 131560.0n 0.20000 131689.9n 0.20000 131690.0n 0.20000 131819.9n 0.20000 131820.0n 0.20000 131949.9n 0.20000 131950.0n 0.20000 132079.9n 0.20000 132080.0n 0.20000 132209.9n 0.20000 132210.0n 0.20000 132339.9n 0.20000 132340.0n 0.20000 132469.9n 0.20000 132470.0n 0.20000 132599.9n 0.20000 132600.0n 0.20000 132729.9n 0.20000 132730.0n 0.20000 132859.9n 0.20000 132860.0n 0.20000 132989.9n 0.20000 132990.0n 0.20000 133119.9n 0.20000 133120.0n 0.20000 133249.9n 0.20000 133250.0n 0.20000 133379.9n 0.20000 133380.0n 0.20000 133509.9n 0.20000 133510.0n 0.20000 133639.9n 0.20000 133640.0n 0.20000 133769.9n 0.20000 133770.0n 0.20000 133899.9n 0.20000 133900.0n 0.20000 134029.9n 0.20000 134030.0n 0.20000 134159.9n 0.20000 134160.0n 0.20000 134289.9n 0.20000 134290.0n 0.20000 134419.9n 0.20000 134420.0n 0.20000 134549.9n 0.20000 134550.0n 0.20000 134679.9n 0.20000 134680.0n 0.20000 134809.9n 0.20000 134810.0n 0.20000 134939.9n 0.20000 134940.0n 0.20000 135069.9n 0.20000 135070.0n 0.20000 135199.9n 0.20000 135200.0n 0.20000 135329.9n 0.20000 135330.0n 0.20000 135459.9n 0.20000 135460.0n 0.20000 135589.9n 0.20000 135590.0n 0.20000 135719.9n 0.20000 135720.0n 0.20000 135849.9n 0.20000 135850.0n 0.20000 135979.9n 0.20000 135980.0n 0.20000 136109.9n 0.20000 136110.0n 0.20000 136239.9n 0.20000 136240.0n 0.20000 136369.9n 0.20000 136370.0n 0.20000 136499.9n 0.20000 136500.0n 0.20000 136629.9n 0.20000 136630.0n 0.20000 136759.9n 0.20000 136760.0n 0.20000 136889.9n 0.20000 136890.0n 0.20000 137019.9n 0.20000 137020.0n 0.20000 137149.9n 0.20000 137150.0n 0.20000 137279.9n 0.20000 137280.0n 0.20000 137409.9n 0.20000 137410.0n 0.20000 137539.9n 0.20000 137540.0n 0.20000 137669.9n 0.20000 137670.0n 0.20000 137799.9n 0.20000 137800.0n 0.20000 137929.9n 0.20000 137930.0n 0.20000 138059.9n 0.20000 138060.0n 0.20000 138189.9n 0.20000 138190.0n 0.20000 138319.9n 0.20000 138320.0n 0.20000 138449.9n 0.20000 138450.0n 0.20000 138579.9n 0.20000 138580.0n 0.20000 138709.9n 0.20000 138710.0n 0.20000 138839.9n 0.20000 138840.0n 0.20000 138969.9n 0.20000 138970.0n 0.20000 139099.9n 0.20000 139100.0n 0.20000 139229.9n 0.20000 139230.0n 0.20000 139359.9n 0.20000 139360.0n 0.20000 139489.9n 0.20000 139490.0n 0.20000 139619.9n 0.20000 139620.0n 0.20000 139749.9n 0.20000 139750.0n 0.20000 139879.9n 0.20000 139880.0n 0.20000 140009.9n 0.20000 140010.0n 0.20000 140139.9n 0.20000 140140.0n 0.20000 140269.9n 0.20000 140270.0n 0.20000 140399.9n 0.20000 140400.0n 0.20000 140529.9n 0.20000 140530.0n 0.20000 140659.9n 0.20000 140660.0n 0.20000 140789.9n 0.20000 140790.0n 0.20000 140919.9n 0.20000 140920.0n 0.20000 141049.9n 0.20000 141050.0n 0.20000 141179.9n 0.20000 141180.0n 0.20000 141309.9n 0.20000 141310.0n 0.20000 141439.9n 0.20000 141440.0n 0.20000 141569.9n 0.20000 141570.0n 0.20000 141699.9n 0.20000 141700.0n 0.20000 141829.9n 0.20000 141830.0n 0.20000 141959.9n 0.20000 141960.0n 0.20000 142089.9n 0.20000 142090.0n 0.20000 142219.9n 0.20000 142220.0n 0.20000 142349.9n 0.20000 142350.0n 0.20000 142479.9n 0.20000 142480.0n 0.20000 142609.9n 0.20000 142610.0n 0.20000 142739.9n 0.20000 142740.0n 0.20000 142869.9n 0.20000 142870.0n 0.20000 142999.9n 0.20000 143000.0n 0.20000 143129.9n 0.20000 143130.0n 0.20000 143259.9n 0.20000 143260.0n 0.20000 143389.9n 0.20000 143390.0n 0.20000 143519.9n 0.20000 143520.0n 0.20000 143649.9n 0.20000 143650.0n 0.20000 143779.9n 0.20000 143780.0n 0.20000 143909.9n 0.20000 143910.0n 0.20000 144039.9n 0.20000 144040.0n 0.20000 144169.9n 0.20000 144170.0n 0.20000 144299.9n 0.20000 144300.0n 0.20000 144429.9n 0.20000 144430.0n 0.20000 144559.9n 0.20000 144560.0n 0.20000 144689.9n 0.20000 144690.0n 0.20000 144819.9n 0.20000 144820.0n 0.20000 144949.9n 0.20000 144950.0n 0.20000 145079.9n 0.20000 145080.0n 0.20000 145209.9n 0.20000 145210.0n 0.20000 145339.9n 0.20000 145340.0n 0.20000 145469.9n 0.20000 145470.0n 0.20000 145599.9n 0.20000 145600.0n 0.20000 145729.9n 0.20000 145730.0n 0.20000 145859.9n 0.20000 145860.0n 0.20000 145989.9n 0.20000 145990.0n 0.20000 146119.9n 0.20000 146120.0n 0.20000 146249.9n 0.20000 146250.0n 0.20000 146379.9n 0.20000 146380.0n 0.20000 146509.9n 0.20000 146510.0n 0.20000 146639.9n 0.20000 146640.0n 0.20000 146769.9n 0.20000 146770.0n 0.20000 146899.9n 0.20000 146900.0n 0.20000 147029.9n 0.20000 147030.0n 0.20000 147159.9n 0.20000 147160.0n 0.20000 147289.9n 0.20000 147290.0n 0.20000 147419.9n 0.20000 147420.0n 0.20000 147549.9n 0.20000 147550.0n 0.20000 147679.9n 0.20000 147680.0n 0.20000 147809.9n 0.20000 147810.0n 0.20000 147939.9n 0.20000 147940.0n 0.20000 148069.9n 0.20000 148070.0n 0.20000 148199.9n 0.20000 148200.0n 0.20000 148329.9n 0.20000 148330.0n 0.20000 148459.9n 0.20000 148460.0n 0.20000 148589.9n 0.20000 148590.0n 0.20000 148719.9n 0.20000 148720.0n 0.20000 148849.9n 0.20000 148850.0n 0.20000 148979.9n 0.20000 148980.0n 0.20000 149109.9n 0.20000 149110.0n 0.20000 149239.9n 0.20000 149240.0n 0.20000 149369.9n 0.20000 149370.0n 0.20000 149499.9n 0.20000 149500.0n 0.20000 149629.9n 0.20000 149630.0n 0.20000 149759.9n 0.20000 149760.0n 0.20000 149889.9n 0.20000 149890.0n 0.20000 150019.9n 0.20000 150020.0n 0.20000 150149.9n 0.20000 150150.0n 0.20000 150279.9n 0.20000 150280.0n 0.20000 150409.9n 0.20000 150410.0n 0.20000 150539.9n 0.20000 150540.0n 0.20000 150669.9n 0.20000 150670.0n 0.20000 150799.9n 0.20000 150800.0n 0.20000 150929.9n 0.20000 150930.0n 0.20000 151059.9n 0.20000 151060.0n 0.20000 151189.9n 0.20000 151190.0n 0.20000 151319.9n 0.20000 151320.0n 0.20000 151449.9n 0.20000 151450.0n 0.20000 151579.9n 0.20000 151580.0n 0.20000 151709.9n 0.20000 151710.0n 0.20000 151839.9n 0.20000 151840.0n 0.20000 151969.9n 0.20000 151970.0n 0.20000 152099.9n 0.20000 152100.0n 0.20000 152229.9n 0.20000 152230.0n 0.20000 152359.9n 0.20000 152360.0n 0.20000 152489.9n 0.20000 152490.0n 0.20000 152619.9n 0.20000 152620.0n 0.20000 152749.9n 0.20000 152750.0n 0.20000 152879.9n 0.20000 152880.0n 0.20000 153009.9n 0.20000 153010.0n 0.20000 153139.9n 0.20000 153140.0n 0.20000 153269.9n 0.20000 153270.0n 0.20000 153399.9n 0.20000 153400.0n 0.20000 153529.9n 0.20000 153530.0n 0.20000 153659.9n 0.20000 153660.0n 0.20000 153789.9n 0.20000 153790.0n 0.20000 153919.9n 0.20000 153920.0n 0.20000 154049.9n 0.20000 154050.0n 0.20000 154179.9n 0.20000 154180.0n 0.20000 154309.9n 0.20000 154310.0n 0.20000 154439.9n 0.20000 154440.0n 0.20000 154569.9n 0.20000 154570.0n 0.20000 154699.9n 0.20000 154700.0n 0.20000 154829.9n 0.20000 154830.0n 0.20000 154959.9n 0.20000 154960.0n 0.20000 155089.9n 0.20000 155090.0n 0.20000 155219.9n 0.20000 155220.0n 0.20000 155349.9n 0.20000 155350.0n 0.20000 155479.9n 0.20000 155480.0n 0.20000 155609.9n 0.20000 155610.0n 0.20000 155739.9n 0.20000 155740.0n 0.20000 155869.9n 0.20000 155870.0n 0.20000 155999.9n 0.20000 156000.0n 0.20000 156129.9n 0.20000 156130.0n 0.20000 156259.9n 0.20000 156260.0n 0.20000 156389.9n 0.20000 156390.0n 0.20000 156519.9n 0.20000 156520.0n 0.20000 156649.9n 0.20000 156650.0n 0.20000 156779.9n 0.20000 156780.0n 0.20000 156909.9n 0.20000 156910.0n 0.20000 157039.9n 0.20000 157040.0n 0.20000 157169.9n 0.20000 157170.0n 0.20000 157299.9n 0.20000 157300.0n 0.20000 157429.9n 0.20000 157430.0n 0.20000 157559.9n 0.20000 157560.0n 0.20000 157689.9n 0.20000 157690.0n 0.20000 157819.9n 0.20000 157820.0n 0.20000 157949.9n 0.20000 157950.0n 0.20000 158079.9n 0.20000 158080.0n 0.20000 158209.9n 0.20000 158210.0n 0.20000 158339.9n 0.20000 158340.0n 0.20000 158469.9n 0.20000 158470.0n 0.20000 158599.9n 0.20000 158600.0n 0.20000 158729.9n 0.20000 158730.0n 0.20000 158859.9n 0.20000 158860.0n 0.20000 158989.9n 0.20000 158990.0n 0.20000 159119.9n 0.20000 159120.0n 0.20000 159249.9n 0.20000 159250.0n 0.20000 159379.9n 0.20000 159380.0n 0.20000 159509.9n 0.20000 159510.0n 0.20000 159639.9n 0.20000 159640.0n 0.20000 159769.9n 0.20000 159770.0n 0.20000 159899.9n 0.20000 159900.0n 0.20000 160029.9n 0.20000 160030.0n 0.20000 160159.9n 0.20000 160160.0n 0.20000 160289.9n 0.20000 160290.0n 0.20000 160419.9n 0.20000 160420.0n 0.20000 160549.9n 0.20000 160550.0n 0.20000 160679.9n 0.20000 160680.0n 0.20000 160809.9n 0.20000 160810.0n 0.20000 160939.9n 0.20000 160940.0n 0.20000 161069.9n 0.20000 161070.0n 0.20000 161199.9n 0.20000 161200.0n 0.20000 161329.9n 0.20000 161330.0n 0.20000 161459.9n 0.20000 161460.0n 0.20000 161589.9n 0.20000 161590.0n 0.20000 161719.9n 0.20000 161720.0n 0.20000 161849.9n 0.20000 161850.0n 0.20000 161979.9n 0.20000 161980.0n 0.20000 162109.9n 0.20000 162110.0n 0.20000 162239.9n 0.20000 162240.0n 0.20000 162369.9n 0.20000 162370.0n 0.20000 162499.9n 0.20000 162500.0n 0.20000 162629.9n 0.20000 162630.0n 0.20000 162759.9n 0.20000 162760.0n 0.20000 162889.9n 0.20000 162890.0n 0.20000 163019.9n 0.20000 163020.0n 0.20000 163149.9n 0.20000 163150.0n 0.20000 163279.9n 0.20000 163280.0n 0.20000 163409.9n 0.20000 163410.0n 0.20000 163539.9n 0.20000 163540.0n 0.20000 163669.9n 0.20000 163670.0n 0.20000 163799.9n 0.20000 163800.0n 0.20000 163929.9n 0.20000 163930.0n 0.20000 164059.9n 0.20000 164060.0n 0.20000 164189.9n 0.20000 164190.0n 0.20000 164319.9n 0.20000 164320.0n 0.20000 164449.9n 0.20000 164450.0n 0.20000 164579.9n 0.20000 164580.0n 0.20000 164709.9n 0.20000 164710.0n 0.20000 164839.9n 0.20000 164840.0n 0.20000 164969.9n 0.20000 164970.0n 0.20000 165099.9n 0.20000 165100.0n 0.20000 165229.9n 0.20000 165230.0n 0.20000 165359.9n 0.20000 165360.0n 0.20000 165489.9n 0.20000 165490.0n 0.20000 165619.9n 0.20000 165620.0n 0.20000 165749.9n 0.20000 165750.0n 0.20000 165879.9n 0.20000 165880.0n 0.20000 166009.9n 0.20000 166010.0n 0.20000 166139.9n 0.20000 166140.0n 0.20000 166269.9n 0.20000 166270.0n 0.20000 166399.9n 0.20000 166400.0n 0.20000 166529.9n 0.20000 166530.0n 0.20000 166659.9n 0.20000 166660.0n 0.20000 166789.9n 0.20000 166790.0n 0.20000 166919.9n 0.20000 166920.0n 0.20000 167049.9n 0.20000 167050.0n 0.20000 167179.9n 0.20000 167180.0n 0.20000 167309.9n 0.20000 167310.0n 0.20000 167439.9n 0.20000 167440.0n 0.20000 167569.9n 0.20000 167570.0n 0.20000 167699.9n 0.20000 167700.0n 0.20000 167829.9n 0.20000 167830.0n 0.20000 167959.9n 0.20000 167960.0n 0.20000 168089.9n 0.20000 168090.0n 0.20000 168219.9n 0.20000 168220.0n 0.20000 168349.9n 0.20000 168350.0n 0.20000)
Vxop0 xop0 0 PWL(0.0n 0.31000 129.9n 0.31000 130.0n 0.25000 259.9n 0.25000 260.0n 0.31000 389.9n 0.31000 390.0n 0.25000 519.9n 0.25000 520.0n 0.25000 649.9n 0.25000 650.0n 0.31000 779.9n 0.31000 780.0n 0.31000 909.9n 0.31000 910.0n 0.31000 1039.9n 0.31000 1040.0n 0.31000 1169.9n 0.31000 1170.0n 0.25000 1299.9n 0.25000 1300.0n 0.31000 1429.9n 0.31000 1430.0n 0.25000 1559.9n 0.25000 1560.0n 0.25000 1689.9n 0.25000 1690.0n 0.31000 1819.9n 0.31000 1820.0n 0.31000 1949.9n 0.31000 1950.0n 0.25000 2079.9n 0.25000 2080.0n 0.25000 2209.9n 0.25000 2210.0n 0.31000 2339.9n 0.31000 2340.0n 0.31000 2469.9n 0.31000 2470.0n 0.25000 2599.9n 0.25000 2600.0n 0.25000 2729.9n 0.25000 2730.0n 0.25000 2859.9n 0.25000 2860.0n 0.31000 2989.9n 0.31000 2990.0n 0.31000 3119.9n 0.31000 3120.0n 0.31000 3249.9n 0.31000 3250.0n 0.25000 3379.9n 0.25000 3380.0n 0.25000 3509.9n 0.25000 3510.0n 0.25000 3639.9n 0.25000 3640.0n 0.25000 3769.9n 0.25000 3770.0n 0.31000 3899.9n 0.31000 3900.0n 0.25000 4029.9n 0.25000 4030.0n 0.25000 4159.9n 0.25000 4160.0n 0.25000 4289.9n 0.25000 4290.0n 0.31000 4419.9n 0.31000 4420.0n 0.31000 4549.9n 0.31000 4550.0n 0.25000 4679.9n 0.25000 4680.0n 0.31000 4809.9n 0.31000 4810.0n 0.31000 4939.9n 0.31000 4940.0n 0.25000 5069.9n 0.25000 5070.0n 0.31000 5199.9n 0.31000 5200.0n 0.31000 5329.9n 0.31000 5330.0n 0.31000 5459.9n 0.31000 5460.0n 0.25000 5589.9n 0.25000 5590.0n 0.25000 5719.9n 0.25000 5720.0n 0.31000 5849.9n 0.31000 5850.0n 0.25000 5979.9n 0.25000 5980.0n 0.25000 6109.9n 0.25000 6110.0n 0.31000 6239.9n 0.31000 6240.0n 0.25000 6369.9n 0.25000 6370.0n 0.31000 6499.9n 0.31000 6500.0n 0.25000 6629.9n 0.25000 6630.0n 0.31000 6759.9n 0.31000 6760.0n 0.25000 6889.9n 0.25000 6890.0n 0.31000 7019.9n 0.31000 7020.0n 0.25000 7149.9n 0.25000 7150.0n 0.31000 7279.9n 0.31000 7280.0n 0.25000 7409.9n 0.25000 7410.0n 0.25000 7539.9n 0.25000 7540.0n 0.25000 7669.9n 0.25000 7670.0n 0.31000 7799.9n 0.31000 7800.0n 0.25000 7929.9n 0.25000 7930.0n 0.25000 8059.9n 0.25000 8060.0n 0.25000 8189.9n 0.25000 8190.0n 0.25000 8319.9n 0.25000 8320.0n 0.31000 8449.9n 0.31000 8450.0n 0.25000 8579.9n 0.25000 8580.0n 0.31000 8709.9n 0.31000 8710.0n 0.31000 8839.9n 0.31000 8840.0n 0.31000 8969.9n 0.31000 8970.0n 0.25000 9099.9n 0.25000 9100.0n 0.31000 9229.9n 0.31000 9230.0n 0.25000 9359.9n 0.25000 9360.0n 0.25000 9489.9n 0.25000 9490.0n 0.25000 9619.9n 0.25000 9620.0n 0.31000 9749.9n 0.31000 9750.0n 0.31000 9879.9n 0.31000 9880.0n 0.31000 10009.9n 0.31000 10010.0n 0.31000 10139.9n 0.31000 10140.0n 0.25000 10269.9n 0.25000 10270.0n 0.31000 10399.9n 0.31000 10400.0n 0.31000 10529.9n 0.31000 10530.0n 0.31000 10659.9n 0.31000 10660.0n 0.25000 10789.9n 0.25000 10790.0n 0.31000 10919.9n 0.31000 10920.0n 0.31000 11049.9n 0.31000 11050.0n 0.25000 11179.9n 0.25000 11180.0n 0.25000 11309.9n 0.25000 11310.0n 0.31000 11439.9n 0.31000 11440.0n 0.31000 11569.9n 0.31000 11570.0n 0.31000 11699.9n 0.31000 11700.0n 0.31000 11829.9n 0.31000 11830.0n 0.25000 11959.9n 0.25000 11960.0n 0.31000 12089.9n 0.31000 12090.0n 0.25000 12219.9n 0.25000 12220.0n 0.31000 12349.9n 0.31000 12350.0n 0.31000 12479.9n 0.31000 12480.0n 0.25000 12609.9n 0.25000 12610.0n 0.31000 12739.9n 0.31000 12740.0n 0.31000 12869.9n 0.31000 12870.0n 0.31000 12999.9n 0.31000 13000.0n 0.25000 13129.9n 0.25000 13130.0n 0.25000 13259.9n 0.25000 13260.0n 0.25000 13389.9n 0.25000 13390.0n 0.31000 13519.9n 0.31000 13520.0n 0.25000 13649.9n 0.25000 13650.0n 0.31000 13779.9n 0.31000 13780.0n 0.25000 13909.9n 0.25000 13910.0n 0.25000 14039.9n 0.25000 14040.0n 0.31000 14169.9n 0.31000 14170.0n 0.25000 14299.9n 0.25000 14300.0n 0.25000 14429.9n 0.25000 14430.0n 0.25000 14559.9n 0.25000 14560.0n 0.25000 14689.9n 0.25000 14690.0n 0.31000 14819.9n 0.31000 14820.0n 0.25000 14949.9n 0.25000 14950.0n 0.31000 15079.9n 0.31000 15080.0n 0.25000 15209.9n 0.25000 15210.0n 0.25000 15339.9n 0.25000 15340.0n 0.25000 15469.9n 0.25000 15470.0n 0.25000 15599.9n 0.25000 15600.0n 0.25000 15729.9n 0.25000 15730.0n 0.31000 15859.9n 0.31000 15860.0n 0.25000 15989.9n 0.25000 15990.0n 0.31000 16119.9n 0.31000 16120.0n 0.25000 16249.9n 0.25000 16250.0n 0.25000 16379.9n 0.25000 16380.0n 0.31000 16509.9n 0.31000 16510.0n 0.31000 16639.9n 0.31000 16640.0n 0.31000 16769.9n 0.31000 16770.0n 0.25000 16899.9n 0.25000 16900.0n 0.25000 17029.9n 0.25000 17030.0n 0.31000 17159.9n 0.31000 17160.0n 0.31000 17289.9n 0.31000 17290.0n 0.31000 17419.9n 0.31000 17420.0n 0.31000 17549.9n 0.31000 17550.0n 0.25000 17679.9n 0.25000 17680.0n 0.31000 17809.9n 0.31000 17810.0n 0.31000 17939.9n 0.31000 17940.0n 0.25000 18069.9n 0.25000 18070.0n 0.31000 18199.9n 0.31000 18200.0n 0.31000 18329.9n 0.31000 18330.0n 0.25000 18459.9n 0.25000 18460.0n 0.31000 18589.9n 0.31000 18590.0n 0.31000 18719.9n 0.31000 18720.0n 0.31000 18849.9n 0.31000 18850.0n 0.31000 18979.9n 0.31000 18980.0n 0.25000 19109.9n 0.25000 19110.0n 0.25000 19239.9n 0.25000 19240.0n 0.25000 19369.9n 0.25000 19370.0n 0.31000 19499.9n 0.31000 19500.0n 0.31000 19629.9n 0.31000 19630.0n 0.25000 19759.9n 0.25000 19760.0n 0.25000 19889.9n 0.25000 19890.0n 0.31000 20019.9n 0.31000 20020.0n 0.25000 20149.9n 0.25000 20150.0n 0.25000 20279.9n 0.25000 20280.0n 0.31000 20409.9n 0.31000 20410.0n 0.25000 20539.9n 0.25000 20540.0n 0.31000 20669.9n 0.31000 20670.0n 0.25000 20799.9n 0.25000 20800.0n 0.25000 20929.9n 0.25000 20930.0n 0.25000 21059.9n 0.25000 21060.0n 0.31000 21189.9n 0.31000 21190.0n 0.25000 21319.9n 0.25000 21320.0n 0.31000 21449.9n 0.31000 21450.0n 0.31000 21579.9n 0.31000 21580.0n 0.25000 21709.9n 0.25000 21710.0n 0.31000 21839.9n 0.31000 21840.0n 0.28000 21969.9n 0.28000 21970.0n 0.28000 22099.9n 0.28000 22100.0n 0.28000 22229.9n 0.28000 22230.0n 0.28000 22359.9n 0.28000 22360.0n 0.28000 22489.9n 0.28000 22490.0n 0.28000 22619.9n 0.28000 22620.0n 0.28000 22749.9n 0.28000 22750.0n 0.28000 22879.9n 0.28000 22880.0n 0.28000 23009.9n 0.28000 23010.0n 0.28000 23139.9n 0.28000 23140.0n 0.28000 23269.9n 0.28000 23270.0n 0.28000 23399.9n 0.28000 23400.0n 0.28000 23529.9n 0.28000 23530.0n 0.28000 23659.9n 0.28000 23660.0n 0.28000 23789.9n 0.28000 23790.0n 0.28000 23919.9n 0.28000 23920.0n 0.28000 24049.9n 0.28000 24050.0n 0.28000 24179.9n 0.28000 24180.0n 0.28000 24309.9n 0.28000 24310.0n 0.28000 24439.9n 0.28000 24440.0n 0.28000 24569.9n 0.28000 24570.0n 0.28000 24699.9n 0.28000 24700.0n 0.28000 24829.9n 0.28000 24830.0n 0.28000 24959.9n 0.28000 24960.0n 0.28000 25089.9n 0.28000 25090.0n 0.28000 25219.9n 0.28000 25220.0n 0.28000 25349.9n 0.28000 25350.0n 0.28000 25479.9n 0.28000 25480.0n 0.28000 25609.9n 0.28000 25610.0n 0.28000 25739.9n 0.28000 25740.0n 0.28000 25869.9n 0.28000 25870.0n 0.28000 25999.9n 0.28000 26000.0n 0.28000 26129.9n 0.28000 26130.0n 0.28000 26259.9n 0.28000 26260.0n 0.28000 26389.9n 0.28000 26390.0n 0.28000 26519.9n 0.28000 26520.0n 0.28000 26649.9n 0.28000 26650.0n 0.28000 26779.9n 0.28000 26780.0n 0.28000 26909.9n 0.28000 26910.0n 0.28000 27039.9n 0.28000 27040.0n 0.28000 27169.9n 0.28000 27170.0n 0.28000 27299.9n 0.28000 27300.0n 0.28000 27429.9n 0.28000 27430.0n 0.28000 27559.9n 0.28000 27560.0n 0.28000 27689.9n 0.28000 27690.0n 0.28000 27819.9n 0.28000 27820.0n 0.28000 27949.9n 0.28000 27950.0n 0.28000 28079.9n 0.28000 28080.0n 0.31000 28209.9n 0.31000 28210.0n 0.31000 28339.9n 0.31000 28340.0n 0.25000 28469.9n 0.25000 28470.0n 0.25000 28599.9n 0.25000 28600.0n 0.25000 28729.9n 0.25000 28730.0n 0.25000 28859.9n 0.25000 28860.0n 0.25000 28989.9n 0.25000 28990.0n 0.31000 29119.9n 0.31000 29120.0n 0.31000 29249.9n 0.31000 29250.0n 0.31000 29379.9n 0.31000 29380.0n 0.31000 29509.9n 0.31000 29510.0n 0.25000 29639.9n 0.25000 29640.0n 0.31000 29769.9n 0.31000 29770.0n 0.25000 29899.9n 0.25000 29900.0n 0.31000 30029.9n 0.31000 30030.0n 0.25000 30159.9n 0.25000 30160.0n 0.25000 30289.9n 0.25000 30290.0n 0.25000 30419.9n 0.25000 30420.0n 0.25000 30549.9n 0.25000 30550.0n 0.25000 30679.9n 0.25000 30680.0n 0.25000 30809.9n 0.25000 30810.0n 0.25000 30939.9n 0.25000 30940.0n 0.31000 31069.9n 0.31000 31070.0n 0.31000 31199.9n 0.31000 31200.0n 0.31000 31329.9n 0.31000 31330.0n 0.31000 31459.9n 0.31000 31460.0n 0.31000 31589.9n 0.31000 31590.0n 0.31000 31719.9n 0.31000 31720.0n 0.25000 31849.9n 0.25000 31850.0n 0.31000 31979.9n 0.31000 31980.0n 0.25000 32109.9n 0.25000 32110.0n 0.25000 32239.9n 0.25000 32240.0n 0.31000 32369.9n 0.31000 32370.0n 0.31000 32499.9n 0.31000 32500.0n 0.31000 32629.9n 0.31000 32630.0n 0.31000 32759.9n 0.31000 32760.0n 0.31000 32889.9n 0.31000 32890.0n 0.31000 33019.9n 0.31000 33020.0n 0.31000 33149.9n 0.31000 33150.0n 0.25000 33279.9n 0.25000 33280.0n 0.25000 33409.9n 0.25000 33410.0n 0.31000 33539.9n 0.31000 33540.0n 0.31000 33669.9n 0.31000 33670.0n 0.25000 33799.9n 0.25000 33800.0n 0.31000 33929.9n 0.31000 33930.0n 0.25000 34059.9n 0.25000 34060.0n 0.25000 34189.9n 0.25000 34190.0n 0.25000 34319.9n 0.25000 34320.0n 0.25000 34449.9n 0.25000 34450.0n 0.31000 34579.9n 0.31000 34580.0n 0.25000 34709.9n 0.25000 34710.0n 0.25000 34839.9n 0.25000 34840.0n 0.31000 34969.9n 0.31000 34970.0n 0.25000 35099.9n 0.25000 35100.0n 0.31000 35229.9n 0.31000 35230.0n 0.25000 35359.9n 0.25000 35360.0n 0.31000 35489.9n 0.31000 35490.0n 0.25000 35619.9n 0.25000 35620.0n 0.25000 35749.9n 0.25000 35750.0n 0.31000 35879.9n 0.31000 35880.0n 0.25000 36009.9n 0.25000 36010.0n 0.25000 36139.9n 0.25000 36140.0n 0.31000 36269.9n 0.31000 36270.0n 0.31000 36399.9n 0.31000 36400.0n 0.31000 36529.9n 0.31000 36530.0n 0.31000 36659.9n 0.31000 36660.0n 0.25000 36789.9n 0.25000 36790.0n 0.25000 36919.9n 0.25000 36920.0n 0.25000 37049.9n 0.25000 37050.0n 0.31000 37179.9n 0.31000 37180.0n 0.25000 37309.9n 0.25000 37310.0n 0.25000 37439.9n 0.25000 37440.0n 0.25000 37569.9n 0.25000 37570.0n 0.25000 37699.9n 0.25000 37700.0n 0.31000 37829.9n 0.31000 37830.0n 0.31000 37959.9n 0.31000 37960.0n 0.31000 38089.9n 0.31000 38090.0n 0.31000 38219.9n 0.31000 38220.0n 0.25000 38349.9n 0.25000 38350.0n 0.25000 38479.9n 0.25000 38480.0n 0.31000 38609.9n 0.31000 38610.0n 0.31000 38739.9n 0.31000 38740.0n 0.25000 38869.9n 0.25000 38870.0n 0.31000 38999.9n 0.31000 39000.0n 0.25000 39129.9n 0.25000 39130.0n 0.25000 39259.9n 0.25000 39260.0n 0.25000 39389.9n 0.25000 39390.0n 0.25000 39519.9n 0.25000 39520.0n 0.31000 39649.9n 0.31000 39650.0n 0.25000 39779.9n 0.25000 39780.0n 0.31000 39909.9n 0.31000 39910.0n 0.31000 40039.9n 0.31000 40040.0n 0.31000 40169.9n 0.31000 40170.0n 0.31000 40299.9n 0.31000 40300.0n 0.31000 40429.9n 0.31000 40430.0n 0.25000 40559.9n 0.25000 40560.0n 0.25000 40689.9n 0.25000 40690.0n 0.31000 40819.9n 0.31000 40820.0n 0.25000 40949.9n 0.25000 40950.0n 0.31000 41079.9n 0.31000 41080.0n 0.25000 41209.9n 0.25000 41210.0n 0.25000 41339.9n 0.25000 41340.0n 0.31000 41469.9n 0.31000 41470.0n 0.31000 41599.9n 0.31000 41600.0n 0.31000 41729.9n 0.31000 41730.0n 0.25000 41859.9n 0.25000 41860.0n 0.31000 41989.9n 0.31000 41990.0n 0.31000 42119.9n 0.31000 42120.0n 0.25000 42249.9n 0.25000 42250.0n 0.25000 42379.9n 0.25000 42380.0n 0.31000 42509.9n 0.31000 42510.0n 0.25000 42639.9n 0.25000 42640.0n 0.25000 42769.9n 0.25000 42770.0n 0.31000 42899.9n 0.31000 42900.0n 0.31000 43029.9n 0.31000 43030.0n 0.31000 43159.9n 0.31000 43160.0n 0.31000 43289.9n 0.31000 43290.0n 0.31000 43419.9n 0.31000 43420.0n 0.31000 43549.9n 0.31000 43550.0n 0.25000 43679.9n 0.25000 43680.0n 0.25000 43809.9n 0.25000 43810.0n 0.31000 43939.9n 0.31000 43940.0n 0.31000 44069.9n 0.31000 44070.0n 0.25000 44199.9n 0.25000 44200.0n 0.31000 44329.9n 0.31000 44330.0n 0.25000 44459.9n 0.25000 44460.0n 0.25000 44589.9n 0.25000 44590.0n 0.25000 44719.9n 0.25000 44720.0n 0.31000 44849.9n 0.31000 44850.0n 0.31000 44979.9n 0.31000 44980.0n 0.25000 45109.9n 0.25000 45110.0n 0.25000 45239.9n 0.25000 45240.0n 0.25000 45369.9n 0.25000 45370.0n 0.25000 45499.9n 0.25000 45500.0n 0.31000 45629.9n 0.31000 45630.0n 0.31000 45759.9n 0.31000 45760.0n 0.25000 45889.9n 0.25000 45890.0n 0.25000 46019.9n 0.25000 46020.0n 0.31000 46149.9n 0.31000 46150.0n 0.25000 46279.9n 0.25000 46280.0n 0.25000 46409.9n 0.25000 46410.0n 0.31000 46539.9n 0.31000 46540.0n 0.31000 46669.9n 0.31000 46670.0n 0.31000 46799.9n 0.31000 46800.0n 0.31000 46929.9n 0.31000 46930.0n 0.31000 47059.9n 0.31000 47060.0n 0.25000 47189.9n 0.25000 47190.0n 0.25000 47319.9n 0.25000 47320.0n 0.25000 47449.9n 0.25000 47450.0n 0.25000 47579.9n 0.25000 47580.0n 0.25000 47709.9n 0.25000 47710.0n 0.31000 47839.9n 0.31000 47840.0n 0.31000 47969.9n 0.31000 47970.0n 0.31000 48099.9n 0.31000 48100.0n 0.25000 48229.9n 0.25000 48230.0n 0.31000 48359.9n 0.31000 48360.0n 0.31000 48489.9n 0.31000 48490.0n 0.25000 48619.9n 0.25000 48620.0n 0.31000 48749.9n 0.31000 48750.0n 0.25000 48879.9n 0.25000 48880.0n 0.25000 49009.9n 0.25000 49010.0n 0.31000 49139.9n 0.31000 49140.0n 0.25000 49269.9n 0.25000 49270.0n 0.25000 49399.9n 0.25000 49400.0n 0.31000 49529.9n 0.31000 49530.0n 0.31000 49659.9n 0.31000 49660.0n 0.25000 49789.9n 0.25000 49790.0n 0.25000 49919.9n 0.25000 49920.0n 0.28000 50049.9n 0.28000 50050.0n 0.28000 50179.9n 0.28000 50180.0n 0.28000 50309.9n 0.28000 50310.0n 0.28000 50439.9n 0.28000 50440.0n 0.28000 50569.9n 0.28000 50570.0n 0.28000 50699.9n 0.28000 50700.0n 0.28000 50829.9n 0.28000 50830.0n 0.28000 50959.9n 0.28000 50960.0n 0.28000 51089.9n 0.28000 51090.0n 0.28000 51219.9n 0.28000 51220.0n 0.28000 51349.9n 0.28000 51350.0n 0.28000 51479.9n 0.28000 51480.0n 0.28000 51609.9n 0.28000 51610.0n 0.28000 51739.9n 0.28000 51740.0n 0.28000 51869.9n 0.28000 51870.0n 0.28000 51999.9n 0.28000 52000.0n 0.28000 52129.9n 0.28000 52130.0n 0.28000 52259.9n 0.28000 52260.0n 0.28000 52389.9n 0.28000 52390.0n 0.28000 52519.9n 0.28000 52520.0n 0.28000 52649.9n 0.28000 52650.0n 0.28000 52779.9n 0.28000 52780.0n 0.28000 52909.9n 0.28000 52910.0n 0.28000 53039.9n 0.28000 53040.0n 0.28000 53169.9n 0.28000 53170.0n 0.28000 53299.9n 0.28000 53300.0n 0.28000 53429.9n 0.28000 53430.0n 0.28000 53559.9n 0.28000 53560.0n 0.28000 53689.9n 0.28000 53690.0n 0.28000 53819.9n 0.28000 53820.0n 0.28000 53949.9n 0.28000 53950.0n 0.28000 54079.9n 0.28000 54080.0n 0.28000 54209.9n 0.28000 54210.0n 0.28000 54339.9n 0.28000 54340.0n 0.28000 54469.9n 0.28000 54470.0n 0.28000 54599.9n 0.28000 54600.0n 0.28000 54729.9n 0.28000 54730.0n 0.28000 54859.9n 0.28000 54860.0n 0.28000 54989.9n 0.28000 54990.0n 0.28000 55119.9n 0.28000 55120.0n 0.28000 55249.9n 0.28000 55250.0n 0.28000 55379.9n 0.28000 55380.0n 0.28000 55509.9n 0.28000 55510.0n 0.28000 55639.9n 0.28000 55640.0n 0.28000 55769.9n 0.28000 55770.0n 0.28000 55899.9n 0.28000 55900.0n 0.28000 56029.9n 0.28000 56030.0n 0.28000 56159.9n 0.28000 56160.0n 0.31000 56289.9n 0.31000 56290.0n 0.25000 56419.9n 0.25000 56420.0n 0.25000 56549.9n 0.25000 56550.0n 0.25000 56679.9n 0.25000 56680.0n 0.31000 56809.9n 0.31000 56810.0n 0.25000 56939.9n 0.25000 56940.0n 0.25000 57069.9n 0.25000 57070.0n 0.25000 57199.9n 0.25000 57200.0n 0.25000 57329.9n 0.25000 57330.0n 0.31000 57459.9n 0.31000 57460.0n 0.31000 57589.9n 0.31000 57590.0n 0.31000 57719.9n 0.31000 57720.0n 0.31000 57849.9n 0.31000 57850.0n 0.31000 57979.9n 0.31000 57980.0n 0.31000 58109.9n 0.31000 58110.0n 0.31000 58239.9n 0.31000 58240.0n 0.25000 58369.9n 0.25000 58370.0n 0.25000 58499.9n 0.25000 58500.0n 0.25000 58629.9n 0.25000 58630.0n 0.25000 58759.9n 0.25000 58760.0n 0.25000 58889.9n 0.25000 58890.0n 0.31000 59019.9n 0.31000 59020.0n 0.31000 59149.9n 0.31000 59150.0n 0.31000 59279.9n 0.31000 59280.0n 0.31000 59409.9n 0.31000 59410.0n 0.25000 59539.9n 0.25000 59540.0n 0.31000 59669.9n 0.31000 59670.0n 0.25000 59799.9n 0.25000 59800.0n 0.31000 59929.9n 0.31000 59930.0n 0.31000 60059.9n 0.31000 60060.0n 0.25000 60189.9n 0.25000 60190.0n 0.31000 60319.9n 0.31000 60320.0n 0.31000 60449.9n 0.31000 60450.0n 0.25000 60579.9n 0.25000 60580.0n 0.25000 60709.9n 0.25000 60710.0n 0.31000 60839.9n 0.31000 60840.0n 0.25000 60969.9n 0.25000 60970.0n 0.25000 61099.9n 0.25000 61100.0n 0.31000 61229.9n 0.31000 61230.0n 0.25000 61359.9n 0.25000 61360.0n 0.31000 61489.9n 0.31000 61490.0n 0.25000 61619.9n 0.25000 61620.0n 0.25000 61749.9n 0.25000 61750.0n 0.31000 61879.9n 0.31000 61880.0n 0.31000 62009.9n 0.31000 62010.0n 0.25000 62139.9n 0.25000 62140.0n 0.31000 62269.9n 0.31000 62270.0n 0.25000 62399.9n 0.25000 62400.0n 0.31000 62529.9n 0.31000 62530.0n 0.31000 62659.9n 0.31000 62660.0n 0.31000 62789.9n 0.31000 62790.0n 0.25000 62919.9n 0.25000 62920.0n 0.25000 63049.9n 0.25000 63050.0n 0.25000 63179.9n 0.25000 63180.0n 0.25000 63309.9n 0.25000 63310.0n 0.31000 63439.9n 0.31000 63440.0n 0.25000 63569.9n 0.25000 63570.0n 0.31000 63699.9n 0.31000 63700.0n 0.31000 63829.9n 0.31000 63830.0n 0.25000 63959.9n 0.25000 63960.0n 0.25000 64089.9n 0.25000 64090.0n 0.31000 64219.9n 0.31000 64220.0n 0.25000 64349.9n 0.25000 64350.0n 0.25000 64479.9n 0.25000 64480.0n 0.31000 64609.9n 0.31000 64610.0n 0.25000 64739.9n 0.25000 64740.0n 0.25000 64869.9n 0.25000 64870.0n 0.31000 64999.9n 0.31000 65000.0n 0.25000 65129.9n 0.25000 65130.0n 0.25000 65259.9n 0.25000 65260.0n 0.25000 65389.9n 0.25000 65390.0n 0.25000 65519.9n 0.25000 65520.0n 0.31000 65649.9n 0.31000 65650.0n 0.31000 65779.9n 0.31000 65780.0n 0.31000 65909.9n 0.31000 65910.0n 0.25000 66039.9n 0.25000 66040.0n 0.31000 66169.9n 0.31000 66170.0n 0.31000 66299.9n 0.31000 66300.0n 0.31000 66429.9n 0.31000 66430.0n 0.31000 66559.9n 0.31000 66560.0n 0.25000 66689.9n 0.25000 66690.0n 0.31000 66819.9n 0.31000 66820.0n 0.25000 66949.9n 0.25000 66950.0n 0.31000 67079.9n 0.31000 67080.0n 0.25000 67209.9n 0.25000 67210.0n 0.31000 67339.9n 0.31000 67340.0n 0.25000 67469.9n 0.25000 67470.0n 0.25000 67599.9n 0.25000 67600.0n 0.31000 67729.9n 0.31000 67730.0n 0.25000 67859.9n 0.25000 67860.0n 0.31000 67989.9n 0.31000 67990.0n 0.31000 68119.9n 0.31000 68120.0n 0.31000 68249.9n 0.31000 68250.0n 0.25000 68379.9n 0.25000 68380.0n 0.25000 68509.9n 0.25000 68510.0n 0.31000 68639.9n 0.31000 68640.0n 0.31000 68769.9n 0.31000 68770.0n 0.25000 68899.9n 0.25000 68900.0n 0.25000 69029.9n 0.25000 69030.0n 0.31000 69159.9n 0.31000 69160.0n 0.25000 69289.9n 0.25000 69290.0n 0.31000 69419.9n 0.31000 69420.0n 0.25000 69549.9n 0.25000 69550.0n 0.31000 69679.9n 0.31000 69680.0n 0.31000 69809.9n 0.31000 69810.0n 0.25000 69939.9n 0.25000 69940.0n 0.31000 70069.9n 0.31000 70070.0n 0.25000 70199.9n 0.25000 70200.0n 0.25000 70329.9n 0.25000 70330.0n 0.25000 70459.9n 0.25000 70460.0n 0.31000 70589.9n 0.31000 70590.0n 0.31000 70719.9n 0.31000 70720.0n 0.25000 70849.9n 0.25000 70850.0n 0.25000 70979.9n 0.25000 70980.0n 0.31000 71109.9n 0.31000 71110.0n 0.31000 71239.9n 0.31000 71240.0n 0.31000 71369.9n 0.31000 71370.0n 0.31000 71499.9n 0.31000 71500.0n 0.31000 71629.9n 0.31000 71630.0n 0.25000 71759.9n 0.25000 71760.0n 0.25000 71889.9n 0.25000 71890.0n 0.25000 72019.9n 0.25000 72020.0n 0.25000 72149.9n 0.25000 72150.0n 0.31000 72279.9n 0.31000 72280.0n 0.25000 72409.9n 0.25000 72410.0n 0.31000 72539.9n 0.31000 72540.0n 0.25000 72669.9n 0.25000 72670.0n 0.31000 72799.9n 0.31000 72800.0n 0.25000 72929.9n 0.25000 72930.0n 0.31000 73059.9n 0.31000 73060.0n 0.31000 73189.9n 0.31000 73190.0n 0.31000 73319.9n 0.31000 73320.0n 0.25000 73449.9n 0.25000 73450.0n 0.25000 73579.9n 0.25000 73580.0n 0.31000 73709.9n 0.31000 73710.0n 0.25000 73839.9n 0.25000 73840.0n 0.31000 73969.9n 0.31000 73970.0n 0.25000 74099.9n 0.25000 74100.0n 0.25000 74229.9n 0.25000 74230.0n 0.31000 74359.9n 0.31000 74360.0n 0.31000 74489.9n 0.31000 74490.0n 0.31000 74619.9n 0.31000 74620.0n 0.25000 74749.9n 0.25000 74750.0n 0.25000 74879.9n 0.25000 74880.0n 0.25000 75009.9n 0.25000 75010.0n 0.31000 75139.9n 0.31000 75140.0n 0.25000 75269.9n 0.25000 75270.0n 0.25000 75399.9n 0.25000 75400.0n 0.31000 75529.9n 0.31000 75530.0n 0.25000 75659.9n 0.25000 75660.0n 0.25000 75789.9n 0.25000 75790.0n 0.31000 75919.9n 0.31000 75920.0n 0.25000 76049.9n 0.25000 76050.0n 0.25000 76179.9n 0.25000 76180.0n 0.31000 76309.9n 0.31000 76310.0n 0.25000 76439.9n 0.25000 76440.0n 0.25000 76569.9n 0.25000 76570.0n 0.25000 76699.9n 0.25000 76700.0n 0.25000 76829.9n 0.25000 76830.0n 0.31000 76959.9n 0.31000 76960.0n 0.31000 77089.9n 0.31000 77090.0n 0.31000 77219.9n 0.31000 77220.0n 0.31000 77349.9n 0.31000 77350.0n 0.31000 77479.9n 0.31000 77480.0n 0.31000 77609.9n 0.31000 77610.0n 0.25000 77739.9n 0.25000 77740.0n 0.31000 77869.9n 0.31000 77870.0n 0.31000 77999.9n 0.31000 78000.0n 0.28000 78129.9n 0.28000 78130.0n 0.28000 78259.9n 0.28000 78260.0n 0.28000 78389.9n 0.28000 78390.0n 0.28000 78519.9n 0.28000 78520.0n 0.28000 78649.9n 0.28000 78650.0n 0.28000 78779.9n 0.28000 78780.0n 0.28000 78909.9n 0.28000 78910.0n 0.28000 79039.9n 0.28000 79040.0n 0.28000 79169.9n 0.28000 79170.0n 0.28000 79299.9n 0.28000 79300.0n 0.28000 79429.9n 0.28000 79430.0n 0.28000 79559.9n 0.28000 79560.0n 0.28000 79689.9n 0.28000 79690.0n 0.28000 79819.9n 0.28000 79820.0n 0.28000 79949.9n 0.28000 79950.0n 0.28000 80079.9n 0.28000 80080.0n 0.28000 80209.9n 0.28000 80210.0n 0.28000 80339.9n 0.28000 80340.0n 0.28000 80469.9n 0.28000 80470.0n 0.28000 80599.9n 0.28000 80600.0n 0.28000 80729.9n 0.28000 80730.0n 0.28000 80859.9n 0.28000 80860.0n 0.28000 80989.9n 0.28000 80990.0n 0.28000 81119.9n 0.28000 81120.0n 0.28000 81249.9n 0.28000 81250.0n 0.28000 81379.9n 0.28000 81380.0n 0.28000 81509.9n 0.28000 81510.0n 0.28000 81639.9n 0.28000 81640.0n 0.28000 81769.9n 0.28000 81770.0n 0.28000 81899.9n 0.28000 81900.0n 0.28000 82029.9n 0.28000 82030.0n 0.28000 82159.9n 0.28000 82160.0n 0.28000 82289.9n 0.28000 82290.0n 0.28000 82419.9n 0.28000 82420.0n 0.28000 82549.9n 0.28000 82550.0n 0.28000 82679.9n 0.28000 82680.0n 0.28000 82809.9n 0.28000 82810.0n 0.28000 82939.9n 0.28000 82940.0n 0.28000 83069.9n 0.28000 83070.0n 0.28000 83199.9n 0.28000 83200.0n 0.28000 83329.9n 0.28000 83330.0n 0.28000 83459.9n 0.28000 83460.0n 0.28000 83589.9n 0.28000 83590.0n 0.28000 83719.9n 0.28000 83720.0n 0.28000 83849.9n 0.28000 83850.0n 0.28000 83979.9n 0.28000 83980.0n 0.28000 84109.9n 0.28000 84110.0n 0.28000 84239.9n 0.28000 84240.0n 0.25000 84369.9n 0.25000 84370.0n 0.31000 84499.9n 0.31000 84500.0n 0.31000 84629.9n 0.31000 84630.0n 0.31000 84759.9n 0.31000 84760.0n 0.31000 84889.9n 0.31000 84890.0n 0.31000 85019.9n 0.31000 85020.0n 0.25000 85149.9n 0.25000 85150.0n 0.25000 85279.9n 0.25000 85280.0n 0.25000 85409.9n 0.25000 85410.0n 0.31000 85539.9n 0.31000 85540.0n 0.25000 85669.9n 0.25000 85670.0n 0.25000 85799.9n 0.25000 85800.0n 0.25000 85929.9n 0.25000 85930.0n 0.25000 86059.9n 0.25000 86060.0n 0.31000 86189.9n 0.31000 86190.0n 0.25000 86319.9n 0.25000 86320.0n 0.31000 86449.9n 0.31000 86450.0n 0.25000 86579.9n 0.25000 86580.0n 0.31000 86709.9n 0.31000 86710.0n 0.31000 86839.9n 0.31000 86840.0n 0.31000 86969.9n 0.31000 86970.0n 0.25000 87099.9n 0.25000 87100.0n 0.31000 87229.9n 0.31000 87230.0n 0.31000 87359.9n 0.31000 87360.0n 0.25000 87489.9n 0.25000 87490.0n 0.25000 87619.9n 0.25000 87620.0n 0.25000 87749.9n 0.25000 87750.0n 0.31000 87879.9n 0.31000 87880.0n 0.25000 88009.9n 0.25000 88010.0n 0.31000 88139.9n 0.31000 88140.0n 0.25000 88269.9n 0.25000 88270.0n 0.25000 88399.9n 0.25000 88400.0n 0.31000 88529.9n 0.31000 88530.0n 0.25000 88659.9n 0.25000 88660.0n 0.25000 88789.9n 0.25000 88790.0n 0.31000 88919.9n 0.31000 88920.0n 0.31000 89049.9n 0.31000 89050.0n 0.31000 89179.9n 0.31000 89180.0n 0.25000 89309.9n 0.25000 89310.0n 0.25000 89439.9n 0.25000 89440.0n 0.25000 89569.9n 0.25000 89570.0n 0.25000 89699.9n 0.25000 89700.0n 0.25000 89829.9n 0.25000 89830.0n 0.25000 89959.9n 0.25000 89960.0n 0.31000 90089.9n 0.31000 90090.0n 0.31000 90219.9n 0.31000 90220.0n 0.31000 90349.9n 0.31000 90350.0n 0.31000 90479.9n 0.31000 90480.0n 0.31000 90609.9n 0.31000 90610.0n 0.31000 90739.9n 0.31000 90740.0n 0.31000 90869.9n 0.31000 90870.0n 0.25000 90999.9n 0.25000 91000.0n 0.25000 91129.9n 0.25000 91130.0n 0.31000 91259.9n 0.31000 91260.0n 0.25000 91389.9n 0.25000 91390.0n 0.31000 91519.9n 0.31000 91520.0n 0.25000 91649.9n 0.25000 91650.0n 0.31000 91779.9n 0.31000 91780.0n 0.31000 91909.9n 0.31000 91910.0n 0.31000 92039.9n 0.31000 92040.0n 0.25000 92169.9n 0.25000 92170.0n 0.31000 92299.9n 0.31000 92300.0n 0.25000 92429.9n 0.25000 92430.0n 0.25000 92559.9n 0.25000 92560.0n 0.25000 92689.9n 0.25000 92690.0n 0.31000 92819.9n 0.31000 92820.0n 0.31000 92949.9n 0.31000 92950.0n 0.31000 93079.9n 0.31000 93080.0n 0.25000 93209.9n 0.25000 93210.0n 0.25000 93339.9n 0.25000 93340.0n 0.31000 93469.9n 0.31000 93470.0n 0.25000 93599.9n 0.25000 93600.0n 0.25000 93729.9n 0.25000 93730.0n 0.25000 93859.9n 0.25000 93860.0n 0.31000 93989.9n 0.31000 93990.0n 0.31000 94119.9n 0.31000 94120.0n 0.25000 94249.9n 0.25000 94250.0n 0.25000 94379.9n 0.25000 94380.0n 0.25000 94509.9n 0.25000 94510.0n 0.31000 94639.9n 0.31000 94640.0n 0.31000 94769.9n 0.31000 94770.0n 0.31000 94899.9n 0.31000 94900.0n 0.31000 95029.9n 0.31000 95030.0n 0.25000 95159.9n 0.25000 95160.0n 0.25000 95289.9n 0.25000 95290.0n 0.31000 95419.9n 0.31000 95420.0n 0.31000 95549.9n 0.31000 95550.0n 0.25000 95679.9n 0.25000 95680.0n 0.31000 95809.9n 0.31000 95810.0n 0.25000 95939.9n 0.25000 95940.0n 0.25000 96069.9n 0.25000 96070.0n 0.25000 96199.9n 0.25000 96200.0n 0.25000 96329.9n 0.25000 96330.0n 0.25000 96459.9n 0.25000 96460.0n 0.31000 96589.9n 0.31000 96590.0n 0.25000 96719.9n 0.25000 96720.0n 0.25000 96849.9n 0.25000 96850.0n 0.31000 96979.9n 0.31000 96980.0n 0.31000 97109.9n 0.31000 97110.0n 0.31000 97239.9n 0.31000 97240.0n 0.31000 97369.9n 0.31000 97370.0n 0.25000 97499.9n 0.25000 97500.0n 0.31000 97629.9n 0.31000 97630.0n 0.25000 97759.9n 0.25000 97760.0n 0.31000 97889.9n 0.31000 97890.0n 0.31000 98019.9n 0.31000 98020.0n 0.31000 98149.9n 0.31000 98150.0n 0.31000 98279.9n 0.31000 98280.0n 0.31000 98409.9n 0.31000 98410.0n 0.25000 98539.9n 0.25000 98540.0n 0.25000 98669.9n 0.25000 98670.0n 0.25000 98799.9n 0.25000 98800.0n 0.25000 98929.9n 0.25000 98930.0n 0.31000 99059.9n 0.31000 99060.0n 0.31000 99189.9n 0.31000 99190.0n 0.25000 99319.9n 0.25000 99320.0n 0.31000 99449.9n 0.31000 99450.0n 0.25000 99579.9n 0.25000 99580.0n 0.25000 99709.9n 0.25000 99710.0n 0.31000 99839.9n 0.31000 99840.0n 0.31000 99969.9n 0.31000 99970.0n 0.31000 100099.9n 0.31000 100100.0n 0.31000 100229.9n 0.31000 100230.0n 0.31000 100359.9n 0.31000 100360.0n 0.31000 100489.9n 0.31000 100490.0n 0.25000 100619.9n 0.25000 100620.0n 0.31000 100749.9n 0.31000 100750.0n 0.25000 100879.9n 0.25000 100880.0n 0.31000 101009.9n 0.31000 101010.0n 0.25000 101139.9n 0.25000 101140.0n 0.25000 101269.9n 0.25000 101270.0n 0.25000 101399.9n 0.25000 101400.0n 0.25000 101529.9n 0.25000 101530.0n 0.25000 101659.9n 0.25000 101660.0n 0.31000 101789.9n 0.31000 101790.0n 0.25000 101919.9n 0.25000 101920.0n 0.31000 102049.9n 0.31000 102050.0n 0.25000 102179.9n 0.25000 102180.0n 0.31000 102309.9n 0.31000 102310.0n 0.25000 102439.9n 0.25000 102440.0n 0.31000 102569.9n 0.31000 102570.0n 0.31000 102699.9n 0.31000 102700.0n 0.25000 102829.9n 0.25000 102830.0n 0.25000 102959.9n 0.25000 102960.0n 0.25000 103089.9n 0.25000 103090.0n 0.31000 103219.9n 0.31000 103220.0n 0.31000 103349.9n 0.31000 103350.0n 0.25000 103479.9n 0.25000 103480.0n 0.25000 103609.9n 0.25000 103610.0n 0.25000 103739.9n 0.25000 103740.0n 0.31000 103869.9n 0.31000 103870.0n 0.31000 103999.9n 0.31000 104000.0n 0.31000 104129.9n 0.31000 104130.0n 0.25000 104259.9n 0.25000 104260.0n 0.31000 104389.9n 0.31000 104390.0n 0.31000 104519.9n 0.31000 104520.0n 0.31000 104649.9n 0.31000 104650.0n 0.25000 104779.9n 0.25000 104780.0n 0.31000 104909.9n 0.31000 104910.0n 0.25000 105039.9n 0.25000 105040.0n 0.25000 105169.9n 0.25000 105170.0n 0.25000 105299.9n 0.25000 105300.0n 0.25000 105429.9n 0.25000 105430.0n 0.25000 105559.9n 0.25000 105560.0n 0.31000 105689.9n 0.31000 105690.0n 0.31000 105819.9n 0.31000 105820.0n 0.31000 105949.9n 0.31000 105950.0n 0.25000 106079.9n 0.25000 106080.0n 0.28000 106209.9n 0.28000 106210.0n 0.28000 106339.9n 0.28000 106340.0n 0.28000 106469.9n 0.28000 106470.0n 0.28000 106599.9n 0.28000 106600.0n 0.28000 106729.9n 0.28000 106730.0n 0.28000 106859.9n 0.28000 106860.0n 0.28000 106989.9n 0.28000 106990.0n 0.28000 107119.9n 0.28000 107120.0n 0.28000 107249.9n 0.28000 107250.0n 0.28000 107379.9n 0.28000 107380.0n 0.28000 107509.9n 0.28000 107510.0n 0.28000 107639.9n 0.28000 107640.0n 0.28000 107769.9n 0.28000 107770.0n 0.28000 107899.9n 0.28000 107900.0n 0.28000 108029.9n 0.28000 108030.0n 0.28000 108159.9n 0.28000 108160.0n 0.28000 108289.9n 0.28000 108290.0n 0.28000 108419.9n 0.28000 108420.0n 0.28000 108549.9n 0.28000 108550.0n 0.28000 108679.9n 0.28000 108680.0n 0.28000 108809.9n 0.28000 108810.0n 0.28000 108939.9n 0.28000 108940.0n 0.28000 109069.9n 0.28000 109070.0n 0.28000 109199.9n 0.28000 109200.0n 0.28000 109329.9n 0.28000 109330.0n 0.28000 109459.9n 0.28000 109460.0n 0.28000 109589.9n 0.28000 109590.0n 0.28000 109719.9n 0.28000 109720.0n 0.28000 109849.9n 0.28000 109850.0n 0.28000 109979.9n 0.28000 109980.0n 0.28000 110109.9n 0.28000 110110.0n 0.28000 110239.9n 0.28000 110240.0n 0.28000 110369.9n 0.28000 110370.0n 0.28000 110499.9n 0.28000 110500.0n 0.28000 110629.9n 0.28000 110630.0n 0.28000 110759.9n 0.28000 110760.0n 0.28000 110889.9n 0.28000 110890.0n 0.28000 111019.9n 0.28000 111020.0n 0.28000 111149.9n 0.28000 111150.0n 0.28000 111279.9n 0.28000 111280.0n 0.28000 111409.9n 0.28000 111410.0n 0.28000 111539.9n 0.28000 111540.0n 0.28000 111669.9n 0.28000 111670.0n 0.28000 111799.9n 0.28000 111800.0n 0.28000 111929.9n 0.28000 111930.0n 0.28000 112059.9n 0.28000 112060.0n 0.28000 112189.9n 0.28000 112190.0n 0.28000 112319.9n 0.28000 112320.0n 0.25000 112449.9n 0.25000 112450.0n 0.31000 112579.9n 0.31000 112580.0n 0.25000 112709.9n 0.25000 112710.0n 0.31000 112839.9n 0.31000 112840.0n 0.31000 112969.9n 0.31000 112970.0n 0.31000 113099.9n 0.31000 113100.0n 0.31000 113229.9n 0.31000 113230.0n 0.25000 113359.9n 0.25000 113360.0n 0.31000 113489.9n 0.31000 113490.0n 0.31000 113619.9n 0.31000 113620.0n 0.31000 113749.9n 0.31000 113750.0n 0.25000 113879.9n 0.25000 113880.0n 0.25000 114009.9n 0.25000 114010.0n 0.31000 114139.9n 0.31000 114140.0n 0.31000 114269.9n 0.31000 114270.0n 0.25000 114399.9n 0.25000 114400.0n 0.31000 114529.9n 0.31000 114530.0n 0.31000 114659.9n 0.31000 114660.0n 0.31000 114789.9n 0.31000 114790.0n 0.25000 114919.9n 0.25000 114920.0n 0.25000 115049.9n 0.25000 115050.0n 0.25000 115179.9n 0.25000 115180.0n 0.25000 115309.9n 0.25000 115310.0n 0.25000 115439.9n 0.25000 115440.0n 0.25000 115569.9n 0.25000 115570.0n 0.25000 115699.9n 0.25000 115700.0n 0.25000 115829.9n 0.25000 115830.0n 0.31000 115959.9n 0.31000 115960.0n 0.25000 116089.9n 0.25000 116090.0n 0.31000 116219.9n 0.31000 116220.0n 0.25000 116349.9n 0.25000 116350.0n 0.25000 116479.9n 0.25000 116480.0n 0.25000 116609.9n 0.25000 116610.0n 0.31000 116739.9n 0.31000 116740.0n 0.25000 116869.9n 0.25000 116870.0n 0.31000 116999.9n 0.31000 117000.0n 0.25000 117129.9n 0.25000 117130.0n 0.31000 117259.9n 0.31000 117260.0n 0.25000 117389.9n 0.25000 117390.0n 0.25000 117519.9n 0.25000 117520.0n 0.25000 117649.9n 0.25000 117650.0n 0.31000 117779.9n 0.31000 117780.0n 0.25000 117909.9n 0.25000 117910.0n 0.25000 118039.9n 0.25000 118040.0n 0.31000 118169.9n 0.31000 118170.0n 0.31000 118299.9n 0.31000 118300.0n 0.31000 118429.9n 0.31000 118430.0n 0.31000 118559.9n 0.31000 118560.0n 0.31000 118689.9n 0.31000 118690.0n 0.31000 118819.9n 0.31000 118820.0n 0.31000 118949.9n 0.31000 118950.0n 0.31000 119079.9n 0.31000 119080.0n 0.25000 119209.9n 0.25000 119210.0n 0.31000 119339.9n 0.31000 119340.0n 0.25000 119469.9n 0.25000 119470.0n 0.25000 119599.9n 0.25000 119600.0n 0.31000 119729.9n 0.31000 119730.0n 0.25000 119859.9n 0.25000 119860.0n 0.25000 119989.9n 0.25000 119990.0n 0.25000 120119.9n 0.25000 120120.0n 0.31000 120249.9n 0.31000 120250.0n 0.31000 120379.9n 0.31000 120380.0n 0.25000 120509.9n 0.25000 120510.0n 0.25000 120639.9n 0.25000 120640.0n 0.31000 120769.9n 0.31000 120770.0n 0.31000 120899.9n 0.31000 120900.0n 0.31000 121029.9n 0.31000 121030.0n 0.25000 121159.9n 0.25000 121160.0n 0.31000 121289.9n 0.31000 121290.0n 0.31000 121419.9n 0.31000 121420.0n 0.25000 121549.9n 0.25000 121550.0n 0.25000 121679.9n 0.25000 121680.0n 0.31000 121809.9n 0.31000 121810.0n 0.25000 121939.9n 0.25000 121940.0n 0.25000 122069.9n 0.25000 122070.0n 0.25000 122199.9n 0.25000 122200.0n 0.31000 122329.9n 0.31000 122330.0n 0.31000 122459.9n 0.31000 122460.0n 0.31000 122589.9n 0.31000 122590.0n 0.25000 122719.9n 0.25000 122720.0n 0.25000 122849.9n 0.25000 122850.0n 0.31000 122979.9n 0.31000 122980.0n 0.25000 123109.9n 0.25000 123110.0n 0.31000 123239.9n 0.31000 123240.0n 0.25000 123369.9n 0.25000 123370.0n 0.31000 123499.9n 0.31000 123500.0n 0.25000 123629.9n 0.25000 123630.0n 0.31000 123759.9n 0.31000 123760.0n 0.25000 123889.9n 0.25000 123890.0n 0.31000 124019.9n 0.31000 124020.0n 0.25000 124149.9n 0.25000 124150.0n 0.25000 124279.9n 0.25000 124280.0n 0.31000 124409.9n 0.31000 124410.0n 0.31000 124539.9n 0.31000 124540.0n 0.31000 124669.9n 0.31000 124670.0n 0.25000 124799.9n 0.25000 124800.0n 0.31000 124929.9n 0.31000 124930.0n 0.25000 125059.9n 0.25000 125060.0n 0.25000 125189.9n 0.25000 125190.0n 0.25000 125319.9n 0.25000 125320.0n 0.25000 125449.9n 0.25000 125450.0n 0.31000 125579.9n 0.31000 125580.0n 0.31000 125709.9n 0.31000 125710.0n 0.31000 125839.9n 0.31000 125840.0n 0.31000 125969.9n 0.31000 125970.0n 0.25000 126099.9n 0.25000 126100.0n 0.25000 126229.9n 0.25000 126230.0n 0.31000 126359.9n 0.31000 126360.0n 0.25000 126489.9n 0.25000 126490.0n 0.25000 126619.9n 0.25000 126620.0n 0.31000 126749.9n 0.31000 126750.0n 0.31000 126879.9n 0.31000 126880.0n 0.25000 127009.9n 0.25000 127010.0n 0.25000 127139.9n 0.25000 127140.0n 0.25000 127269.9n 0.25000 127270.0n 0.31000 127399.9n 0.31000 127400.0n 0.31000 127529.9n 0.31000 127530.0n 0.31000 127659.9n 0.31000 127660.0n 0.25000 127789.9n 0.25000 127790.0n 0.25000 127919.9n 0.25000 127920.0n 0.31000 128049.9n 0.31000 128050.0n 0.31000 128179.9n 0.31000 128180.0n 0.25000 128309.9n 0.25000 128310.0n 0.31000 128439.9n 0.31000 128440.0n 0.31000 128569.9n 0.31000 128570.0n 0.31000 128699.9n 0.31000 128700.0n 0.25000 128829.9n 0.25000 128830.0n 0.25000 128959.9n 0.25000 128960.0n 0.31000 129089.9n 0.31000 129090.0n 0.25000 129219.9n 0.25000 129220.0n 0.31000 129349.9n 0.31000 129350.0n 0.25000 129479.9n 0.25000 129480.0n 0.25000 129609.9n 0.25000 129610.0n 0.31000 129739.9n 0.31000 129740.0n 0.31000 129869.9n 0.31000 129870.0n 0.31000 129999.9n 0.31000 130000.0n 0.25000 130129.9n 0.25000 130130.0n 0.25000 130259.9n 0.25000 130260.0n 0.31000 130389.9n 0.31000 130390.0n 0.25000 130519.9n 0.25000 130520.0n 0.31000 130649.9n 0.31000 130650.0n 0.31000 130779.9n 0.31000 130780.0n 0.31000 130909.9n 0.31000 130910.0n 0.25000 131039.9n 0.25000 131040.0n 0.31000 131169.9n 0.31000 131170.0n 0.31000 131299.9n 0.31000 131300.0n 0.25000 131429.9n 0.25000 131430.0n 0.25000 131559.9n 0.25000 131560.0n 0.31000 131689.9n 0.31000 131690.0n 0.31000 131819.9n 0.31000 131820.0n 0.31000 131949.9n 0.31000 131950.0n 0.25000 132079.9n 0.25000 132080.0n 0.31000 132209.9n 0.31000 132210.0n 0.25000 132339.9n 0.25000 132340.0n 0.25000 132469.9n 0.25000 132470.0n 0.25000 132599.9n 0.25000 132600.0n 0.31000 132729.9n 0.31000 132730.0n 0.31000 132859.9n 0.31000 132860.0n 0.25000 132989.9n 0.25000 132990.0n 0.25000 133119.9n 0.25000 133120.0n 0.25000 133249.9n 0.25000 133250.0n 0.25000 133379.9n 0.25000 133380.0n 0.25000 133509.9n 0.25000 133510.0n 0.25000 133639.9n 0.25000 133640.0n 0.31000 133769.9n 0.31000 133770.0n 0.25000 133899.9n 0.25000 133900.0n 0.31000 134029.9n 0.31000 134030.0n 0.31000 134159.9n 0.31000 134160.0n 0.28000 134289.9n 0.28000 134290.0n 0.28000 134419.9n 0.28000 134420.0n 0.28000 134549.9n 0.28000 134550.0n 0.28000 134679.9n 0.28000 134680.0n 0.28000 134809.9n 0.28000 134810.0n 0.28000 134939.9n 0.28000 134940.0n 0.28000 135069.9n 0.28000 135070.0n 0.28000 135199.9n 0.28000 135200.0n 0.28000 135329.9n 0.28000 135330.0n 0.28000 135459.9n 0.28000 135460.0n 0.28000 135589.9n 0.28000 135590.0n 0.28000 135719.9n 0.28000 135720.0n 0.28000 135849.9n 0.28000 135850.0n 0.28000 135979.9n 0.28000 135980.0n 0.28000 136109.9n 0.28000 136110.0n 0.28000 136239.9n 0.28000 136240.0n 0.28000 136369.9n 0.28000 136370.0n 0.28000 136499.9n 0.28000 136500.0n 0.28000 136629.9n 0.28000 136630.0n 0.28000 136759.9n 0.28000 136760.0n 0.28000 136889.9n 0.28000 136890.0n 0.28000 137019.9n 0.28000 137020.0n 0.28000 137149.9n 0.28000 137150.0n 0.28000 137279.9n 0.28000 137280.0n 0.28000 137409.9n 0.28000 137410.0n 0.28000 137539.9n 0.28000 137540.0n 0.28000 137669.9n 0.28000 137670.0n 0.28000 137799.9n 0.28000 137800.0n 0.28000 137929.9n 0.28000 137930.0n 0.28000 138059.9n 0.28000 138060.0n 0.28000 138189.9n 0.28000 138190.0n 0.28000 138319.9n 0.28000 138320.0n 0.28000 138449.9n 0.28000 138450.0n 0.28000 138579.9n 0.28000 138580.0n 0.28000 138709.9n 0.28000 138710.0n 0.28000 138839.9n 0.28000 138840.0n 0.28000 138969.9n 0.28000 138970.0n 0.28000 139099.9n 0.28000 139100.0n 0.28000 139229.9n 0.28000 139230.0n 0.28000 139359.9n 0.28000 139360.0n 0.28000 139489.9n 0.28000 139490.0n 0.28000 139619.9n 0.28000 139620.0n 0.28000 139749.9n 0.28000 139750.0n 0.28000 139879.9n 0.28000 139880.0n 0.28000 140009.9n 0.28000 140010.0n 0.28000 140139.9n 0.28000 140140.0n 0.28000 140269.9n 0.28000 140270.0n 0.28000 140399.9n 0.28000 140400.0n 0.31000 140529.9n 0.31000 140530.0n 0.25000 140659.9n 0.25000 140660.0n 0.31000 140789.9n 0.31000 140790.0n 0.31000 140919.9n 0.31000 140920.0n 0.25000 141049.9n 0.25000 141050.0n 0.31000 141179.9n 0.31000 141180.0n 0.25000 141309.9n 0.25000 141310.0n 0.31000 141439.9n 0.31000 141440.0n 0.31000 141569.9n 0.31000 141570.0n 0.31000 141699.9n 0.31000 141700.0n 0.31000 141829.9n 0.31000 141830.0n 0.25000 141959.9n 0.25000 141960.0n 0.25000 142089.9n 0.25000 142090.0n 0.25000 142219.9n 0.25000 142220.0n 0.25000 142349.9n 0.25000 142350.0n 0.25000 142479.9n 0.25000 142480.0n 0.25000 142609.9n 0.25000 142610.0n 0.31000 142739.9n 0.31000 142740.0n 0.31000 142869.9n 0.31000 142870.0n 0.25000 142999.9n 0.25000 143000.0n 0.31000 143129.9n 0.31000 143130.0n 0.31000 143259.9n 0.31000 143260.0n 0.25000 143389.9n 0.25000 143390.0n 0.25000 143519.9n 0.25000 143520.0n 0.25000 143649.9n 0.25000 143650.0n 0.25000 143779.9n 0.25000 143780.0n 0.31000 143909.9n 0.31000 143910.0n 0.31000 144039.9n 0.31000 144040.0n 0.25000 144169.9n 0.25000 144170.0n 0.25000 144299.9n 0.25000 144300.0n 0.25000 144429.9n 0.25000 144430.0n 0.31000 144559.9n 0.31000 144560.0n 0.31000 144689.9n 0.31000 144690.0n 0.25000 144819.9n 0.25000 144820.0n 0.25000 144949.9n 0.25000 144950.0n 0.31000 145079.9n 0.31000 145080.0n 0.25000 145209.9n 0.25000 145210.0n 0.31000 145339.9n 0.31000 145340.0n 0.31000 145469.9n 0.31000 145470.0n 0.31000 145599.9n 0.31000 145600.0n 0.25000 145729.9n 0.25000 145730.0n 0.31000 145859.9n 0.31000 145860.0n 0.25000 145989.9n 0.25000 145990.0n 0.25000 146119.9n 0.25000 146120.0n 0.31000 146249.9n 0.31000 146250.0n 0.31000 146379.9n 0.31000 146380.0n 0.25000 146509.9n 0.25000 146510.0n 0.31000 146639.9n 0.31000 146640.0n 0.25000 146769.9n 0.25000 146770.0n 0.31000 146899.9n 0.31000 146900.0n 0.25000 147029.9n 0.25000 147030.0n 0.25000 147159.9n 0.25000 147160.0n 0.25000 147289.9n 0.25000 147290.0n 0.31000 147419.9n 0.31000 147420.0n 0.31000 147549.9n 0.31000 147550.0n 0.31000 147679.9n 0.31000 147680.0n 0.31000 147809.9n 0.31000 147810.0n 0.31000 147939.9n 0.31000 147940.0n 0.25000 148069.9n 0.25000 148070.0n 0.25000 148199.9n 0.25000 148200.0n 0.31000 148329.9n 0.31000 148330.0n 0.31000 148459.9n 0.31000 148460.0n 0.25000 148589.9n 0.25000 148590.0n 0.25000 148719.9n 0.25000 148720.0n 0.31000 148849.9n 0.31000 148850.0n 0.25000 148979.9n 0.25000 148980.0n 0.25000 149109.9n 0.25000 149110.0n 0.31000 149239.9n 0.31000 149240.0n 0.25000 149369.9n 0.25000 149370.0n 0.31000 149499.9n 0.31000 149500.0n 0.31000 149629.9n 0.31000 149630.0n 0.31000 149759.9n 0.31000 149760.0n 0.25000 149889.9n 0.25000 149890.0n 0.25000 150019.9n 0.25000 150020.0n 0.25000 150149.9n 0.25000 150150.0n 0.25000 150279.9n 0.25000 150280.0n 0.25000 150409.9n 0.25000 150410.0n 0.31000 150539.9n 0.31000 150540.0n 0.31000 150669.9n 0.31000 150670.0n 0.31000 150799.9n 0.31000 150800.0n 0.31000 150929.9n 0.31000 150930.0n 0.25000 151059.9n 0.25000 151060.0n 0.25000 151189.9n 0.25000 151190.0n 0.31000 151319.9n 0.31000 151320.0n 0.25000 151449.9n 0.25000 151450.0n 0.31000 151579.9n 0.31000 151580.0n 0.31000 151709.9n 0.31000 151710.0n 0.31000 151839.9n 0.31000 151840.0n 0.25000 151969.9n 0.25000 151970.0n 0.31000 152099.9n 0.31000 152100.0n 0.25000 152229.9n 0.25000 152230.0n 0.31000 152359.9n 0.31000 152360.0n 0.25000 152489.9n 0.25000 152490.0n 0.25000 152619.9n 0.25000 152620.0n 0.25000 152749.9n 0.25000 152750.0n 0.25000 152879.9n 0.25000 152880.0n 0.25000 153009.9n 0.25000 153010.0n 0.31000 153139.9n 0.31000 153140.0n 0.25000 153269.9n 0.25000 153270.0n 0.31000 153399.9n 0.31000 153400.0n 0.25000 153529.9n 0.25000 153530.0n 0.31000 153659.9n 0.31000 153660.0n 0.25000 153789.9n 0.25000 153790.0n 0.25000 153919.9n 0.25000 153920.0n 0.31000 154049.9n 0.31000 154050.0n 0.31000 154179.9n 0.31000 154180.0n 0.31000 154309.9n 0.31000 154310.0n 0.25000 154439.9n 0.25000 154440.0n 0.31000 154569.9n 0.31000 154570.0n 0.31000 154699.9n 0.31000 154700.0n 0.25000 154829.9n 0.25000 154830.0n 0.31000 154959.9n 0.31000 154960.0n 0.31000 155089.9n 0.31000 155090.0n 0.31000 155219.9n 0.31000 155220.0n 0.25000 155349.9n 0.25000 155350.0n 0.25000 155479.9n 0.25000 155480.0n 0.25000 155609.9n 0.25000 155610.0n 0.25000 155739.9n 0.25000 155740.0n 0.31000 155869.9n 0.31000 155870.0n 0.31000 155999.9n 0.31000 156000.0n 0.31000 156129.9n 0.31000 156130.0n 0.25000 156259.9n 0.25000 156260.0n 0.31000 156389.9n 0.31000 156390.0n 0.31000 156519.9n 0.31000 156520.0n 0.31000 156649.9n 0.31000 156650.0n 0.31000 156779.9n 0.31000 156780.0n 0.31000 156909.9n 0.31000 156910.0n 0.25000 157039.9n 0.25000 157040.0n 0.25000 157169.9n 0.25000 157170.0n 0.25000 157299.9n 0.25000 157300.0n 0.25000 157429.9n 0.25000 157430.0n 0.25000 157559.9n 0.25000 157560.0n 0.31000 157689.9n 0.31000 157690.0n 0.25000 157819.9n 0.25000 157820.0n 0.31000 157949.9n 0.31000 157950.0n 0.31000 158079.9n 0.31000 158080.0n 0.25000 158209.9n 0.25000 158210.0n 0.31000 158339.9n 0.31000 158340.0n 0.25000 158469.9n 0.25000 158470.0n 0.25000 158599.9n 0.25000 158600.0n 0.31000 158729.9n 0.31000 158730.0n 0.31000 158859.9n 0.31000 158860.0n 0.25000 158989.9n 0.25000 158990.0n 0.31000 159119.9n 0.31000 159120.0n 0.25000 159249.9n 0.25000 159250.0n 0.31000 159379.9n 0.31000 159380.0n 0.31000 159509.9n 0.31000 159510.0n 0.25000 159639.9n 0.25000 159640.0n 0.25000 159769.9n 0.25000 159770.0n 0.25000 159899.9n 0.25000 159900.0n 0.31000 160029.9n 0.31000 160030.0n 0.25000 160159.9n 0.25000 160160.0n 0.25000 160289.9n 0.25000 160290.0n 0.31000 160419.9n 0.31000 160420.0n 0.31000 160549.9n 0.31000 160550.0n 0.31000 160679.9n 0.31000 160680.0n 0.31000 160809.9n 0.31000 160810.0n 0.25000 160939.9n 0.25000 160940.0n 0.31000 161069.9n 0.31000 161070.0n 0.25000 161199.9n 0.25000 161200.0n 0.25000 161329.9n 0.25000 161330.0n 0.25000 161459.9n 0.25000 161460.0n 0.31000 161589.9n 0.31000 161590.0n 0.25000 161719.9n 0.25000 161720.0n 0.31000 161849.9n 0.31000 161850.0n 0.25000 161979.9n 0.25000 161980.0n 0.31000 162109.9n 0.31000 162110.0n 0.25000 162239.9n 0.25000 162240.0n 0.28000 162369.9n 0.28000 162370.0n 0.28000 162499.9n 0.28000 162500.0n 0.28000 162629.9n 0.28000 162630.0n 0.28000 162759.9n 0.28000 162760.0n 0.28000 162889.9n 0.28000 162890.0n 0.28000 163019.9n 0.28000 163020.0n 0.28000 163149.9n 0.28000 163150.0n 0.28000 163279.9n 0.28000 163280.0n 0.28000 163409.9n 0.28000 163410.0n 0.28000 163539.9n 0.28000 163540.0n 0.28000 163669.9n 0.28000 163670.0n 0.28000 163799.9n 0.28000 163800.0n 0.28000 163929.9n 0.28000 163930.0n 0.28000 164059.9n 0.28000 164060.0n 0.28000 164189.9n 0.28000 164190.0n 0.28000 164319.9n 0.28000 164320.0n 0.28000 164449.9n 0.28000 164450.0n 0.28000 164579.9n 0.28000 164580.0n 0.28000 164709.9n 0.28000 164710.0n 0.28000 164839.9n 0.28000 164840.0n 0.28000 164969.9n 0.28000 164970.0n 0.28000 165099.9n 0.28000 165100.0n 0.28000 165229.9n 0.28000 165230.0n 0.28000 165359.9n 0.28000 165360.0n 0.28000 165489.9n 0.28000 165490.0n 0.28000 165619.9n 0.28000 165620.0n 0.28000 165749.9n 0.28000 165750.0n 0.28000 165879.9n 0.28000 165880.0n 0.28000 166009.9n 0.28000 166010.0n 0.28000 166139.9n 0.28000 166140.0n 0.28000 166269.9n 0.28000 166270.0n 0.28000 166399.9n 0.28000 166400.0n 0.28000 166529.9n 0.28000 166530.0n 0.28000 166659.9n 0.28000 166660.0n 0.28000 166789.9n 0.28000 166790.0n 0.28000 166919.9n 0.28000 166920.0n 0.28000 167049.9n 0.28000 167050.0n 0.28000 167179.9n 0.28000 167180.0n 0.28000 167309.9n 0.28000 167310.0n 0.28000 167439.9n 0.28000 167440.0n 0.28000 167569.9n 0.28000 167570.0n 0.28000 167699.9n 0.28000 167700.0n 0.28000 167829.9n 0.28000 167830.0n 0.28000 167959.9n 0.28000 167960.0n 0.28000 168089.9n 0.28000 168090.0n 0.28000 168219.9n 0.28000 168220.0n 0.28000 168349.9n 0.28000 168350.0n 0.28000)
Vxon0 xon0 0 PWL(0.0n 0.25000 129.9n 0.25000 130.0n 0.31000 259.9n 0.31000 260.0n 0.25000 389.9n 0.25000 390.0n 0.31000 519.9n 0.31000 520.0n 0.31000 649.9n 0.31000 650.0n 0.25000 779.9n 0.25000 780.0n 0.25000 909.9n 0.25000 910.0n 0.25000 1039.9n 0.25000 1040.0n 0.25000 1169.9n 0.25000 1170.0n 0.31000 1299.9n 0.31000 1300.0n 0.25000 1429.9n 0.25000 1430.0n 0.31000 1559.9n 0.31000 1560.0n 0.31000 1689.9n 0.31000 1690.0n 0.25000 1819.9n 0.25000 1820.0n 0.25000 1949.9n 0.25000 1950.0n 0.31000 2079.9n 0.31000 2080.0n 0.31000 2209.9n 0.31000 2210.0n 0.25000 2339.9n 0.25000 2340.0n 0.25000 2469.9n 0.25000 2470.0n 0.31000 2599.9n 0.31000 2600.0n 0.31000 2729.9n 0.31000 2730.0n 0.31000 2859.9n 0.31000 2860.0n 0.25000 2989.9n 0.25000 2990.0n 0.25000 3119.9n 0.25000 3120.0n 0.25000 3249.9n 0.25000 3250.0n 0.31000 3379.9n 0.31000 3380.0n 0.31000 3509.9n 0.31000 3510.0n 0.31000 3639.9n 0.31000 3640.0n 0.31000 3769.9n 0.31000 3770.0n 0.25000 3899.9n 0.25000 3900.0n 0.31000 4029.9n 0.31000 4030.0n 0.31000 4159.9n 0.31000 4160.0n 0.31000 4289.9n 0.31000 4290.0n 0.25000 4419.9n 0.25000 4420.0n 0.25000 4549.9n 0.25000 4550.0n 0.31000 4679.9n 0.31000 4680.0n 0.25000 4809.9n 0.25000 4810.0n 0.25000 4939.9n 0.25000 4940.0n 0.31000 5069.9n 0.31000 5070.0n 0.25000 5199.9n 0.25000 5200.0n 0.25000 5329.9n 0.25000 5330.0n 0.25000 5459.9n 0.25000 5460.0n 0.31000 5589.9n 0.31000 5590.0n 0.31000 5719.9n 0.31000 5720.0n 0.25000 5849.9n 0.25000 5850.0n 0.31000 5979.9n 0.31000 5980.0n 0.31000 6109.9n 0.31000 6110.0n 0.25000 6239.9n 0.25000 6240.0n 0.31000 6369.9n 0.31000 6370.0n 0.25000 6499.9n 0.25000 6500.0n 0.31000 6629.9n 0.31000 6630.0n 0.25000 6759.9n 0.25000 6760.0n 0.31000 6889.9n 0.31000 6890.0n 0.25000 7019.9n 0.25000 7020.0n 0.31000 7149.9n 0.31000 7150.0n 0.25000 7279.9n 0.25000 7280.0n 0.31000 7409.9n 0.31000 7410.0n 0.31000 7539.9n 0.31000 7540.0n 0.31000 7669.9n 0.31000 7670.0n 0.25000 7799.9n 0.25000 7800.0n 0.31000 7929.9n 0.31000 7930.0n 0.31000 8059.9n 0.31000 8060.0n 0.31000 8189.9n 0.31000 8190.0n 0.31000 8319.9n 0.31000 8320.0n 0.25000 8449.9n 0.25000 8450.0n 0.31000 8579.9n 0.31000 8580.0n 0.25000 8709.9n 0.25000 8710.0n 0.25000 8839.9n 0.25000 8840.0n 0.25000 8969.9n 0.25000 8970.0n 0.31000 9099.9n 0.31000 9100.0n 0.25000 9229.9n 0.25000 9230.0n 0.31000 9359.9n 0.31000 9360.0n 0.31000 9489.9n 0.31000 9490.0n 0.31000 9619.9n 0.31000 9620.0n 0.25000 9749.9n 0.25000 9750.0n 0.25000 9879.9n 0.25000 9880.0n 0.25000 10009.9n 0.25000 10010.0n 0.25000 10139.9n 0.25000 10140.0n 0.31000 10269.9n 0.31000 10270.0n 0.25000 10399.9n 0.25000 10400.0n 0.25000 10529.9n 0.25000 10530.0n 0.25000 10659.9n 0.25000 10660.0n 0.31000 10789.9n 0.31000 10790.0n 0.25000 10919.9n 0.25000 10920.0n 0.25000 11049.9n 0.25000 11050.0n 0.31000 11179.9n 0.31000 11180.0n 0.31000 11309.9n 0.31000 11310.0n 0.25000 11439.9n 0.25000 11440.0n 0.25000 11569.9n 0.25000 11570.0n 0.25000 11699.9n 0.25000 11700.0n 0.25000 11829.9n 0.25000 11830.0n 0.31000 11959.9n 0.31000 11960.0n 0.25000 12089.9n 0.25000 12090.0n 0.31000 12219.9n 0.31000 12220.0n 0.25000 12349.9n 0.25000 12350.0n 0.25000 12479.9n 0.25000 12480.0n 0.31000 12609.9n 0.31000 12610.0n 0.25000 12739.9n 0.25000 12740.0n 0.25000 12869.9n 0.25000 12870.0n 0.25000 12999.9n 0.25000 13000.0n 0.31000 13129.9n 0.31000 13130.0n 0.31000 13259.9n 0.31000 13260.0n 0.31000 13389.9n 0.31000 13390.0n 0.25000 13519.9n 0.25000 13520.0n 0.31000 13649.9n 0.31000 13650.0n 0.25000 13779.9n 0.25000 13780.0n 0.31000 13909.9n 0.31000 13910.0n 0.31000 14039.9n 0.31000 14040.0n 0.25000 14169.9n 0.25000 14170.0n 0.31000 14299.9n 0.31000 14300.0n 0.31000 14429.9n 0.31000 14430.0n 0.31000 14559.9n 0.31000 14560.0n 0.31000 14689.9n 0.31000 14690.0n 0.25000 14819.9n 0.25000 14820.0n 0.31000 14949.9n 0.31000 14950.0n 0.25000 15079.9n 0.25000 15080.0n 0.31000 15209.9n 0.31000 15210.0n 0.31000 15339.9n 0.31000 15340.0n 0.31000 15469.9n 0.31000 15470.0n 0.31000 15599.9n 0.31000 15600.0n 0.31000 15729.9n 0.31000 15730.0n 0.25000 15859.9n 0.25000 15860.0n 0.31000 15989.9n 0.31000 15990.0n 0.25000 16119.9n 0.25000 16120.0n 0.31000 16249.9n 0.31000 16250.0n 0.31000 16379.9n 0.31000 16380.0n 0.25000 16509.9n 0.25000 16510.0n 0.25000 16639.9n 0.25000 16640.0n 0.25000 16769.9n 0.25000 16770.0n 0.31000 16899.9n 0.31000 16900.0n 0.31000 17029.9n 0.31000 17030.0n 0.25000 17159.9n 0.25000 17160.0n 0.25000 17289.9n 0.25000 17290.0n 0.25000 17419.9n 0.25000 17420.0n 0.25000 17549.9n 0.25000 17550.0n 0.31000 17679.9n 0.31000 17680.0n 0.25000 17809.9n 0.25000 17810.0n 0.25000 17939.9n 0.25000 17940.0n 0.31000 18069.9n 0.31000 18070.0n 0.25000 18199.9n 0.25000 18200.0n 0.25000 18329.9n 0.25000 18330.0n 0.31000 18459.9n 0.31000 18460.0n 0.25000 18589.9n 0.25000 18590.0n 0.25000 18719.9n 0.25000 18720.0n 0.25000 18849.9n 0.25000 18850.0n 0.25000 18979.9n 0.25000 18980.0n 0.31000 19109.9n 0.31000 19110.0n 0.31000 19239.9n 0.31000 19240.0n 0.31000 19369.9n 0.31000 19370.0n 0.25000 19499.9n 0.25000 19500.0n 0.25000 19629.9n 0.25000 19630.0n 0.31000 19759.9n 0.31000 19760.0n 0.31000 19889.9n 0.31000 19890.0n 0.25000 20019.9n 0.25000 20020.0n 0.31000 20149.9n 0.31000 20150.0n 0.31000 20279.9n 0.31000 20280.0n 0.25000 20409.9n 0.25000 20410.0n 0.31000 20539.9n 0.31000 20540.0n 0.25000 20669.9n 0.25000 20670.0n 0.31000 20799.9n 0.31000 20800.0n 0.31000 20929.9n 0.31000 20930.0n 0.31000 21059.9n 0.31000 21060.0n 0.25000 21189.9n 0.25000 21190.0n 0.31000 21319.9n 0.31000 21320.0n 0.25000 21449.9n 0.25000 21450.0n 0.25000 21579.9n 0.25000 21580.0n 0.31000 21709.9n 0.31000 21710.0n 0.25000 21839.9n 0.25000 21840.0n 0.28000 21969.9n 0.28000 21970.0n 0.28000 22099.9n 0.28000 22100.0n 0.28000 22229.9n 0.28000 22230.0n 0.28000 22359.9n 0.28000 22360.0n 0.28000 22489.9n 0.28000 22490.0n 0.28000 22619.9n 0.28000 22620.0n 0.28000 22749.9n 0.28000 22750.0n 0.28000 22879.9n 0.28000 22880.0n 0.28000 23009.9n 0.28000 23010.0n 0.28000 23139.9n 0.28000 23140.0n 0.28000 23269.9n 0.28000 23270.0n 0.28000 23399.9n 0.28000 23400.0n 0.28000 23529.9n 0.28000 23530.0n 0.28000 23659.9n 0.28000 23660.0n 0.28000 23789.9n 0.28000 23790.0n 0.28000 23919.9n 0.28000 23920.0n 0.28000 24049.9n 0.28000 24050.0n 0.28000 24179.9n 0.28000 24180.0n 0.28000 24309.9n 0.28000 24310.0n 0.28000 24439.9n 0.28000 24440.0n 0.28000 24569.9n 0.28000 24570.0n 0.28000 24699.9n 0.28000 24700.0n 0.28000 24829.9n 0.28000 24830.0n 0.28000 24959.9n 0.28000 24960.0n 0.28000 25089.9n 0.28000 25090.0n 0.28000 25219.9n 0.28000 25220.0n 0.28000 25349.9n 0.28000 25350.0n 0.28000 25479.9n 0.28000 25480.0n 0.28000 25609.9n 0.28000 25610.0n 0.28000 25739.9n 0.28000 25740.0n 0.28000 25869.9n 0.28000 25870.0n 0.28000 25999.9n 0.28000 26000.0n 0.28000 26129.9n 0.28000 26130.0n 0.28000 26259.9n 0.28000 26260.0n 0.28000 26389.9n 0.28000 26390.0n 0.28000 26519.9n 0.28000 26520.0n 0.28000 26649.9n 0.28000 26650.0n 0.28000 26779.9n 0.28000 26780.0n 0.28000 26909.9n 0.28000 26910.0n 0.28000 27039.9n 0.28000 27040.0n 0.28000 27169.9n 0.28000 27170.0n 0.28000 27299.9n 0.28000 27300.0n 0.28000 27429.9n 0.28000 27430.0n 0.28000 27559.9n 0.28000 27560.0n 0.28000 27689.9n 0.28000 27690.0n 0.28000 27819.9n 0.28000 27820.0n 0.28000 27949.9n 0.28000 27950.0n 0.28000 28079.9n 0.28000 28080.0n 0.25000 28209.9n 0.25000 28210.0n 0.25000 28339.9n 0.25000 28340.0n 0.31000 28469.9n 0.31000 28470.0n 0.31000 28599.9n 0.31000 28600.0n 0.31000 28729.9n 0.31000 28730.0n 0.31000 28859.9n 0.31000 28860.0n 0.31000 28989.9n 0.31000 28990.0n 0.25000 29119.9n 0.25000 29120.0n 0.25000 29249.9n 0.25000 29250.0n 0.25000 29379.9n 0.25000 29380.0n 0.25000 29509.9n 0.25000 29510.0n 0.31000 29639.9n 0.31000 29640.0n 0.25000 29769.9n 0.25000 29770.0n 0.31000 29899.9n 0.31000 29900.0n 0.25000 30029.9n 0.25000 30030.0n 0.31000 30159.9n 0.31000 30160.0n 0.31000 30289.9n 0.31000 30290.0n 0.31000 30419.9n 0.31000 30420.0n 0.31000 30549.9n 0.31000 30550.0n 0.31000 30679.9n 0.31000 30680.0n 0.31000 30809.9n 0.31000 30810.0n 0.31000 30939.9n 0.31000 30940.0n 0.25000 31069.9n 0.25000 31070.0n 0.25000 31199.9n 0.25000 31200.0n 0.25000 31329.9n 0.25000 31330.0n 0.25000 31459.9n 0.25000 31460.0n 0.25000 31589.9n 0.25000 31590.0n 0.25000 31719.9n 0.25000 31720.0n 0.31000 31849.9n 0.31000 31850.0n 0.25000 31979.9n 0.25000 31980.0n 0.31000 32109.9n 0.31000 32110.0n 0.31000 32239.9n 0.31000 32240.0n 0.25000 32369.9n 0.25000 32370.0n 0.25000 32499.9n 0.25000 32500.0n 0.25000 32629.9n 0.25000 32630.0n 0.25000 32759.9n 0.25000 32760.0n 0.25000 32889.9n 0.25000 32890.0n 0.25000 33019.9n 0.25000 33020.0n 0.25000 33149.9n 0.25000 33150.0n 0.31000 33279.9n 0.31000 33280.0n 0.31000 33409.9n 0.31000 33410.0n 0.25000 33539.9n 0.25000 33540.0n 0.25000 33669.9n 0.25000 33670.0n 0.31000 33799.9n 0.31000 33800.0n 0.25000 33929.9n 0.25000 33930.0n 0.31000 34059.9n 0.31000 34060.0n 0.31000 34189.9n 0.31000 34190.0n 0.31000 34319.9n 0.31000 34320.0n 0.31000 34449.9n 0.31000 34450.0n 0.25000 34579.9n 0.25000 34580.0n 0.31000 34709.9n 0.31000 34710.0n 0.31000 34839.9n 0.31000 34840.0n 0.25000 34969.9n 0.25000 34970.0n 0.31000 35099.9n 0.31000 35100.0n 0.25000 35229.9n 0.25000 35230.0n 0.31000 35359.9n 0.31000 35360.0n 0.25000 35489.9n 0.25000 35490.0n 0.31000 35619.9n 0.31000 35620.0n 0.31000 35749.9n 0.31000 35750.0n 0.25000 35879.9n 0.25000 35880.0n 0.31000 36009.9n 0.31000 36010.0n 0.31000 36139.9n 0.31000 36140.0n 0.25000 36269.9n 0.25000 36270.0n 0.25000 36399.9n 0.25000 36400.0n 0.25000 36529.9n 0.25000 36530.0n 0.25000 36659.9n 0.25000 36660.0n 0.31000 36789.9n 0.31000 36790.0n 0.31000 36919.9n 0.31000 36920.0n 0.31000 37049.9n 0.31000 37050.0n 0.25000 37179.9n 0.25000 37180.0n 0.31000 37309.9n 0.31000 37310.0n 0.31000 37439.9n 0.31000 37440.0n 0.31000 37569.9n 0.31000 37570.0n 0.31000 37699.9n 0.31000 37700.0n 0.25000 37829.9n 0.25000 37830.0n 0.25000 37959.9n 0.25000 37960.0n 0.25000 38089.9n 0.25000 38090.0n 0.25000 38219.9n 0.25000 38220.0n 0.31000 38349.9n 0.31000 38350.0n 0.31000 38479.9n 0.31000 38480.0n 0.25000 38609.9n 0.25000 38610.0n 0.25000 38739.9n 0.25000 38740.0n 0.31000 38869.9n 0.31000 38870.0n 0.25000 38999.9n 0.25000 39000.0n 0.31000 39129.9n 0.31000 39130.0n 0.31000 39259.9n 0.31000 39260.0n 0.31000 39389.9n 0.31000 39390.0n 0.31000 39519.9n 0.31000 39520.0n 0.25000 39649.9n 0.25000 39650.0n 0.31000 39779.9n 0.31000 39780.0n 0.25000 39909.9n 0.25000 39910.0n 0.25000 40039.9n 0.25000 40040.0n 0.25000 40169.9n 0.25000 40170.0n 0.25000 40299.9n 0.25000 40300.0n 0.25000 40429.9n 0.25000 40430.0n 0.31000 40559.9n 0.31000 40560.0n 0.31000 40689.9n 0.31000 40690.0n 0.25000 40819.9n 0.25000 40820.0n 0.31000 40949.9n 0.31000 40950.0n 0.25000 41079.9n 0.25000 41080.0n 0.31000 41209.9n 0.31000 41210.0n 0.31000 41339.9n 0.31000 41340.0n 0.25000 41469.9n 0.25000 41470.0n 0.25000 41599.9n 0.25000 41600.0n 0.25000 41729.9n 0.25000 41730.0n 0.31000 41859.9n 0.31000 41860.0n 0.25000 41989.9n 0.25000 41990.0n 0.25000 42119.9n 0.25000 42120.0n 0.31000 42249.9n 0.31000 42250.0n 0.31000 42379.9n 0.31000 42380.0n 0.25000 42509.9n 0.25000 42510.0n 0.31000 42639.9n 0.31000 42640.0n 0.31000 42769.9n 0.31000 42770.0n 0.25000 42899.9n 0.25000 42900.0n 0.25000 43029.9n 0.25000 43030.0n 0.25000 43159.9n 0.25000 43160.0n 0.25000 43289.9n 0.25000 43290.0n 0.25000 43419.9n 0.25000 43420.0n 0.25000 43549.9n 0.25000 43550.0n 0.31000 43679.9n 0.31000 43680.0n 0.31000 43809.9n 0.31000 43810.0n 0.25000 43939.9n 0.25000 43940.0n 0.25000 44069.9n 0.25000 44070.0n 0.31000 44199.9n 0.31000 44200.0n 0.25000 44329.9n 0.25000 44330.0n 0.31000 44459.9n 0.31000 44460.0n 0.31000 44589.9n 0.31000 44590.0n 0.31000 44719.9n 0.31000 44720.0n 0.25000 44849.9n 0.25000 44850.0n 0.25000 44979.9n 0.25000 44980.0n 0.31000 45109.9n 0.31000 45110.0n 0.31000 45239.9n 0.31000 45240.0n 0.31000 45369.9n 0.31000 45370.0n 0.31000 45499.9n 0.31000 45500.0n 0.25000 45629.9n 0.25000 45630.0n 0.25000 45759.9n 0.25000 45760.0n 0.31000 45889.9n 0.31000 45890.0n 0.31000 46019.9n 0.31000 46020.0n 0.25000 46149.9n 0.25000 46150.0n 0.31000 46279.9n 0.31000 46280.0n 0.31000 46409.9n 0.31000 46410.0n 0.25000 46539.9n 0.25000 46540.0n 0.25000 46669.9n 0.25000 46670.0n 0.25000 46799.9n 0.25000 46800.0n 0.25000 46929.9n 0.25000 46930.0n 0.25000 47059.9n 0.25000 47060.0n 0.31000 47189.9n 0.31000 47190.0n 0.31000 47319.9n 0.31000 47320.0n 0.31000 47449.9n 0.31000 47450.0n 0.31000 47579.9n 0.31000 47580.0n 0.31000 47709.9n 0.31000 47710.0n 0.25000 47839.9n 0.25000 47840.0n 0.25000 47969.9n 0.25000 47970.0n 0.25000 48099.9n 0.25000 48100.0n 0.31000 48229.9n 0.31000 48230.0n 0.25000 48359.9n 0.25000 48360.0n 0.25000 48489.9n 0.25000 48490.0n 0.31000 48619.9n 0.31000 48620.0n 0.25000 48749.9n 0.25000 48750.0n 0.31000 48879.9n 0.31000 48880.0n 0.31000 49009.9n 0.31000 49010.0n 0.25000 49139.9n 0.25000 49140.0n 0.31000 49269.9n 0.31000 49270.0n 0.31000 49399.9n 0.31000 49400.0n 0.25000 49529.9n 0.25000 49530.0n 0.25000 49659.9n 0.25000 49660.0n 0.31000 49789.9n 0.31000 49790.0n 0.31000 49919.9n 0.31000 49920.0n 0.28000 50049.9n 0.28000 50050.0n 0.28000 50179.9n 0.28000 50180.0n 0.28000 50309.9n 0.28000 50310.0n 0.28000 50439.9n 0.28000 50440.0n 0.28000 50569.9n 0.28000 50570.0n 0.28000 50699.9n 0.28000 50700.0n 0.28000 50829.9n 0.28000 50830.0n 0.28000 50959.9n 0.28000 50960.0n 0.28000 51089.9n 0.28000 51090.0n 0.28000 51219.9n 0.28000 51220.0n 0.28000 51349.9n 0.28000 51350.0n 0.28000 51479.9n 0.28000 51480.0n 0.28000 51609.9n 0.28000 51610.0n 0.28000 51739.9n 0.28000 51740.0n 0.28000 51869.9n 0.28000 51870.0n 0.28000 51999.9n 0.28000 52000.0n 0.28000 52129.9n 0.28000 52130.0n 0.28000 52259.9n 0.28000 52260.0n 0.28000 52389.9n 0.28000 52390.0n 0.28000 52519.9n 0.28000 52520.0n 0.28000 52649.9n 0.28000 52650.0n 0.28000 52779.9n 0.28000 52780.0n 0.28000 52909.9n 0.28000 52910.0n 0.28000 53039.9n 0.28000 53040.0n 0.28000 53169.9n 0.28000 53170.0n 0.28000 53299.9n 0.28000 53300.0n 0.28000 53429.9n 0.28000 53430.0n 0.28000 53559.9n 0.28000 53560.0n 0.28000 53689.9n 0.28000 53690.0n 0.28000 53819.9n 0.28000 53820.0n 0.28000 53949.9n 0.28000 53950.0n 0.28000 54079.9n 0.28000 54080.0n 0.28000 54209.9n 0.28000 54210.0n 0.28000 54339.9n 0.28000 54340.0n 0.28000 54469.9n 0.28000 54470.0n 0.28000 54599.9n 0.28000 54600.0n 0.28000 54729.9n 0.28000 54730.0n 0.28000 54859.9n 0.28000 54860.0n 0.28000 54989.9n 0.28000 54990.0n 0.28000 55119.9n 0.28000 55120.0n 0.28000 55249.9n 0.28000 55250.0n 0.28000 55379.9n 0.28000 55380.0n 0.28000 55509.9n 0.28000 55510.0n 0.28000 55639.9n 0.28000 55640.0n 0.28000 55769.9n 0.28000 55770.0n 0.28000 55899.9n 0.28000 55900.0n 0.28000 56029.9n 0.28000 56030.0n 0.28000 56159.9n 0.28000 56160.0n 0.25000 56289.9n 0.25000 56290.0n 0.31000 56419.9n 0.31000 56420.0n 0.31000 56549.9n 0.31000 56550.0n 0.31000 56679.9n 0.31000 56680.0n 0.25000 56809.9n 0.25000 56810.0n 0.31000 56939.9n 0.31000 56940.0n 0.31000 57069.9n 0.31000 57070.0n 0.31000 57199.9n 0.31000 57200.0n 0.31000 57329.9n 0.31000 57330.0n 0.25000 57459.9n 0.25000 57460.0n 0.25000 57589.9n 0.25000 57590.0n 0.25000 57719.9n 0.25000 57720.0n 0.25000 57849.9n 0.25000 57850.0n 0.25000 57979.9n 0.25000 57980.0n 0.25000 58109.9n 0.25000 58110.0n 0.25000 58239.9n 0.25000 58240.0n 0.31000 58369.9n 0.31000 58370.0n 0.31000 58499.9n 0.31000 58500.0n 0.31000 58629.9n 0.31000 58630.0n 0.31000 58759.9n 0.31000 58760.0n 0.31000 58889.9n 0.31000 58890.0n 0.25000 59019.9n 0.25000 59020.0n 0.25000 59149.9n 0.25000 59150.0n 0.25000 59279.9n 0.25000 59280.0n 0.25000 59409.9n 0.25000 59410.0n 0.31000 59539.9n 0.31000 59540.0n 0.25000 59669.9n 0.25000 59670.0n 0.31000 59799.9n 0.31000 59800.0n 0.25000 59929.9n 0.25000 59930.0n 0.25000 60059.9n 0.25000 60060.0n 0.31000 60189.9n 0.31000 60190.0n 0.25000 60319.9n 0.25000 60320.0n 0.25000 60449.9n 0.25000 60450.0n 0.31000 60579.9n 0.31000 60580.0n 0.31000 60709.9n 0.31000 60710.0n 0.25000 60839.9n 0.25000 60840.0n 0.31000 60969.9n 0.31000 60970.0n 0.31000 61099.9n 0.31000 61100.0n 0.25000 61229.9n 0.25000 61230.0n 0.31000 61359.9n 0.31000 61360.0n 0.25000 61489.9n 0.25000 61490.0n 0.31000 61619.9n 0.31000 61620.0n 0.31000 61749.9n 0.31000 61750.0n 0.25000 61879.9n 0.25000 61880.0n 0.25000 62009.9n 0.25000 62010.0n 0.31000 62139.9n 0.31000 62140.0n 0.25000 62269.9n 0.25000 62270.0n 0.31000 62399.9n 0.31000 62400.0n 0.25000 62529.9n 0.25000 62530.0n 0.25000 62659.9n 0.25000 62660.0n 0.25000 62789.9n 0.25000 62790.0n 0.31000 62919.9n 0.31000 62920.0n 0.31000 63049.9n 0.31000 63050.0n 0.31000 63179.9n 0.31000 63180.0n 0.31000 63309.9n 0.31000 63310.0n 0.25000 63439.9n 0.25000 63440.0n 0.31000 63569.9n 0.31000 63570.0n 0.25000 63699.9n 0.25000 63700.0n 0.25000 63829.9n 0.25000 63830.0n 0.31000 63959.9n 0.31000 63960.0n 0.31000 64089.9n 0.31000 64090.0n 0.25000 64219.9n 0.25000 64220.0n 0.31000 64349.9n 0.31000 64350.0n 0.31000 64479.9n 0.31000 64480.0n 0.25000 64609.9n 0.25000 64610.0n 0.31000 64739.9n 0.31000 64740.0n 0.31000 64869.9n 0.31000 64870.0n 0.25000 64999.9n 0.25000 65000.0n 0.31000 65129.9n 0.31000 65130.0n 0.31000 65259.9n 0.31000 65260.0n 0.31000 65389.9n 0.31000 65390.0n 0.31000 65519.9n 0.31000 65520.0n 0.25000 65649.9n 0.25000 65650.0n 0.25000 65779.9n 0.25000 65780.0n 0.25000 65909.9n 0.25000 65910.0n 0.31000 66039.9n 0.31000 66040.0n 0.25000 66169.9n 0.25000 66170.0n 0.25000 66299.9n 0.25000 66300.0n 0.25000 66429.9n 0.25000 66430.0n 0.25000 66559.9n 0.25000 66560.0n 0.31000 66689.9n 0.31000 66690.0n 0.25000 66819.9n 0.25000 66820.0n 0.31000 66949.9n 0.31000 66950.0n 0.25000 67079.9n 0.25000 67080.0n 0.31000 67209.9n 0.31000 67210.0n 0.25000 67339.9n 0.25000 67340.0n 0.31000 67469.9n 0.31000 67470.0n 0.31000 67599.9n 0.31000 67600.0n 0.25000 67729.9n 0.25000 67730.0n 0.31000 67859.9n 0.31000 67860.0n 0.25000 67989.9n 0.25000 67990.0n 0.25000 68119.9n 0.25000 68120.0n 0.25000 68249.9n 0.25000 68250.0n 0.31000 68379.9n 0.31000 68380.0n 0.31000 68509.9n 0.31000 68510.0n 0.25000 68639.9n 0.25000 68640.0n 0.25000 68769.9n 0.25000 68770.0n 0.31000 68899.9n 0.31000 68900.0n 0.31000 69029.9n 0.31000 69030.0n 0.25000 69159.9n 0.25000 69160.0n 0.31000 69289.9n 0.31000 69290.0n 0.25000 69419.9n 0.25000 69420.0n 0.31000 69549.9n 0.31000 69550.0n 0.25000 69679.9n 0.25000 69680.0n 0.25000 69809.9n 0.25000 69810.0n 0.31000 69939.9n 0.31000 69940.0n 0.25000 70069.9n 0.25000 70070.0n 0.31000 70199.9n 0.31000 70200.0n 0.31000 70329.9n 0.31000 70330.0n 0.31000 70459.9n 0.31000 70460.0n 0.25000 70589.9n 0.25000 70590.0n 0.25000 70719.9n 0.25000 70720.0n 0.31000 70849.9n 0.31000 70850.0n 0.31000 70979.9n 0.31000 70980.0n 0.25000 71109.9n 0.25000 71110.0n 0.25000 71239.9n 0.25000 71240.0n 0.25000 71369.9n 0.25000 71370.0n 0.25000 71499.9n 0.25000 71500.0n 0.25000 71629.9n 0.25000 71630.0n 0.31000 71759.9n 0.31000 71760.0n 0.31000 71889.9n 0.31000 71890.0n 0.31000 72019.9n 0.31000 72020.0n 0.31000 72149.9n 0.31000 72150.0n 0.25000 72279.9n 0.25000 72280.0n 0.31000 72409.9n 0.31000 72410.0n 0.25000 72539.9n 0.25000 72540.0n 0.31000 72669.9n 0.31000 72670.0n 0.25000 72799.9n 0.25000 72800.0n 0.31000 72929.9n 0.31000 72930.0n 0.25000 73059.9n 0.25000 73060.0n 0.25000 73189.9n 0.25000 73190.0n 0.25000 73319.9n 0.25000 73320.0n 0.31000 73449.9n 0.31000 73450.0n 0.31000 73579.9n 0.31000 73580.0n 0.25000 73709.9n 0.25000 73710.0n 0.31000 73839.9n 0.31000 73840.0n 0.25000 73969.9n 0.25000 73970.0n 0.31000 74099.9n 0.31000 74100.0n 0.31000 74229.9n 0.31000 74230.0n 0.25000 74359.9n 0.25000 74360.0n 0.25000 74489.9n 0.25000 74490.0n 0.25000 74619.9n 0.25000 74620.0n 0.31000 74749.9n 0.31000 74750.0n 0.31000 74879.9n 0.31000 74880.0n 0.31000 75009.9n 0.31000 75010.0n 0.25000 75139.9n 0.25000 75140.0n 0.31000 75269.9n 0.31000 75270.0n 0.31000 75399.9n 0.31000 75400.0n 0.25000 75529.9n 0.25000 75530.0n 0.31000 75659.9n 0.31000 75660.0n 0.31000 75789.9n 0.31000 75790.0n 0.25000 75919.9n 0.25000 75920.0n 0.31000 76049.9n 0.31000 76050.0n 0.31000 76179.9n 0.31000 76180.0n 0.25000 76309.9n 0.25000 76310.0n 0.31000 76439.9n 0.31000 76440.0n 0.31000 76569.9n 0.31000 76570.0n 0.31000 76699.9n 0.31000 76700.0n 0.31000 76829.9n 0.31000 76830.0n 0.25000 76959.9n 0.25000 76960.0n 0.25000 77089.9n 0.25000 77090.0n 0.25000 77219.9n 0.25000 77220.0n 0.25000 77349.9n 0.25000 77350.0n 0.25000 77479.9n 0.25000 77480.0n 0.25000 77609.9n 0.25000 77610.0n 0.31000 77739.9n 0.31000 77740.0n 0.25000 77869.9n 0.25000 77870.0n 0.25000 77999.9n 0.25000 78000.0n 0.28000 78129.9n 0.28000 78130.0n 0.28000 78259.9n 0.28000 78260.0n 0.28000 78389.9n 0.28000 78390.0n 0.28000 78519.9n 0.28000 78520.0n 0.28000 78649.9n 0.28000 78650.0n 0.28000 78779.9n 0.28000 78780.0n 0.28000 78909.9n 0.28000 78910.0n 0.28000 79039.9n 0.28000 79040.0n 0.28000 79169.9n 0.28000 79170.0n 0.28000 79299.9n 0.28000 79300.0n 0.28000 79429.9n 0.28000 79430.0n 0.28000 79559.9n 0.28000 79560.0n 0.28000 79689.9n 0.28000 79690.0n 0.28000 79819.9n 0.28000 79820.0n 0.28000 79949.9n 0.28000 79950.0n 0.28000 80079.9n 0.28000 80080.0n 0.28000 80209.9n 0.28000 80210.0n 0.28000 80339.9n 0.28000 80340.0n 0.28000 80469.9n 0.28000 80470.0n 0.28000 80599.9n 0.28000 80600.0n 0.28000 80729.9n 0.28000 80730.0n 0.28000 80859.9n 0.28000 80860.0n 0.28000 80989.9n 0.28000 80990.0n 0.28000 81119.9n 0.28000 81120.0n 0.28000 81249.9n 0.28000 81250.0n 0.28000 81379.9n 0.28000 81380.0n 0.28000 81509.9n 0.28000 81510.0n 0.28000 81639.9n 0.28000 81640.0n 0.28000 81769.9n 0.28000 81770.0n 0.28000 81899.9n 0.28000 81900.0n 0.28000 82029.9n 0.28000 82030.0n 0.28000 82159.9n 0.28000 82160.0n 0.28000 82289.9n 0.28000 82290.0n 0.28000 82419.9n 0.28000 82420.0n 0.28000 82549.9n 0.28000 82550.0n 0.28000 82679.9n 0.28000 82680.0n 0.28000 82809.9n 0.28000 82810.0n 0.28000 82939.9n 0.28000 82940.0n 0.28000 83069.9n 0.28000 83070.0n 0.28000 83199.9n 0.28000 83200.0n 0.28000 83329.9n 0.28000 83330.0n 0.28000 83459.9n 0.28000 83460.0n 0.28000 83589.9n 0.28000 83590.0n 0.28000 83719.9n 0.28000 83720.0n 0.28000 83849.9n 0.28000 83850.0n 0.28000 83979.9n 0.28000 83980.0n 0.28000 84109.9n 0.28000 84110.0n 0.28000 84239.9n 0.28000 84240.0n 0.31000 84369.9n 0.31000 84370.0n 0.25000 84499.9n 0.25000 84500.0n 0.25000 84629.9n 0.25000 84630.0n 0.25000 84759.9n 0.25000 84760.0n 0.25000 84889.9n 0.25000 84890.0n 0.25000 85019.9n 0.25000 85020.0n 0.31000 85149.9n 0.31000 85150.0n 0.31000 85279.9n 0.31000 85280.0n 0.31000 85409.9n 0.31000 85410.0n 0.25000 85539.9n 0.25000 85540.0n 0.31000 85669.9n 0.31000 85670.0n 0.31000 85799.9n 0.31000 85800.0n 0.31000 85929.9n 0.31000 85930.0n 0.31000 86059.9n 0.31000 86060.0n 0.25000 86189.9n 0.25000 86190.0n 0.31000 86319.9n 0.31000 86320.0n 0.25000 86449.9n 0.25000 86450.0n 0.31000 86579.9n 0.31000 86580.0n 0.25000 86709.9n 0.25000 86710.0n 0.25000 86839.9n 0.25000 86840.0n 0.25000 86969.9n 0.25000 86970.0n 0.31000 87099.9n 0.31000 87100.0n 0.25000 87229.9n 0.25000 87230.0n 0.25000 87359.9n 0.25000 87360.0n 0.31000 87489.9n 0.31000 87490.0n 0.31000 87619.9n 0.31000 87620.0n 0.31000 87749.9n 0.31000 87750.0n 0.25000 87879.9n 0.25000 87880.0n 0.31000 88009.9n 0.31000 88010.0n 0.25000 88139.9n 0.25000 88140.0n 0.31000 88269.9n 0.31000 88270.0n 0.31000 88399.9n 0.31000 88400.0n 0.25000 88529.9n 0.25000 88530.0n 0.31000 88659.9n 0.31000 88660.0n 0.31000 88789.9n 0.31000 88790.0n 0.25000 88919.9n 0.25000 88920.0n 0.25000 89049.9n 0.25000 89050.0n 0.25000 89179.9n 0.25000 89180.0n 0.31000 89309.9n 0.31000 89310.0n 0.31000 89439.9n 0.31000 89440.0n 0.31000 89569.9n 0.31000 89570.0n 0.31000 89699.9n 0.31000 89700.0n 0.31000 89829.9n 0.31000 89830.0n 0.31000 89959.9n 0.31000 89960.0n 0.25000 90089.9n 0.25000 90090.0n 0.25000 90219.9n 0.25000 90220.0n 0.25000 90349.9n 0.25000 90350.0n 0.25000 90479.9n 0.25000 90480.0n 0.25000 90609.9n 0.25000 90610.0n 0.25000 90739.9n 0.25000 90740.0n 0.25000 90869.9n 0.25000 90870.0n 0.31000 90999.9n 0.31000 91000.0n 0.31000 91129.9n 0.31000 91130.0n 0.25000 91259.9n 0.25000 91260.0n 0.31000 91389.9n 0.31000 91390.0n 0.25000 91519.9n 0.25000 91520.0n 0.31000 91649.9n 0.31000 91650.0n 0.25000 91779.9n 0.25000 91780.0n 0.25000 91909.9n 0.25000 91910.0n 0.25000 92039.9n 0.25000 92040.0n 0.31000 92169.9n 0.31000 92170.0n 0.25000 92299.9n 0.25000 92300.0n 0.31000 92429.9n 0.31000 92430.0n 0.31000 92559.9n 0.31000 92560.0n 0.31000 92689.9n 0.31000 92690.0n 0.25000 92819.9n 0.25000 92820.0n 0.25000 92949.9n 0.25000 92950.0n 0.25000 93079.9n 0.25000 93080.0n 0.31000 93209.9n 0.31000 93210.0n 0.31000 93339.9n 0.31000 93340.0n 0.25000 93469.9n 0.25000 93470.0n 0.31000 93599.9n 0.31000 93600.0n 0.31000 93729.9n 0.31000 93730.0n 0.31000 93859.9n 0.31000 93860.0n 0.25000 93989.9n 0.25000 93990.0n 0.25000 94119.9n 0.25000 94120.0n 0.31000 94249.9n 0.31000 94250.0n 0.31000 94379.9n 0.31000 94380.0n 0.31000 94509.9n 0.31000 94510.0n 0.25000 94639.9n 0.25000 94640.0n 0.25000 94769.9n 0.25000 94770.0n 0.25000 94899.9n 0.25000 94900.0n 0.25000 95029.9n 0.25000 95030.0n 0.31000 95159.9n 0.31000 95160.0n 0.31000 95289.9n 0.31000 95290.0n 0.25000 95419.9n 0.25000 95420.0n 0.25000 95549.9n 0.25000 95550.0n 0.31000 95679.9n 0.31000 95680.0n 0.25000 95809.9n 0.25000 95810.0n 0.31000 95939.9n 0.31000 95940.0n 0.31000 96069.9n 0.31000 96070.0n 0.31000 96199.9n 0.31000 96200.0n 0.31000 96329.9n 0.31000 96330.0n 0.31000 96459.9n 0.31000 96460.0n 0.25000 96589.9n 0.25000 96590.0n 0.31000 96719.9n 0.31000 96720.0n 0.31000 96849.9n 0.31000 96850.0n 0.25000 96979.9n 0.25000 96980.0n 0.25000 97109.9n 0.25000 97110.0n 0.25000 97239.9n 0.25000 97240.0n 0.25000 97369.9n 0.25000 97370.0n 0.31000 97499.9n 0.31000 97500.0n 0.25000 97629.9n 0.25000 97630.0n 0.31000 97759.9n 0.31000 97760.0n 0.25000 97889.9n 0.25000 97890.0n 0.25000 98019.9n 0.25000 98020.0n 0.25000 98149.9n 0.25000 98150.0n 0.25000 98279.9n 0.25000 98280.0n 0.25000 98409.9n 0.25000 98410.0n 0.31000 98539.9n 0.31000 98540.0n 0.31000 98669.9n 0.31000 98670.0n 0.31000 98799.9n 0.31000 98800.0n 0.31000 98929.9n 0.31000 98930.0n 0.25000 99059.9n 0.25000 99060.0n 0.25000 99189.9n 0.25000 99190.0n 0.31000 99319.9n 0.31000 99320.0n 0.25000 99449.9n 0.25000 99450.0n 0.31000 99579.9n 0.31000 99580.0n 0.31000 99709.9n 0.31000 99710.0n 0.25000 99839.9n 0.25000 99840.0n 0.25000 99969.9n 0.25000 99970.0n 0.25000 100099.9n 0.25000 100100.0n 0.25000 100229.9n 0.25000 100230.0n 0.25000 100359.9n 0.25000 100360.0n 0.25000 100489.9n 0.25000 100490.0n 0.31000 100619.9n 0.31000 100620.0n 0.25000 100749.9n 0.25000 100750.0n 0.31000 100879.9n 0.31000 100880.0n 0.25000 101009.9n 0.25000 101010.0n 0.31000 101139.9n 0.31000 101140.0n 0.31000 101269.9n 0.31000 101270.0n 0.31000 101399.9n 0.31000 101400.0n 0.31000 101529.9n 0.31000 101530.0n 0.31000 101659.9n 0.31000 101660.0n 0.25000 101789.9n 0.25000 101790.0n 0.31000 101919.9n 0.31000 101920.0n 0.25000 102049.9n 0.25000 102050.0n 0.31000 102179.9n 0.31000 102180.0n 0.25000 102309.9n 0.25000 102310.0n 0.31000 102439.9n 0.31000 102440.0n 0.25000 102569.9n 0.25000 102570.0n 0.25000 102699.9n 0.25000 102700.0n 0.31000 102829.9n 0.31000 102830.0n 0.31000 102959.9n 0.31000 102960.0n 0.31000 103089.9n 0.31000 103090.0n 0.25000 103219.9n 0.25000 103220.0n 0.25000 103349.9n 0.25000 103350.0n 0.31000 103479.9n 0.31000 103480.0n 0.31000 103609.9n 0.31000 103610.0n 0.31000 103739.9n 0.31000 103740.0n 0.25000 103869.9n 0.25000 103870.0n 0.25000 103999.9n 0.25000 104000.0n 0.25000 104129.9n 0.25000 104130.0n 0.31000 104259.9n 0.31000 104260.0n 0.25000 104389.9n 0.25000 104390.0n 0.25000 104519.9n 0.25000 104520.0n 0.25000 104649.9n 0.25000 104650.0n 0.31000 104779.9n 0.31000 104780.0n 0.25000 104909.9n 0.25000 104910.0n 0.31000 105039.9n 0.31000 105040.0n 0.31000 105169.9n 0.31000 105170.0n 0.31000 105299.9n 0.31000 105300.0n 0.31000 105429.9n 0.31000 105430.0n 0.31000 105559.9n 0.31000 105560.0n 0.25000 105689.9n 0.25000 105690.0n 0.25000 105819.9n 0.25000 105820.0n 0.25000 105949.9n 0.25000 105950.0n 0.31000 106079.9n 0.31000 106080.0n 0.28000 106209.9n 0.28000 106210.0n 0.28000 106339.9n 0.28000 106340.0n 0.28000 106469.9n 0.28000 106470.0n 0.28000 106599.9n 0.28000 106600.0n 0.28000 106729.9n 0.28000 106730.0n 0.28000 106859.9n 0.28000 106860.0n 0.28000 106989.9n 0.28000 106990.0n 0.28000 107119.9n 0.28000 107120.0n 0.28000 107249.9n 0.28000 107250.0n 0.28000 107379.9n 0.28000 107380.0n 0.28000 107509.9n 0.28000 107510.0n 0.28000 107639.9n 0.28000 107640.0n 0.28000 107769.9n 0.28000 107770.0n 0.28000 107899.9n 0.28000 107900.0n 0.28000 108029.9n 0.28000 108030.0n 0.28000 108159.9n 0.28000 108160.0n 0.28000 108289.9n 0.28000 108290.0n 0.28000 108419.9n 0.28000 108420.0n 0.28000 108549.9n 0.28000 108550.0n 0.28000 108679.9n 0.28000 108680.0n 0.28000 108809.9n 0.28000 108810.0n 0.28000 108939.9n 0.28000 108940.0n 0.28000 109069.9n 0.28000 109070.0n 0.28000 109199.9n 0.28000 109200.0n 0.28000 109329.9n 0.28000 109330.0n 0.28000 109459.9n 0.28000 109460.0n 0.28000 109589.9n 0.28000 109590.0n 0.28000 109719.9n 0.28000 109720.0n 0.28000 109849.9n 0.28000 109850.0n 0.28000 109979.9n 0.28000 109980.0n 0.28000 110109.9n 0.28000 110110.0n 0.28000 110239.9n 0.28000 110240.0n 0.28000 110369.9n 0.28000 110370.0n 0.28000 110499.9n 0.28000 110500.0n 0.28000 110629.9n 0.28000 110630.0n 0.28000 110759.9n 0.28000 110760.0n 0.28000 110889.9n 0.28000 110890.0n 0.28000 111019.9n 0.28000 111020.0n 0.28000 111149.9n 0.28000 111150.0n 0.28000 111279.9n 0.28000 111280.0n 0.28000 111409.9n 0.28000 111410.0n 0.28000 111539.9n 0.28000 111540.0n 0.28000 111669.9n 0.28000 111670.0n 0.28000 111799.9n 0.28000 111800.0n 0.28000 111929.9n 0.28000 111930.0n 0.28000 112059.9n 0.28000 112060.0n 0.28000 112189.9n 0.28000 112190.0n 0.28000 112319.9n 0.28000 112320.0n 0.31000 112449.9n 0.31000 112450.0n 0.25000 112579.9n 0.25000 112580.0n 0.31000 112709.9n 0.31000 112710.0n 0.25000 112839.9n 0.25000 112840.0n 0.25000 112969.9n 0.25000 112970.0n 0.25000 113099.9n 0.25000 113100.0n 0.25000 113229.9n 0.25000 113230.0n 0.31000 113359.9n 0.31000 113360.0n 0.25000 113489.9n 0.25000 113490.0n 0.25000 113619.9n 0.25000 113620.0n 0.25000 113749.9n 0.25000 113750.0n 0.31000 113879.9n 0.31000 113880.0n 0.31000 114009.9n 0.31000 114010.0n 0.25000 114139.9n 0.25000 114140.0n 0.25000 114269.9n 0.25000 114270.0n 0.31000 114399.9n 0.31000 114400.0n 0.25000 114529.9n 0.25000 114530.0n 0.25000 114659.9n 0.25000 114660.0n 0.25000 114789.9n 0.25000 114790.0n 0.31000 114919.9n 0.31000 114920.0n 0.31000 115049.9n 0.31000 115050.0n 0.31000 115179.9n 0.31000 115180.0n 0.31000 115309.9n 0.31000 115310.0n 0.31000 115439.9n 0.31000 115440.0n 0.31000 115569.9n 0.31000 115570.0n 0.31000 115699.9n 0.31000 115700.0n 0.31000 115829.9n 0.31000 115830.0n 0.25000 115959.9n 0.25000 115960.0n 0.31000 116089.9n 0.31000 116090.0n 0.25000 116219.9n 0.25000 116220.0n 0.31000 116349.9n 0.31000 116350.0n 0.31000 116479.9n 0.31000 116480.0n 0.31000 116609.9n 0.31000 116610.0n 0.25000 116739.9n 0.25000 116740.0n 0.31000 116869.9n 0.31000 116870.0n 0.25000 116999.9n 0.25000 117000.0n 0.31000 117129.9n 0.31000 117130.0n 0.25000 117259.9n 0.25000 117260.0n 0.31000 117389.9n 0.31000 117390.0n 0.31000 117519.9n 0.31000 117520.0n 0.31000 117649.9n 0.31000 117650.0n 0.25000 117779.9n 0.25000 117780.0n 0.31000 117909.9n 0.31000 117910.0n 0.31000 118039.9n 0.31000 118040.0n 0.25000 118169.9n 0.25000 118170.0n 0.25000 118299.9n 0.25000 118300.0n 0.25000 118429.9n 0.25000 118430.0n 0.25000 118559.9n 0.25000 118560.0n 0.25000 118689.9n 0.25000 118690.0n 0.25000 118819.9n 0.25000 118820.0n 0.25000 118949.9n 0.25000 118950.0n 0.25000 119079.9n 0.25000 119080.0n 0.31000 119209.9n 0.31000 119210.0n 0.25000 119339.9n 0.25000 119340.0n 0.31000 119469.9n 0.31000 119470.0n 0.31000 119599.9n 0.31000 119600.0n 0.25000 119729.9n 0.25000 119730.0n 0.31000 119859.9n 0.31000 119860.0n 0.31000 119989.9n 0.31000 119990.0n 0.31000 120119.9n 0.31000 120120.0n 0.25000 120249.9n 0.25000 120250.0n 0.25000 120379.9n 0.25000 120380.0n 0.31000 120509.9n 0.31000 120510.0n 0.31000 120639.9n 0.31000 120640.0n 0.25000 120769.9n 0.25000 120770.0n 0.25000 120899.9n 0.25000 120900.0n 0.25000 121029.9n 0.25000 121030.0n 0.31000 121159.9n 0.31000 121160.0n 0.25000 121289.9n 0.25000 121290.0n 0.25000 121419.9n 0.25000 121420.0n 0.31000 121549.9n 0.31000 121550.0n 0.31000 121679.9n 0.31000 121680.0n 0.25000 121809.9n 0.25000 121810.0n 0.31000 121939.9n 0.31000 121940.0n 0.31000 122069.9n 0.31000 122070.0n 0.31000 122199.9n 0.31000 122200.0n 0.25000 122329.9n 0.25000 122330.0n 0.25000 122459.9n 0.25000 122460.0n 0.25000 122589.9n 0.25000 122590.0n 0.31000 122719.9n 0.31000 122720.0n 0.31000 122849.9n 0.31000 122850.0n 0.25000 122979.9n 0.25000 122980.0n 0.31000 123109.9n 0.31000 123110.0n 0.25000 123239.9n 0.25000 123240.0n 0.31000 123369.9n 0.31000 123370.0n 0.25000 123499.9n 0.25000 123500.0n 0.31000 123629.9n 0.31000 123630.0n 0.25000 123759.9n 0.25000 123760.0n 0.31000 123889.9n 0.31000 123890.0n 0.25000 124019.9n 0.25000 124020.0n 0.31000 124149.9n 0.31000 124150.0n 0.31000 124279.9n 0.31000 124280.0n 0.25000 124409.9n 0.25000 124410.0n 0.25000 124539.9n 0.25000 124540.0n 0.25000 124669.9n 0.25000 124670.0n 0.31000 124799.9n 0.31000 124800.0n 0.25000 124929.9n 0.25000 124930.0n 0.31000 125059.9n 0.31000 125060.0n 0.31000 125189.9n 0.31000 125190.0n 0.31000 125319.9n 0.31000 125320.0n 0.31000 125449.9n 0.31000 125450.0n 0.25000 125579.9n 0.25000 125580.0n 0.25000 125709.9n 0.25000 125710.0n 0.25000 125839.9n 0.25000 125840.0n 0.25000 125969.9n 0.25000 125970.0n 0.31000 126099.9n 0.31000 126100.0n 0.31000 126229.9n 0.31000 126230.0n 0.25000 126359.9n 0.25000 126360.0n 0.31000 126489.9n 0.31000 126490.0n 0.31000 126619.9n 0.31000 126620.0n 0.25000 126749.9n 0.25000 126750.0n 0.25000 126879.9n 0.25000 126880.0n 0.31000 127009.9n 0.31000 127010.0n 0.31000 127139.9n 0.31000 127140.0n 0.31000 127269.9n 0.31000 127270.0n 0.25000 127399.9n 0.25000 127400.0n 0.25000 127529.9n 0.25000 127530.0n 0.25000 127659.9n 0.25000 127660.0n 0.31000 127789.9n 0.31000 127790.0n 0.31000 127919.9n 0.31000 127920.0n 0.25000 128049.9n 0.25000 128050.0n 0.25000 128179.9n 0.25000 128180.0n 0.31000 128309.9n 0.31000 128310.0n 0.25000 128439.9n 0.25000 128440.0n 0.25000 128569.9n 0.25000 128570.0n 0.25000 128699.9n 0.25000 128700.0n 0.31000 128829.9n 0.31000 128830.0n 0.31000 128959.9n 0.31000 128960.0n 0.25000 129089.9n 0.25000 129090.0n 0.31000 129219.9n 0.31000 129220.0n 0.25000 129349.9n 0.25000 129350.0n 0.31000 129479.9n 0.31000 129480.0n 0.31000 129609.9n 0.31000 129610.0n 0.25000 129739.9n 0.25000 129740.0n 0.25000 129869.9n 0.25000 129870.0n 0.25000 129999.9n 0.25000 130000.0n 0.31000 130129.9n 0.31000 130130.0n 0.31000 130259.9n 0.31000 130260.0n 0.25000 130389.9n 0.25000 130390.0n 0.31000 130519.9n 0.31000 130520.0n 0.25000 130649.9n 0.25000 130650.0n 0.25000 130779.9n 0.25000 130780.0n 0.25000 130909.9n 0.25000 130910.0n 0.31000 131039.9n 0.31000 131040.0n 0.25000 131169.9n 0.25000 131170.0n 0.25000 131299.9n 0.25000 131300.0n 0.31000 131429.9n 0.31000 131430.0n 0.31000 131559.9n 0.31000 131560.0n 0.25000 131689.9n 0.25000 131690.0n 0.25000 131819.9n 0.25000 131820.0n 0.25000 131949.9n 0.25000 131950.0n 0.31000 132079.9n 0.31000 132080.0n 0.25000 132209.9n 0.25000 132210.0n 0.31000 132339.9n 0.31000 132340.0n 0.31000 132469.9n 0.31000 132470.0n 0.31000 132599.9n 0.31000 132600.0n 0.25000 132729.9n 0.25000 132730.0n 0.25000 132859.9n 0.25000 132860.0n 0.31000 132989.9n 0.31000 132990.0n 0.31000 133119.9n 0.31000 133120.0n 0.31000 133249.9n 0.31000 133250.0n 0.31000 133379.9n 0.31000 133380.0n 0.31000 133509.9n 0.31000 133510.0n 0.31000 133639.9n 0.31000 133640.0n 0.25000 133769.9n 0.25000 133770.0n 0.31000 133899.9n 0.31000 133900.0n 0.25000 134029.9n 0.25000 134030.0n 0.25000 134159.9n 0.25000 134160.0n 0.28000 134289.9n 0.28000 134290.0n 0.28000 134419.9n 0.28000 134420.0n 0.28000 134549.9n 0.28000 134550.0n 0.28000 134679.9n 0.28000 134680.0n 0.28000 134809.9n 0.28000 134810.0n 0.28000 134939.9n 0.28000 134940.0n 0.28000 135069.9n 0.28000 135070.0n 0.28000 135199.9n 0.28000 135200.0n 0.28000 135329.9n 0.28000 135330.0n 0.28000 135459.9n 0.28000 135460.0n 0.28000 135589.9n 0.28000 135590.0n 0.28000 135719.9n 0.28000 135720.0n 0.28000 135849.9n 0.28000 135850.0n 0.28000 135979.9n 0.28000 135980.0n 0.28000 136109.9n 0.28000 136110.0n 0.28000 136239.9n 0.28000 136240.0n 0.28000 136369.9n 0.28000 136370.0n 0.28000 136499.9n 0.28000 136500.0n 0.28000 136629.9n 0.28000 136630.0n 0.28000 136759.9n 0.28000 136760.0n 0.28000 136889.9n 0.28000 136890.0n 0.28000 137019.9n 0.28000 137020.0n 0.28000 137149.9n 0.28000 137150.0n 0.28000 137279.9n 0.28000 137280.0n 0.28000 137409.9n 0.28000 137410.0n 0.28000 137539.9n 0.28000 137540.0n 0.28000 137669.9n 0.28000 137670.0n 0.28000 137799.9n 0.28000 137800.0n 0.28000 137929.9n 0.28000 137930.0n 0.28000 138059.9n 0.28000 138060.0n 0.28000 138189.9n 0.28000 138190.0n 0.28000 138319.9n 0.28000 138320.0n 0.28000 138449.9n 0.28000 138450.0n 0.28000 138579.9n 0.28000 138580.0n 0.28000 138709.9n 0.28000 138710.0n 0.28000 138839.9n 0.28000 138840.0n 0.28000 138969.9n 0.28000 138970.0n 0.28000 139099.9n 0.28000 139100.0n 0.28000 139229.9n 0.28000 139230.0n 0.28000 139359.9n 0.28000 139360.0n 0.28000 139489.9n 0.28000 139490.0n 0.28000 139619.9n 0.28000 139620.0n 0.28000 139749.9n 0.28000 139750.0n 0.28000 139879.9n 0.28000 139880.0n 0.28000 140009.9n 0.28000 140010.0n 0.28000 140139.9n 0.28000 140140.0n 0.28000 140269.9n 0.28000 140270.0n 0.28000 140399.9n 0.28000 140400.0n 0.25000 140529.9n 0.25000 140530.0n 0.31000 140659.9n 0.31000 140660.0n 0.25000 140789.9n 0.25000 140790.0n 0.25000 140919.9n 0.25000 140920.0n 0.31000 141049.9n 0.31000 141050.0n 0.25000 141179.9n 0.25000 141180.0n 0.31000 141309.9n 0.31000 141310.0n 0.25000 141439.9n 0.25000 141440.0n 0.25000 141569.9n 0.25000 141570.0n 0.25000 141699.9n 0.25000 141700.0n 0.25000 141829.9n 0.25000 141830.0n 0.31000 141959.9n 0.31000 141960.0n 0.31000 142089.9n 0.31000 142090.0n 0.31000 142219.9n 0.31000 142220.0n 0.31000 142349.9n 0.31000 142350.0n 0.31000 142479.9n 0.31000 142480.0n 0.31000 142609.9n 0.31000 142610.0n 0.25000 142739.9n 0.25000 142740.0n 0.25000 142869.9n 0.25000 142870.0n 0.31000 142999.9n 0.31000 143000.0n 0.25000 143129.9n 0.25000 143130.0n 0.25000 143259.9n 0.25000 143260.0n 0.31000 143389.9n 0.31000 143390.0n 0.31000 143519.9n 0.31000 143520.0n 0.31000 143649.9n 0.31000 143650.0n 0.31000 143779.9n 0.31000 143780.0n 0.25000 143909.9n 0.25000 143910.0n 0.25000 144039.9n 0.25000 144040.0n 0.31000 144169.9n 0.31000 144170.0n 0.31000 144299.9n 0.31000 144300.0n 0.31000 144429.9n 0.31000 144430.0n 0.25000 144559.9n 0.25000 144560.0n 0.25000 144689.9n 0.25000 144690.0n 0.31000 144819.9n 0.31000 144820.0n 0.31000 144949.9n 0.31000 144950.0n 0.25000 145079.9n 0.25000 145080.0n 0.31000 145209.9n 0.31000 145210.0n 0.25000 145339.9n 0.25000 145340.0n 0.25000 145469.9n 0.25000 145470.0n 0.25000 145599.9n 0.25000 145600.0n 0.31000 145729.9n 0.31000 145730.0n 0.25000 145859.9n 0.25000 145860.0n 0.31000 145989.9n 0.31000 145990.0n 0.31000 146119.9n 0.31000 146120.0n 0.25000 146249.9n 0.25000 146250.0n 0.25000 146379.9n 0.25000 146380.0n 0.31000 146509.9n 0.31000 146510.0n 0.25000 146639.9n 0.25000 146640.0n 0.31000 146769.9n 0.31000 146770.0n 0.25000 146899.9n 0.25000 146900.0n 0.31000 147029.9n 0.31000 147030.0n 0.31000 147159.9n 0.31000 147160.0n 0.31000 147289.9n 0.31000 147290.0n 0.25000 147419.9n 0.25000 147420.0n 0.25000 147549.9n 0.25000 147550.0n 0.25000 147679.9n 0.25000 147680.0n 0.25000 147809.9n 0.25000 147810.0n 0.25000 147939.9n 0.25000 147940.0n 0.31000 148069.9n 0.31000 148070.0n 0.31000 148199.9n 0.31000 148200.0n 0.25000 148329.9n 0.25000 148330.0n 0.25000 148459.9n 0.25000 148460.0n 0.31000 148589.9n 0.31000 148590.0n 0.31000 148719.9n 0.31000 148720.0n 0.25000 148849.9n 0.25000 148850.0n 0.31000 148979.9n 0.31000 148980.0n 0.31000 149109.9n 0.31000 149110.0n 0.25000 149239.9n 0.25000 149240.0n 0.31000 149369.9n 0.31000 149370.0n 0.25000 149499.9n 0.25000 149500.0n 0.25000 149629.9n 0.25000 149630.0n 0.25000 149759.9n 0.25000 149760.0n 0.31000 149889.9n 0.31000 149890.0n 0.31000 150019.9n 0.31000 150020.0n 0.31000 150149.9n 0.31000 150150.0n 0.31000 150279.9n 0.31000 150280.0n 0.31000 150409.9n 0.31000 150410.0n 0.25000 150539.9n 0.25000 150540.0n 0.25000 150669.9n 0.25000 150670.0n 0.25000 150799.9n 0.25000 150800.0n 0.25000 150929.9n 0.25000 150930.0n 0.31000 151059.9n 0.31000 151060.0n 0.31000 151189.9n 0.31000 151190.0n 0.25000 151319.9n 0.25000 151320.0n 0.31000 151449.9n 0.31000 151450.0n 0.25000 151579.9n 0.25000 151580.0n 0.25000 151709.9n 0.25000 151710.0n 0.25000 151839.9n 0.25000 151840.0n 0.31000 151969.9n 0.31000 151970.0n 0.25000 152099.9n 0.25000 152100.0n 0.31000 152229.9n 0.31000 152230.0n 0.25000 152359.9n 0.25000 152360.0n 0.31000 152489.9n 0.31000 152490.0n 0.31000 152619.9n 0.31000 152620.0n 0.31000 152749.9n 0.31000 152750.0n 0.31000 152879.9n 0.31000 152880.0n 0.31000 153009.9n 0.31000 153010.0n 0.25000 153139.9n 0.25000 153140.0n 0.31000 153269.9n 0.31000 153270.0n 0.25000 153399.9n 0.25000 153400.0n 0.31000 153529.9n 0.31000 153530.0n 0.25000 153659.9n 0.25000 153660.0n 0.31000 153789.9n 0.31000 153790.0n 0.31000 153919.9n 0.31000 153920.0n 0.25000 154049.9n 0.25000 154050.0n 0.25000 154179.9n 0.25000 154180.0n 0.25000 154309.9n 0.25000 154310.0n 0.31000 154439.9n 0.31000 154440.0n 0.25000 154569.9n 0.25000 154570.0n 0.25000 154699.9n 0.25000 154700.0n 0.31000 154829.9n 0.31000 154830.0n 0.25000 154959.9n 0.25000 154960.0n 0.25000 155089.9n 0.25000 155090.0n 0.25000 155219.9n 0.25000 155220.0n 0.31000 155349.9n 0.31000 155350.0n 0.31000 155479.9n 0.31000 155480.0n 0.31000 155609.9n 0.31000 155610.0n 0.31000 155739.9n 0.31000 155740.0n 0.25000 155869.9n 0.25000 155870.0n 0.25000 155999.9n 0.25000 156000.0n 0.25000 156129.9n 0.25000 156130.0n 0.31000 156259.9n 0.31000 156260.0n 0.25000 156389.9n 0.25000 156390.0n 0.25000 156519.9n 0.25000 156520.0n 0.25000 156649.9n 0.25000 156650.0n 0.25000 156779.9n 0.25000 156780.0n 0.25000 156909.9n 0.25000 156910.0n 0.31000 157039.9n 0.31000 157040.0n 0.31000 157169.9n 0.31000 157170.0n 0.31000 157299.9n 0.31000 157300.0n 0.31000 157429.9n 0.31000 157430.0n 0.31000 157559.9n 0.31000 157560.0n 0.25000 157689.9n 0.25000 157690.0n 0.31000 157819.9n 0.31000 157820.0n 0.25000 157949.9n 0.25000 157950.0n 0.25000 158079.9n 0.25000 158080.0n 0.31000 158209.9n 0.31000 158210.0n 0.25000 158339.9n 0.25000 158340.0n 0.31000 158469.9n 0.31000 158470.0n 0.31000 158599.9n 0.31000 158600.0n 0.25000 158729.9n 0.25000 158730.0n 0.25000 158859.9n 0.25000 158860.0n 0.31000 158989.9n 0.31000 158990.0n 0.25000 159119.9n 0.25000 159120.0n 0.31000 159249.9n 0.31000 159250.0n 0.25000 159379.9n 0.25000 159380.0n 0.25000 159509.9n 0.25000 159510.0n 0.31000 159639.9n 0.31000 159640.0n 0.31000 159769.9n 0.31000 159770.0n 0.31000 159899.9n 0.31000 159900.0n 0.25000 160029.9n 0.25000 160030.0n 0.31000 160159.9n 0.31000 160160.0n 0.31000 160289.9n 0.31000 160290.0n 0.25000 160419.9n 0.25000 160420.0n 0.25000 160549.9n 0.25000 160550.0n 0.25000 160679.9n 0.25000 160680.0n 0.25000 160809.9n 0.25000 160810.0n 0.31000 160939.9n 0.31000 160940.0n 0.25000 161069.9n 0.25000 161070.0n 0.31000 161199.9n 0.31000 161200.0n 0.31000 161329.9n 0.31000 161330.0n 0.31000 161459.9n 0.31000 161460.0n 0.25000 161589.9n 0.25000 161590.0n 0.31000 161719.9n 0.31000 161720.0n 0.25000 161849.9n 0.25000 161850.0n 0.31000 161979.9n 0.31000 161980.0n 0.25000 162109.9n 0.25000 162110.0n 0.31000 162239.9n 0.31000 162240.0n 0.28000 162369.9n 0.28000 162370.0n 0.28000 162499.9n 0.28000 162500.0n 0.28000 162629.9n 0.28000 162630.0n 0.28000 162759.9n 0.28000 162760.0n 0.28000 162889.9n 0.28000 162890.0n 0.28000 163019.9n 0.28000 163020.0n 0.28000 163149.9n 0.28000 163150.0n 0.28000 163279.9n 0.28000 163280.0n 0.28000 163409.9n 0.28000 163410.0n 0.28000 163539.9n 0.28000 163540.0n 0.28000 163669.9n 0.28000 163670.0n 0.28000 163799.9n 0.28000 163800.0n 0.28000 163929.9n 0.28000 163930.0n 0.28000 164059.9n 0.28000 164060.0n 0.28000 164189.9n 0.28000 164190.0n 0.28000 164319.9n 0.28000 164320.0n 0.28000 164449.9n 0.28000 164450.0n 0.28000 164579.9n 0.28000 164580.0n 0.28000 164709.9n 0.28000 164710.0n 0.28000 164839.9n 0.28000 164840.0n 0.28000 164969.9n 0.28000 164970.0n 0.28000 165099.9n 0.28000 165100.0n 0.28000 165229.9n 0.28000 165230.0n 0.28000 165359.9n 0.28000 165360.0n 0.28000 165489.9n 0.28000 165490.0n 0.28000 165619.9n 0.28000 165620.0n 0.28000 165749.9n 0.28000 165750.0n 0.28000 165879.9n 0.28000 165880.0n 0.28000 166009.9n 0.28000 166010.0n 0.28000 166139.9n 0.28000 166140.0n 0.28000 166269.9n 0.28000 166270.0n 0.28000 166399.9n 0.28000 166400.0n 0.28000 166529.9n 0.28000 166530.0n 0.28000 166659.9n 0.28000 166660.0n 0.28000 166789.9n 0.28000 166790.0n 0.28000 166919.9n 0.28000 166920.0n 0.28000 167049.9n 0.28000 167050.0n 0.28000 167179.9n 0.28000 167180.0n 0.28000 167309.9n 0.28000 167310.0n 0.28000 167439.9n 0.28000 167440.0n 0.28000 167569.9n 0.28000 167570.0n 0.28000 167699.9n 0.28000 167700.0n 0.28000 167829.9n 0.28000 167830.0n 0.28000 167959.9n 0.28000 167960.0n 0.28000 168089.9n 0.28000 168090.0n 0.28000 168219.9n 0.28000 168220.0n 0.28000 168349.9n 0.28000 168350.0n 0.28000)
Vxop1 xop1 0 PWL(0.0n 0.25000 129.9n 0.25000 130.0n 0.31000 259.9n 0.31000 260.0n 0.25000 389.9n 0.25000 390.0n 0.31000 519.9n 0.31000 520.0n 0.31000 649.9n 0.31000 650.0n 0.25000 779.9n 0.25000 780.0n 0.25000 909.9n 0.25000 910.0n 0.25000 1039.9n 0.25000 1040.0n 0.25000 1169.9n 0.25000 1170.0n 0.31000 1299.9n 0.31000 1300.0n 0.25000 1429.9n 0.25000 1430.0n 0.31000 1559.9n 0.31000 1560.0n 0.31000 1689.9n 0.31000 1690.0n 0.25000 1819.9n 0.25000 1820.0n 0.25000 1949.9n 0.25000 1950.0n 0.31000 2079.9n 0.31000 2080.0n 0.31000 2209.9n 0.31000 2210.0n 0.25000 2339.9n 0.25000 2340.0n 0.25000 2469.9n 0.25000 2470.0n 0.31000 2599.9n 0.31000 2600.0n 0.31000 2729.9n 0.31000 2730.0n 0.31000 2859.9n 0.31000 2860.0n 0.25000 2989.9n 0.25000 2990.0n 0.25000 3119.9n 0.25000 3120.0n 0.25000 3249.9n 0.25000 3250.0n 0.31000 3379.9n 0.31000 3380.0n 0.31000 3509.9n 0.31000 3510.0n 0.31000 3639.9n 0.31000 3640.0n 0.31000 3769.9n 0.31000 3770.0n 0.25000 3899.9n 0.25000 3900.0n 0.31000 4029.9n 0.31000 4030.0n 0.31000 4159.9n 0.31000 4160.0n 0.31000 4289.9n 0.31000 4290.0n 0.25000 4419.9n 0.25000 4420.0n 0.25000 4549.9n 0.25000 4550.0n 0.31000 4679.9n 0.31000 4680.0n 0.25000 4809.9n 0.25000 4810.0n 0.25000 4939.9n 0.25000 4940.0n 0.31000 5069.9n 0.31000 5070.0n 0.25000 5199.9n 0.25000 5200.0n 0.25000 5329.9n 0.25000 5330.0n 0.25000 5459.9n 0.25000 5460.0n 0.31000 5589.9n 0.31000 5590.0n 0.31000 5719.9n 0.31000 5720.0n 0.25000 5849.9n 0.25000 5850.0n 0.31000 5979.9n 0.31000 5980.0n 0.31000 6109.9n 0.31000 6110.0n 0.25000 6239.9n 0.25000 6240.0n 0.31000 6369.9n 0.31000 6370.0n 0.25000 6499.9n 0.25000 6500.0n 0.31000 6629.9n 0.31000 6630.0n 0.25000 6759.9n 0.25000 6760.0n 0.31000 6889.9n 0.31000 6890.0n 0.25000 7019.9n 0.25000 7020.0n 0.31000 7149.9n 0.31000 7150.0n 0.25000 7279.9n 0.25000 7280.0n 0.31000 7409.9n 0.31000 7410.0n 0.31000 7539.9n 0.31000 7540.0n 0.31000 7669.9n 0.31000 7670.0n 0.25000 7799.9n 0.25000 7800.0n 0.31000 7929.9n 0.31000 7930.0n 0.31000 8059.9n 0.31000 8060.0n 0.31000 8189.9n 0.31000 8190.0n 0.31000 8319.9n 0.31000 8320.0n 0.25000 8449.9n 0.25000 8450.0n 0.31000 8579.9n 0.31000 8580.0n 0.25000 8709.9n 0.25000 8710.0n 0.25000 8839.9n 0.25000 8840.0n 0.25000 8969.9n 0.25000 8970.0n 0.31000 9099.9n 0.31000 9100.0n 0.25000 9229.9n 0.25000 9230.0n 0.31000 9359.9n 0.31000 9360.0n 0.31000 9489.9n 0.31000 9490.0n 0.31000 9619.9n 0.31000 9620.0n 0.25000 9749.9n 0.25000 9750.0n 0.25000 9879.9n 0.25000 9880.0n 0.25000 10009.9n 0.25000 10010.0n 0.25000 10139.9n 0.25000 10140.0n 0.31000 10269.9n 0.31000 10270.0n 0.25000 10399.9n 0.25000 10400.0n 0.25000 10529.9n 0.25000 10530.0n 0.25000 10659.9n 0.25000 10660.0n 0.31000 10789.9n 0.31000 10790.0n 0.25000 10919.9n 0.25000 10920.0n 0.25000 11049.9n 0.25000 11050.0n 0.31000 11179.9n 0.31000 11180.0n 0.31000 11309.9n 0.31000 11310.0n 0.25000 11439.9n 0.25000 11440.0n 0.25000 11569.9n 0.25000 11570.0n 0.25000 11699.9n 0.25000 11700.0n 0.25000 11829.9n 0.25000 11830.0n 0.31000 11959.9n 0.31000 11960.0n 0.25000 12089.9n 0.25000 12090.0n 0.31000 12219.9n 0.31000 12220.0n 0.25000 12349.9n 0.25000 12350.0n 0.25000 12479.9n 0.25000 12480.0n 0.31000 12609.9n 0.31000 12610.0n 0.25000 12739.9n 0.25000 12740.0n 0.25000 12869.9n 0.25000 12870.0n 0.25000 12999.9n 0.25000 13000.0n 0.31000 13129.9n 0.31000 13130.0n 0.31000 13259.9n 0.31000 13260.0n 0.31000 13389.9n 0.31000 13390.0n 0.25000 13519.9n 0.25000 13520.0n 0.31000 13649.9n 0.31000 13650.0n 0.25000 13779.9n 0.25000 13780.0n 0.31000 13909.9n 0.31000 13910.0n 0.31000 14039.9n 0.31000 14040.0n 0.25000 14169.9n 0.25000 14170.0n 0.31000 14299.9n 0.31000 14300.0n 0.31000 14429.9n 0.31000 14430.0n 0.31000 14559.9n 0.31000 14560.0n 0.31000 14689.9n 0.31000 14690.0n 0.25000 14819.9n 0.25000 14820.0n 0.31000 14949.9n 0.31000 14950.0n 0.25000 15079.9n 0.25000 15080.0n 0.31000 15209.9n 0.31000 15210.0n 0.31000 15339.9n 0.31000 15340.0n 0.31000 15469.9n 0.31000 15470.0n 0.31000 15599.9n 0.31000 15600.0n 0.31000 15729.9n 0.31000 15730.0n 0.25000 15859.9n 0.25000 15860.0n 0.31000 15989.9n 0.31000 15990.0n 0.25000 16119.9n 0.25000 16120.0n 0.31000 16249.9n 0.31000 16250.0n 0.31000 16379.9n 0.31000 16380.0n 0.25000 16509.9n 0.25000 16510.0n 0.25000 16639.9n 0.25000 16640.0n 0.25000 16769.9n 0.25000 16770.0n 0.31000 16899.9n 0.31000 16900.0n 0.31000 17029.9n 0.31000 17030.0n 0.25000 17159.9n 0.25000 17160.0n 0.25000 17289.9n 0.25000 17290.0n 0.25000 17419.9n 0.25000 17420.0n 0.25000 17549.9n 0.25000 17550.0n 0.31000 17679.9n 0.31000 17680.0n 0.25000 17809.9n 0.25000 17810.0n 0.25000 17939.9n 0.25000 17940.0n 0.31000 18069.9n 0.31000 18070.0n 0.25000 18199.9n 0.25000 18200.0n 0.25000 18329.9n 0.25000 18330.0n 0.31000 18459.9n 0.31000 18460.0n 0.25000 18589.9n 0.25000 18590.0n 0.25000 18719.9n 0.25000 18720.0n 0.25000 18849.9n 0.25000 18850.0n 0.25000 18979.9n 0.25000 18980.0n 0.31000 19109.9n 0.31000 19110.0n 0.31000 19239.9n 0.31000 19240.0n 0.31000 19369.9n 0.31000 19370.0n 0.25000 19499.9n 0.25000 19500.0n 0.25000 19629.9n 0.25000 19630.0n 0.31000 19759.9n 0.31000 19760.0n 0.31000 19889.9n 0.31000 19890.0n 0.25000 20019.9n 0.25000 20020.0n 0.31000 20149.9n 0.31000 20150.0n 0.31000 20279.9n 0.31000 20280.0n 0.25000 20409.9n 0.25000 20410.0n 0.31000 20539.9n 0.31000 20540.0n 0.25000 20669.9n 0.25000 20670.0n 0.31000 20799.9n 0.31000 20800.0n 0.31000 20929.9n 0.31000 20930.0n 0.31000 21059.9n 0.31000 21060.0n 0.25000 21189.9n 0.25000 21190.0n 0.31000 21319.9n 0.31000 21320.0n 0.25000 21449.9n 0.25000 21450.0n 0.25000 21579.9n 0.25000 21580.0n 0.31000 21709.9n 0.31000 21710.0n 0.25000 21839.9n 0.25000 21840.0n 0.28000 21969.9n 0.28000 21970.0n 0.28000 22099.9n 0.28000 22100.0n 0.28000 22229.9n 0.28000 22230.0n 0.28000 22359.9n 0.28000 22360.0n 0.28000 22489.9n 0.28000 22490.0n 0.28000 22619.9n 0.28000 22620.0n 0.28000 22749.9n 0.28000 22750.0n 0.28000 22879.9n 0.28000 22880.0n 0.28000 23009.9n 0.28000 23010.0n 0.28000 23139.9n 0.28000 23140.0n 0.28000 23269.9n 0.28000 23270.0n 0.28000 23399.9n 0.28000 23400.0n 0.28000 23529.9n 0.28000 23530.0n 0.28000 23659.9n 0.28000 23660.0n 0.28000 23789.9n 0.28000 23790.0n 0.28000 23919.9n 0.28000 23920.0n 0.28000 24049.9n 0.28000 24050.0n 0.28000 24179.9n 0.28000 24180.0n 0.28000 24309.9n 0.28000 24310.0n 0.28000 24439.9n 0.28000 24440.0n 0.28000 24569.9n 0.28000 24570.0n 0.28000 24699.9n 0.28000 24700.0n 0.28000 24829.9n 0.28000 24830.0n 0.28000 24959.9n 0.28000 24960.0n 0.28000 25089.9n 0.28000 25090.0n 0.28000 25219.9n 0.28000 25220.0n 0.28000 25349.9n 0.28000 25350.0n 0.28000 25479.9n 0.28000 25480.0n 0.28000 25609.9n 0.28000 25610.0n 0.28000 25739.9n 0.28000 25740.0n 0.28000 25869.9n 0.28000 25870.0n 0.28000 25999.9n 0.28000 26000.0n 0.28000 26129.9n 0.28000 26130.0n 0.28000 26259.9n 0.28000 26260.0n 0.28000 26389.9n 0.28000 26390.0n 0.28000 26519.9n 0.28000 26520.0n 0.28000 26649.9n 0.28000 26650.0n 0.28000 26779.9n 0.28000 26780.0n 0.28000 26909.9n 0.28000 26910.0n 0.28000 27039.9n 0.28000 27040.0n 0.28000 27169.9n 0.28000 27170.0n 0.28000 27299.9n 0.28000 27300.0n 0.28000 27429.9n 0.28000 27430.0n 0.28000 27559.9n 0.28000 27560.0n 0.28000 27689.9n 0.28000 27690.0n 0.28000 27819.9n 0.28000 27820.0n 0.28000 27949.9n 0.28000 27950.0n 0.28000 28079.9n 0.28000 28080.0n 0.25000 28209.9n 0.25000 28210.0n 0.25000 28339.9n 0.25000 28340.0n 0.31000 28469.9n 0.31000 28470.0n 0.31000 28599.9n 0.31000 28600.0n 0.31000 28729.9n 0.31000 28730.0n 0.31000 28859.9n 0.31000 28860.0n 0.31000 28989.9n 0.31000 28990.0n 0.25000 29119.9n 0.25000 29120.0n 0.25000 29249.9n 0.25000 29250.0n 0.25000 29379.9n 0.25000 29380.0n 0.25000 29509.9n 0.25000 29510.0n 0.31000 29639.9n 0.31000 29640.0n 0.25000 29769.9n 0.25000 29770.0n 0.31000 29899.9n 0.31000 29900.0n 0.25000 30029.9n 0.25000 30030.0n 0.31000 30159.9n 0.31000 30160.0n 0.31000 30289.9n 0.31000 30290.0n 0.31000 30419.9n 0.31000 30420.0n 0.31000 30549.9n 0.31000 30550.0n 0.31000 30679.9n 0.31000 30680.0n 0.31000 30809.9n 0.31000 30810.0n 0.31000 30939.9n 0.31000 30940.0n 0.25000 31069.9n 0.25000 31070.0n 0.25000 31199.9n 0.25000 31200.0n 0.25000 31329.9n 0.25000 31330.0n 0.25000 31459.9n 0.25000 31460.0n 0.25000 31589.9n 0.25000 31590.0n 0.25000 31719.9n 0.25000 31720.0n 0.31000 31849.9n 0.31000 31850.0n 0.25000 31979.9n 0.25000 31980.0n 0.31000 32109.9n 0.31000 32110.0n 0.31000 32239.9n 0.31000 32240.0n 0.25000 32369.9n 0.25000 32370.0n 0.25000 32499.9n 0.25000 32500.0n 0.25000 32629.9n 0.25000 32630.0n 0.25000 32759.9n 0.25000 32760.0n 0.25000 32889.9n 0.25000 32890.0n 0.25000 33019.9n 0.25000 33020.0n 0.25000 33149.9n 0.25000 33150.0n 0.31000 33279.9n 0.31000 33280.0n 0.31000 33409.9n 0.31000 33410.0n 0.25000 33539.9n 0.25000 33540.0n 0.25000 33669.9n 0.25000 33670.0n 0.31000 33799.9n 0.31000 33800.0n 0.25000 33929.9n 0.25000 33930.0n 0.31000 34059.9n 0.31000 34060.0n 0.31000 34189.9n 0.31000 34190.0n 0.31000 34319.9n 0.31000 34320.0n 0.31000 34449.9n 0.31000 34450.0n 0.25000 34579.9n 0.25000 34580.0n 0.31000 34709.9n 0.31000 34710.0n 0.31000 34839.9n 0.31000 34840.0n 0.25000 34969.9n 0.25000 34970.0n 0.31000 35099.9n 0.31000 35100.0n 0.25000 35229.9n 0.25000 35230.0n 0.31000 35359.9n 0.31000 35360.0n 0.25000 35489.9n 0.25000 35490.0n 0.31000 35619.9n 0.31000 35620.0n 0.31000 35749.9n 0.31000 35750.0n 0.25000 35879.9n 0.25000 35880.0n 0.31000 36009.9n 0.31000 36010.0n 0.31000 36139.9n 0.31000 36140.0n 0.25000 36269.9n 0.25000 36270.0n 0.25000 36399.9n 0.25000 36400.0n 0.25000 36529.9n 0.25000 36530.0n 0.25000 36659.9n 0.25000 36660.0n 0.31000 36789.9n 0.31000 36790.0n 0.31000 36919.9n 0.31000 36920.0n 0.31000 37049.9n 0.31000 37050.0n 0.25000 37179.9n 0.25000 37180.0n 0.31000 37309.9n 0.31000 37310.0n 0.31000 37439.9n 0.31000 37440.0n 0.31000 37569.9n 0.31000 37570.0n 0.31000 37699.9n 0.31000 37700.0n 0.25000 37829.9n 0.25000 37830.0n 0.25000 37959.9n 0.25000 37960.0n 0.25000 38089.9n 0.25000 38090.0n 0.25000 38219.9n 0.25000 38220.0n 0.31000 38349.9n 0.31000 38350.0n 0.31000 38479.9n 0.31000 38480.0n 0.25000 38609.9n 0.25000 38610.0n 0.25000 38739.9n 0.25000 38740.0n 0.31000 38869.9n 0.31000 38870.0n 0.25000 38999.9n 0.25000 39000.0n 0.31000 39129.9n 0.31000 39130.0n 0.31000 39259.9n 0.31000 39260.0n 0.31000 39389.9n 0.31000 39390.0n 0.31000 39519.9n 0.31000 39520.0n 0.25000 39649.9n 0.25000 39650.0n 0.31000 39779.9n 0.31000 39780.0n 0.25000 39909.9n 0.25000 39910.0n 0.25000 40039.9n 0.25000 40040.0n 0.25000 40169.9n 0.25000 40170.0n 0.25000 40299.9n 0.25000 40300.0n 0.25000 40429.9n 0.25000 40430.0n 0.31000 40559.9n 0.31000 40560.0n 0.31000 40689.9n 0.31000 40690.0n 0.25000 40819.9n 0.25000 40820.0n 0.31000 40949.9n 0.31000 40950.0n 0.25000 41079.9n 0.25000 41080.0n 0.31000 41209.9n 0.31000 41210.0n 0.31000 41339.9n 0.31000 41340.0n 0.25000 41469.9n 0.25000 41470.0n 0.25000 41599.9n 0.25000 41600.0n 0.25000 41729.9n 0.25000 41730.0n 0.31000 41859.9n 0.31000 41860.0n 0.25000 41989.9n 0.25000 41990.0n 0.25000 42119.9n 0.25000 42120.0n 0.31000 42249.9n 0.31000 42250.0n 0.31000 42379.9n 0.31000 42380.0n 0.25000 42509.9n 0.25000 42510.0n 0.31000 42639.9n 0.31000 42640.0n 0.31000 42769.9n 0.31000 42770.0n 0.25000 42899.9n 0.25000 42900.0n 0.25000 43029.9n 0.25000 43030.0n 0.25000 43159.9n 0.25000 43160.0n 0.25000 43289.9n 0.25000 43290.0n 0.25000 43419.9n 0.25000 43420.0n 0.25000 43549.9n 0.25000 43550.0n 0.31000 43679.9n 0.31000 43680.0n 0.31000 43809.9n 0.31000 43810.0n 0.25000 43939.9n 0.25000 43940.0n 0.25000 44069.9n 0.25000 44070.0n 0.31000 44199.9n 0.31000 44200.0n 0.25000 44329.9n 0.25000 44330.0n 0.31000 44459.9n 0.31000 44460.0n 0.31000 44589.9n 0.31000 44590.0n 0.31000 44719.9n 0.31000 44720.0n 0.25000 44849.9n 0.25000 44850.0n 0.25000 44979.9n 0.25000 44980.0n 0.31000 45109.9n 0.31000 45110.0n 0.31000 45239.9n 0.31000 45240.0n 0.31000 45369.9n 0.31000 45370.0n 0.31000 45499.9n 0.31000 45500.0n 0.25000 45629.9n 0.25000 45630.0n 0.25000 45759.9n 0.25000 45760.0n 0.31000 45889.9n 0.31000 45890.0n 0.31000 46019.9n 0.31000 46020.0n 0.25000 46149.9n 0.25000 46150.0n 0.31000 46279.9n 0.31000 46280.0n 0.31000 46409.9n 0.31000 46410.0n 0.25000 46539.9n 0.25000 46540.0n 0.25000 46669.9n 0.25000 46670.0n 0.25000 46799.9n 0.25000 46800.0n 0.25000 46929.9n 0.25000 46930.0n 0.25000 47059.9n 0.25000 47060.0n 0.31000 47189.9n 0.31000 47190.0n 0.31000 47319.9n 0.31000 47320.0n 0.31000 47449.9n 0.31000 47450.0n 0.31000 47579.9n 0.31000 47580.0n 0.31000 47709.9n 0.31000 47710.0n 0.25000 47839.9n 0.25000 47840.0n 0.25000 47969.9n 0.25000 47970.0n 0.25000 48099.9n 0.25000 48100.0n 0.31000 48229.9n 0.31000 48230.0n 0.25000 48359.9n 0.25000 48360.0n 0.25000 48489.9n 0.25000 48490.0n 0.31000 48619.9n 0.31000 48620.0n 0.25000 48749.9n 0.25000 48750.0n 0.31000 48879.9n 0.31000 48880.0n 0.31000 49009.9n 0.31000 49010.0n 0.25000 49139.9n 0.25000 49140.0n 0.31000 49269.9n 0.31000 49270.0n 0.31000 49399.9n 0.31000 49400.0n 0.25000 49529.9n 0.25000 49530.0n 0.25000 49659.9n 0.25000 49660.0n 0.31000 49789.9n 0.31000 49790.0n 0.31000 49919.9n 0.31000 49920.0n 0.28000 50049.9n 0.28000 50050.0n 0.28000 50179.9n 0.28000 50180.0n 0.28000 50309.9n 0.28000 50310.0n 0.28000 50439.9n 0.28000 50440.0n 0.28000 50569.9n 0.28000 50570.0n 0.28000 50699.9n 0.28000 50700.0n 0.28000 50829.9n 0.28000 50830.0n 0.28000 50959.9n 0.28000 50960.0n 0.28000 51089.9n 0.28000 51090.0n 0.28000 51219.9n 0.28000 51220.0n 0.28000 51349.9n 0.28000 51350.0n 0.28000 51479.9n 0.28000 51480.0n 0.28000 51609.9n 0.28000 51610.0n 0.28000 51739.9n 0.28000 51740.0n 0.28000 51869.9n 0.28000 51870.0n 0.28000 51999.9n 0.28000 52000.0n 0.28000 52129.9n 0.28000 52130.0n 0.28000 52259.9n 0.28000 52260.0n 0.28000 52389.9n 0.28000 52390.0n 0.28000 52519.9n 0.28000 52520.0n 0.28000 52649.9n 0.28000 52650.0n 0.28000 52779.9n 0.28000 52780.0n 0.28000 52909.9n 0.28000 52910.0n 0.28000 53039.9n 0.28000 53040.0n 0.28000 53169.9n 0.28000 53170.0n 0.28000 53299.9n 0.28000 53300.0n 0.28000 53429.9n 0.28000 53430.0n 0.28000 53559.9n 0.28000 53560.0n 0.28000 53689.9n 0.28000 53690.0n 0.28000 53819.9n 0.28000 53820.0n 0.28000 53949.9n 0.28000 53950.0n 0.28000 54079.9n 0.28000 54080.0n 0.28000 54209.9n 0.28000 54210.0n 0.28000 54339.9n 0.28000 54340.0n 0.28000 54469.9n 0.28000 54470.0n 0.28000 54599.9n 0.28000 54600.0n 0.28000 54729.9n 0.28000 54730.0n 0.28000 54859.9n 0.28000 54860.0n 0.28000 54989.9n 0.28000 54990.0n 0.28000 55119.9n 0.28000 55120.0n 0.28000 55249.9n 0.28000 55250.0n 0.28000 55379.9n 0.28000 55380.0n 0.28000 55509.9n 0.28000 55510.0n 0.28000 55639.9n 0.28000 55640.0n 0.28000 55769.9n 0.28000 55770.0n 0.28000 55899.9n 0.28000 55900.0n 0.28000 56029.9n 0.28000 56030.0n 0.28000 56159.9n 0.28000 56160.0n 0.25000 56289.9n 0.25000 56290.0n 0.31000 56419.9n 0.31000 56420.0n 0.31000 56549.9n 0.31000 56550.0n 0.31000 56679.9n 0.31000 56680.0n 0.25000 56809.9n 0.25000 56810.0n 0.31000 56939.9n 0.31000 56940.0n 0.31000 57069.9n 0.31000 57070.0n 0.31000 57199.9n 0.31000 57200.0n 0.31000 57329.9n 0.31000 57330.0n 0.25000 57459.9n 0.25000 57460.0n 0.25000 57589.9n 0.25000 57590.0n 0.25000 57719.9n 0.25000 57720.0n 0.25000 57849.9n 0.25000 57850.0n 0.25000 57979.9n 0.25000 57980.0n 0.25000 58109.9n 0.25000 58110.0n 0.25000 58239.9n 0.25000 58240.0n 0.31000 58369.9n 0.31000 58370.0n 0.31000 58499.9n 0.31000 58500.0n 0.31000 58629.9n 0.31000 58630.0n 0.31000 58759.9n 0.31000 58760.0n 0.31000 58889.9n 0.31000 58890.0n 0.25000 59019.9n 0.25000 59020.0n 0.25000 59149.9n 0.25000 59150.0n 0.25000 59279.9n 0.25000 59280.0n 0.25000 59409.9n 0.25000 59410.0n 0.31000 59539.9n 0.31000 59540.0n 0.25000 59669.9n 0.25000 59670.0n 0.31000 59799.9n 0.31000 59800.0n 0.25000 59929.9n 0.25000 59930.0n 0.25000 60059.9n 0.25000 60060.0n 0.31000 60189.9n 0.31000 60190.0n 0.25000 60319.9n 0.25000 60320.0n 0.25000 60449.9n 0.25000 60450.0n 0.31000 60579.9n 0.31000 60580.0n 0.31000 60709.9n 0.31000 60710.0n 0.25000 60839.9n 0.25000 60840.0n 0.31000 60969.9n 0.31000 60970.0n 0.31000 61099.9n 0.31000 61100.0n 0.25000 61229.9n 0.25000 61230.0n 0.31000 61359.9n 0.31000 61360.0n 0.25000 61489.9n 0.25000 61490.0n 0.31000 61619.9n 0.31000 61620.0n 0.31000 61749.9n 0.31000 61750.0n 0.25000 61879.9n 0.25000 61880.0n 0.25000 62009.9n 0.25000 62010.0n 0.31000 62139.9n 0.31000 62140.0n 0.25000 62269.9n 0.25000 62270.0n 0.31000 62399.9n 0.31000 62400.0n 0.25000 62529.9n 0.25000 62530.0n 0.25000 62659.9n 0.25000 62660.0n 0.25000 62789.9n 0.25000 62790.0n 0.31000 62919.9n 0.31000 62920.0n 0.31000 63049.9n 0.31000 63050.0n 0.31000 63179.9n 0.31000 63180.0n 0.31000 63309.9n 0.31000 63310.0n 0.25000 63439.9n 0.25000 63440.0n 0.31000 63569.9n 0.31000 63570.0n 0.25000 63699.9n 0.25000 63700.0n 0.25000 63829.9n 0.25000 63830.0n 0.31000 63959.9n 0.31000 63960.0n 0.31000 64089.9n 0.31000 64090.0n 0.25000 64219.9n 0.25000 64220.0n 0.31000 64349.9n 0.31000 64350.0n 0.31000 64479.9n 0.31000 64480.0n 0.25000 64609.9n 0.25000 64610.0n 0.31000 64739.9n 0.31000 64740.0n 0.31000 64869.9n 0.31000 64870.0n 0.25000 64999.9n 0.25000 65000.0n 0.31000 65129.9n 0.31000 65130.0n 0.31000 65259.9n 0.31000 65260.0n 0.31000 65389.9n 0.31000 65390.0n 0.31000 65519.9n 0.31000 65520.0n 0.25000 65649.9n 0.25000 65650.0n 0.25000 65779.9n 0.25000 65780.0n 0.25000 65909.9n 0.25000 65910.0n 0.31000 66039.9n 0.31000 66040.0n 0.25000 66169.9n 0.25000 66170.0n 0.25000 66299.9n 0.25000 66300.0n 0.25000 66429.9n 0.25000 66430.0n 0.25000 66559.9n 0.25000 66560.0n 0.31000 66689.9n 0.31000 66690.0n 0.25000 66819.9n 0.25000 66820.0n 0.31000 66949.9n 0.31000 66950.0n 0.25000 67079.9n 0.25000 67080.0n 0.31000 67209.9n 0.31000 67210.0n 0.25000 67339.9n 0.25000 67340.0n 0.31000 67469.9n 0.31000 67470.0n 0.31000 67599.9n 0.31000 67600.0n 0.25000 67729.9n 0.25000 67730.0n 0.31000 67859.9n 0.31000 67860.0n 0.25000 67989.9n 0.25000 67990.0n 0.25000 68119.9n 0.25000 68120.0n 0.25000 68249.9n 0.25000 68250.0n 0.31000 68379.9n 0.31000 68380.0n 0.31000 68509.9n 0.31000 68510.0n 0.25000 68639.9n 0.25000 68640.0n 0.25000 68769.9n 0.25000 68770.0n 0.31000 68899.9n 0.31000 68900.0n 0.31000 69029.9n 0.31000 69030.0n 0.25000 69159.9n 0.25000 69160.0n 0.31000 69289.9n 0.31000 69290.0n 0.25000 69419.9n 0.25000 69420.0n 0.31000 69549.9n 0.31000 69550.0n 0.25000 69679.9n 0.25000 69680.0n 0.25000 69809.9n 0.25000 69810.0n 0.31000 69939.9n 0.31000 69940.0n 0.25000 70069.9n 0.25000 70070.0n 0.31000 70199.9n 0.31000 70200.0n 0.31000 70329.9n 0.31000 70330.0n 0.31000 70459.9n 0.31000 70460.0n 0.25000 70589.9n 0.25000 70590.0n 0.25000 70719.9n 0.25000 70720.0n 0.31000 70849.9n 0.31000 70850.0n 0.31000 70979.9n 0.31000 70980.0n 0.25000 71109.9n 0.25000 71110.0n 0.25000 71239.9n 0.25000 71240.0n 0.25000 71369.9n 0.25000 71370.0n 0.25000 71499.9n 0.25000 71500.0n 0.25000 71629.9n 0.25000 71630.0n 0.31000 71759.9n 0.31000 71760.0n 0.31000 71889.9n 0.31000 71890.0n 0.31000 72019.9n 0.31000 72020.0n 0.31000 72149.9n 0.31000 72150.0n 0.25000 72279.9n 0.25000 72280.0n 0.31000 72409.9n 0.31000 72410.0n 0.25000 72539.9n 0.25000 72540.0n 0.31000 72669.9n 0.31000 72670.0n 0.25000 72799.9n 0.25000 72800.0n 0.31000 72929.9n 0.31000 72930.0n 0.25000 73059.9n 0.25000 73060.0n 0.25000 73189.9n 0.25000 73190.0n 0.25000 73319.9n 0.25000 73320.0n 0.31000 73449.9n 0.31000 73450.0n 0.31000 73579.9n 0.31000 73580.0n 0.25000 73709.9n 0.25000 73710.0n 0.31000 73839.9n 0.31000 73840.0n 0.25000 73969.9n 0.25000 73970.0n 0.31000 74099.9n 0.31000 74100.0n 0.31000 74229.9n 0.31000 74230.0n 0.25000 74359.9n 0.25000 74360.0n 0.25000 74489.9n 0.25000 74490.0n 0.25000 74619.9n 0.25000 74620.0n 0.31000 74749.9n 0.31000 74750.0n 0.31000 74879.9n 0.31000 74880.0n 0.31000 75009.9n 0.31000 75010.0n 0.25000 75139.9n 0.25000 75140.0n 0.31000 75269.9n 0.31000 75270.0n 0.31000 75399.9n 0.31000 75400.0n 0.25000 75529.9n 0.25000 75530.0n 0.31000 75659.9n 0.31000 75660.0n 0.31000 75789.9n 0.31000 75790.0n 0.25000 75919.9n 0.25000 75920.0n 0.31000 76049.9n 0.31000 76050.0n 0.31000 76179.9n 0.31000 76180.0n 0.25000 76309.9n 0.25000 76310.0n 0.31000 76439.9n 0.31000 76440.0n 0.31000 76569.9n 0.31000 76570.0n 0.31000 76699.9n 0.31000 76700.0n 0.31000 76829.9n 0.31000 76830.0n 0.25000 76959.9n 0.25000 76960.0n 0.25000 77089.9n 0.25000 77090.0n 0.25000 77219.9n 0.25000 77220.0n 0.25000 77349.9n 0.25000 77350.0n 0.25000 77479.9n 0.25000 77480.0n 0.25000 77609.9n 0.25000 77610.0n 0.31000 77739.9n 0.31000 77740.0n 0.25000 77869.9n 0.25000 77870.0n 0.25000 77999.9n 0.25000 78000.0n 0.28000 78129.9n 0.28000 78130.0n 0.28000 78259.9n 0.28000 78260.0n 0.28000 78389.9n 0.28000 78390.0n 0.28000 78519.9n 0.28000 78520.0n 0.28000 78649.9n 0.28000 78650.0n 0.28000 78779.9n 0.28000 78780.0n 0.28000 78909.9n 0.28000 78910.0n 0.28000 79039.9n 0.28000 79040.0n 0.28000 79169.9n 0.28000 79170.0n 0.28000 79299.9n 0.28000 79300.0n 0.28000 79429.9n 0.28000 79430.0n 0.28000 79559.9n 0.28000 79560.0n 0.28000 79689.9n 0.28000 79690.0n 0.28000 79819.9n 0.28000 79820.0n 0.28000 79949.9n 0.28000 79950.0n 0.28000 80079.9n 0.28000 80080.0n 0.28000 80209.9n 0.28000 80210.0n 0.28000 80339.9n 0.28000 80340.0n 0.28000 80469.9n 0.28000 80470.0n 0.28000 80599.9n 0.28000 80600.0n 0.28000 80729.9n 0.28000 80730.0n 0.28000 80859.9n 0.28000 80860.0n 0.28000 80989.9n 0.28000 80990.0n 0.28000 81119.9n 0.28000 81120.0n 0.28000 81249.9n 0.28000 81250.0n 0.28000 81379.9n 0.28000 81380.0n 0.28000 81509.9n 0.28000 81510.0n 0.28000 81639.9n 0.28000 81640.0n 0.28000 81769.9n 0.28000 81770.0n 0.28000 81899.9n 0.28000 81900.0n 0.28000 82029.9n 0.28000 82030.0n 0.28000 82159.9n 0.28000 82160.0n 0.28000 82289.9n 0.28000 82290.0n 0.28000 82419.9n 0.28000 82420.0n 0.28000 82549.9n 0.28000 82550.0n 0.28000 82679.9n 0.28000 82680.0n 0.28000 82809.9n 0.28000 82810.0n 0.28000 82939.9n 0.28000 82940.0n 0.28000 83069.9n 0.28000 83070.0n 0.28000 83199.9n 0.28000 83200.0n 0.28000 83329.9n 0.28000 83330.0n 0.28000 83459.9n 0.28000 83460.0n 0.28000 83589.9n 0.28000 83590.0n 0.28000 83719.9n 0.28000 83720.0n 0.28000 83849.9n 0.28000 83850.0n 0.28000 83979.9n 0.28000 83980.0n 0.28000 84109.9n 0.28000 84110.0n 0.28000 84239.9n 0.28000 84240.0n 0.31000 84369.9n 0.31000 84370.0n 0.25000 84499.9n 0.25000 84500.0n 0.25000 84629.9n 0.25000 84630.0n 0.25000 84759.9n 0.25000 84760.0n 0.25000 84889.9n 0.25000 84890.0n 0.25000 85019.9n 0.25000 85020.0n 0.31000 85149.9n 0.31000 85150.0n 0.31000 85279.9n 0.31000 85280.0n 0.31000 85409.9n 0.31000 85410.0n 0.25000 85539.9n 0.25000 85540.0n 0.31000 85669.9n 0.31000 85670.0n 0.31000 85799.9n 0.31000 85800.0n 0.31000 85929.9n 0.31000 85930.0n 0.31000 86059.9n 0.31000 86060.0n 0.25000 86189.9n 0.25000 86190.0n 0.31000 86319.9n 0.31000 86320.0n 0.25000 86449.9n 0.25000 86450.0n 0.31000 86579.9n 0.31000 86580.0n 0.25000 86709.9n 0.25000 86710.0n 0.25000 86839.9n 0.25000 86840.0n 0.25000 86969.9n 0.25000 86970.0n 0.31000 87099.9n 0.31000 87100.0n 0.25000 87229.9n 0.25000 87230.0n 0.25000 87359.9n 0.25000 87360.0n 0.31000 87489.9n 0.31000 87490.0n 0.31000 87619.9n 0.31000 87620.0n 0.31000 87749.9n 0.31000 87750.0n 0.25000 87879.9n 0.25000 87880.0n 0.31000 88009.9n 0.31000 88010.0n 0.25000 88139.9n 0.25000 88140.0n 0.31000 88269.9n 0.31000 88270.0n 0.31000 88399.9n 0.31000 88400.0n 0.25000 88529.9n 0.25000 88530.0n 0.31000 88659.9n 0.31000 88660.0n 0.31000 88789.9n 0.31000 88790.0n 0.25000 88919.9n 0.25000 88920.0n 0.25000 89049.9n 0.25000 89050.0n 0.25000 89179.9n 0.25000 89180.0n 0.31000 89309.9n 0.31000 89310.0n 0.31000 89439.9n 0.31000 89440.0n 0.31000 89569.9n 0.31000 89570.0n 0.31000 89699.9n 0.31000 89700.0n 0.31000 89829.9n 0.31000 89830.0n 0.31000 89959.9n 0.31000 89960.0n 0.25000 90089.9n 0.25000 90090.0n 0.25000 90219.9n 0.25000 90220.0n 0.25000 90349.9n 0.25000 90350.0n 0.25000 90479.9n 0.25000 90480.0n 0.25000 90609.9n 0.25000 90610.0n 0.25000 90739.9n 0.25000 90740.0n 0.25000 90869.9n 0.25000 90870.0n 0.31000 90999.9n 0.31000 91000.0n 0.31000 91129.9n 0.31000 91130.0n 0.25000 91259.9n 0.25000 91260.0n 0.31000 91389.9n 0.31000 91390.0n 0.25000 91519.9n 0.25000 91520.0n 0.31000 91649.9n 0.31000 91650.0n 0.25000 91779.9n 0.25000 91780.0n 0.25000 91909.9n 0.25000 91910.0n 0.25000 92039.9n 0.25000 92040.0n 0.31000 92169.9n 0.31000 92170.0n 0.25000 92299.9n 0.25000 92300.0n 0.31000 92429.9n 0.31000 92430.0n 0.31000 92559.9n 0.31000 92560.0n 0.31000 92689.9n 0.31000 92690.0n 0.25000 92819.9n 0.25000 92820.0n 0.25000 92949.9n 0.25000 92950.0n 0.25000 93079.9n 0.25000 93080.0n 0.31000 93209.9n 0.31000 93210.0n 0.31000 93339.9n 0.31000 93340.0n 0.25000 93469.9n 0.25000 93470.0n 0.31000 93599.9n 0.31000 93600.0n 0.31000 93729.9n 0.31000 93730.0n 0.31000 93859.9n 0.31000 93860.0n 0.25000 93989.9n 0.25000 93990.0n 0.25000 94119.9n 0.25000 94120.0n 0.31000 94249.9n 0.31000 94250.0n 0.31000 94379.9n 0.31000 94380.0n 0.31000 94509.9n 0.31000 94510.0n 0.25000 94639.9n 0.25000 94640.0n 0.25000 94769.9n 0.25000 94770.0n 0.25000 94899.9n 0.25000 94900.0n 0.25000 95029.9n 0.25000 95030.0n 0.31000 95159.9n 0.31000 95160.0n 0.31000 95289.9n 0.31000 95290.0n 0.25000 95419.9n 0.25000 95420.0n 0.25000 95549.9n 0.25000 95550.0n 0.31000 95679.9n 0.31000 95680.0n 0.25000 95809.9n 0.25000 95810.0n 0.31000 95939.9n 0.31000 95940.0n 0.31000 96069.9n 0.31000 96070.0n 0.31000 96199.9n 0.31000 96200.0n 0.31000 96329.9n 0.31000 96330.0n 0.31000 96459.9n 0.31000 96460.0n 0.25000 96589.9n 0.25000 96590.0n 0.31000 96719.9n 0.31000 96720.0n 0.31000 96849.9n 0.31000 96850.0n 0.25000 96979.9n 0.25000 96980.0n 0.25000 97109.9n 0.25000 97110.0n 0.25000 97239.9n 0.25000 97240.0n 0.25000 97369.9n 0.25000 97370.0n 0.31000 97499.9n 0.31000 97500.0n 0.25000 97629.9n 0.25000 97630.0n 0.31000 97759.9n 0.31000 97760.0n 0.25000 97889.9n 0.25000 97890.0n 0.25000 98019.9n 0.25000 98020.0n 0.25000 98149.9n 0.25000 98150.0n 0.25000 98279.9n 0.25000 98280.0n 0.25000 98409.9n 0.25000 98410.0n 0.31000 98539.9n 0.31000 98540.0n 0.31000 98669.9n 0.31000 98670.0n 0.31000 98799.9n 0.31000 98800.0n 0.31000 98929.9n 0.31000 98930.0n 0.25000 99059.9n 0.25000 99060.0n 0.25000 99189.9n 0.25000 99190.0n 0.31000 99319.9n 0.31000 99320.0n 0.25000 99449.9n 0.25000 99450.0n 0.31000 99579.9n 0.31000 99580.0n 0.31000 99709.9n 0.31000 99710.0n 0.25000 99839.9n 0.25000 99840.0n 0.25000 99969.9n 0.25000 99970.0n 0.25000 100099.9n 0.25000 100100.0n 0.25000 100229.9n 0.25000 100230.0n 0.25000 100359.9n 0.25000 100360.0n 0.25000 100489.9n 0.25000 100490.0n 0.31000 100619.9n 0.31000 100620.0n 0.25000 100749.9n 0.25000 100750.0n 0.31000 100879.9n 0.31000 100880.0n 0.25000 101009.9n 0.25000 101010.0n 0.31000 101139.9n 0.31000 101140.0n 0.31000 101269.9n 0.31000 101270.0n 0.31000 101399.9n 0.31000 101400.0n 0.31000 101529.9n 0.31000 101530.0n 0.31000 101659.9n 0.31000 101660.0n 0.25000 101789.9n 0.25000 101790.0n 0.31000 101919.9n 0.31000 101920.0n 0.25000 102049.9n 0.25000 102050.0n 0.31000 102179.9n 0.31000 102180.0n 0.25000 102309.9n 0.25000 102310.0n 0.31000 102439.9n 0.31000 102440.0n 0.25000 102569.9n 0.25000 102570.0n 0.25000 102699.9n 0.25000 102700.0n 0.31000 102829.9n 0.31000 102830.0n 0.31000 102959.9n 0.31000 102960.0n 0.31000 103089.9n 0.31000 103090.0n 0.25000 103219.9n 0.25000 103220.0n 0.25000 103349.9n 0.25000 103350.0n 0.31000 103479.9n 0.31000 103480.0n 0.31000 103609.9n 0.31000 103610.0n 0.31000 103739.9n 0.31000 103740.0n 0.25000 103869.9n 0.25000 103870.0n 0.25000 103999.9n 0.25000 104000.0n 0.25000 104129.9n 0.25000 104130.0n 0.31000 104259.9n 0.31000 104260.0n 0.25000 104389.9n 0.25000 104390.0n 0.25000 104519.9n 0.25000 104520.0n 0.25000 104649.9n 0.25000 104650.0n 0.31000 104779.9n 0.31000 104780.0n 0.25000 104909.9n 0.25000 104910.0n 0.31000 105039.9n 0.31000 105040.0n 0.31000 105169.9n 0.31000 105170.0n 0.31000 105299.9n 0.31000 105300.0n 0.31000 105429.9n 0.31000 105430.0n 0.31000 105559.9n 0.31000 105560.0n 0.25000 105689.9n 0.25000 105690.0n 0.25000 105819.9n 0.25000 105820.0n 0.25000 105949.9n 0.25000 105950.0n 0.31000 106079.9n 0.31000 106080.0n 0.28000 106209.9n 0.28000 106210.0n 0.28000 106339.9n 0.28000 106340.0n 0.28000 106469.9n 0.28000 106470.0n 0.28000 106599.9n 0.28000 106600.0n 0.28000 106729.9n 0.28000 106730.0n 0.28000 106859.9n 0.28000 106860.0n 0.28000 106989.9n 0.28000 106990.0n 0.28000 107119.9n 0.28000 107120.0n 0.28000 107249.9n 0.28000 107250.0n 0.28000 107379.9n 0.28000 107380.0n 0.28000 107509.9n 0.28000 107510.0n 0.28000 107639.9n 0.28000 107640.0n 0.28000 107769.9n 0.28000 107770.0n 0.28000 107899.9n 0.28000 107900.0n 0.28000 108029.9n 0.28000 108030.0n 0.28000 108159.9n 0.28000 108160.0n 0.28000 108289.9n 0.28000 108290.0n 0.28000 108419.9n 0.28000 108420.0n 0.28000 108549.9n 0.28000 108550.0n 0.28000 108679.9n 0.28000 108680.0n 0.28000 108809.9n 0.28000 108810.0n 0.28000 108939.9n 0.28000 108940.0n 0.28000 109069.9n 0.28000 109070.0n 0.28000 109199.9n 0.28000 109200.0n 0.28000 109329.9n 0.28000 109330.0n 0.28000 109459.9n 0.28000 109460.0n 0.28000 109589.9n 0.28000 109590.0n 0.28000 109719.9n 0.28000 109720.0n 0.28000 109849.9n 0.28000 109850.0n 0.28000 109979.9n 0.28000 109980.0n 0.28000 110109.9n 0.28000 110110.0n 0.28000 110239.9n 0.28000 110240.0n 0.28000 110369.9n 0.28000 110370.0n 0.28000 110499.9n 0.28000 110500.0n 0.28000 110629.9n 0.28000 110630.0n 0.28000 110759.9n 0.28000 110760.0n 0.28000 110889.9n 0.28000 110890.0n 0.28000 111019.9n 0.28000 111020.0n 0.28000 111149.9n 0.28000 111150.0n 0.28000 111279.9n 0.28000 111280.0n 0.28000 111409.9n 0.28000 111410.0n 0.28000 111539.9n 0.28000 111540.0n 0.28000 111669.9n 0.28000 111670.0n 0.28000 111799.9n 0.28000 111800.0n 0.28000 111929.9n 0.28000 111930.0n 0.28000 112059.9n 0.28000 112060.0n 0.28000 112189.9n 0.28000 112190.0n 0.28000 112319.9n 0.28000 112320.0n 0.31000 112449.9n 0.31000 112450.0n 0.25000 112579.9n 0.25000 112580.0n 0.31000 112709.9n 0.31000 112710.0n 0.25000 112839.9n 0.25000 112840.0n 0.25000 112969.9n 0.25000 112970.0n 0.25000 113099.9n 0.25000 113100.0n 0.25000 113229.9n 0.25000 113230.0n 0.31000 113359.9n 0.31000 113360.0n 0.25000 113489.9n 0.25000 113490.0n 0.25000 113619.9n 0.25000 113620.0n 0.25000 113749.9n 0.25000 113750.0n 0.31000 113879.9n 0.31000 113880.0n 0.31000 114009.9n 0.31000 114010.0n 0.25000 114139.9n 0.25000 114140.0n 0.25000 114269.9n 0.25000 114270.0n 0.31000 114399.9n 0.31000 114400.0n 0.25000 114529.9n 0.25000 114530.0n 0.25000 114659.9n 0.25000 114660.0n 0.25000 114789.9n 0.25000 114790.0n 0.31000 114919.9n 0.31000 114920.0n 0.31000 115049.9n 0.31000 115050.0n 0.31000 115179.9n 0.31000 115180.0n 0.31000 115309.9n 0.31000 115310.0n 0.31000 115439.9n 0.31000 115440.0n 0.31000 115569.9n 0.31000 115570.0n 0.31000 115699.9n 0.31000 115700.0n 0.31000 115829.9n 0.31000 115830.0n 0.25000 115959.9n 0.25000 115960.0n 0.31000 116089.9n 0.31000 116090.0n 0.25000 116219.9n 0.25000 116220.0n 0.31000 116349.9n 0.31000 116350.0n 0.31000 116479.9n 0.31000 116480.0n 0.31000 116609.9n 0.31000 116610.0n 0.25000 116739.9n 0.25000 116740.0n 0.31000 116869.9n 0.31000 116870.0n 0.25000 116999.9n 0.25000 117000.0n 0.31000 117129.9n 0.31000 117130.0n 0.25000 117259.9n 0.25000 117260.0n 0.31000 117389.9n 0.31000 117390.0n 0.31000 117519.9n 0.31000 117520.0n 0.31000 117649.9n 0.31000 117650.0n 0.25000 117779.9n 0.25000 117780.0n 0.31000 117909.9n 0.31000 117910.0n 0.31000 118039.9n 0.31000 118040.0n 0.25000 118169.9n 0.25000 118170.0n 0.25000 118299.9n 0.25000 118300.0n 0.25000 118429.9n 0.25000 118430.0n 0.25000 118559.9n 0.25000 118560.0n 0.25000 118689.9n 0.25000 118690.0n 0.25000 118819.9n 0.25000 118820.0n 0.25000 118949.9n 0.25000 118950.0n 0.25000 119079.9n 0.25000 119080.0n 0.31000 119209.9n 0.31000 119210.0n 0.25000 119339.9n 0.25000 119340.0n 0.31000 119469.9n 0.31000 119470.0n 0.31000 119599.9n 0.31000 119600.0n 0.25000 119729.9n 0.25000 119730.0n 0.31000 119859.9n 0.31000 119860.0n 0.31000 119989.9n 0.31000 119990.0n 0.31000 120119.9n 0.31000 120120.0n 0.25000 120249.9n 0.25000 120250.0n 0.25000 120379.9n 0.25000 120380.0n 0.31000 120509.9n 0.31000 120510.0n 0.31000 120639.9n 0.31000 120640.0n 0.25000 120769.9n 0.25000 120770.0n 0.25000 120899.9n 0.25000 120900.0n 0.25000 121029.9n 0.25000 121030.0n 0.31000 121159.9n 0.31000 121160.0n 0.25000 121289.9n 0.25000 121290.0n 0.25000 121419.9n 0.25000 121420.0n 0.31000 121549.9n 0.31000 121550.0n 0.31000 121679.9n 0.31000 121680.0n 0.25000 121809.9n 0.25000 121810.0n 0.31000 121939.9n 0.31000 121940.0n 0.31000 122069.9n 0.31000 122070.0n 0.31000 122199.9n 0.31000 122200.0n 0.25000 122329.9n 0.25000 122330.0n 0.25000 122459.9n 0.25000 122460.0n 0.25000 122589.9n 0.25000 122590.0n 0.31000 122719.9n 0.31000 122720.0n 0.31000 122849.9n 0.31000 122850.0n 0.25000 122979.9n 0.25000 122980.0n 0.31000 123109.9n 0.31000 123110.0n 0.25000 123239.9n 0.25000 123240.0n 0.31000 123369.9n 0.31000 123370.0n 0.25000 123499.9n 0.25000 123500.0n 0.31000 123629.9n 0.31000 123630.0n 0.25000 123759.9n 0.25000 123760.0n 0.31000 123889.9n 0.31000 123890.0n 0.25000 124019.9n 0.25000 124020.0n 0.31000 124149.9n 0.31000 124150.0n 0.31000 124279.9n 0.31000 124280.0n 0.25000 124409.9n 0.25000 124410.0n 0.25000 124539.9n 0.25000 124540.0n 0.25000 124669.9n 0.25000 124670.0n 0.31000 124799.9n 0.31000 124800.0n 0.25000 124929.9n 0.25000 124930.0n 0.31000 125059.9n 0.31000 125060.0n 0.31000 125189.9n 0.31000 125190.0n 0.31000 125319.9n 0.31000 125320.0n 0.31000 125449.9n 0.31000 125450.0n 0.25000 125579.9n 0.25000 125580.0n 0.25000 125709.9n 0.25000 125710.0n 0.25000 125839.9n 0.25000 125840.0n 0.25000 125969.9n 0.25000 125970.0n 0.31000 126099.9n 0.31000 126100.0n 0.31000 126229.9n 0.31000 126230.0n 0.25000 126359.9n 0.25000 126360.0n 0.31000 126489.9n 0.31000 126490.0n 0.31000 126619.9n 0.31000 126620.0n 0.25000 126749.9n 0.25000 126750.0n 0.25000 126879.9n 0.25000 126880.0n 0.31000 127009.9n 0.31000 127010.0n 0.31000 127139.9n 0.31000 127140.0n 0.31000 127269.9n 0.31000 127270.0n 0.25000 127399.9n 0.25000 127400.0n 0.25000 127529.9n 0.25000 127530.0n 0.25000 127659.9n 0.25000 127660.0n 0.31000 127789.9n 0.31000 127790.0n 0.31000 127919.9n 0.31000 127920.0n 0.25000 128049.9n 0.25000 128050.0n 0.25000 128179.9n 0.25000 128180.0n 0.31000 128309.9n 0.31000 128310.0n 0.25000 128439.9n 0.25000 128440.0n 0.25000 128569.9n 0.25000 128570.0n 0.25000 128699.9n 0.25000 128700.0n 0.31000 128829.9n 0.31000 128830.0n 0.31000 128959.9n 0.31000 128960.0n 0.25000 129089.9n 0.25000 129090.0n 0.31000 129219.9n 0.31000 129220.0n 0.25000 129349.9n 0.25000 129350.0n 0.31000 129479.9n 0.31000 129480.0n 0.31000 129609.9n 0.31000 129610.0n 0.25000 129739.9n 0.25000 129740.0n 0.25000 129869.9n 0.25000 129870.0n 0.25000 129999.9n 0.25000 130000.0n 0.31000 130129.9n 0.31000 130130.0n 0.31000 130259.9n 0.31000 130260.0n 0.25000 130389.9n 0.25000 130390.0n 0.31000 130519.9n 0.31000 130520.0n 0.25000 130649.9n 0.25000 130650.0n 0.25000 130779.9n 0.25000 130780.0n 0.25000 130909.9n 0.25000 130910.0n 0.31000 131039.9n 0.31000 131040.0n 0.25000 131169.9n 0.25000 131170.0n 0.25000 131299.9n 0.25000 131300.0n 0.31000 131429.9n 0.31000 131430.0n 0.31000 131559.9n 0.31000 131560.0n 0.25000 131689.9n 0.25000 131690.0n 0.25000 131819.9n 0.25000 131820.0n 0.25000 131949.9n 0.25000 131950.0n 0.31000 132079.9n 0.31000 132080.0n 0.25000 132209.9n 0.25000 132210.0n 0.31000 132339.9n 0.31000 132340.0n 0.31000 132469.9n 0.31000 132470.0n 0.31000 132599.9n 0.31000 132600.0n 0.25000 132729.9n 0.25000 132730.0n 0.25000 132859.9n 0.25000 132860.0n 0.31000 132989.9n 0.31000 132990.0n 0.31000 133119.9n 0.31000 133120.0n 0.31000 133249.9n 0.31000 133250.0n 0.31000 133379.9n 0.31000 133380.0n 0.31000 133509.9n 0.31000 133510.0n 0.31000 133639.9n 0.31000 133640.0n 0.25000 133769.9n 0.25000 133770.0n 0.31000 133899.9n 0.31000 133900.0n 0.25000 134029.9n 0.25000 134030.0n 0.25000 134159.9n 0.25000 134160.0n 0.28000 134289.9n 0.28000 134290.0n 0.28000 134419.9n 0.28000 134420.0n 0.28000 134549.9n 0.28000 134550.0n 0.28000 134679.9n 0.28000 134680.0n 0.28000 134809.9n 0.28000 134810.0n 0.28000 134939.9n 0.28000 134940.0n 0.28000 135069.9n 0.28000 135070.0n 0.28000 135199.9n 0.28000 135200.0n 0.28000 135329.9n 0.28000 135330.0n 0.28000 135459.9n 0.28000 135460.0n 0.28000 135589.9n 0.28000 135590.0n 0.28000 135719.9n 0.28000 135720.0n 0.28000 135849.9n 0.28000 135850.0n 0.28000 135979.9n 0.28000 135980.0n 0.28000 136109.9n 0.28000 136110.0n 0.28000 136239.9n 0.28000 136240.0n 0.28000 136369.9n 0.28000 136370.0n 0.28000 136499.9n 0.28000 136500.0n 0.28000 136629.9n 0.28000 136630.0n 0.28000 136759.9n 0.28000 136760.0n 0.28000 136889.9n 0.28000 136890.0n 0.28000 137019.9n 0.28000 137020.0n 0.28000 137149.9n 0.28000 137150.0n 0.28000 137279.9n 0.28000 137280.0n 0.28000 137409.9n 0.28000 137410.0n 0.28000 137539.9n 0.28000 137540.0n 0.28000 137669.9n 0.28000 137670.0n 0.28000 137799.9n 0.28000 137800.0n 0.28000 137929.9n 0.28000 137930.0n 0.28000 138059.9n 0.28000 138060.0n 0.28000 138189.9n 0.28000 138190.0n 0.28000 138319.9n 0.28000 138320.0n 0.28000 138449.9n 0.28000 138450.0n 0.28000 138579.9n 0.28000 138580.0n 0.28000 138709.9n 0.28000 138710.0n 0.28000 138839.9n 0.28000 138840.0n 0.28000 138969.9n 0.28000 138970.0n 0.28000 139099.9n 0.28000 139100.0n 0.28000 139229.9n 0.28000 139230.0n 0.28000 139359.9n 0.28000 139360.0n 0.28000 139489.9n 0.28000 139490.0n 0.28000 139619.9n 0.28000 139620.0n 0.28000 139749.9n 0.28000 139750.0n 0.28000 139879.9n 0.28000 139880.0n 0.28000 140009.9n 0.28000 140010.0n 0.28000 140139.9n 0.28000 140140.0n 0.28000 140269.9n 0.28000 140270.0n 0.28000 140399.9n 0.28000 140400.0n 0.25000 140529.9n 0.25000 140530.0n 0.31000 140659.9n 0.31000 140660.0n 0.25000 140789.9n 0.25000 140790.0n 0.25000 140919.9n 0.25000 140920.0n 0.31000 141049.9n 0.31000 141050.0n 0.25000 141179.9n 0.25000 141180.0n 0.31000 141309.9n 0.31000 141310.0n 0.25000 141439.9n 0.25000 141440.0n 0.25000 141569.9n 0.25000 141570.0n 0.25000 141699.9n 0.25000 141700.0n 0.25000 141829.9n 0.25000 141830.0n 0.31000 141959.9n 0.31000 141960.0n 0.31000 142089.9n 0.31000 142090.0n 0.31000 142219.9n 0.31000 142220.0n 0.31000 142349.9n 0.31000 142350.0n 0.31000 142479.9n 0.31000 142480.0n 0.31000 142609.9n 0.31000 142610.0n 0.25000 142739.9n 0.25000 142740.0n 0.25000 142869.9n 0.25000 142870.0n 0.31000 142999.9n 0.31000 143000.0n 0.25000 143129.9n 0.25000 143130.0n 0.25000 143259.9n 0.25000 143260.0n 0.31000 143389.9n 0.31000 143390.0n 0.31000 143519.9n 0.31000 143520.0n 0.31000 143649.9n 0.31000 143650.0n 0.31000 143779.9n 0.31000 143780.0n 0.25000 143909.9n 0.25000 143910.0n 0.25000 144039.9n 0.25000 144040.0n 0.31000 144169.9n 0.31000 144170.0n 0.31000 144299.9n 0.31000 144300.0n 0.31000 144429.9n 0.31000 144430.0n 0.25000 144559.9n 0.25000 144560.0n 0.25000 144689.9n 0.25000 144690.0n 0.31000 144819.9n 0.31000 144820.0n 0.31000 144949.9n 0.31000 144950.0n 0.25000 145079.9n 0.25000 145080.0n 0.31000 145209.9n 0.31000 145210.0n 0.25000 145339.9n 0.25000 145340.0n 0.25000 145469.9n 0.25000 145470.0n 0.25000 145599.9n 0.25000 145600.0n 0.31000 145729.9n 0.31000 145730.0n 0.25000 145859.9n 0.25000 145860.0n 0.31000 145989.9n 0.31000 145990.0n 0.31000 146119.9n 0.31000 146120.0n 0.25000 146249.9n 0.25000 146250.0n 0.25000 146379.9n 0.25000 146380.0n 0.31000 146509.9n 0.31000 146510.0n 0.25000 146639.9n 0.25000 146640.0n 0.31000 146769.9n 0.31000 146770.0n 0.25000 146899.9n 0.25000 146900.0n 0.31000 147029.9n 0.31000 147030.0n 0.31000 147159.9n 0.31000 147160.0n 0.31000 147289.9n 0.31000 147290.0n 0.25000 147419.9n 0.25000 147420.0n 0.25000 147549.9n 0.25000 147550.0n 0.25000 147679.9n 0.25000 147680.0n 0.25000 147809.9n 0.25000 147810.0n 0.25000 147939.9n 0.25000 147940.0n 0.31000 148069.9n 0.31000 148070.0n 0.31000 148199.9n 0.31000 148200.0n 0.25000 148329.9n 0.25000 148330.0n 0.25000 148459.9n 0.25000 148460.0n 0.31000 148589.9n 0.31000 148590.0n 0.31000 148719.9n 0.31000 148720.0n 0.25000 148849.9n 0.25000 148850.0n 0.31000 148979.9n 0.31000 148980.0n 0.31000 149109.9n 0.31000 149110.0n 0.25000 149239.9n 0.25000 149240.0n 0.31000 149369.9n 0.31000 149370.0n 0.25000 149499.9n 0.25000 149500.0n 0.25000 149629.9n 0.25000 149630.0n 0.25000 149759.9n 0.25000 149760.0n 0.31000 149889.9n 0.31000 149890.0n 0.31000 150019.9n 0.31000 150020.0n 0.31000 150149.9n 0.31000 150150.0n 0.31000 150279.9n 0.31000 150280.0n 0.31000 150409.9n 0.31000 150410.0n 0.25000 150539.9n 0.25000 150540.0n 0.25000 150669.9n 0.25000 150670.0n 0.25000 150799.9n 0.25000 150800.0n 0.25000 150929.9n 0.25000 150930.0n 0.31000 151059.9n 0.31000 151060.0n 0.31000 151189.9n 0.31000 151190.0n 0.25000 151319.9n 0.25000 151320.0n 0.31000 151449.9n 0.31000 151450.0n 0.25000 151579.9n 0.25000 151580.0n 0.25000 151709.9n 0.25000 151710.0n 0.25000 151839.9n 0.25000 151840.0n 0.31000 151969.9n 0.31000 151970.0n 0.25000 152099.9n 0.25000 152100.0n 0.31000 152229.9n 0.31000 152230.0n 0.25000 152359.9n 0.25000 152360.0n 0.31000 152489.9n 0.31000 152490.0n 0.31000 152619.9n 0.31000 152620.0n 0.31000 152749.9n 0.31000 152750.0n 0.31000 152879.9n 0.31000 152880.0n 0.31000 153009.9n 0.31000 153010.0n 0.25000 153139.9n 0.25000 153140.0n 0.31000 153269.9n 0.31000 153270.0n 0.25000 153399.9n 0.25000 153400.0n 0.31000 153529.9n 0.31000 153530.0n 0.25000 153659.9n 0.25000 153660.0n 0.31000 153789.9n 0.31000 153790.0n 0.31000 153919.9n 0.31000 153920.0n 0.25000 154049.9n 0.25000 154050.0n 0.25000 154179.9n 0.25000 154180.0n 0.25000 154309.9n 0.25000 154310.0n 0.31000 154439.9n 0.31000 154440.0n 0.25000 154569.9n 0.25000 154570.0n 0.25000 154699.9n 0.25000 154700.0n 0.31000 154829.9n 0.31000 154830.0n 0.25000 154959.9n 0.25000 154960.0n 0.25000 155089.9n 0.25000 155090.0n 0.25000 155219.9n 0.25000 155220.0n 0.31000 155349.9n 0.31000 155350.0n 0.31000 155479.9n 0.31000 155480.0n 0.31000 155609.9n 0.31000 155610.0n 0.31000 155739.9n 0.31000 155740.0n 0.25000 155869.9n 0.25000 155870.0n 0.25000 155999.9n 0.25000 156000.0n 0.25000 156129.9n 0.25000 156130.0n 0.31000 156259.9n 0.31000 156260.0n 0.25000 156389.9n 0.25000 156390.0n 0.25000 156519.9n 0.25000 156520.0n 0.25000 156649.9n 0.25000 156650.0n 0.25000 156779.9n 0.25000 156780.0n 0.25000 156909.9n 0.25000 156910.0n 0.31000 157039.9n 0.31000 157040.0n 0.31000 157169.9n 0.31000 157170.0n 0.31000 157299.9n 0.31000 157300.0n 0.31000 157429.9n 0.31000 157430.0n 0.31000 157559.9n 0.31000 157560.0n 0.25000 157689.9n 0.25000 157690.0n 0.31000 157819.9n 0.31000 157820.0n 0.25000 157949.9n 0.25000 157950.0n 0.25000 158079.9n 0.25000 158080.0n 0.31000 158209.9n 0.31000 158210.0n 0.25000 158339.9n 0.25000 158340.0n 0.31000 158469.9n 0.31000 158470.0n 0.31000 158599.9n 0.31000 158600.0n 0.25000 158729.9n 0.25000 158730.0n 0.25000 158859.9n 0.25000 158860.0n 0.31000 158989.9n 0.31000 158990.0n 0.25000 159119.9n 0.25000 159120.0n 0.31000 159249.9n 0.31000 159250.0n 0.25000 159379.9n 0.25000 159380.0n 0.25000 159509.9n 0.25000 159510.0n 0.31000 159639.9n 0.31000 159640.0n 0.31000 159769.9n 0.31000 159770.0n 0.31000 159899.9n 0.31000 159900.0n 0.25000 160029.9n 0.25000 160030.0n 0.31000 160159.9n 0.31000 160160.0n 0.31000 160289.9n 0.31000 160290.0n 0.25000 160419.9n 0.25000 160420.0n 0.25000 160549.9n 0.25000 160550.0n 0.25000 160679.9n 0.25000 160680.0n 0.25000 160809.9n 0.25000 160810.0n 0.31000 160939.9n 0.31000 160940.0n 0.25000 161069.9n 0.25000 161070.0n 0.31000 161199.9n 0.31000 161200.0n 0.31000 161329.9n 0.31000 161330.0n 0.31000 161459.9n 0.31000 161460.0n 0.25000 161589.9n 0.25000 161590.0n 0.31000 161719.9n 0.31000 161720.0n 0.25000 161849.9n 0.25000 161850.0n 0.31000 161979.9n 0.31000 161980.0n 0.25000 162109.9n 0.25000 162110.0n 0.31000 162239.9n 0.31000 162240.0n 0.28000 162369.9n 0.28000 162370.0n 0.28000 162499.9n 0.28000 162500.0n 0.28000 162629.9n 0.28000 162630.0n 0.28000 162759.9n 0.28000 162760.0n 0.28000 162889.9n 0.28000 162890.0n 0.28000 163019.9n 0.28000 163020.0n 0.28000 163149.9n 0.28000 163150.0n 0.28000 163279.9n 0.28000 163280.0n 0.28000 163409.9n 0.28000 163410.0n 0.28000 163539.9n 0.28000 163540.0n 0.28000 163669.9n 0.28000 163670.0n 0.28000 163799.9n 0.28000 163800.0n 0.28000 163929.9n 0.28000 163930.0n 0.28000 164059.9n 0.28000 164060.0n 0.28000 164189.9n 0.28000 164190.0n 0.28000 164319.9n 0.28000 164320.0n 0.28000 164449.9n 0.28000 164450.0n 0.28000 164579.9n 0.28000 164580.0n 0.28000 164709.9n 0.28000 164710.0n 0.28000 164839.9n 0.28000 164840.0n 0.28000 164969.9n 0.28000 164970.0n 0.28000 165099.9n 0.28000 165100.0n 0.28000 165229.9n 0.28000 165230.0n 0.28000 165359.9n 0.28000 165360.0n 0.28000 165489.9n 0.28000 165490.0n 0.28000 165619.9n 0.28000 165620.0n 0.28000 165749.9n 0.28000 165750.0n 0.28000 165879.9n 0.28000 165880.0n 0.28000 166009.9n 0.28000 166010.0n 0.28000 166139.9n 0.28000 166140.0n 0.28000 166269.9n 0.28000 166270.0n 0.28000 166399.9n 0.28000 166400.0n 0.28000 166529.9n 0.28000 166530.0n 0.28000 166659.9n 0.28000 166660.0n 0.28000 166789.9n 0.28000 166790.0n 0.28000 166919.9n 0.28000 166920.0n 0.28000 167049.9n 0.28000 167050.0n 0.28000 167179.9n 0.28000 167180.0n 0.28000 167309.9n 0.28000 167310.0n 0.28000 167439.9n 0.28000 167440.0n 0.28000 167569.9n 0.28000 167570.0n 0.28000 167699.9n 0.28000 167700.0n 0.28000 167829.9n 0.28000 167830.0n 0.28000 167959.9n 0.28000 167960.0n 0.28000 168089.9n 0.28000 168090.0n 0.28000 168219.9n 0.28000 168220.0n 0.28000 168349.9n 0.28000 168350.0n 0.28000)
Vxon1 xon1 0 PWL(0.0n 0.31000 129.9n 0.31000 130.0n 0.25000 259.9n 0.25000 260.0n 0.31000 389.9n 0.31000 390.0n 0.25000 519.9n 0.25000 520.0n 0.25000 649.9n 0.25000 650.0n 0.31000 779.9n 0.31000 780.0n 0.31000 909.9n 0.31000 910.0n 0.31000 1039.9n 0.31000 1040.0n 0.31000 1169.9n 0.31000 1170.0n 0.25000 1299.9n 0.25000 1300.0n 0.31000 1429.9n 0.31000 1430.0n 0.25000 1559.9n 0.25000 1560.0n 0.25000 1689.9n 0.25000 1690.0n 0.31000 1819.9n 0.31000 1820.0n 0.31000 1949.9n 0.31000 1950.0n 0.25000 2079.9n 0.25000 2080.0n 0.25000 2209.9n 0.25000 2210.0n 0.31000 2339.9n 0.31000 2340.0n 0.31000 2469.9n 0.31000 2470.0n 0.25000 2599.9n 0.25000 2600.0n 0.25000 2729.9n 0.25000 2730.0n 0.25000 2859.9n 0.25000 2860.0n 0.31000 2989.9n 0.31000 2990.0n 0.31000 3119.9n 0.31000 3120.0n 0.31000 3249.9n 0.31000 3250.0n 0.25000 3379.9n 0.25000 3380.0n 0.25000 3509.9n 0.25000 3510.0n 0.25000 3639.9n 0.25000 3640.0n 0.25000 3769.9n 0.25000 3770.0n 0.31000 3899.9n 0.31000 3900.0n 0.25000 4029.9n 0.25000 4030.0n 0.25000 4159.9n 0.25000 4160.0n 0.25000 4289.9n 0.25000 4290.0n 0.31000 4419.9n 0.31000 4420.0n 0.31000 4549.9n 0.31000 4550.0n 0.25000 4679.9n 0.25000 4680.0n 0.31000 4809.9n 0.31000 4810.0n 0.31000 4939.9n 0.31000 4940.0n 0.25000 5069.9n 0.25000 5070.0n 0.31000 5199.9n 0.31000 5200.0n 0.31000 5329.9n 0.31000 5330.0n 0.31000 5459.9n 0.31000 5460.0n 0.25000 5589.9n 0.25000 5590.0n 0.25000 5719.9n 0.25000 5720.0n 0.31000 5849.9n 0.31000 5850.0n 0.25000 5979.9n 0.25000 5980.0n 0.25000 6109.9n 0.25000 6110.0n 0.31000 6239.9n 0.31000 6240.0n 0.25000 6369.9n 0.25000 6370.0n 0.31000 6499.9n 0.31000 6500.0n 0.25000 6629.9n 0.25000 6630.0n 0.31000 6759.9n 0.31000 6760.0n 0.25000 6889.9n 0.25000 6890.0n 0.31000 7019.9n 0.31000 7020.0n 0.25000 7149.9n 0.25000 7150.0n 0.31000 7279.9n 0.31000 7280.0n 0.25000 7409.9n 0.25000 7410.0n 0.25000 7539.9n 0.25000 7540.0n 0.25000 7669.9n 0.25000 7670.0n 0.31000 7799.9n 0.31000 7800.0n 0.25000 7929.9n 0.25000 7930.0n 0.25000 8059.9n 0.25000 8060.0n 0.25000 8189.9n 0.25000 8190.0n 0.25000 8319.9n 0.25000 8320.0n 0.31000 8449.9n 0.31000 8450.0n 0.25000 8579.9n 0.25000 8580.0n 0.31000 8709.9n 0.31000 8710.0n 0.31000 8839.9n 0.31000 8840.0n 0.31000 8969.9n 0.31000 8970.0n 0.25000 9099.9n 0.25000 9100.0n 0.31000 9229.9n 0.31000 9230.0n 0.25000 9359.9n 0.25000 9360.0n 0.25000 9489.9n 0.25000 9490.0n 0.25000 9619.9n 0.25000 9620.0n 0.31000 9749.9n 0.31000 9750.0n 0.31000 9879.9n 0.31000 9880.0n 0.31000 10009.9n 0.31000 10010.0n 0.31000 10139.9n 0.31000 10140.0n 0.25000 10269.9n 0.25000 10270.0n 0.31000 10399.9n 0.31000 10400.0n 0.31000 10529.9n 0.31000 10530.0n 0.31000 10659.9n 0.31000 10660.0n 0.25000 10789.9n 0.25000 10790.0n 0.31000 10919.9n 0.31000 10920.0n 0.31000 11049.9n 0.31000 11050.0n 0.25000 11179.9n 0.25000 11180.0n 0.25000 11309.9n 0.25000 11310.0n 0.31000 11439.9n 0.31000 11440.0n 0.31000 11569.9n 0.31000 11570.0n 0.31000 11699.9n 0.31000 11700.0n 0.31000 11829.9n 0.31000 11830.0n 0.25000 11959.9n 0.25000 11960.0n 0.31000 12089.9n 0.31000 12090.0n 0.25000 12219.9n 0.25000 12220.0n 0.31000 12349.9n 0.31000 12350.0n 0.31000 12479.9n 0.31000 12480.0n 0.25000 12609.9n 0.25000 12610.0n 0.31000 12739.9n 0.31000 12740.0n 0.31000 12869.9n 0.31000 12870.0n 0.31000 12999.9n 0.31000 13000.0n 0.25000 13129.9n 0.25000 13130.0n 0.25000 13259.9n 0.25000 13260.0n 0.25000 13389.9n 0.25000 13390.0n 0.31000 13519.9n 0.31000 13520.0n 0.25000 13649.9n 0.25000 13650.0n 0.31000 13779.9n 0.31000 13780.0n 0.25000 13909.9n 0.25000 13910.0n 0.25000 14039.9n 0.25000 14040.0n 0.31000 14169.9n 0.31000 14170.0n 0.25000 14299.9n 0.25000 14300.0n 0.25000 14429.9n 0.25000 14430.0n 0.25000 14559.9n 0.25000 14560.0n 0.25000 14689.9n 0.25000 14690.0n 0.31000 14819.9n 0.31000 14820.0n 0.25000 14949.9n 0.25000 14950.0n 0.31000 15079.9n 0.31000 15080.0n 0.25000 15209.9n 0.25000 15210.0n 0.25000 15339.9n 0.25000 15340.0n 0.25000 15469.9n 0.25000 15470.0n 0.25000 15599.9n 0.25000 15600.0n 0.25000 15729.9n 0.25000 15730.0n 0.31000 15859.9n 0.31000 15860.0n 0.25000 15989.9n 0.25000 15990.0n 0.31000 16119.9n 0.31000 16120.0n 0.25000 16249.9n 0.25000 16250.0n 0.25000 16379.9n 0.25000 16380.0n 0.31000 16509.9n 0.31000 16510.0n 0.31000 16639.9n 0.31000 16640.0n 0.31000 16769.9n 0.31000 16770.0n 0.25000 16899.9n 0.25000 16900.0n 0.25000 17029.9n 0.25000 17030.0n 0.31000 17159.9n 0.31000 17160.0n 0.31000 17289.9n 0.31000 17290.0n 0.31000 17419.9n 0.31000 17420.0n 0.31000 17549.9n 0.31000 17550.0n 0.25000 17679.9n 0.25000 17680.0n 0.31000 17809.9n 0.31000 17810.0n 0.31000 17939.9n 0.31000 17940.0n 0.25000 18069.9n 0.25000 18070.0n 0.31000 18199.9n 0.31000 18200.0n 0.31000 18329.9n 0.31000 18330.0n 0.25000 18459.9n 0.25000 18460.0n 0.31000 18589.9n 0.31000 18590.0n 0.31000 18719.9n 0.31000 18720.0n 0.31000 18849.9n 0.31000 18850.0n 0.31000 18979.9n 0.31000 18980.0n 0.25000 19109.9n 0.25000 19110.0n 0.25000 19239.9n 0.25000 19240.0n 0.25000 19369.9n 0.25000 19370.0n 0.31000 19499.9n 0.31000 19500.0n 0.31000 19629.9n 0.31000 19630.0n 0.25000 19759.9n 0.25000 19760.0n 0.25000 19889.9n 0.25000 19890.0n 0.31000 20019.9n 0.31000 20020.0n 0.25000 20149.9n 0.25000 20150.0n 0.25000 20279.9n 0.25000 20280.0n 0.31000 20409.9n 0.31000 20410.0n 0.25000 20539.9n 0.25000 20540.0n 0.31000 20669.9n 0.31000 20670.0n 0.25000 20799.9n 0.25000 20800.0n 0.25000 20929.9n 0.25000 20930.0n 0.25000 21059.9n 0.25000 21060.0n 0.31000 21189.9n 0.31000 21190.0n 0.25000 21319.9n 0.25000 21320.0n 0.31000 21449.9n 0.31000 21450.0n 0.31000 21579.9n 0.31000 21580.0n 0.25000 21709.9n 0.25000 21710.0n 0.31000 21839.9n 0.31000 21840.0n 0.28000 21969.9n 0.28000 21970.0n 0.28000 22099.9n 0.28000 22100.0n 0.28000 22229.9n 0.28000 22230.0n 0.28000 22359.9n 0.28000 22360.0n 0.28000 22489.9n 0.28000 22490.0n 0.28000 22619.9n 0.28000 22620.0n 0.28000 22749.9n 0.28000 22750.0n 0.28000 22879.9n 0.28000 22880.0n 0.28000 23009.9n 0.28000 23010.0n 0.28000 23139.9n 0.28000 23140.0n 0.28000 23269.9n 0.28000 23270.0n 0.28000 23399.9n 0.28000 23400.0n 0.28000 23529.9n 0.28000 23530.0n 0.28000 23659.9n 0.28000 23660.0n 0.28000 23789.9n 0.28000 23790.0n 0.28000 23919.9n 0.28000 23920.0n 0.28000 24049.9n 0.28000 24050.0n 0.28000 24179.9n 0.28000 24180.0n 0.28000 24309.9n 0.28000 24310.0n 0.28000 24439.9n 0.28000 24440.0n 0.28000 24569.9n 0.28000 24570.0n 0.28000 24699.9n 0.28000 24700.0n 0.28000 24829.9n 0.28000 24830.0n 0.28000 24959.9n 0.28000 24960.0n 0.28000 25089.9n 0.28000 25090.0n 0.28000 25219.9n 0.28000 25220.0n 0.28000 25349.9n 0.28000 25350.0n 0.28000 25479.9n 0.28000 25480.0n 0.28000 25609.9n 0.28000 25610.0n 0.28000 25739.9n 0.28000 25740.0n 0.28000 25869.9n 0.28000 25870.0n 0.28000 25999.9n 0.28000 26000.0n 0.28000 26129.9n 0.28000 26130.0n 0.28000 26259.9n 0.28000 26260.0n 0.28000 26389.9n 0.28000 26390.0n 0.28000 26519.9n 0.28000 26520.0n 0.28000 26649.9n 0.28000 26650.0n 0.28000 26779.9n 0.28000 26780.0n 0.28000 26909.9n 0.28000 26910.0n 0.28000 27039.9n 0.28000 27040.0n 0.28000 27169.9n 0.28000 27170.0n 0.28000 27299.9n 0.28000 27300.0n 0.28000 27429.9n 0.28000 27430.0n 0.28000 27559.9n 0.28000 27560.0n 0.28000 27689.9n 0.28000 27690.0n 0.28000 27819.9n 0.28000 27820.0n 0.28000 27949.9n 0.28000 27950.0n 0.28000 28079.9n 0.28000 28080.0n 0.31000 28209.9n 0.31000 28210.0n 0.31000 28339.9n 0.31000 28340.0n 0.25000 28469.9n 0.25000 28470.0n 0.25000 28599.9n 0.25000 28600.0n 0.25000 28729.9n 0.25000 28730.0n 0.25000 28859.9n 0.25000 28860.0n 0.25000 28989.9n 0.25000 28990.0n 0.31000 29119.9n 0.31000 29120.0n 0.31000 29249.9n 0.31000 29250.0n 0.31000 29379.9n 0.31000 29380.0n 0.31000 29509.9n 0.31000 29510.0n 0.25000 29639.9n 0.25000 29640.0n 0.31000 29769.9n 0.31000 29770.0n 0.25000 29899.9n 0.25000 29900.0n 0.31000 30029.9n 0.31000 30030.0n 0.25000 30159.9n 0.25000 30160.0n 0.25000 30289.9n 0.25000 30290.0n 0.25000 30419.9n 0.25000 30420.0n 0.25000 30549.9n 0.25000 30550.0n 0.25000 30679.9n 0.25000 30680.0n 0.25000 30809.9n 0.25000 30810.0n 0.25000 30939.9n 0.25000 30940.0n 0.31000 31069.9n 0.31000 31070.0n 0.31000 31199.9n 0.31000 31200.0n 0.31000 31329.9n 0.31000 31330.0n 0.31000 31459.9n 0.31000 31460.0n 0.31000 31589.9n 0.31000 31590.0n 0.31000 31719.9n 0.31000 31720.0n 0.25000 31849.9n 0.25000 31850.0n 0.31000 31979.9n 0.31000 31980.0n 0.25000 32109.9n 0.25000 32110.0n 0.25000 32239.9n 0.25000 32240.0n 0.31000 32369.9n 0.31000 32370.0n 0.31000 32499.9n 0.31000 32500.0n 0.31000 32629.9n 0.31000 32630.0n 0.31000 32759.9n 0.31000 32760.0n 0.31000 32889.9n 0.31000 32890.0n 0.31000 33019.9n 0.31000 33020.0n 0.31000 33149.9n 0.31000 33150.0n 0.25000 33279.9n 0.25000 33280.0n 0.25000 33409.9n 0.25000 33410.0n 0.31000 33539.9n 0.31000 33540.0n 0.31000 33669.9n 0.31000 33670.0n 0.25000 33799.9n 0.25000 33800.0n 0.31000 33929.9n 0.31000 33930.0n 0.25000 34059.9n 0.25000 34060.0n 0.25000 34189.9n 0.25000 34190.0n 0.25000 34319.9n 0.25000 34320.0n 0.25000 34449.9n 0.25000 34450.0n 0.31000 34579.9n 0.31000 34580.0n 0.25000 34709.9n 0.25000 34710.0n 0.25000 34839.9n 0.25000 34840.0n 0.31000 34969.9n 0.31000 34970.0n 0.25000 35099.9n 0.25000 35100.0n 0.31000 35229.9n 0.31000 35230.0n 0.25000 35359.9n 0.25000 35360.0n 0.31000 35489.9n 0.31000 35490.0n 0.25000 35619.9n 0.25000 35620.0n 0.25000 35749.9n 0.25000 35750.0n 0.31000 35879.9n 0.31000 35880.0n 0.25000 36009.9n 0.25000 36010.0n 0.25000 36139.9n 0.25000 36140.0n 0.31000 36269.9n 0.31000 36270.0n 0.31000 36399.9n 0.31000 36400.0n 0.31000 36529.9n 0.31000 36530.0n 0.31000 36659.9n 0.31000 36660.0n 0.25000 36789.9n 0.25000 36790.0n 0.25000 36919.9n 0.25000 36920.0n 0.25000 37049.9n 0.25000 37050.0n 0.31000 37179.9n 0.31000 37180.0n 0.25000 37309.9n 0.25000 37310.0n 0.25000 37439.9n 0.25000 37440.0n 0.25000 37569.9n 0.25000 37570.0n 0.25000 37699.9n 0.25000 37700.0n 0.31000 37829.9n 0.31000 37830.0n 0.31000 37959.9n 0.31000 37960.0n 0.31000 38089.9n 0.31000 38090.0n 0.31000 38219.9n 0.31000 38220.0n 0.25000 38349.9n 0.25000 38350.0n 0.25000 38479.9n 0.25000 38480.0n 0.31000 38609.9n 0.31000 38610.0n 0.31000 38739.9n 0.31000 38740.0n 0.25000 38869.9n 0.25000 38870.0n 0.31000 38999.9n 0.31000 39000.0n 0.25000 39129.9n 0.25000 39130.0n 0.25000 39259.9n 0.25000 39260.0n 0.25000 39389.9n 0.25000 39390.0n 0.25000 39519.9n 0.25000 39520.0n 0.31000 39649.9n 0.31000 39650.0n 0.25000 39779.9n 0.25000 39780.0n 0.31000 39909.9n 0.31000 39910.0n 0.31000 40039.9n 0.31000 40040.0n 0.31000 40169.9n 0.31000 40170.0n 0.31000 40299.9n 0.31000 40300.0n 0.31000 40429.9n 0.31000 40430.0n 0.25000 40559.9n 0.25000 40560.0n 0.25000 40689.9n 0.25000 40690.0n 0.31000 40819.9n 0.31000 40820.0n 0.25000 40949.9n 0.25000 40950.0n 0.31000 41079.9n 0.31000 41080.0n 0.25000 41209.9n 0.25000 41210.0n 0.25000 41339.9n 0.25000 41340.0n 0.31000 41469.9n 0.31000 41470.0n 0.31000 41599.9n 0.31000 41600.0n 0.31000 41729.9n 0.31000 41730.0n 0.25000 41859.9n 0.25000 41860.0n 0.31000 41989.9n 0.31000 41990.0n 0.31000 42119.9n 0.31000 42120.0n 0.25000 42249.9n 0.25000 42250.0n 0.25000 42379.9n 0.25000 42380.0n 0.31000 42509.9n 0.31000 42510.0n 0.25000 42639.9n 0.25000 42640.0n 0.25000 42769.9n 0.25000 42770.0n 0.31000 42899.9n 0.31000 42900.0n 0.31000 43029.9n 0.31000 43030.0n 0.31000 43159.9n 0.31000 43160.0n 0.31000 43289.9n 0.31000 43290.0n 0.31000 43419.9n 0.31000 43420.0n 0.31000 43549.9n 0.31000 43550.0n 0.25000 43679.9n 0.25000 43680.0n 0.25000 43809.9n 0.25000 43810.0n 0.31000 43939.9n 0.31000 43940.0n 0.31000 44069.9n 0.31000 44070.0n 0.25000 44199.9n 0.25000 44200.0n 0.31000 44329.9n 0.31000 44330.0n 0.25000 44459.9n 0.25000 44460.0n 0.25000 44589.9n 0.25000 44590.0n 0.25000 44719.9n 0.25000 44720.0n 0.31000 44849.9n 0.31000 44850.0n 0.31000 44979.9n 0.31000 44980.0n 0.25000 45109.9n 0.25000 45110.0n 0.25000 45239.9n 0.25000 45240.0n 0.25000 45369.9n 0.25000 45370.0n 0.25000 45499.9n 0.25000 45500.0n 0.31000 45629.9n 0.31000 45630.0n 0.31000 45759.9n 0.31000 45760.0n 0.25000 45889.9n 0.25000 45890.0n 0.25000 46019.9n 0.25000 46020.0n 0.31000 46149.9n 0.31000 46150.0n 0.25000 46279.9n 0.25000 46280.0n 0.25000 46409.9n 0.25000 46410.0n 0.31000 46539.9n 0.31000 46540.0n 0.31000 46669.9n 0.31000 46670.0n 0.31000 46799.9n 0.31000 46800.0n 0.31000 46929.9n 0.31000 46930.0n 0.31000 47059.9n 0.31000 47060.0n 0.25000 47189.9n 0.25000 47190.0n 0.25000 47319.9n 0.25000 47320.0n 0.25000 47449.9n 0.25000 47450.0n 0.25000 47579.9n 0.25000 47580.0n 0.25000 47709.9n 0.25000 47710.0n 0.31000 47839.9n 0.31000 47840.0n 0.31000 47969.9n 0.31000 47970.0n 0.31000 48099.9n 0.31000 48100.0n 0.25000 48229.9n 0.25000 48230.0n 0.31000 48359.9n 0.31000 48360.0n 0.31000 48489.9n 0.31000 48490.0n 0.25000 48619.9n 0.25000 48620.0n 0.31000 48749.9n 0.31000 48750.0n 0.25000 48879.9n 0.25000 48880.0n 0.25000 49009.9n 0.25000 49010.0n 0.31000 49139.9n 0.31000 49140.0n 0.25000 49269.9n 0.25000 49270.0n 0.25000 49399.9n 0.25000 49400.0n 0.31000 49529.9n 0.31000 49530.0n 0.31000 49659.9n 0.31000 49660.0n 0.25000 49789.9n 0.25000 49790.0n 0.25000 49919.9n 0.25000 49920.0n 0.28000 50049.9n 0.28000 50050.0n 0.28000 50179.9n 0.28000 50180.0n 0.28000 50309.9n 0.28000 50310.0n 0.28000 50439.9n 0.28000 50440.0n 0.28000 50569.9n 0.28000 50570.0n 0.28000 50699.9n 0.28000 50700.0n 0.28000 50829.9n 0.28000 50830.0n 0.28000 50959.9n 0.28000 50960.0n 0.28000 51089.9n 0.28000 51090.0n 0.28000 51219.9n 0.28000 51220.0n 0.28000 51349.9n 0.28000 51350.0n 0.28000 51479.9n 0.28000 51480.0n 0.28000 51609.9n 0.28000 51610.0n 0.28000 51739.9n 0.28000 51740.0n 0.28000 51869.9n 0.28000 51870.0n 0.28000 51999.9n 0.28000 52000.0n 0.28000 52129.9n 0.28000 52130.0n 0.28000 52259.9n 0.28000 52260.0n 0.28000 52389.9n 0.28000 52390.0n 0.28000 52519.9n 0.28000 52520.0n 0.28000 52649.9n 0.28000 52650.0n 0.28000 52779.9n 0.28000 52780.0n 0.28000 52909.9n 0.28000 52910.0n 0.28000 53039.9n 0.28000 53040.0n 0.28000 53169.9n 0.28000 53170.0n 0.28000 53299.9n 0.28000 53300.0n 0.28000 53429.9n 0.28000 53430.0n 0.28000 53559.9n 0.28000 53560.0n 0.28000 53689.9n 0.28000 53690.0n 0.28000 53819.9n 0.28000 53820.0n 0.28000 53949.9n 0.28000 53950.0n 0.28000 54079.9n 0.28000 54080.0n 0.28000 54209.9n 0.28000 54210.0n 0.28000 54339.9n 0.28000 54340.0n 0.28000 54469.9n 0.28000 54470.0n 0.28000 54599.9n 0.28000 54600.0n 0.28000 54729.9n 0.28000 54730.0n 0.28000 54859.9n 0.28000 54860.0n 0.28000 54989.9n 0.28000 54990.0n 0.28000 55119.9n 0.28000 55120.0n 0.28000 55249.9n 0.28000 55250.0n 0.28000 55379.9n 0.28000 55380.0n 0.28000 55509.9n 0.28000 55510.0n 0.28000 55639.9n 0.28000 55640.0n 0.28000 55769.9n 0.28000 55770.0n 0.28000 55899.9n 0.28000 55900.0n 0.28000 56029.9n 0.28000 56030.0n 0.28000 56159.9n 0.28000 56160.0n 0.31000 56289.9n 0.31000 56290.0n 0.25000 56419.9n 0.25000 56420.0n 0.25000 56549.9n 0.25000 56550.0n 0.25000 56679.9n 0.25000 56680.0n 0.31000 56809.9n 0.31000 56810.0n 0.25000 56939.9n 0.25000 56940.0n 0.25000 57069.9n 0.25000 57070.0n 0.25000 57199.9n 0.25000 57200.0n 0.25000 57329.9n 0.25000 57330.0n 0.31000 57459.9n 0.31000 57460.0n 0.31000 57589.9n 0.31000 57590.0n 0.31000 57719.9n 0.31000 57720.0n 0.31000 57849.9n 0.31000 57850.0n 0.31000 57979.9n 0.31000 57980.0n 0.31000 58109.9n 0.31000 58110.0n 0.31000 58239.9n 0.31000 58240.0n 0.25000 58369.9n 0.25000 58370.0n 0.25000 58499.9n 0.25000 58500.0n 0.25000 58629.9n 0.25000 58630.0n 0.25000 58759.9n 0.25000 58760.0n 0.25000 58889.9n 0.25000 58890.0n 0.31000 59019.9n 0.31000 59020.0n 0.31000 59149.9n 0.31000 59150.0n 0.31000 59279.9n 0.31000 59280.0n 0.31000 59409.9n 0.31000 59410.0n 0.25000 59539.9n 0.25000 59540.0n 0.31000 59669.9n 0.31000 59670.0n 0.25000 59799.9n 0.25000 59800.0n 0.31000 59929.9n 0.31000 59930.0n 0.31000 60059.9n 0.31000 60060.0n 0.25000 60189.9n 0.25000 60190.0n 0.31000 60319.9n 0.31000 60320.0n 0.31000 60449.9n 0.31000 60450.0n 0.25000 60579.9n 0.25000 60580.0n 0.25000 60709.9n 0.25000 60710.0n 0.31000 60839.9n 0.31000 60840.0n 0.25000 60969.9n 0.25000 60970.0n 0.25000 61099.9n 0.25000 61100.0n 0.31000 61229.9n 0.31000 61230.0n 0.25000 61359.9n 0.25000 61360.0n 0.31000 61489.9n 0.31000 61490.0n 0.25000 61619.9n 0.25000 61620.0n 0.25000 61749.9n 0.25000 61750.0n 0.31000 61879.9n 0.31000 61880.0n 0.31000 62009.9n 0.31000 62010.0n 0.25000 62139.9n 0.25000 62140.0n 0.31000 62269.9n 0.31000 62270.0n 0.25000 62399.9n 0.25000 62400.0n 0.31000 62529.9n 0.31000 62530.0n 0.31000 62659.9n 0.31000 62660.0n 0.31000 62789.9n 0.31000 62790.0n 0.25000 62919.9n 0.25000 62920.0n 0.25000 63049.9n 0.25000 63050.0n 0.25000 63179.9n 0.25000 63180.0n 0.25000 63309.9n 0.25000 63310.0n 0.31000 63439.9n 0.31000 63440.0n 0.25000 63569.9n 0.25000 63570.0n 0.31000 63699.9n 0.31000 63700.0n 0.31000 63829.9n 0.31000 63830.0n 0.25000 63959.9n 0.25000 63960.0n 0.25000 64089.9n 0.25000 64090.0n 0.31000 64219.9n 0.31000 64220.0n 0.25000 64349.9n 0.25000 64350.0n 0.25000 64479.9n 0.25000 64480.0n 0.31000 64609.9n 0.31000 64610.0n 0.25000 64739.9n 0.25000 64740.0n 0.25000 64869.9n 0.25000 64870.0n 0.31000 64999.9n 0.31000 65000.0n 0.25000 65129.9n 0.25000 65130.0n 0.25000 65259.9n 0.25000 65260.0n 0.25000 65389.9n 0.25000 65390.0n 0.25000 65519.9n 0.25000 65520.0n 0.31000 65649.9n 0.31000 65650.0n 0.31000 65779.9n 0.31000 65780.0n 0.31000 65909.9n 0.31000 65910.0n 0.25000 66039.9n 0.25000 66040.0n 0.31000 66169.9n 0.31000 66170.0n 0.31000 66299.9n 0.31000 66300.0n 0.31000 66429.9n 0.31000 66430.0n 0.31000 66559.9n 0.31000 66560.0n 0.25000 66689.9n 0.25000 66690.0n 0.31000 66819.9n 0.31000 66820.0n 0.25000 66949.9n 0.25000 66950.0n 0.31000 67079.9n 0.31000 67080.0n 0.25000 67209.9n 0.25000 67210.0n 0.31000 67339.9n 0.31000 67340.0n 0.25000 67469.9n 0.25000 67470.0n 0.25000 67599.9n 0.25000 67600.0n 0.31000 67729.9n 0.31000 67730.0n 0.25000 67859.9n 0.25000 67860.0n 0.31000 67989.9n 0.31000 67990.0n 0.31000 68119.9n 0.31000 68120.0n 0.31000 68249.9n 0.31000 68250.0n 0.25000 68379.9n 0.25000 68380.0n 0.25000 68509.9n 0.25000 68510.0n 0.31000 68639.9n 0.31000 68640.0n 0.31000 68769.9n 0.31000 68770.0n 0.25000 68899.9n 0.25000 68900.0n 0.25000 69029.9n 0.25000 69030.0n 0.31000 69159.9n 0.31000 69160.0n 0.25000 69289.9n 0.25000 69290.0n 0.31000 69419.9n 0.31000 69420.0n 0.25000 69549.9n 0.25000 69550.0n 0.31000 69679.9n 0.31000 69680.0n 0.31000 69809.9n 0.31000 69810.0n 0.25000 69939.9n 0.25000 69940.0n 0.31000 70069.9n 0.31000 70070.0n 0.25000 70199.9n 0.25000 70200.0n 0.25000 70329.9n 0.25000 70330.0n 0.25000 70459.9n 0.25000 70460.0n 0.31000 70589.9n 0.31000 70590.0n 0.31000 70719.9n 0.31000 70720.0n 0.25000 70849.9n 0.25000 70850.0n 0.25000 70979.9n 0.25000 70980.0n 0.31000 71109.9n 0.31000 71110.0n 0.31000 71239.9n 0.31000 71240.0n 0.31000 71369.9n 0.31000 71370.0n 0.31000 71499.9n 0.31000 71500.0n 0.31000 71629.9n 0.31000 71630.0n 0.25000 71759.9n 0.25000 71760.0n 0.25000 71889.9n 0.25000 71890.0n 0.25000 72019.9n 0.25000 72020.0n 0.25000 72149.9n 0.25000 72150.0n 0.31000 72279.9n 0.31000 72280.0n 0.25000 72409.9n 0.25000 72410.0n 0.31000 72539.9n 0.31000 72540.0n 0.25000 72669.9n 0.25000 72670.0n 0.31000 72799.9n 0.31000 72800.0n 0.25000 72929.9n 0.25000 72930.0n 0.31000 73059.9n 0.31000 73060.0n 0.31000 73189.9n 0.31000 73190.0n 0.31000 73319.9n 0.31000 73320.0n 0.25000 73449.9n 0.25000 73450.0n 0.25000 73579.9n 0.25000 73580.0n 0.31000 73709.9n 0.31000 73710.0n 0.25000 73839.9n 0.25000 73840.0n 0.31000 73969.9n 0.31000 73970.0n 0.25000 74099.9n 0.25000 74100.0n 0.25000 74229.9n 0.25000 74230.0n 0.31000 74359.9n 0.31000 74360.0n 0.31000 74489.9n 0.31000 74490.0n 0.31000 74619.9n 0.31000 74620.0n 0.25000 74749.9n 0.25000 74750.0n 0.25000 74879.9n 0.25000 74880.0n 0.25000 75009.9n 0.25000 75010.0n 0.31000 75139.9n 0.31000 75140.0n 0.25000 75269.9n 0.25000 75270.0n 0.25000 75399.9n 0.25000 75400.0n 0.31000 75529.9n 0.31000 75530.0n 0.25000 75659.9n 0.25000 75660.0n 0.25000 75789.9n 0.25000 75790.0n 0.31000 75919.9n 0.31000 75920.0n 0.25000 76049.9n 0.25000 76050.0n 0.25000 76179.9n 0.25000 76180.0n 0.31000 76309.9n 0.31000 76310.0n 0.25000 76439.9n 0.25000 76440.0n 0.25000 76569.9n 0.25000 76570.0n 0.25000 76699.9n 0.25000 76700.0n 0.25000 76829.9n 0.25000 76830.0n 0.31000 76959.9n 0.31000 76960.0n 0.31000 77089.9n 0.31000 77090.0n 0.31000 77219.9n 0.31000 77220.0n 0.31000 77349.9n 0.31000 77350.0n 0.31000 77479.9n 0.31000 77480.0n 0.31000 77609.9n 0.31000 77610.0n 0.25000 77739.9n 0.25000 77740.0n 0.31000 77869.9n 0.31000 77870.0n 0.31000 77999.9n 0.31000 78000.0n 0.28000 78129.9n 0.28000 78130.0n 0.28000 78259.9n 0.28000 78260.0n 0.28000 78389.9n 0.28000 78390.0n 0.28000 78519.9n 0.28000 78520.0n 0.28000 78649.9n 0.28000 78650.0n 0.28000 78779.9n 0.28000 78780.0n 0.28000 78909.9n 0.28000 78910.0n 0.28000 79039.9n 0.28000 79040.0n 0.28000 79169.9n 0.28000 79170.0n 0.28000 79299.9n 0.28000 79300.0n 0.28000 79429.9n 0.28000 79430.0n 0.28000 79559.9n 0.28000 79560.0n 0.28000 79689.9n 0.28000 79690.0n 0.28000 79819.9n 0.28000 79820.0n 0.28000 79949.9n 0.28000 79950.0n 0.28000 80079.9n 0.28000 80080.0n 0.28000 80209.9n 0.28000 80210.0n 0.28000 80339.9n 0.28000 80340.0n 0.28000 80469.9n 0.28000 80470.0n 0.28000 80599.9n 0.28000 80600.0n 0.28000 80729.9n 0.28000 80730.0n 0.28000 80859.9n 0.28000 80860.0n 0.28000 80989.9n 0.28000 80990.0n 0.28000 81119.9n 0.28000 81120.0n 0.28000 81249.9n 0.28000 81250.0n 0.28000 81379.9n 0.28000 81380.0n 0.28000 81509.9n 0.28000 81510.0n 0.28000 81639.9n 0.28000 81640.0n 0.28000 81769.9n 0.28000 81770.0n 0.28000 81899.9n 0.28000 81900.0n 0.28000 82029.9n 0.28000 82030.0n 0.28000 82159.9n 0.28000 82160.0n 0.28000 82289.9n 0.28000 82290.0n 0.28000 82419.9n 0.28000 82420.0n 0.28000 82549.9n 0.28000 82550.0n 0.28000 82679.9n 0.28000 82680.0n 0.28000 82809.9n 0.28000 82810.0n 0.28000 82939.9n 0.28000 82940.0n 0.28000 83069.9n 0.28000 83070.0n 0.28000 83199.9n 0.28000 83200.0n 0.28000 83329.9n 0.28000 83330.0n 0.28000 83459.9n 0.28000 83460.0n 0.28000 83589.9n 0.28000 83590.0n 0.28000 83719.9n 0.28000 83720.0n 0.28000 83849.9n 0.28000 83850.0n 0.28000 83979.9n 0.28000 83980.0n 0.28000 84109.9n 0.28000 84110.0n 0.28000 84239.9n 0.28000 84240.0n 0.25000 84369.9n 0.25000 84370.0n 0.31000 84499.9n 0.31000 84500.0n 0.31000 84629.9n 0.31000 84630.0n 0.31000 84759.9n 0.31000 84760.0n 0.31000 84889.9n 0.31000 84890.0n 0.31000 85019.9n 0.31000 85020.0n 0.25000 85149.9n 0.25000 85150.0n 0.25000 85279.9n 0.25000 85280.0n 0.25000 85409.9n 0.25000 85410.0n 0.31000 85539.9n 0.31000 85540.0n 0.25000 85669.9n 0.25000 85670.0n 0.25000 85799.9n 0.25000 85800.0n 0.25000 85929.9n 0.25000 85930.0n 0.25000 86059.9n 0.25000 86060.0n 0.31000 86189.9n 0.31000 86190.0n 0.25000 86319.9n 0.25000 86320.0n 0.31000 86449.9n 0.31000 86450.0n 0.25000 86579.9n 0.25000 86580.0n 0.31000 86709.9n 0.31000 86710.0n 0.31000 86839.9n 0.31000 86840.0n 0.31000 86969.9n 0.31000 86970.0n 0.25000 87099.9n 0.25000 87100.0n 0.31000 87229.9n 0.31000 87230.0n 0.31000 87359.9n 0.31000 87360.0n 0.25000 87489.9n 0.25000 87490.0n 0.25000 87619.9n 0.25000 87620.0n 0.25000 87749.9n 0.25000 87750.0n 0.31000 87879.9n 0.31000 87880.0n 0.25000 88009.9n 0.25000 88010.0n 0.31000 88139.9n 0.31000 88140.0n 0.25000 88269.9n 0.25000 88270.0n 0.25000 88399.9n 0.25000 88400.0n 0.31000 88529.9n 0.31000 88530.0n 0.25000 88659.9n 0.25000 88660.0n 0.25000 88789.9n 0.25000 88790.0n 0.31000 88919.9n 0.31000 88920.0n 0.31000 89049.9n 0.31000 89050.0n 0.31000 89179.9n 0.31000 89180.0n 0.25000 89309.9n 0.25000 89310.0n 0.25000 89439.9n 0.25000 89440.0n 0.25000 89569.9n 0.25000 89570.0n 0.25000 89699.9n 0.25000 89700.0n 0.25000 89829.9n 0.25000 89830.0n 0.25000 89959.9n 0.25000 89960.0n 0.31000 90089.9n 0.31000 90090.0n 0.31000 90219.9n 0.31000 90220.0n 0.31000 90349.9n 0.31000 90350.0n 0.31000 90479.9n 0.31000 90480.0n 0.31000 90609.9n 0.31000 90610.0n 0.31000 90739.9n 0.31000 90740.0n 0.31000 90869.9n 0.31000 90870.0n 0.25000 90999.9n 0.25000 91000.0n 0.25000 91129.9n 0.25000 91130.0n 0.31000 91259.9n 0.31000 91260.0n 0.25000 91389.9n 0.25000 91390.0n 0.31000 91519.9n 0.31000 91520.0n 0.25000 91649.9n 0.25000 91650.0n 0.31000 91779.9n 0.31000 91780.0n 0.31000 91909.9n 0.31000 91910.0n 0.31000 92039.9n 0.31000 92040.0n 0.25000 92169.9n 0.25000 92170.0n 0.31000 92299.9n 0.31000 92300.0n 0.25000 92429.9n 0.25000 92430.0n 0.25000 92559.9n 0.25000 92560.0n 0.25000 92689.9n 0.25000 92690.0n 0.31000 92819.9n 0.31000 92820.0n 0.31000 92949.9n 0.31000 92950.0n 0.31000 93079.9n 0.31000 93080.0n 0.25000 93209.9n 0.25000 93210.0n 0.25000 93339.9n 0.25000 93340.0n 0.31000 93469.9n 0.31000 93470.0n 0.25000 93599.9n 0.25000 93600.0n 0.25000 93729.9n 0.25000 93730.0n 0.25000 93859.9n 0.25000 93860.0n 0.31000 93989.9n 0.31000 93990.0n 0.31000 94119.9n 0.31000 94120.0n 0.25000 94249.9n 0.25000 94250.0n 0.25000 94379.9n 0.25000 94380.0n 0.25000 94509.9n 0.25000 94510.0n 0.31000 94639.9n 0.31000 94640.0n 0.31000 94769.9n 0.31000 94770.0n 0.31000 94899.9n 0.31000 94900.0n 0.31000 95029.9n 0.31000 95030.0n 0.25000 95159.9n 0.25000 95160.0n 0.25000 95289.9n 0.25000 95290.0n 0.31000 95419.9n 0.31000 95420.0n 0.31000 95549.9n 0.31000 95550.0n 0.25000 95679.9n 0.25000 95680.0n 0.31000 95809.9n 0.31000 95810.0n 0.25000 95939.9n 0.25000 95940.0n 0.25000 96069.9n 0.25000 96070.0n 0.25000 96199.9n 0.25000 96200.0n 0.25000 96329.9n 0.25000 96330.0n 0.25000 96459.9n 0.25000 96460.0n 0.31000 96589.9n 0.31000 96590.0n 0.25000 96719.9n 0.25000 96720.0n 0.25000 96849.9n 0.25000 96850.0n 0.31000 96979.9n 0.31000 96980.0n 0.31000 97109.9n 0.31000 97110.0n 0.31000 97239.9n 0.31000 97240.0n 0.31000 97369.9n 0.31000 97370.0n 0.25000 97499.9n 0.25000 97500.0n 0.31000 97629.9n 0.31000 97630.0n 0.25000 97759.9n 0.25000 97760.0n 0.31000 97889.9n 0.31000 97890.0n 0.31000 98019.9n 0.31000 98020.0n 0.31000 98149.9n 0.31000 98150.0n 0.31000 98279.9n 0.31000 98280.0n 0.31000 98409.9n 0.31000 98410.0n 0.25000 98539.9n 0.25000 98540.0n 0.25000 98669.9n 0.25000 98670.0n 0.25000 98799.9n 0.25000 98800.0n 0.25000 98929.9n 0.25000 98930.0n 0.31000 99059.9n 0.31000 99060.0n 0.31000 99189.9n 0.31000 99190.0n 0.25000 99319.9n 0.25000 99320.0n 0.31000 99449.9n 0.31000 99450.0n 0.25000 99579.9n 0.25000 99580.0n 0.25000 99709.9n 0.25000 99710.0n 0.31000 99839.9n 0.31000 99840.0n 0.31000 99969.9n 0.31000 99970.0n 0.31000 100099.9n 0.31000 100100.0n 0.31000 100229.9n 0.31000 100230.0n 0.31000 100359.9n 0.31000 100360.0n 0.31000 100489.9n 0.31000 100490.0n 0.25000 100619.9n 0.25000 100620.0n 0.31000 100749.9n 0.31000 100750.0n 0.25000 100879.9n 0.25000 100880.0n 0.31000 101009.9n 0.31000 101010.0n 0.25000 101139.9n 0.25000 101140.0n 0.25000 101269.9n 0.25000 101270.0n 0.25000 101399.9n 0.25000 101400.0n 0.25000 101529.9n 0.25000 101530.0n 0.25000 101659.9n 0.25000 101660.0n 0.31000 101789.9n 0.31000 101790.0n 0.25000 101919.9n 0.25000 101920.0n 0.31000 102049.9n 0.31000 102050.0n 0.25000 102179.9n 0.25000 102180.0n 0.31000 102309.9n 0.31000 102310.0n 0.25000 102439.9n 0.25000 102440.0n 0.31000 102569.9n 0.31000 102570.0n 0.31000 102699.9n 0.31000 102700.0n 0.25000 102829.9n 0.25000 102830.0n 0.25000 102959.9n 0.25000 102960.0n 0.25000 103089.9n 0.25000 103090.0n 0.31000 103219.9n 0.31000 103220.0n 0.31000 103349.9n 0.31000 103350.0n 0.25000 103479.9n 0.25000 103480.0n 0.25000 103609.9n 0.25000 103610.0n 0.25000 103739.9n 0.25000 103740.0n 0.31000 103869.9n 0.31000 103870.0n 0.31000 103999.9n 0.31000 104000.0n 0.31000 104129.9n 0.31000 104130.0n 0.25000 104259.9n 0.25000 104260.0n 0.31000 104389.9n 0.31000 104390.0n 0.31000 104519.9n 0.31000 104520.0n 0.31000 104649.9n 0.31000 104650.0n 0.25000 104779.9n 0.25000 104780.0n 0.31000 104909.9n 0.31000 104910.0n 0.25000 105039.9n 0.25000 105040.0n 0.25000 105169.9n 0.25000 105170.0n 0.25000 105299.9n 0.25000 105300.0n 0.25000 105429.9n 0.25000 105430.0n 0.25000 105559.9n 0.25000 105560.0n 0.31000 105689.9n 0.31000 105690.0n 0.31000 105819.9n 0.31000 105820.0n 0.31000 105949.9n 0.31000 105950.0n 0.25000 106079.9n 0.25000 106080.0n 0.28000 106209.9n 0.28000 106210.0n 0.28000 106339.9n 0.28000 106340.0n 0.28000 106469.9n 0.28000 106470.0n 0.28000 106599.9n 0.28000 106600.0n 0.28000 106729.9n 0.28000 106730.0n 0.28000 106859.9n 0.28000 106860.0n 0.28000 106989.9n 0.28000 106990.0n 0.28000 107119.9n 0.28000 107120.0n 0.28000 107249.9n 0.28000 107250.0n 0.28000 107379.9n 0.28000 107380.0n 0.28000 107509.9n 0.28000 107510.0n 0.28000 107639.9n 0.28000 107640.0n 0.28000 107769.9n 0.28000 107770.0n 0.28000 107899.9n 0.28000 107900.0n 0.28000 108029.9n 0.28000 108030.0n 0.28000 108159.9n 0.28000 108160.0n 0.28000 108289.9n 0.28000 108290.0n 0.28000 108419.9n 0.28000 108420.0n 0.28000 108549.9n 0.28000 108550.0n 0.28000 108679.9n 0.28000 108680.0n 0.28000 108809.9n 0.28000 108810.0n 0.28000 108939.9n 0.28000 108940.0n 0.28000 109069.9n 0.28000 109070.0n 0.28000 109199.9n 0.28000 109200.0n 0.28000 109329.9n 0.28000 109330.0n 0.28000 109459.9n 0.28000 109460.0n 0.28000 109589.9n 0.28000 109590.0n 0.28000 109719.9n 0.28000 109720.0n 0.28000 109849.9n 0.28000 109850.0n 0.28000 109979.9n 0.28000 109980.0n 0.28000 110109.9n 0.28000 110110.0n 0.28000 110239.9n 0.28000 110240.0n 0.28000 110369.9n 0.28000 110370.0n 0.28000 110499.9n 0.28000 110500.0n 0.28000 110629.9n 0.28000 110630.0n 0.28000 110759.9n 0.28000 110760.0n 0.28000 110889.9n 0.28000 110890.0n 0.28000 111019.9n 0.28000 111020.0n 0.28000 111149.9n 0.28000 111150.0n 0.28000 111279.9n 0.28000 111280.0n 0.28000 111409.9n 0.28000 111410.0n 0.28000 111539.9n 0.28000 111540.0n 0.28000 111669.9n 0.28000 111670.0n 0.28000 111799.9n 0.28000 111800.0n 0.28000 111929.9n 0.28000 111930.0n 0.28000 112059.9n 0.28000 112060.0n 0.28000 112189.9n 0.28000 112190.0n 0.28000 112319.9n 0.28000 112320.0n 0.25000 112449.9n 0.25000 112450.0n 0.31000 112579.9n 0.31000 112580.0n 0.25000 112709.9n 0.25000 112710.0n 0.31000 112839.9n 0.31000 112840.0n 0.31000 112969.9n 0.31000 112970.0n 0.31000 113099.9n 0.31000 113100.0n 0.31000 113229.9n 0.31000 113230.0n 0.25000 113359.9n 0.25000 113360.0n 0.31000 113489.9n 0.31000 113490.0n 0.31000 113619.9n 0.31000 113620.0n 0.31000 113749.9n 0.31000 113750.0n 0.25000 113879.9n 0.25000 113880.0n 0.25000 114009.9n 0.25000 114010.0n 0.31000 114139.9n 0.31000 114140.0n 0.31000 114269.9n 0.31000 114270.0n 0.25000 114399.9n 0.25000 114400.0n 0.31000 114529.9n 0.31000 114530.0n 0.31000 114659.9n 0.31000 114660.0n 0.31000 114789.9n 0.31000 114790.0n 0.25000 114919.9n 0.25000 114920.0n 0.25000 115049.9n 0.25000 115050.0n 0.25000 115179.9n 0.25000 115180.0n 0.25000 115309.9n 0.25000 115310.0n 0.25000 115439.9n 0.25000 115440.0n 0.25000 115569.9n 0.25000 115570.0n 0.25000 115699.9n 0.25000 115700.0n 0.25000 115829.9n 0.25000 115830.0n 0.31000 115959.9n 0.31000 115960.0n 0.25000 116089.9n 0.25000 116090.0n 0.31000 116219.9n 0.31000 116220.0n 0.25000 116349.9n 0.25000 116350.0n 0.25000 116479.9n 0.25000 116480.0n 0.25000 116609.9n 0.25000 116610.0n 0.31000 116739.9n 0.31000 116740.0n 0.25000 116869.9n 0.25000 116870.0n 0.31000 116999.9n 0.31000 117000.0n 0.25000 117129.9n 0.25000 117130.0n 0.31000 117259.9n 0.31000 117260.0n 0.25000 117389.9n 0.25000 117390.0n 0.25000 117519.9n 0.25000 117520.0n 0.25000 117649.9n 0.25000 117650.0n 0.31000 117779.9n 0.31000 117780.0n 0.25000 117909.9n 0.25000 117910.0n 0.25000 118039.9n 0.25000 118040.0n 0.31000 118169.9n 0.31000 118170.0n 0.31000 118299.9n 0.31000 118300.0n 0.31000 118429.9n 0.31000 118430.0n 0.31000 118559.9n 0.31000 118560.0n 0.31000 118689.9n 0.31000 118690.0n 0.31000 118819.9n 0.31000 118820.0n 0.31000 118949.9n 0.31000 118950.0n 0.31000 119079.9n 0.31000 119080.0n 0.25000 119209.9n 0.25000 119210.0n 0.31000 119339.9n 0.31000 119340.0n 0.25000 119469.9n 0.25000 119470.0n 0.25000 119599.9n 0.25000 119600.0n 0.31000 119729.9n 0.31000 119730.0n 0.25000 119859.9n 0.25000 119860.0n 0.25000 119989.9n 0.25000 119990.0n 0.25000 120119.9n 0.25000 120120.0n 0.31000 120249.9n 0.31000 120250.0n 0.31000 120379.9n 0.31000 120380.0n 0.25000 120509.9n 0.25000 120510.0n 0.25000 120639.9n 0.25000 120640.0n 0.31000 120769.9n 0.31000 120770.0n 0.31000 120899.9n 0.31000 120900.0n 0.31000 121029.9n 0.31000 121030.0n 0.25000 121159.9n 0.25000 121160.0n 0.31000 121289.9n 0.31000 121290.0n 0.31000 121419.9n 0.31000 121420.0n 0.25000 121549.9n 0.25000 121550.0n 0.25000 121679.9n 0.25000 121680.0n 0.31000 121809.9n 0.31000 121810.0n 0.25000 121939.9n 0.25000 121940.0n 0.25000 122069.9n 0.25000 122070.0n 0.25000 122199.9n 0.25000 122200.0n 0.31000 122329.9n 0.31000 122330.0n 0.31000 122459.9n 0.31000 122460.0n 0.31000 122589.9n 0.31000 122590.0n 0.25000 122719.9n 0.25000 122720.0n 0.25000 122849.9n 0.25000 122850.0n 0.31000 122979.9n 0.31000 122980.0n 0.25000 123109.9n 0.25000 123110.0n 0.31000 123239.9n 0.31000 123240.0n 0.25000 123369.9n 0.25000 123370.0n 0.31000 123499.9n 0.31000 123500.0n 0.25000 123629.9n 0.25000 123630.0n 0.31000 123759.9n 0.31000 123760.0n 0.25000 123889.9n 0.25000 123890.0n 0.31000 124019.9n 0.31000 124020.0n 0.25000 124149.9n 0.25000 124150.0n 0.25000 124279.9n 0.25000 124280.0n 0.31000 124409.9n 0.31000 124410.0n 0.31000 124539.9n 0.31000 124540.0n 0.31000 124669.9n 0.31000 124670.0n 0.25000 124799.9n 0.25000 124800.0n 0.31000 124929.9n 0.31000 124930.0n 0.25000 125059.9n 0.25000 125060.0n 0.25000 125189.9n 0.25000 125190.0n 0.25000 125319.9n 0.25000 125320.0n 0.25000 125449.9n 0.25000 125450.0n 0.31000 125579.9n 0.31000 125580.0n 0.31000 125709.9n 0.31000 125710.0n 0.31000 125839.9n 0.31000 125840.0n 0.31000 125969.9n 0.31000 125970.0n 0.25000 126099.9n 0.25000 126100.0n 0.25000 126229.9n 0.25000 126230.0n 0.31000 126359.9n 0.31000 126360.0n 0.25000 126489.9n 0.25000 126490.0n 0.25000 126619.9n 0.25000 126620.0n 0.31000 126749.9n 0.31000 126750.0n 0.31000 126879.9n 0.31000 126880.0n 0.25000 127009.9n 0.25000 127010.0n 0.25000 127139.9n 0.25000 127140.0n 0.25000 127269.9n 0.25000 127270.0n 0.31000 127399.9n 0.31000 127400.0n 0.31000 127529.9n 0.31000 127530.0n 0.31000 127659.9n 0.31000 127660.0n 0.25000 127789.9n 0.25000 127790.0n 0.25000 127919.9n 0.25000 127920.0n 0.31000 128049.9n 0.31000 128050.0n 0.31000 128179.9n 0.31000 128180.0n 0.25000 128309.9n 0.25000 128310.0n 0.31000 128439.9n 0.31000 128440.0n 0.31000 128569.9n 0.31000 128570.0n 0.31000 128699.9n 0.31000 128700.0n 0.25000 128829.9n 0.25000 128830.0n 0.25000 128959.9n 0.25000 128960.0n 0.31000 129089.9n 0.31000 129090.0n 0.25000 129219.9n 0.25000 129220.0n 0.31000 129349.9n 0.31000 129350.0n 0.25000 129479.9n 0.25000 129480.0n 0.25000 129609.9n 0.25000 129610.0n 0.31000 129739.9n 0.31000 129740.0n 0.31000 129869.9n 0.31000 129870.0n 0.31000 129999.9n 0.31000 130000.0n 0.25000 130129.9n 0.25000 130130.0n 0.25000 130259.9n 0.25000 130260.0n 0.31000 130389.9n 0.31000 130390.0n 0.25000 130519.9n 0.25000 130520.0n 0.31000 130649.9n 0.31000 130650.0n 0.31000 130779.9n 0.31000 130780.0n 0.31000 130909.9n 0.31000 130910.0n 0.25000 131039.9n 0.25000 131040.0n 0.31000 131169.9n 0.31000 131170.0n 0.31000 131299.9n 0.31000 131300.0n 0.25000 131429.9n 0.25000 131430.0n 0.25000 131559.9n 0.25000 131560.0n 0.31000 131689.9n 0.31000 131690.0n 0.31000 131819.9n 0.31000 131820.0n 0.31000 131949.9n 0.31000 131950.0n 0.25000 132079.9n 0.25000 132080.0n 0.31000 132209.9n 0.31000 132210.0n 0.25000 132339.9n 0.25000 132340.0n 0.25000 132469.9n 0.25000 132470.0n 0.25000 132599.9n 0.25000 132600.0n 0.31000 132729.9n 0.31000 132730.0n 0.31000 132859.9n 0.31000 132860.0n 0.25000 132989.9n 0.25000 132990.0n 0.25000 133119.9n 0.25000 133120.0n 0.25000 133249.9n 0.25000 133250.0n 0.25000 133379.9n 0.25000 133380.0n 0.25000 133509.9n 0.25000 133510.0n 0.25000 133639.9n 0.25000 133640.0n 0.31000 133769.9n 0.31000 133770.0n 0.25000 133899.9n 0.25000 133900.0n 0.31000 134029.9n 0.31000 134030.0n 0.31000 134159.9n 0.31000 134160.0n 0.28000 134289.9n 0.28000 134290.0n 0.28000 134419.9n 0.28000 134420.0n 0.28000 134549.9n 0.28000 134550.0n 0.28000 134679.9n 0.28000 134680.0n 0.28000 134809.9n 0.28000 134810.0n 0.28000 134939.9n 0.28000 134940.0n 0.28000 135069.9n 0.28000 135070.0n 0.28000 135199.9n 0.28000 135200.0n 0.28000 135329.9n 0.28000 135330.0n 0.28000 135459.9n 0.28000 135460.0n 0.28000 135589.9n 0.28000 135590.0n 0.28000 135719.9n 0.28000 135720.0n 0.28000 135849.9n 0.28000 135850.0n 0.28000 135979.9n 0.28000 135980.0n 0.28000 136109.9n 0.28000 136110.0n 0.28000 136239.9n 0.28000 136240.0n 0.28000 136369.9n 0.28000 136370.0n 0.28000 136499.9n 0.28000 136500.0n 0.28000 136629.9n 0.28000 136630.0n 0.28000 136759.9n 0.28000 136760.0n 0.28000 136889.9n 0.28000 136890.0n 0.28000 137019.9n 0.28000 137020.0n 0.28000 137149.9n 0.28000 137150.0n 0.28000 137279.9n 0.28000 137280.0n 0.28000 137409.9n 0.28000 137410.0n 0.28000 137539.9n 0.28000 137540.0n 0.28000 137669.9n 0.28000 137670.0n 0.28000 137799.9n 0.28000 137800.0n 0.28000 137929.9n 0.28000 137930.0n 0.28000 138059.9n 0.28000 138060.0n 0.28000 138189.9n 0.28000 138190.0n 0.28000 138319.9n 0.28000 138320.0n 0.28000 138449.9n 0.28000 138450.0n 0.28000 138579.9n 0.28000 138580.0n 0.28000 138709.9n 0.28000 138710.0n 0.28000 138839.9n 0.28000 138840.0n 0.28000 138969.9n 0.28000 138970.0n 0.28000 139099.9n 0.28000 139100.0n 0.28000 139229.9n 0.28000 139230.0n 0.28000 139359.9n 0.28000 139360.0n 0.28000 139489.9n 0.28000 139490.0n 0.28000 139619.9n 0.28000 139620.0n 0.28000 139749.9n 0.28000 139750.0n 0.28000 139879.9n 0.28000 139880.0n 0.28000 140009.9n 0.28000 140010.0n 0.28000 140139.9n 0.28000 140140.0n 0.28000 140269.9n 0.28000 140270.0n 0.28000 140399.9n 0.28000 140400.0n 0.31000 140529.9n 0.31000 140530.0n 0.25000 140659.9n 0.25000 140660.0n 0.31000 140789.9n 0.31000 140790.0n 0.31000 140919.9n 0.31000 140920.0n 0.25000 141049.9n 0.25000 141050.0n 0.31000 141179.9n 0.31000 141180.0n 0.25000 141309.9n 0.25000 141310.0n 0.31000 141439.9n 0.31000 141440.0n 0.31000 141569.9n 0.31000 141570.0n 0.31000 141699.9n 0.31000 141700.0n 0.31000 141829.9n 0.31000 141830.0n 0.25000 141959.9n 0.25000 141960.0n 0.25000 142089.9n 0.25000 142090.0n 0.25000 142219.9n 0.25000 142220.0n 0.25000 142349.9n 0.25000 142350.0n 0.25000 142479.9n 0.25000 142480.0n 0.25000 142609.9n 0.25000 142610.0n 0.31000 142739.9n 0.31000 142740.0n 0.31000 142869.9n 0.31000 142870.0n 0.25000 142999.9n 0.25000 143000.0n 0.31000 143129.9n 0.31000 143130.0n 0.31000 143259.9n 0.31000 143260.0n 0.25000 143389.9n 0.25000 143390.0n 0.25000 143519.9n 0.25000 143520.0n 0.25000 143649.9n 0.25000 143650.0n 0.25000 143779.9n 0.25000 143780.0n 0.31000 143909.9n 0.31000 143910.0n 0.31000 144039.9n 0.31000 144040.0n 0.25000 144169.9n 0.25000 144170.0n 0.25000 144299.9n 0.25000 144300.0n 0.25000 144429.9n 0.25000 144430.0n 0.31000 144559.9n 0.31000 144560.0n 0.31000 144689.9n 0.31000 144690.0n 0.25000 144819.9n 0.25000 144820.0n 0.25000 144949.9n 0.25000 144950.0n 0.31000 145079.9n 0.31000 145080.0n 0.25000 145209.9n 0.25000 145210.0n 0.31000 145339.9n 0.31000 145340.0n 0.31000 145469.9n 0.31000 145470.0n 0.31000 145599.9n 0.31000 145600.0n 0.25000 145729.9n 0.25000 145730.0n 0.31000 145859.9n 0.31000 145860.0n 0.25000 145989.9n 0.25000 145990.0n 0.25000 146119.9n 0.25000 146120.0n 0.31000 146249.9n 0.31000 146250.0n 0.31000 146379.9n 0.31000 146380.0n 0.25000 146509.9n 0.25000 146510.0n 0.31000 146639.9n 0.31000 146640.0n 0.25000 146769.9n 0.25000 146770.0n 0.31000 146899.9n 0.31000 146900.0n 0.25000 147029.9n 0.25000 147030.0n 0.25000 147159.9n 0.25000 147160.0n 0.25000 147289.9n 0.25000 147290.0n 0.31000 147419.9n 0.31000 147420.0n 0.31000 147549.9n 0.31000 147550.0n 0.31000 147679.9n 0.31000 147680.0n 0.31000 147809.9n 0.31000 147810.0n 0.31000 147939.9n 0.31000 147940.0n 0.25000 148069.9n 0.25000 148070.0n 0.25000 148199.9n 0.25000 148200.0n 0.31000 148329.9n 0.31000 148330.0n 0.31000 148459.9n 0.31000 148460.0n 0.25000 148589.9n 0.25000 148590.0n 0.25000 148719.9n 0.25000 148720.0n 0.31000 148849.9n 0.31000 148850.0n 0.25000 148979.9n 0.25000 148980.0n 0.25000 149109.9n 0.25000 149110.0n 0.31000 149239.9n 0.31000 149240.0n 0.25000 149369.9n 0.25000 149370.0n 0.31000 149499.9n 0.31000 149500.0n 0.31000 149629.9n 0.31000 149630.0n 0.31000 149759.9n 0.31000 149760.0n 0.25000 149889.9n 0.25000 149890.0n 0.25000 150019.9n 0.25000 150020.0n 0.25000 150149.9n 0.25000 150150.0n 0.25000 150279.9n 0.25000 150280.0n 0.25000 150409.9n 0.25000 150410.0n 0.31000 150539.9n 0.31000 150540.0n 0.31000 150669.9n 0.31000 150670.0n 0.31000 150799.9n 0.31000 150800.0n 0.31000 150929.9n 0.31000 150930.0n 0.25000 151059.9n 0.25000 151060.0n 0.25000 151189.9n 0.25000 151190.0n 0.31000 151319.9n 0.31000 151320.0n 0.25000 151449.9n 0.25000 151450.0n 0.31000 151579.9n 0.31000 151580.0n 0.31000 151709.9n 0.31000 151710.0n 0.31000 151839.9n 0.31000 151840.0n 0.25000 151969.9n 0.25000 151970.0n 0.31000 152099.9n 0.31000 152100.0n 0.25000 152229.9n 0.25000 152230.0n 0.31000 152359.9n 0.31000 152360.0n 0.25000 152489.9n 0.25000 152490.0n 0.25000 152619.9n 0.25000 152620.0n 0.25000 152749.9n 0.25000 152750.0n 0.25000 152879.9n 0.25000 152880.0n 0.25000 153009.9n 0.25000 153010.0n 0.31000 153139.9n 0.31000 153140.0n 0.25000 153269.9n 0.25000 153270.0n 0.31000 153399.9n 0.31000 153400.0n 0.25000 153529.9n 0.25000 153530.0n 0.31000 153659.9n 0.31000 153660.0n 0.25000 153789.9n 0.25000 153790.0n 0.25000 153919.9n 0.25000 153920.0n 0.31000 154049.9n 0.31000 154050.0n 0.31000 154179.9n 0.31000 154180.0n 0.31000 154309.9n 0.31000 154310.0n 0.25000 154439.9n 0.25000 154440.0n 0.31000 154569.9n 0.31000 154570.0n 0.31000 154699.9n 0.31000 154700.0n 0.25000 154829.9n 0.25000 154830.0n 0.31000 154959.9n 0.31000 154960.0n 0.31000 155089.9n 0.31000 155090.0n 0.31000 155219.9n 0.31000 155220.0n 0.25000 155349.9n 0.25000 155350.0n 0.25000 155479.9n 0.25000 155480.0n 0.25000 155609.9n 0.25000 155610.0n 0.25000 155739.9n 0.25000 155740.0n 0.31000 155869.9n 0.31000 155870.0n 0.31000 155999.9n 0.31000 156000.0n 0.31000 156129.9n 0.31000 156130.0n 0.25000 156259.9n 0.25000 156260.0n 0.31000 156389.9n 0.31000 156390.0n 0.31000 156519.9n 0.31000 156520.0n 0.31000 156649.9n 0.31000 156650.0n 0.31000 156779.9n 0.31000 156780.0n 0.31000 156909.9n 0.31000 156910.0n 0.25000 157039.9n 0.25000 157040.0n 0.25000 157169.9n 0.25000 157170.0n 0.25000 157299.9n 0.25000 157300.0n 0.25000 157429.9n 0.25000 157430.0n 0.25000 157559.9n 0.25000 157560.0n 0.31000 157689.9n 0.31000 157690.0n 0.25000 157819.9n 0.25000 157820.0n 0.31000 157949.9n 0.31000 157950.0n 0.31000 158079.9n 0.31000 158080.0n 0.25000 158209.9n 0.25000 158210.0n 0.31000 158339.9n 0.31000 158340.0n 0.25000 158469.9n 0.25000 158470.0n 0.25000 158599.9n 0.25000 158600.0n 0.31000 158729.9n 0.31000 158730.0n 0.31000 158859.9n 0.31000 158860.0n 0.25000 158989.9n 0.25000 158990.0n 0.31000 159119.9n 0.31000 159120.0n 0.25000 159249.9n 0.25000 159250.0n 0.31000 159379.9n 0.31000 159380.0n 0.31000 159509.9n 0.31000 159510.0n 0.25000 159639.9n 0.25000 159640.0n 0.25000 159769.9n 0.25000 159770.0n 0.25000 159899.9n 0.25000 159900.0n 0.31000 160029.9n 0.31000 160030.0n 0.25000 160159.9n 0.25000 160160.0n 0.25000 160289.9n 0.25000 160290.0n 0.31000 160419.9n 0.31000 160420.0n 0.31000 160549.9n 0.31000 160550.0n 0.31000 160679.9n 0.31000 160680.0n 0.31000 160809.9n 0.31000 160810.0n 0.25000 160939.9n 0.25000 160940.0n 0.31000 161069.9n 0.31000 161070.0n 0.25000 161199.9n 0.25000 161200.0n 0.25000 161329.9n 0.25000 161330.0n 0.25000 161459.9n 0.25000 161460.0n 0.31000 161589.9n 0.31000 161590.0n 0.25000 161719.9n 0.25000 161720.0n 0.31000 161849.9n 0.31000 161850.0n 0.25000 161979.9n 0.25000 161980.0n 0.31000 162109.9n 0.31000 162110.0n 0.25000 162239.9n 0.25000 162240.0n 0.28000 162369.9n 0.28000 162370.0n 0.28000 162499.9n 0.28000 162500.0n 0.28000 162629.9n 0.28000 162630.0n 0.28000 162759.9n 0.28000 162760.0n 0.28000 162889.9n 0.28000 162890.0n 0.28000 163019.9n 0.28000 163020.0n 0.28000 163149.9n 0.28000 163150.0n 0.28000 163279.9n 0.28000 163280.0n 0.28000 163409.9n 0.28000 163410.0n 0.28000 163539.9n 0.28000 163540.0n 0.28000 163669.9n 0.28000 163670.0n 0.28000 163799.9n 0.28000 163800.0n 0.28000 163929.9n 0.28000 163930.0n 0.28000 164059.9n 0.28000 164060.0n 0.28000 164189.9n 0.28000 164190.0n 0.28000 164319.9n 0.28000 164320.0n 0.28000 164449.9n 0.28000 164450.0n 0.28000 164579.9n 0.28000 164580.0n 0.28000 164709.9n 0.28000 164710.0n 0.28000 164839.9n 0.28000 164840.0n 0.28000 164969.9n 0.28000 164970.0n 0.28000 165099.9n 0.28000 165100.0n 0.28000 165229.9n 0.28000 165230.0n 0.28000 165359.9n 0.28000 165360.0n 0.28000 165489.9n 0.28000 165490.0n 0.28000 165619.9n 0.28000 165620.0n 0.28000 165749.9n 0.28000 165750.0n 0.28000 165879.9n 0.28000 165880.0n 0.28000 166009.9n 0.28000 166010.0n 0.28000 166139.9n 0.28000 166140.0n 0.28000 166269.9n 0.28000 166270.0n 0.28000 166399.9n 0.28000 166400.0n 0.28000 166529.9n 0.28000 166530.0n 0.28000 166659.9n 0.28000 166660.0n 0.28000 166789.9n 0.28000 166790.0n 0.28000 166919.9n 0.28000 166920.0n 0.28000 167049.9n 0.28000 167050.0n 0.28000 167179.9n 0.28000 167180.0n 0.28000 167309.9n 0.28000 167310.0n 0.28000 167439.9n 0.28000 167440.0n 0.28000 167569.9n 0.28000 167570.0n 0.28000 167699.9n 0.28000 167700.0n 0.28000 167829.9n 0.28000 167830.0n 0.28000 167959.9n 0.28000 167960.0n 0.28000 168089.9n 0.28000 168090.0n 0.28000 168219.9n 0.28000 168220.0n 0.28000 168349.9n 0.28000 168350.0n 0.28000)
Vahcm ahcm 0 0.666
Vwih_p_0_0 wih_p_0_0 0 0.9
Vwih_n_0_0 wih_n_0_0 0 0.3
Vwih_p_1_0 wih_p_1_0 0 0.3
Vwih_n_1_0 wih_n_1_0 0 0.8077526372768347
Vwih_p_2_0 wih_p_2_0 0 0.9
Vwih_n_2_0 wih_n_2_0 0 0.3
Xcm_xh0 xhp0 xhn0 vdd cmld
Rnd_xh0 xhp0 xhn0 20k
Cxh0p xhp0 0 1e-13
Cxh0n xhn0 0 1e-13
Xih_0_0 a_xp0 a_xn0 wih_p_0_0 wih_n_0_0 xhp0 xhn0 vdd vbsyn gsyn
Xih_1_0 a_xp1 a_xn1 wih_p_1_0 wih_n_1_0 xhp0 xhn0 vdd vbsyn gsyn
Xih_2_0 a_xp2 a_xn2 wih_p_2_0 wih_n_2_0 xhp0 xhn0 vdd vbsyn gsyn
Xn0 xhp0 xhn0 ahp0 ahn0 vdd vbneu dneuron
Vwih_p_0_1 wih_p_0_1 0 0.4076074543279496
Vwih_n_0_1 wih_n_0_1 0 0.5923925456720505
Vwih_p_1_1 wih_p_1_1 0 0.6875517955179162
Vwih_n_1_1 wih_n_1_1 0 0.31244820448208377
Vwih_p_2_1 wih_p_2_1 0 0.9
Vwih_n_2_1 wih_n_2_1 0 0.3
Xcm_xh1 xhp1 xhn1 vdd cmld
Rnd_xh1 xhp1 xhn1 20k
Cxh1p xhp1 0 1e-13
Cxh1n xhn1 0 1e-13
Xih_0_1 a_xp0 a_xn0 wih_p_0_1 wih_n_0_1 xhp1 xhn1 vdd vbsyn gsyn
Xih_1_1 a_xp1 a_xn1 wih_p_1_1 wih_n_1_1 xhp1 xhn1 vdd vbsyn gsyn
Xih_2_1 a_xp2 a_xn2 wih_p_2_1 wih_n_2_1 xhp1 xhn1 vdd vbsyn gsyn
Xn1 xhp1 xhn1 ahp1 ahn1 vdd vbneu dneuron
Vwih_p_0_2 wih_p_0_2 0 0.6986905748958001
Vwih_n_0_2 wih_n_0_2 0 0.30130942510419984
Vwih_p_1_2 wih_p_1_2 0 0.8611596583173695
Vwih_n_1_2 wih_n_1_2 0 0.3
Vwih_p_2_2 wih_p_2_2 0 0.3
Vwih_n_2_2 wih_n_2_2 0 0.9
Xcm_xh2 xhp2 xhn2 vdd cmld
Rnd_xh2 xhp2 xhn2 20k
Cxh2p xhp2 0 1e-13
Cxh2n xhn2 0 1e-13
Xih_0_2 a_xp0 a_xn0 wih_p_0_2 wih_n_0_2 xhp2 xhn2 vdd vbsyn gsyn
Xih_1_2 a_xp1 a_xn1 wih_p_1_2 wih_n_1_2 xhp2 xhn2 vdd vbsyn gsyn
Xih_2_2 a_xp2 a_xn2 wih_p_2_2 wih_n_2_2 xhp2 xhn2 vdd vbsyn gsyn
Xn2 xhp2 xhn2 ahp2 ahn2 vdd vbneu dneuron
Vwih_p_0_3 wih_p_0_3 0 0.3
Vwih_n_0_3 wih_n_0_3 0 0.7073156875091838
Vwih_p_1_3 wih_p_1_3 0 0.9
Vwih_n_1_3 wih_n_1_3 0 0.3
Vwih_p_2_3 wih_p_2_3 0 0.3968886139217385
Vwih_n_2_3 wih_n_2_3 0 0.6031113860782614
Xcm_xh3 xhp3 xhn3 vdd cmld
Rnd_xh3 xhp3 xhn3 20k
Cxh3p xhp3 0 1e-13
Cxh3n xhn3 0 1e-13
Xih_0_3 a_xp0 a_xn0 wih_p_0_3 wih_n_0_3 xhp3 xhn3 vdd vbsyn gsyn
Xih_1_3 a_xp1 a_xn1 wih_p_1_3 wih_n_1_3 xhp3 xhn3 vdd vbsyn gsyn
Xih_2_3 a_xp2 a_xn2 wih_p_2_3 wih_n_2_3 xhp3 xhn3 vdd vbsyn gsyn
Xn3 xhp3 xhn3 ahp3 ahn3 vdd vbneu dneuron
Vwih_p_0_4 wih_p_0_4 0 0.643383333655023
Vwih_n_0_4 wih_n_0_4 0 0.356616666344977
Vwih_p_1_4 wih_p_1_4 0 0.426609605197966
Vwih_n_1_4 wih_n_1_4 0 0.573390394802034
Vwih_p_2_4 wih_p_2_4 0 0.3
Vwih_n_2_4 wih_n_2_4 0 0.779710110256914
Xcm_xh4 xhp4 xhn4 vdd cmld
Rnd_xh4 xhp4 xhn4 20k
Cxh4p xhp4 0 1e-13
Cxh4n xhn4 0 1e-13
Xih_0_4 a_xp0 a_xn0 wih_p_0_4 wih_n_0_4 xhp4 xhn4 vdd vbsyn gsyn
Xih_1_4 a_xp1 a_xn1 wih_p_1_4 wih_n_1_4 xhp4 xhn4 vdd vbsyn gsyn
Xih_2_4 a_xp2 a_xn2 wih_p_2_4 wih_n_2_4 xhp4 xhn4 vdd vbsyn gsyn
Xn4 xhp4 xhn4 ahp4 ahn4 vdd vbneu dneuron
Vwih_p_0_5 wih_p_0_5 0 0.3
Vwih_n_0_5 wih_n_0_5 0 0.9
Vwih_p_1_5 wih_p_1_5 0 0.3
Vwih_n_1_5 wih_n_1_5 0 0.9
Vwih_p_2_5 wih_p_2_5 0 0.9
Vwih_n_2_5 wih_n_2_5 0 0.3
Xcm_xh5 xhp5 xhn5 vdd cmld
Rnd_xh5 xhp5 xhn5 20k
Cxh5p xhp5 0 1e-13
Cxh5n xhn5 0 1e-13
Xih_0_5 a_xp0 a_xn0 wih_p_0_5 wih_n_0_5 xhp5 xhn5 vdd vbsyn gsyn
Xih_1_5 a_xp1 a_xn1 wih_p_1_5 wih_n_1_5 xhp5 xhn5 vdd vbsyn gsyn
Xih_2_5 a_xp2 a_xn2 wih_p_2_5 wih_n_2_5 xhp5 xhn5 vdd vbsyn gsyn
Xn5 xhp5 xhn5 ahp5 ahn5 vdd vbneu dneuron
Vwih_p_0_6 wih_p_0_6 0 0.4644227134047597
Vwih_n_0_6 wih_n_0_6 0 0.5355772865952403
Vwih_p_1_6 wih_p_1_6 0 0.3
Vwih_n_1_6 wih_n_1_6 0 0.9
Vwih_p_2_6 wih_p_2_6 0 0.3
Vwih_n_2_6 wih_n_2_6 0 0.9
Xcm_xh6 xhp6 xhn6 vdd cmld
Rnd_xh6 xhp6 xhn6 20k
Cxh6p xhp6 0 1e-13
Cxh6n xhn6 0 1e-13
Xih_0_6 a_xp0 a_xn0 wih_p_0_6 wih_n_0_6 xhp6 xhn6 vdd vbsyn gsyn
Xih_1_6 a_xp1 a_xn1 wih_p_1_6 wih_n_1_6 xhp6 xhn6 vdd vbsyn gsyn
Xih_2_6 a_xp2 a_xn2 wih_p_2_6 wih_n_2_6 xhp6 xhn6 vdd vbsyn gsyn
Xn6 xhp6 xhn6 ahp6 ahn6 vdd vbneu dneuron
Vwih_p_0_7 wih_p_0_7 0 0.8930428788399948
Vwih_n_0_7 wih_n_0_7 0 0.3
Vwih_p_1_7 wih_p_1_7 0 0.3
Vwih_n_1_7 wih_n_1_7 0 0.9
Vwih_p_2_7 wih_p_2_7 0 0.3
Vwih_n_2_7 wih_n_2_7 0 0.7814083238372862
Xcm_xh7 xhp7 xhn7 vdd cmld
Rnd_xh7 xhp7 xhn7 20k
Cxh7p xhp7 0 1e-13
Cxh7n xhn7 0 1e-13
Xih_0_7 a_xp0 a_xn0 wih_p_0_7 wih_n_0_7 xhp7 xhn7 vdd vbsyn gsyn
Xih_1_7 a_xp1 a_xn1 wih_p_1_7 wih_n_1_7 xhp7 xhn7 vdd vbsyn gsyn
Xih_2_7 a_xp2 a_xn2 wih_p_2_7 wih_n_2_7 xhp7 xhn7 vdd vbsyn gsyn
Xn7 xhp7 xhn7 ahp7 ahn7 vdd vbneu dneuron
Vwih_p_0_8 wih_p_0_8 0 0.3
Vwih_n_0_8 wih_n_0_8 0 0.9
Vwih_p_1_8 wih_p_1_8 0 0.3
Vwih_n_1_8 wih_n_1_8 0 0.9
Vwih_p_2_8 wih_p_2_8 0 0.9
Vwih_n_2_8 wih_n_2_8 0 0.3
Xcm_xh8 xhp8 xhn8 vdd cmld
Rnd_xh8 xhp8 xhn8 20k
Cxh8p xhp8 0 1e-13
Cxh8n xhn8 0 1e-13
Xih_0_8 a_xp0 a_xn0 wih_p_0_8 wih_n_0_8 xhp8 xhn8 vdd vbsyn gsyn
Xih_1_8 a_xp1 a_xn1 wih_p_1_8 wih_n_1_8 xhp8 xhn8 vdd vbsyn gsyn
Xih_2_8 a_xp2 a_xn2 wih_p_2_8 wih_n_2_8 xhp8 xhn8 vdd vbsyn gsyn
Xn8 xhp8 xhn8 ahp8 ahn8 vdd vbneu dneuron
Vwih_p_0_9 wih_p_0_9 0 0.43659969851895275
Vwih_n_0_9 wih_n_0_9 0 0.5634003014810472
Vwih_p_1_9 wih_p_1_9 0 0.35532188681769517
Vwih_n_1_9 wih_n_1_9 0 0.6446781131823048
Vwih_p_2_9 wih_p_2_9 0 0.3
Vwih_n_2_9 wih_n_2_9 0 0.770652332104687
Xcm_xh9 xhp9 xhn9 vdd cmld
Rnd_xh9 xhp9 xhn9 20k
Cxh9p xhp9 0 1e-13
Cxh9n xhn9 0 1e-13
Xih_0_9 a_xp0 a_xn0 wih_p_0_9 wih_n_0_9 xhp9 xhn9 vdd vbsyn gsyn
Xih_1_9 a_xp1 a_xn1 wih_p_1_9 wih_n_1_9 xhp9 xhn9 vdd vbsyn gsyn
Xih_2_9 a_xp2 a_xn2 wih_p_2_9 wih_n_2_9 xhp9 xhn9 vdd vbsyn gsyn
Xn9 xhp9 xhn9 ahp9 ahn9 vdd vbneu dneuron
Vwih_p_0_10 wih_p_0_10 0 0.8206037983083873
Vwih_n_0_10 wih_n_0_10 0 0.3
Vwih_p_1_10 wih_p_1_10 0 0.5276620970012434
Vwih_n_1_10 wih_n_1_10 0 0.47233790299875655
Vwih_p_2_10 wih_p_2_10 0 0.6315537008964082
Vwih_n_2_10 wih_n_2_10 0 0.36844629910359183
Xcm_xh10 xhp10 xhn10 vdd cmld
Rnd_xh10 xhp10 xhn10 20k
Cxh10p xhp10 0 1e-13
Cxh10n xhn10 0 1e-13
Xih_0_10 a_xp0 a_xn0 wih_p_0_10 wih_n_0_10 xhp10 xhn10 vdd vbsyn gsyn
Xih_1_10 a_xp1 a_xn1 wih_p_1_10 wih_n_1_10 xhp10 xhn10 vdd vbsyn gsyn
Xih_2_10 a_xp2 a_xn2 wih_p_2_10 wih_n_2_10 xhp10 xhn10 vdd vbsyn gsyn
Xn10 xhp10 xhn10 ahp10 ahn10 vdd vbneu dneuron
Vwih_p_0_11 wih_p_0_11 0 0.5615896328228672
Vwih_n_0_11 wih_n_0_11 0 0.4384103671771328
Vwih_p_1_11 wih_p_1_11 0 0.3392052445189821
Vwih_n_1_11 wih_n_1_11 0 0.6607947554810178
Vwih_p_2_11 wih_p_2_11 0 0.3
Vwih_n_2_11 wih_n_2_11 0 0.7163998120574444
Xcm_xh11 xhp11 xhn11 vdd cmld
Rnd_xh11 xhp11 xhn11 20k
Cxh11p xhp11 0 1e-13
Cxh11n xhn11 0 1e-13
Xih_0_11 a_xp0 a_xn0 wih_p_0_11 wih_n_0_11 xhp11 xhn11 vdd vbsyn gsyn
Xih_1_11 a_xp1 a_xn1 wih_p_1_11 wih_n_1_11 xhp11 xhn11 vdd vbsyn gsyn
Xih_2_11 a_xp2 a_xn2 wih_p_2_11 wih_n_2_11 xhp11 xhn11 vdd vbsyn gsyn
Xn11 xhp11 xhn11 ahp11 ahn11 vdd vbneu dneuron
Vwih_p_0_12 wih_p_0_12 0 0.3
Vwih_n_0_12 wih_n_0_12 0 0.9
Vwih_p_1_12 wih_p_1_12 0 0.3
Vwih_n_1_12 wih_n_1_12 0 0.7213002021183876
Vwih_p_2_12 wih_p_2_12 0 0.9
Vwih_n_2_12 wih_n_2_12 0 0.3
Xcm_xh12 xhp12 xhn12 vdd cmld
Rnd_xh12 xhp12 xhn12 20k
Cxh12p xhp12 0 1e-13
Cxh12n xhn12 0 1e-13
Xih_0_12 a_xp0 a_xn0 wih_p_0_12 wih_n_0_12 xhp12 xhn12 vdd vbsyn gsyn
Xih_1_12 a_xp1 a_xn1 wih_p_1_12 wih_n_1_12 xhp12 xhn12 vdd vbsyn gsyn
Xih_2_12 a_xp2 a_xn2 wih_p_2_12 wih_n_2_12 xhp12 xhn12 vdd vbsyn gsyn
Xn12 xhp12 xhn12 ahp12 ahn12 vdd vbneu dneuron
Vwih_p_0_13 wih_p_0_13 0 0.3
Vwih_n_0_13 wih_n_0_13 0 0.9
Vwih_p_1_13 wih_p_1_13 0 0.5019673310802524
Vwih_n_1_13 wih_n_1_13 0 0.4980326689197476
Vwih_p_2_13 wih_p_2_13 0 0.6510764412903762
Vwih_n_2_13 wih_n_2_13 0 0.3489235587096237
Xcm_xh13 xhp13 xhn13 vdd cmld
Rnd_xh13 xhp13 xhn13 20k
Cxh13p xhp13 0 1e-13
Cxh13n xhn13 0 1e-13
Xih_0_13 a_xp0 a_xn0 wih_p_0_13 wih_n_0_13 xhp13 xhn13 vdd vbsyn gsyn
Xih_1_13 a_xp1 a_xn1 wih_p_1_13 wih_n_1_13 xhp13 xhn13 vdd vbsyn gsyn
Xih_2_13 a_xp2 a_xn2 wih_p_2_13 wih_n_2_13 xhp13 xhn13 vdd vbsyn gsyn
Xn13 xhp13 xhn13 ahp13 ahn13 vdd vbneu dneuron
Vwih_p_0_14 wih_p_0_14 0 0.9
Vwih_n_0_14 wih_n_0_14 0 0.3
Vwih_p_1_14 wih_p_1_14 0 0.9
Vwih_n_1_14 wih_n_1_14 0 0.3
Vwih_p_2_14 wih_p_2_14 0 0.321441830538693
Vwih_n_2_14 wih_n_2_14 0 0.678558169461307
Xcm_xh14 xhp14 xhn14 vdd cmld
Rnd_xh14 xhp14 xhn14 20k
Cxh14p xhp14 0 1e-13
Cxh14n xhn14 0 1e-13
Xih_0_14 a_xp0 a_xn0 wih_p_0_14 wih_n_0_14 xhp14 xhn14 vdd vbsyn gsyn
Xih_1_14 a_xp1 a_xn1 wih_p_1_14 wih_n_1_14 xhp14 xhn14 vdd vbsyn gsyn
Xih_2_14 a_xp2 a_xn2 wih_p_2_14 wih_n_2_14 xhp14 xhn14 vdd vbsyn gsyn
Xn14 xhp14 xhn14 ahp14 ahn14 vdd vbneu dneuron
Vwih_p_0_15 wih_p_0_15 0 0.3
Vwih_n_0_15 wih_n_0_15 0 0.8946964794631206
Vwih_p_1_15 wih_p_1_15 0 0.9
Vwih_n_1_15 wih_n_1_15 0 0.3
Vwih_p_2_15 wih_p_2_15 0 0.5958540050197993
Vwih_n_2_15 wih_n_2_15 0 0.4041459949802006
Xcm_xh15 xhp15 xhn15 vdd cmld
Rnd_xh15 xhp15 xhn15 20k
Cxh15p xhp15 0 1e-13
Cxh15n xhn15 0 1e-13
Xih_0_15 a_xp0 a_xn0 wih_p_0_15 wih_n_0_15 xhp15 xhn15 vdd vbsyn gsyn
Xih_1_15 a_xp1 a_xn1 wih_p_1_15 wih_n_1_15 xhp15 xhn15 vdd vbsyn gsyn
Xih_2_15 a_xp2 a_xn2 wih_p_2_15 wih_n_2_15 xhp15 xhn15 vdd vbsyn gsyn
Xn15 xhp15 xhn15 ahp15 ahn15 vdd vbneu dneuron
Vwih_p_0_16 wih_p_0_16 0 0.9
Vwih_n_0_16 wih_n_0_16 0 0.3
Vwih_p_1_16 wih_p_1_16 0 0.8264016782997259
Vwih_n_1_16 wih_n_1_16 0 0.3
Vwih_p_2_16 wih_p_2_16 0 0.3
Vwih_n_2_16 wih_n_2_16 0 0.8009587065328215
Xcm_xh16 xhp16 xhn16 vdd cmld
Rnd_xh16 xhp16 xhn16 20k
Cxh16p xhp16 0 1e-13
Cxh16n xhn16 0 1e-13
Xih_0_16 a_xp0 a_xn0 wih_p_0_16 wih_n_0_16 xhp16 xhn16 vdd vbsyn gsyn
Xih_1_16 a_xp1 a_xn1 wih_p_1_16 wih_n_1_16 xhp16 xhn16 vdd vbsyn gsyn
Xih_2_16 a_xp2 a_xn2 wih_p_2_16 wih_n_2_16 xhp16 xhn16 vdd vbsyn gsyn
Xn16 xhp16 xhn16 ahp16 ahn16 vdd vbneu dneuron
Vwih_p_0_17 wih_p_0_17 0 0.4115141976338063
Vwih_n_0_17 wih_n_0_17 0 0.5884858023661936
Vwih_p_1_17 wih_p_1_17 0 0.6903674851964131
Vwih_n_1_17 wih_n_1_17 0 0.3096325148035869
Vwih_p_2_17 wih_p_2_17 0 0.7253099866650734
Vwih_n_2_17 wih_n_2_17 0 0.3
Xcm_xh17 xhp17 xhn17 vdd cmld
Rnd_xh17 xhp17 xhn17 20k
Cxh17p xhp17 0 1e-13
Cxh17n xhn17 0 1e-13
Xih_0_17 a_xp0 a_xn0 wih_p_0_17 wih_n_0_17 xhp17 xhn17 vdd vbsyn gsyn
Xih_1_17 a_xp1 a_xn1 wih_p_1_17 wih_n_1_17 xhp17 xhn17 vdd vbsyn gsyn
Xih_2_17 a_xp2 a_xn2 wih_p_2_17 wih_n_2_17 xhp17 xhn17 vdd vbsyn gsyn
Xn17 xhp17 xhn17 ahp17 ahn17 vdd vbneu dneuron
Vwih_p_0_18 wih_p_0_18 0 0.3
Vwih_n_0_18 wih_n_0_18 0 0.9
Vwih_p_1_18 wih_p_1_18 0 0.3
Vwih_n_1_18 wih_n_1_18 0 0.9
Vwih_p_2_18 wih_p_2_18 0 0.3
Vwih_n_2_18 wih_n_2_18 0 0.9
Xcm_xh18 xhp18 xhn18 vdd cmld
Rnd_xh18 xhp18 xhn18 20k
Cxh18p xhp18 0 1e-13
Cxh18n xhn18 0 1e-13
Xih_0_18 a_xp0 a_xn0 wih_p_0_18 wih_n_0_18 xhp18 xhn18 vdd vbsyn gsyn
Xih_1_18 a_xp1 a_xn1 wih_p_1_18 wih_n_1_18 xhp18 xhn18 vdd vbsyn gsyn
Xih_2_18 a_xp2 a_xn2 wih_p_2_18 wih_n_2_18 xhp18 xhn18 vdd vbsyn gsyn
Xn18 xhp18 xhn18 ahp18 ahn18 vdd vbneu dneuron
Vwih_p_0_19 wih_p_0_19 0 0.7777220499589362
Vwih_n_0_19 wih_n_0_19 0 0.3
Vwih_p_1_19 wih_p_1_19 0 0.4310427827422266
Vwih_n_1_19 wih_n_1_19 0 0.5689572172577734
Vwih_p_2_19 wih_p_2_19 0 0.3
Vwih_n_2_19 wih_n_2_19 0 0.9
Xcm_xh19 xhp19 xhn19 vdd cmld
Rnd_xh19 xhp19 xhn19 20k
Cxh19p xhp19 0 1e-13
Cxh19n xhn19 0 1e-13
Xih_0_19 a_xp0 a_xn0 wih_p_0_19 wih_n_0_19 xhp19 xhn19 vdd vbsyn gsyn
Xih_1_19 a_xp1 a_xn1 wih_p_1_19 wih_n_1_19 xhp19 xhn19 vdd vbsyn gsyn
Xih_2_19 a_xp2 a_xn2 wih_p_2_19 wih_n_2_19 xhp19 xhn19 vdd vbsyn gsyn
Xn19 xhp19 xhn19 ahp19 ahn19 vdd vbneu dneuron
Vwih_p_0_20 wih_p_0_20 0 0.3
Vwih_n_0_20 wih_n_0_20 0 0.7478781116735951
Vwih_p_1_20 wih_p_1_20 0 0.3
Vwih_n_1_20 wih_n_1_20 0 0.9
Vwih_p_2_20 wih_p_2_20 0 0.3815696565850669
Vwih_n_2_20 wih_n_2_20 0 0.6184303434149331
Xcm_xh20 xhp20 xhn20 vdd cmld
Rnd_xh20 xhp20 xhn20 20k
Cxh20p xhp20 0 1e-13
Cxh20n xhn20 0 1e-13
Xih_0_20 a_xp0 a_xn0 wih_p_0_20 wih_n_0_20 xhp20 xhn20 vdd vbsyn gsyn
Xih_1_20 a_xp1 a_xn1 wih_p_1_20 wih_n_1_20 xhp20 xhn20 vdd vbsyn gsyn
Xih_2_20 a_xp2 a_xn2 wih_p_2_20 wih_n_2_20 xhp20 xhn20 vdd vbsyn gsyn
Xn20 xhp20 xhn20 ahp20 ahn20 vdd vbneu dneuron
Vwih_p_0_21 wih_p_0_21 0 0.3
Vwih_n_0_21 wih_n_0_21 0 0.8894118236059116
Vwih_p_1_21 wih_p_1_21 0 0.3
Vwih_n_1_21 wih_n_1_21 0 0.7510846099149556
Vwih_p_2_21 wih_p_2_21 0 0.46204030518827083
Vwih_n_2_21 wih_n_2_21 0 0.5379596948117292
Xcm_xh21 xhp21 xhn21 vdd cmld
Rnd_xh21 xhp21 xhn21 20k
Cxh21p xhp21 0 1e-13
Cxh21n xhn21 0 1e-13
Xih_0_21 a_xp0 a_xn0 wih_p_0_21 wih_n_0_21 xhp21 xhn21 vdd vbsyn gsyn
Xih_1_21 a_xp1 a_xn1 wih_p_1_21 wih_n_1_21 xhp21 xhn21 vdd vbsyn gsyn
Xih_2_21 a_xp2 a_xn2 wih_p_2_21 wih_n_2_21 xhp21 xhn21 vdd vbsyn gsyn
Xn21 xhp21 xhn21 ahp21 ahn21 vdd vbneu dneuron
Vwih_p_0_22 wih_p_0_22 0 0.582183485192292
Vwih_n_0_22 wih_n_0_22 0 0.417816514807708
Vwih_p_1_22 wih_p_1_22 0 0.5267999164136071
Vwih_n_1_22 wih_n_1_22 0 0.47320008358639293
Vwih_p_2_22 wih_p_2_22 0 0.9
Vwih_n_2_22 wih_n_2_22 0 0.3
Xcm_xh22 xhp22 xhn22 vdd cmld
Rnd_xh22 xhp22 xhn22 20k
Cxh22p xhp22 0 1e-13
Cxh22n xhn22 0 1e-13
Xih_0_22 a_xp0 a_xn0 wih_p_0_22 wih_n_0_22 xhp22 xhn22 vdd vbsyn gsyn
Xih_1_22 a_xp1 a_xn1 wih_p_1_22 wih_n_1_22 xhp22 xhn22 vdd vbsyn gsyn
Xih_2_22 a_xp2 a_xn2 wih_p_2_22 wih_n_2_22 xhp22 xhn22 vdd vbsyn gsyn
Xn22 xhp22 xhn22 ahp22 ahn22 vdd vbneu dneuron
Vwih_p_0_23 wih_p_0_23 0 0.9
Vwih_n_0_23 wih_n_0_23 0 0.3
Vwih_p_1_23 wih_p_1_23 0 0.8833839713323164
Vwih_n_1_23 wih_n_1_23 0 0.3
Vwih_p_2_23 wih_p_2_23 0 0.41466542792757277
Vwih_n_2_23 wih_n_2_23 0 0.5853345720724272
Xcm_xh23 xhp23 xhn23 vdd cmld
Rnd_xh23 xhp23 xhn23 20k
Cxh23p xhp23 0 1e-13
Cxh23n xhn23 0 1e-13
Xih_0_23 a_xp0 a_xn0 wih_p_0_23 wih_n_0_23 xhp23 xhn23 vdd vbsyn gsyn
Xih_1_23 a_xp1 a_xn1 wih_p_1_23 wih_n_1_23 xhp23 xhn23 vdd vbsyn gsyn
Xih_2_23 a_xp2 a_xn2 wih_p_2_23 wih_n_2_23 xhp23 xhn23 vdd vbsyn gsyn
Xn23 xhp23 xhn23 ahp23 ahn23 vdd vbneu dneuron
Vwih_p_0_24 wih_p_0_24 0 0.8383855046538757
Vwih_n_0_24 wih_n_0_24 0 0.3
Vwih_p_1_24 wih_p_1_24 0 0.3
Vwih_n_1_24 wih_n_1_24 0 0.8272699221557627
Vwih_p_2_24 wih_p_2_24 0 0.3
Vwih_n_2_24 wih_n_2_24 0 0.8716267349962367
Xcm_xh24 xhp24 xhn24 vdd cmld
Rnd_xh24 xhp24 xhn24 20k
Cxh24p xhp24 0 1e-13
Cxh24n xhn24 0 1e-13
Xih_0_24 a_xp0 a_xn0 wih_p_0_24 wih_n_0_24 xhp24 xhn24 vdd vbsyn gsyn
Xih_1_24 a_xp1 a_xn1 wih_p_1_24 wih_n_1_24 xhp24 xhn24 vdd vbsyn gsyn
Xih_2_24 a_xp2 a_xn2 wih_p_2_24 wih_n_2_24 xhp24 xhn24 vdd vbsyn gsyn
Xn24 xhp24 xhn24 ahp24 ahn24 vdd vbneu dneuron
Vwih_p_0_25 wih_p_0_25 0 0.3
Vwih_n_0_25 wih_n_0_25 0 0.8920600682828617
Vwih_p_1_25 wih_p_1_25 0 0.6315617547273517
Vwih_n_1_25 wih_n_1_25 0 0.36843824527264835
Vwih_p_2_25 wih_p_2_25 0 0.9
Vwih_n_2_25 wih_n_2_25 0 0.3
Xcm_xh25 xhp25 xhn25 vdd cmld
Rnd_xh25 xhp25 xhn25 20k
Cxh25p xhp25 0 1e-13
Cxh25n xhn25 0 1e-13
Xih_0_25 a_xp0 a_xn0 wih_p_0_25 wih_n_0_25 xhp25 xhn25 vdd vbsyn gsyn
Xih_1_25 a_xp1 a_xn1 wih_p_1_25 wih_n_1_25 xhp25 xhn25 vdd vbsyn gsyn
Xih_2_25 a_xp2 a_xn2 wih_p_2_25 wih_n_2_25 xhp25 xhn25 vdd vbsyn gsyn
Xn25 xhp25 xhn25 ahp25 ahn25 vdd vbneu dneuron
Vwih_p_0_26 wih_p_0_26 0 0.9
Vwih_n_0_26 wih_n_0_26 0 0.3
Vwih_p_1_26 wih_p_1_26 0 0.9
Vwih_n_1_26 wih_n_1_26 0 0.3
Vwih_p_2_26 wih_p_2_26 0 0.8139593149778681
Vwih_n_2_26 wih_n_2_26 0 0.3
Xcm_xh26 xhp26 xhn26 vdd cmld
Rnd_xh26 xhp26 xhn26 20k
Cxh26p xhp26 0 1e-13
Cxh26n xhn26 0 1e-13
Xih_0_26 a_xp0 a_xn0 wih_p_0_26 wih_n_0_26 xhp26 xhn26 vdd vbsyn gsyn
Xih_1_26 a_xp1 a_xn1 wih_p_1_26 wih_n_1_26 xhp26 xhn26 vdd vbsyn gsyn
Xih_2_26 a_xp2 a_xn2 wih_p_2_26 wih_n_2_26 xhp26 xhn26 vdd vbsyn gsyn
Xn26 xhp26 xhn26 ahp26 ahn26 vdd vbneu dneuron
Vwih_p_0_27 wih_p_0_27 0 0.3
Vwih_n_0_27 wih_n_0_27 0 0.8097470131671487
Vwih_p_1_27 wih_p_1_27 0 0.5344916941866533
Vwih_n_1_27 wih_n_1_27 0 0.4655083058133466
Vwih_p_2_27 wih_p_2_27 0 0.7445566783958016
Vwih_n_2_27 wih_n_2_27 0 0.3
Xcm_xh27 xhp27 xhn27 vdd cmld
Rnd_xh27 xhp27 xhn27 20k
Cxh27p xhp27 0 1e-13
Cxh27n xhn27 0 1e-13
Xih_0_27 a_xp0 a_xn0 wih_p_0_27 wih_n_0_27 xhp27 xhn27 vdd vbsyn gsyn
Xih_1_27 a_xp1 a_xn1 wih_p_1_27 wih_n_1_27 xhp27 xhn27 vdd vbsyn gsyn
Xih_2_27 a_xp2 a_xn2 wih_p_2_27 wih_n_2_27 xhp27 xhn27 vdd vbsyn gsyn
Xn27 xhp27 xhn27 ahp27 ahn27 vdd vbneu dneuron
Vwih_p_0_28 wih_p_0_28 0 0.44498611311859815
Vwih_n_0_28 wih_n_0_28 0 0.5550138868814019
Vwih_p_1_28 wih_p_1_28 0 0.9
Vwih_n_1_28 wih_n_1_28 0 0.3
Vwih_p_2_28 wih_p_2_28 0 0.3
Vwih_n_2_28 wih_n_2_28 0 0.8689778346029556
Xcm_xh28 xhp28 xhn28 vdd cmld
Rnd_xh28 xhp28 xhn28 20k
Cxh28p xhp28 0 1e-13
Cxh28n xhn28 0 1e-13
Xih_0_28 a_xp0 a_xn0 wih_p_0_28 wih_n_0_28 xhp28 xhn28 vdd vbsyn gsyn
Xih_1_28 a_xp1 a_xn1 wih_p_1_28 wih_n_1_28 xhp28 xhn28 vdd vbsyn gsyn
Xih_2_28 a_xp2 a_xn2 wih_p_2_28 wih_n_2_28 xhp28 xhn28 vdd vbsyn gsyn
Xn28 xhp28 xhn28 ahp28 ahn28 vdd vbneu dneuron
Vwih_p_0_29 wih_p_0_29 0 0.3
Vwih_n_0_29 wih_n_0_29 0 0.8213620141203385
Vwih_p_1_29 wih_p_1_29 0 0.6710202455048602
Vwih_n_1_29 wih_n_1_29 0 0.32897975449513983
Vwih_p_2_29 wih_p_2_29 0 0.9
Vwih_n_2_29 wih_n_2_29 0 0.3
Xcm_xh29 xhp29 xhn29 vdd cmld
Rnd_xh29 xhp29 xhn29 20k
Cxh29p xhp29 0 1e-13
Cxh29n xhn29 0 1e-13
Xih_0_29 a_xp0 a_xn0 wih_p_0_29 wih_n_0_29 xhp29 xhn29 vdd vbsyn gsyn
Xih_1_29 a_xp1 a_xn1 wih_p_1_29 wih_n_1_29 xhp29 xhn29 vdd vbsyn gsyn
Xih_2_29 a_xp2 a_xn2 wih_p_2_29 wih_n_2_29 xhp29 xhn29 vdd vbsyn gsyn
Xn29 xhp29 xhn29 ahp29 ahn29 vdd vbneu dneuron
Vwih_p_0_30 wih_p_0_30 0 0.3
Vwih_n_0_30 wih_n_0_30 0 0.9
Vwih_p_1_30 wih_p_1_30 0 0.3
Vwih_n_1_30 wih_n_1_30 0 0.88071809457155
Vwih_p_2_30 wih_p_2_30 0 0.9
Vwih_n_2_30 wih_n_2_30 0 0.3
Xcm_xh30 xhp30 xhn30 vdd cmld
Rnd_xh30 xhp30 xhn30 20k
Cxh30p xhp30 0 1e-13
Cxh30n xhn30 0 1e-13
Xih_0_30 a_xp0 a_xn0 wih_p_0_30 wih_n_0_30 xhp30 xhn30 vdd vbsyn gsyn
Xih_1_30 a_xp1 a_xn1 wih_p_1_30 wih_n_1_30 xhp30 xhn30 vdd vbsyn gsyn
Xih_2_30 a_xp2 a_xn2 wih_p_2_30 wih_n_2_30 xhp30 xhn30 vdd vbsyn gsyn
Xn30 xhp30 xhn30 ahp30 ahn30 vdd vbneu dneuron
Vwih_p_0_31 wih_p_0_31 0 0.3
Vwih_n_0_31 wih_n_0_31 0 0.80552795301878
Vwih_p_1_31 wih_p_1_31 0 0.9
Vwih_n_1_31 wih_n_1_31 0 0.3
Vwih_p_2_31 wih_p_2_31 0 0.3
Vwih_n_2_31 wih_n_2_31 0 0.869683849401294
Xcm_xh31 xhp31 xhn31 vdd cmld
Rnd_xh31 xhp31 xhn31 20k
Cxh31p xhp31 0 1e-13
Cxh31n xhn31 0 1e-13
Xih_0_31 a_xp0 a_xn0 wih_p_0_31 wih_n_0_31 xhp31 xhn31 vdd vbsyn gsyn
Xih_1_31 a_xp1 a_xn1 wih_p_1_31 wih_n_1_31 xhp31 xhn31 vdd vbsyn gsyn
Xih_2_31 a_xp2 a_xn2 wih_p_2_31 wih_n_2_31 xhp31 xhn31 vdd vbsyn gsyn
Xn31 xhp31 xhn31 ahp31 ahn31 vdd vbneu dneuron
Vwih_p_0_32 wih_p_0_32 0 0.9
Vwih_n_0_32 wih_n_0_32 0 0.3
Vwih_p_1_32 wih_p_1_32 0 0.46032013524786275
Vwih_n_1_32 wih_n_1_32 0 0.5396798647521373
Vwih_p_2_32 wih_p_2_32 0 0.7068015234877614
Vwih_n_2_32 wih_n_2_32 0 0.3
Xcm_xh32 xhp32 xhn32 vdd cmld
Rnd_xh32 xhp32 xhn32 20k
Cxh32p xhp32 0 1e-13
Cxh32n xhn32 0 1e-13
Xih_0_32 a_xp0 a_xn0 wih_p_0_32 wih_n_0_32 xhp32 xhn32 vdd vbsyn gsyn
Xih_1_32 a_xp1 a_xn1 wih_p_1_32 wih_n_1_32 xhp32 xhn32 vdd vbsyn gsyn
Xih_2_32 a_xp2 a_xn2 wih_p_2_32 wih_n_2_32 xhp32 xhn32 vdd vbsyn gsyn
Xn32 xhp32 xhn32 ahp32 ahn32 vdd vbneu dneuron
Vwih_p_0_33 wih_p_0_33 0 0.3
Vwih_n_0_33 wih_n_0_33 0 0.9
Vwih_p_1_33 wih_p_1_33 0 0.3
Vwih_n_1_33 wih_n_1_33 0 0.9
Vwih_p_2_33 wih_p_2_33 0 0.8489973052653754
Vwih_n_2_33 wih_n_2_33 0 0.3
Xcm_xh33 xhp33 xhn33 vdd cmld
Rnd_xh33 xhp33 xhn33 20k
Cxh33p xhp33 0 1e-13
Cxh33n xhn33 0 1e-13
Xih_0_33 a_xp0 a_xn0 wih_p_0_33 wih_n_0_33 xhp33 xhn33 vdd vbsyn gsyn
Xih_1_33 a_xp1 a_xn1 wih_p_1_33 wih_n_1_33 xhp33 xhn33 vdd vbsyn gsyn
Xih_2_33 a_xp2 a_xn2 wih_p_2_33 wih_n_2_33 xhp33 xhn33 vdd vbsyn gsyn
Xn33 xhp33 xhn33 ahp33 ahn33 vdd vbneu dneuron
Vwih_p_0_34 wih_p_0_34 0 0.3
Vwih_n_0_34 wih_n_0_34 0 0.7381884171432876
Vwih_p_1_34 wih_p_1_34 0 0.3
Vwih_n_1_34 wih_n_1_34 0 0.9
Vwih_p_2_34 wih_p_2_34 0 0.3
Vwih_n_2_34 wih_n_2_34 0 0.9
Xcm_xh34 xhp34 xhn34 vdd cmld
Rnd_xh34 xhp34 xhn34 20k
Cxh34p xhp34 0 1e-13
Cxh34n xhn34 0 1e-13
Xih_0_34 a_xp0 a_xn0 wih_p_0_34 wih_n_0_34 xhp34 xhn34 vdd vbsyn gsyn
Xih_1_34 a_xp1 a_xn1 wih_p_1_34 wih_n_1_34 xhp34 xhn34 vdd vbsyn gsyn
Xih_2_34 a_xp2 a_xn2 wih_p_2_34 wih_n_2_34 xhp34 xhn34 vdd vbsyn gsyn
Xn34 xhp34 xhn34 ahp34 ahn34 vdd vbneu dneuron
Vwih_p_0_35 wih_p_0_35 0 0.3
Vwih_n_0_35 wih_n_0_35 0 0.9
Vwih_p_1_35 wih_p_1_35 0 0.9
Vwih_n_1_35 wih_n_1_35 0 0.3
Vwih_p_2_35 wih_p_2_35 0 0.3
Vwih_n_2_35 wih_n_2_35 0 0.9
Xcm_xh35 xhp35 xhn35 vdd cmld
Rnd_xh35 xhp35 xhn35 20k
Cxh35p xhp35 0 1e-13
Cxh35n xhn35 0 1e-13
Xih_0_35 a_xp0 a_xn0 wih_p_0_35 wih_n_0_35 xhp35 xhn35 vdd vbsyn gsyn
Xih_1_35 a_xp1 a_xn1 wih_p_1_35 wih_n_1_35 xhp35 xhn35 vdd vbsyn gsyn
Xih_2_35 a_xp2 a_xn2 wih_p_2_35 wih_n_2_35 xhp35 xhn35 vdd vbsyn gsyn
Xn35 xhp35 xhn35 ahp35 ahn35 vdd vbneu dneuron
Vwih_p_0_36 wih_p_0_36 0 0.3
Vwih_n_0_36 wih_n_0_36 0 0.7441127802641893
Vwih_p_1_36 wih_p_1_36 0 0.9
Vwih_n_1_36 wih_n_1_36 0 0.3
Vwih_p_2_36 wih_p_2_36 0 0.30545784665024955
Vwih_n_2_36 wih_n_2_36 0 0.6945421533497504
Xcm_xh36 xhp36 xhn36 vdd cmld
Rnd_xh36 xhp36 xhn36 20k
Cxh36p xhp36 0 1e-13
Cxh36n xhn36 0 1e-13
Xih_0_36 a_xp0 a_xn0 wih_p_0_36 wih_n_0_36 xhp36 xhn36 vdd vbsyn gsyn
Xih_1_36 a_xp1 a_xn1 wih_p_1_36 wih_n_1_36 xhp36 xhn36 vdd vbsyn gsyn
Xih_2_36 a_xp2 a_xn2 wih_p_2_36 wih_n_2_36 xhp36 xhn36 vdd vbsyn gsyn
Xn36 xhp36 xhn36 ahp36 ahn36 vdd vbneu dneuron
Vwih_p_0_37 wih_p_0_37 0 0.49745463332008677
Vwih_n_0_37 wih_n_0_37 0 0.5025453666799132
Vwih_p_1_37 wih_p_1_37 0 0.6654429058906062
Vwih_n_1_37 wih_n_1_37 0 0.33455709410939377
Vwih_p_2_37 wih_p_2_37 0 0.3668004096194789
Vwih_n_2_37 wih_n_2_37 0 0.6331995903805211
Xcm_xh37 xhp37 xhn37 vdd cmld
Rnd_xh37 xhp37 xhn37 20k
Cxh37p xhp37 0 1e-13
Cxh37n xhn37 0 1e-13
Xih_0_37 a_xp0 a_xn0 wih_p_0_37 wih_n_0_37 xhp37 xhn37 vdd vbsyn gsyn
Xih_1_37 a_xp1 a_xn1 wih_p_1_37 wih_n_1_37 xhp37 xhn37 vdd vbsyn gsyn
Xih_2_37 a_xp2 a_xn2 wih_p_2_37 wih_n_2_37 xhp37 xhn37 vdd vbsyn gsyn
Xn37 xhp37 xhn37 ahp37 ahn37 vdd vbneu dneuron
Vwih_p_0_38 wih_p_0_38 0 0.3
Vwih_n_0_38 wih_n_0_38 0 0.8096569867443947
Vwih_p_1_38 wih_p_1_38 0 0.9
Vwih_n_1_38 wih_n_1_38 0 0.3
Vwih_p_2_38 wih_p_2_38 0 0.6439238158355183
Vwih_n_2_38 wih_n_2_38 0 0.3560761841644817
Xcm_xh38 xhp38 xhn38 vdd cmld
Rnd_xh38 xhp38 xhn38 20k
Cxh38p xhp38 0 1e-13
Cxh38n xhn38 0 1e-13
Xih_0_38 a_xp0 a_xn0 wih_p_0_38 wih_n_0_38 xhp38 xhn38 vdd vbsyn gsyn
Xih_1_38 a_xp1 a_xn1 wih_p_1_38 wih_n_1_38 xhp38 xhn38 vdd vbsyn gsyn
Xih_2_38 a_xp2 a_xn2 wih_p_2_38 wih_n_2_38 xhp38 xhn38 vdd vbsyn gsyn
Xn38 xhp38 xhn38 ahp38 ahn38 vdd vbneu dneuron
Vwih_p_0_39 wih_p_0_39 0 0.3
Vwih_n_0_39 wih_n_0_39 0 0.7832721220996146
Vwih_p_1_39 wih_p_1_39 0 0.3
Vwih_n_1_39 wih_n_1_39 0 0.9
Vwih_p_2_39 wih_p_2_39 0 0.3
Vwih_n_2_39 wih_n_2_39 0 0.9
Xcm_xh39 xhp39 xhn39 vdd cmld
Rnd_xh39 xhp39 xhn39 20k
Cxh39p xhp39 0 1e-13
Cxh39n xhn39 0 1e-13
Xih_0_39 a_xp0 a_xn0 wih_p_0_39 wih_n_0_39 xhp39 xhn39 vdd vbsyn gsyn
Xih_1_39 a_xp1 a_xn1 wih_p_1_39 wih_n_1_39 xhp39 xhn39 vdd vbsyn gsyn
Xih_2_39 a_xp2 a_xn2 wih_p_2_39 wih_n_2_39 xhp39 xhn39 vdd vbsyn gsyn
Xn39 xhp39 xhn39 ahp39 ahn39 vdd vbneu dneuron
Vwih_p_0_40 wih_p_0_40 0 0.3
Vwih_n_0_40 wih_n_0_40 0 0.9
Vwih_p_1_40 wih_p_1_40 0 0.3
Vwih_n_1_40 wih_n_1_40 0 0.9
Vwih_p_2_40 wih_p_2_40 0 0.9
Vwih_n_2_40 wih_n_2_40 0 0.3
Xcm_xh40 xhp40 xhn40 vdd cmld
Rnd_xh40 xhp40 xhn40 20k
Cxh40p xhp40 0 1e-13
Cxh40n xhn40 0 1e-13
Xih_0_40 a_xp0 a_xn0 wih_p_0_40 wih_n_0_40 xhp40 xhn40 vdd vbsyn gsyn
Xih_1_40 a_xp1 a_xn1 wih_p_1_40 wih_n_1_40 xhp40 xhn40 vdd vbsyn gsyn
Xih_2_40 a_xp2 a_xn2 wih_p_2_40 wih_n_2_40 xhp40 xhn40 vdd vbsyn gsyn
Xn40 xhp40 xhn40 ahp40 ahn40 vdd vbneu dneuron
Vwih_p_0_41 wih_p_0_41 0 0.545945311956818
Vwih_n_0_41 wih_n_0_41 0 0.45405468804318205
Vwih_p_1_41 wih_p_1_41 0 0.7414942389409386
Vwih_n_1_41 wih_n_1_41 0 0.3
Vwih_p_2_41 wih_p_2_41 0 0.3
Vwih_n_2_41 wih_n_2_41 0 0.9
Xcm_xh41 xhp41 xhn41 vdd cmld
Rnd_xh41 xhp41 xhn41 20k
Cxh41p xhp41 0 1e-13
Cxh41n xhn41 0 1e-13
Xih_0_41 a_xp0 a_xn0 wih_p_0_41 wih_n_0_41 xhp41 xhn41 vdd vbsyn gsyn
Xih_1_41 a_xp1 a_xn1 wih_p_1_41 wih_n_1_41 xhp41 xhn41 vdd vbsyn gsyn
Xih_2_41 a_xp2 a_xn2 wih_p_2_41 wih_n_2_41 xhp41 xhn41 vdd vbsyn gsyn
Xn41 xhp41 xhn41 ahp41 ahn41 vdd vbneu dneuron
Vwih_p_0_42 wih_p_0_42 0 0.3
Vwih_n_0_42 wih_n_0_42 0 0.7182984640498192
Vwih_p_1_42 wih_p_1_42 0 0.391955216733866
Vwih_n_1_42 wih_n_1_42 0 0.608044783266134
Vwih_p_2_42 wih_p_2_42 0 0.5340154011067261
Vwih_n_2_42 wih_n_2_42 0 0.4659845988932739
Xcm_xh42 xhp42 xhn42 vdd cmld
Rnd_xh42 xhp42 xhn42 20k
Cxh42p xhp42 0 1e-13
Cxh42n xhn42 0 1e-13
Xih_0_42 a_xp0 a_xn0 wih_p_0_42 wih_n_0_42 xhp42 xhn42 vdd vbsyn gsyn
Xih_1_42 a_xp1 a_xn1 wih_p_1_42 wih_n_1_42 xhp42 xhn42 vdd vbsyn gsyn
Xih_2_42 a_xp2 a_xn2 wih_p_2_42 wih_n_2_42 xhp42 xhn42 vdd vbsyn gsyn
Xn42 xhp42 xhn42 ahp42 ahn42 vdd vbneu dneuron
Vwih_p_0_43 wih_p_0_43 0 0.40717131769752773
Vwih_n_0_43 wih_n_0_43 0 0.5928286823024723
Vwih_p_1_43 wih_p_1_43 0 0.3
Vwih_n_1_43 wih_n_1_43 0 0.9
Vwih_p_2_43 wih_p_2_43 0 0.9
Vwih_n_2_43 wih_n_2_43 0 0.3
Xcm_xh43 xhp43 xhn43 vdd cmld
Rnd_xh43 xhp43 xhn43 20k
Cxh43p xhp43 0 1e-13
Cxh43n xhn43 0 1e-13
Xih_0_43 a_xp0 a_xn0 wih_p_0_43 wih_n_0_43 xhp43 xhn43 vdd vbsyn gsyn
Xih_1_43 a_xp1 a_xn1 wih_p_1_43 wih_n_1_43 xhp43 xhn43 vdd vbsyn gsyn
Xih_2_43 a_xp2 a_xn2 wih_p_2_43 wih_n_2_43 xhp43 xhn43 vdd vbsyn gsyn
Xn43 xhp43 xhn43 ahp43 ahn43 vdd vbneu dneuron
Vwih_p_0_44 wih_p_0_44 0 0.819627809974411
Vwih_n_0_44 wih_n_0_44 0 0.3
Vwih_p_1_44 wih_p_1_44 0 0.5336870102570914
Vwih_n_1_44 wih_n_1_44 0 0.4663129897429086
Vwih_p_2_44 wih_p_2_44 0 0.9
Vwih_n_2_44 wih_n_2_44 0 0.3
Xcm_xh44 xhp44 xhn44 vdd cmld
Rnd_xh44 xhp44 xhn44 20k
Cxh44p xhp44 0 1e-13
Cxh44n xhn44 0 1e-13
Xih_0_44 a_xp0 a_xn0 wih_p_0_44 wih_n_0_44 xhp44 xhn44 vdd vbsyn gsyn
Xih_1_44 a_xp1 a_xn1 wih_p_1_44 wih_n_1_44 xhp44 xhn44 vdd vbsyn gsyn
Xih_2_44 a_xp2 a_xn2 wih_p_2_44 wih_n_2_44 xhp44 xhn44 vdd vbsyn gsyn
Xn44 xhp44 xhn44 ahp44 ahn44 vdd vbneu dneuron
Vwih_p_0_45 wih_p_0_45 0 0.9
Vwih_n_0_45 wih_n_0_45 0 0.3
Vwih_p_1_45 wih_p_1_45 0 0.9
Vwih_n_1_45 wih_n_1_45 0 0.3
Vwih_p_2_45 wih_p_2_45 0 0.5733614275646088
Vwih_n_2_45 wih_n_2_45 0 0.42663857243539116
Xcm_xh45 xhp45 xhn45 vdd cmld
Rnd_xh45 xhp45 xhn45 20k
Cxh45p xhp45 0 1e-13
Cxh45n xhn45 0 1e-13
Xih_0_45 a_xp0 a_xn0 wih_p_0_45 wih_n_0_45 xhp45 xhn45 vdd vbsyn gsyn
Xih_1_45 a_xp1 a_xn1 wih_p_1_45 wih_n_1_45 xhp45 xhn45 vdd vbsyn gsyn
Xih_2_45 a_xp2 a_xn2 wih_p_2_45 wih_n_2_45 xhp45 xhn45 vdd vbsyn gsyn
Xn45 xhp45 xhn45 ahp45 ahn45 vdd vbneu dneuron
Vwih_p_0_46 wih_p_0_46 0 0.35834223316014435
Vwih_n_0_46 wih_n_0_46 0 0.6416577668398556
Vwih_p_1_46 wih_p_1_46 0 0.3
Vwih_n_1_46 wih_n_1_46 0 0.7159153700612526
Vwih_p_2_46 wih_p_2_46 0 0.9
Vwih_n_2_46 wih_n_2_46 0 0.3
Xcm_xh46 xhp46 xhn46 vdd cmld
Rnd_xh46 xhp46 xhn46 20k
Cxh46p xhp46 0 1e-13
Cxh46n xhn46 0 1e-13
Xih_0_46 a_xp0 a_xn0 wih_p_0_46 wih_n_0_46 xhp46 xhn46 vdd vbsyn gsyn
Xih_1_46 a_xp1 a_xn1 wih_p_1_46 wih_n_1_46 xhp46 xhn46 vdd vbsyn gsyn
Xih_2_46 a_xp2 a_xn2 wih_p_2_46 wih_n_2_46 xhp46 xhn46 vdd vbsyn gsyn
Xn46 xhp46 xhn46 ahp46 ahn46 vdd vbneu dneuron
Vwih_p_0_47 wih_p_0_47 0 0.3
Vwih_n_0_47 wih_n_0_47 0 0.8156592033861805
Vwih_p_1_47 wih_p_1_47 0 0.3
Vwih_n_1_47 wih_n_1_47 0 0.9
Vwih_p_2_47 wih_p_2_47 0 0.7494786102536782
Vwih_n_2_47 wih_n_2_47 0 0.3
Xcm_xh47 xhp47 xhn47 vdd cmld
Rnd_xh47 xhp47 xhn47 20k
Cxh47p xhp47 0 1e-13
Cxh47n xhn47 0 1e-13
Xih_0_47 a_xp0 a_xn0 wih_p_0_47 wih_n_0_47 xhp47 xhn47 vdd vbsyn gsyn
Xih_1_47 a_xp1 a_xn1 wih_p_1_47 wih_n_1_47 xhp47 xhn47 vdd vbsyn gsyn
Xih_2_47 a_xp2 a_xn2 wih_p_2_47 wih_n_2_47 xhp47 xhn47 vdd vbsyn gsyn
Xn47 xhp47 xhn47 ahp47 ahn47 vdd vbneu dneuron
Vwih_p_0_48 wih_p_0_48 0 0.7353518784808435
Vwih_n_0_48 wih_n_0_48 0 0.3
Vwih_p_1_48 wih_p_1_48 0 0.7864473361073496
Vwih_n_1_48 wih_n_1_48 0 0.3
Vwih_p_2_48 wih_p_2_48 0 0.3
Vwih_n_2_48 wih_n_2_48 0 0.8821481185277097
Xcm_xh48 xhp48 xhn48 vdd cmld
Rnd_xh48 xhp48 xhn48 20k
Cxh48p xhp48 0 1e-13
Cxh48n xhn48 0 1e-13
Xih_0_48 a_xp0 a_xn0 wih_p_0_48 wih_n_0_48 xhp48 xhn48 vdd vbsyn gsyn
Xih_1_48 a_xp1 a_xn1 wih_p_1_48 wih_n_1_48 xhp48 xhn48 vdd vbsyn gsyn
Xih_2_48 a_xp2 a_xn2 wih_p_2_48 wih_n_2_48 xhp48 xhn48 vdd vbsyn gsyn
Xn48 xhp48 xhn48 ahp48 ahn48 vdd vbneu dneuron
Vwih_p_0_49 wih_p_0_49 0 0.6353317413555474
Vwih_n_0_49 wih_n_0_49 0 0.3646682586444526
Vwih_p_1_49 wih_p_1_49 0 0.9
Vwih_n_1_49 wih_n_1_49 0 0.3
Vwih_p_2_49 wih_p_2_49 0 0.3
Vwih_n_2_49 wih_n_2_49 0 0.7159241599321791
Xcm_xh49 xhp49 xhn49 vdd cmld
Rnd_xh49 xhp49 xhn49 20k
Cxh49p xhp49 0 1e-13
Cxh49n xhn49 0 1e-13
Xih_0_49 a_xp0 a_xn0 wih_p_0_49 wih_n_0_49 xhp49 xhn49 vdd vbsyn gsyn
Xih_1_49 a_xp1 a_xn1 wih_p_1_49 wih_n_1_49 xhp49 xhn49 vdd vbsyn gsyn
Xih_2_49 a_xp2 a_xn2 wih_p_2_49 wih_n_2_49 xhp49 xhn49 vdd vbsyn gsyn
Xn49 xhp49 xhn49 ahp49 ahn49 vdd vbneu dneuron
Vwih_p_0_50 wih_p_0_50 0 0.3793377422043865
Vwih_n_0_50 wih_n_0_50 0 0.6206622577956136
Vwih_p_1_50 wih_p_1_50 0 0.365920675272937
Vwih_n_1_50 wih_n_1_50 0 0.6340793247270631
Vwih_p_2_50 wih_p_2_50 0 0.9
Vwih_n_2_50 wih_n_2_50 0 0.3
Xcm_xh50 xhp50 xhn50 vdd cmld
Rnd_xh50 xhp50 xhn50 20k
Cxh50p xhp50 0 1e-13
Cxh50n xhn50 0 1e-13
Xih_0_50 a_xp0 a_xn0 wih_p_0_50 wih_n_0_50 xhp50 xhn50 vdd vbsyn gsyn
Xih_1_50 a_xp1 a_xn1 wih_p_1_50 wih_n_1_50 xhp50 xhn50 vdd vbsyn gsyn
Xih_2_50 a_xp2 a_xn2 wih_p_2_50 wih_n_2_50 xhp50 xhn50 vdd vbsyn gsyn
Xn50 xhp50 xhn50 ahp50 ahn50 vdd vbneu dneuron
Vwih_p_0_51 wih_p_0_51 0 0.9
Vwih_n_0_51 wih_n_0_51 0 0.3
Vwih_p_1_51 wih_p_1_51 0 0.3
Vwih_n_1_51 wih_n_1_51 0 0.9
Vwih_p_2_51 wih_p_2_51 0 0.3
Vwih_n_2_51 wih_n_2_51 0 0.9
Xcm_xh51 xhp51 xhn51 vdd cmld
Rnd_xh51 xhp51 xhn51 20k
Cxh51p xhp51 0 1e-13
Cxh51n xhn51 0 1e-13
Xih_0_51 a_xp0 a_xn0 wih_p_0_51 wih_n_0_51 xhp51 xhn51 vdd vbsyn gsyn
Xih_1_51 a_xp1 a_xn1 wih_p_1_51 wih_n_1_51 xhp51 xhn51 vdd vbsyn gsyn
Xih_2_51 a_xp2 a_xn2 wih_p_2_51 wih_n_2_51 xhp51 xhn51 vdd vbsyn gsyn
Xn51 xhp51 xhn51 ahp51 ahn51 vdd vbneu dneuron
Vwih_p_0_52 wih_p_0_52 0 0.7925498192806302
Vwih_n_0_52 wih_n_0_52 0 0.3
Vwih_p_1_52 wih_p_1_52 0 0.4041036081999998
Vwih_n_1_52 wih_n_1_52 0 0.5958963918000002
Vwih_p_2_52 wih_p_2_52 0 0.7396576140261645
Vwih_n_2_52 wih_n_2_52 0 0.3
Xcm_xh52 xhp52 xhn52 vdd cmld
Rnd_xh52 xhp52 xhn52 20k
Cxh52p xhp52 0 1e-13
Cxh52n xhn52 0 1e-13
Xih_0_52 a_xp0 a_xn0 wih_p_0_52 wih_n_0_52 xhp52 xhn52 vdd vbsyn gsyn
Xih_1_52 a_xp1 a_xn1 wih_p_1_52 wih_n_1_52 xhp52 xhn52 vdd vbsyn gsyn
Xih_2_52 a_xp2 a_xn2 wih_p_2_52 wih_n_2_52 xhp52 xhn52 vdd vbsyn gsyn
Xn52 xhp52 xhn52 ahp52 ahn52 vdd vbneu dneuron
Vwih_p_0_53 wih_p_0_53 0 0.6195629441664396
Vwih_n_0_53 wih_n_0_53 0 0.38043705583356036
Vwih_p_1_53 wih_p_1_53 0 0.9
Vwih_n_1_53 wih_n_1_53 0 0.3
Vwih_p_2_53 wih_p_2_53 0 0.3
Vwih_n_2_53 wih_n_2_53 0 0.9
Xcm_xh53 xhp53 xhn53 vdd cmld
Rnd_xh53 xhp53 xhn53 20k
Cxh53p xhp53 0 1e-13
Cxh53n xhn53 0 1e-13
Xih_0_53 a_xp0 a_xn0 wih_p_0_53 wih_n_0_53 xhp53 xhn53 vdd vbsyn gsyn
Xih_1_53 a_xp1 a_xn1 wih_p_1_53 wih_n_1_53 xhp53 xhn53 vdd vbsyn gsyn
Xih_2_53 a_xp2 a_xn2 wih_p_2_53 wih_n_2_53 xhp53 xhn53 vdd vbsyn gsyn
Xn53 xhp53 xhn53 ahp53 ahn53 vdd vbneu dneuron
Vwih_p_0_54 wih_p_0_54 0 0.3
Vwih_n_0_54 wih_n_0_54 0 0.746538352649824
Vwih_p_1_54 wih_p_1_54 0 0.6129473320835633
Vwih_n_1_54 wih_n_1_54 0 0.38705266791643667
Vwih_p_2_54 wih_p_2_54 0 0.6055112896363872
Vwih_n_2_54 wih_n_2_54 0 0.39448871036361277
Xcm_xh54 xhp54 xhn54 vdd cmld
Rnd_xh54 xhp54 xhn54 20k
Cxh54p xhp54 0 1e-13
Cxh54n xhn54 0 1e-13
Xih_0_54 a_xp0 a_xn0 wih_p_0_54 wih_n_0_54 xhp54 xhn54 vdd vbsyn gsyn
Xih_1_54 a_xp1 a_xn1 wih_p_1_54 wih_n_1_54 xhp54 xhn54 vdd vbsyn gsyn
Xih_2_54 a_xp2 a_xn2 wih_p_2_54 wih_n_2_54 xhp54 xhn54 vdd vbsyn gsyn
Xn54 xhp54 xhn54 ahp54 ahn54 vdd vbneu dneuron
Vwih_p_0_55 wih_p_0_55 0 0.3
Vwih_n_0_55 wih_n_0_55 0 0.9
Vwih_p_1_55 wih_p_1_55 0 0.3
Vwih_n_1_55 wih_n_1_55 0 0.7372215230570436
Vwih_p_2_55 wih_p_2_55 0 0.3
Vwih_n_2_55 wih_n_2_55 0 0.7636292676416085
Xcm_xh55 xhp55 xhn55 vdd cmld
Rnd_xh55 xhp55 xhn55 20k
Cxh55p xhp55 0 1e-13
Cxh55n xhn55 0 1e-13
Xih_0_55 a_xp0 a_xn0 wih_p_0_55 wih_n_0_55 xhp55 xhn55 vdd vbsyn gsyn
Xih_1_55 a_xp1 a_xn1 wih_p_1_55 wih_n_1_55 xhp55 xhn55 vdd vbsyn gsyn
Xih_2_55 a_xp2 a_xn2 wih_p_2_55 wih_n_2_55 xhp55 xhn55 vdd vbsyn gsyn
Xn55 xhp55 xhn55 ahp55 ahn55 vdd vbneu dneuron
Vwih_p_0_56 wih_p_0_56 0 0.5201056250909194
Vwih_n_0_56 wih_n_0_56 0 0.47989437490908066
Vwih_p_1_56 wih_p_1_56 0 0.8152539128329557
Vwih_n_1_56 wih_n_1_56 0 0.3
Vwih_p_2_56 wih_p_2_56 0 0.37603917677592913
Vwih_n_2_56 wih_n_2_56 0 0.6239608232240709
Xcm_xh56 xhp56 xhn56 vdd cmld
Rnd_xh56 xhp56 xhn56 20k
Cxh56p xhp56 0 1e-13
Cxh56n xhn56 0 1e-13
Xih_0_56 a_xp0 a_xn0 wih_p_0_56 wih_n_0_56 xhp56 xhn56 vdd vbsyn gsyn
Xih_1_56 a_xp1 a_xn1 wih_p_1_56 wih_n_1_56 xhp56 xhn56 vdd vbsyn gsyn
Xih_2_56 a_xp2 a_xn2 wih_p_2_56 wih_n_2_56 xhp56 xhn56 vdd vbsyn gsyn
Xn56 xhp56 xhn56 ahp56 ahn56 vdd vbneu dneuron
Vwih_p_0_57 wih_p_0_57 0 0.43112567553536857
Vwih_n_0_57 wih_n_0_57 0 0.5688743244646315
Vwih_p_1_57 wih_p_1_57 0 0.3
Vwih_n_1_57 wih_n_1_57 0 0.9
Vwih_p_2_57 wih_p_2_57 0 0.3
Vwih_n_2_57 wih_n_2_57 0 0.9
Xcm_xh57 xhp57 xhn57 vdd cmld
Rnd_xh57 xhp57 xhn57 20k
Cxh57p xhp57 0 1e-13
Cxh57n xhn57 0 1e-13
Xih_0_57 a_xp0 a_xn0 wih_p_0_57 wih_n_0_57 xhp57 xhn57 vdd vbsyn gsyn
Xih_1_57 a_xp1 a_xn1 wih_p_1_57 wih_n_1_57 xhp57 xhn57 vdd vbsyn gsyn
Xih_2_57 a_xp2 a_xn2 wih_p_2_57 wih_n_2_57 xhp57 xhn57 vdd vbsyn gsyn
Xn57 xhp57 xhn57 ahp57 ahn57 vdd vbneu dneuron
Vwih_p_0_58 wih_p_0_58 0 0.9
Vwih_n_0_58 wih_n_0_58 0 0.3
Vwih_p_1_58 wih_p_1_58 0 0.3
Vwih_n_1_58 wih_n_1_58 0 0.9
Vwih_p_2_58 wih_p_2_58 0 0.9
Vwih_n_2_58 wih_n_2_58 0 0.3
Xcm_xh58 xhp58 xhn58 vdd cmld
Rnd_xh58 xhp58 xhn58 20k
Cxh58p xhp58 0 1e-13
Cxh58n xhn58 0 1e-13
Xih_0_58 a_xp0 a_xn0 wih_p_0_58 wih_n_0_58 xhp58 xhn58 vdd vbsyn gsyn
Xih_1_58 a_xp1 a_xn1 wih_p_1_58 wih_n_1_58 xhp58 xhn58 vdd vbsyn gsyn
Xih_2_58 a_xp2 a_xn2 wih_p_2_58 wih_n_2_58 xhp58 xhn58 vdd vbsyn gsyn
Xn58 xhp58 xhn58 ahp58 ahn58 vdd vbneu dneuron
Vwih_p_0_59 wih_p_0_59 0 0.36594869412007386
Vwih_n_0_59 wih_n_0_59 0 0.6340513058799262
Vwih_p_1_59 wih_p_1_59 0 0.3
Vwih_n_1_59 wih_n_1_59 0 0.9
Vwih_p_2_59 wih_p_2_59 0 0.9
Vwih_n_2_59 wih_n_2_59 0 0.3
Xcm_xh59 xhp59 xhn59 vdd cmld
Rnd_xh59 xhp59 xhn59 20k
Cxh59p xhp59 0 1e-13
Cxh59n xhn59 0 1e-13
Xih_0_59 a_xp0 a_xn0 wih_p_0_59 wih_n_0_59 xhp59 xhn59 vdd vbsyn gsyn
Xih_1_59 a_xp1 a_xn1 wih_p_1_59 wih_n_1_59 xhp59 xhn59 vdd vbsyn gsyn
Xih_2_59 a_xp2 a_xn2 wih_p_2_59 wih_n_2_59 xhp59 xhn59 vdd vbsyn gsyn
Xn59 xhp59 xhn59 ahp59 ahn59 vdd vbneu dneuron
Vwih_p_0_60 wih_p_0_60 0 0.9
Vwih_n_0_60 wih_n_0_60 0 0.3
Vwih_p_1_60 wih_p_1_60 0 0.3
Vwih_n_1_60 wih_n_1_60 0 0.726461700047706
Vwih_p_2_60 wih_p_2_60 0 0.8902746457551964
Vwih_n_2_60 wih_n_2_60 0 0.3
Xcm_xh60 xhp60 xhn60 vdd cmld
Rnd_xh60 xhp60 xhn60 20k
Cxh60p xhp60 0 1e-13
Cxh60n xhn60 0 1e-13
Xih_0_60 a_xp0 a_xn0 wih_p_0_60 wih_n_0_60 xhp60 xhn60 vdd vbsyn gsyn
Xih_1_60 a_xp1 a_xn1 wih_p_1_60 wih_n_1_60 xhp60 xhn60 vdd vbsyn gsyn
Xih_2_60 a_xp2 a_xn2 wih_p_2_60 wih_n_2_60 xhp60 xhn60 vdd vbsyn gsyn
Xn60 xhp60 xhn60 ahp60 ahn60 vdd vbneu dneuron
Vwih_p_0_61 wih_p_0_61 0 0.3398474587622422
Vwih_n_0_61 wih_n_0_61 0 0.6601525412377578
Vwih_p_1_61 wih_p_1_61 0 0.5229168232790989
Vwih_n_1_61 wih_n_1_61 0 0.4770831767209011
Vwih_p_2_61 wih_p_2_61 0 0.5748212749168133
Vwih_n_2_61 wih_n_2_61 0 0.4251787250831866
Xcm_xh61 xhp61 xhn61 vdd cmld
Rnd_xh61 xhp61 xhn61 20k
Cxh61p xhp61 0 1e-13
Cxh61n xhn61 0 1e-13
Xih_0_61 a_xp0 a_xn0 wih_p_0_61 wih_n_0_61 xhp61 xhn61 vdd vbsyn gsyn
Xih_1_61 a_xp1 a_xn1 wih_p_1_61 wih_n_1_61 xhp61 xhn61 vdd vbsyn gsyn
Xih_2_61 a_xp2 a_xn2 wih_p_2_61 wih_n_2_61 xhp61 xhn61 vdd vbsyn gsyn
Xn61 xhp61 xhn61 ahp61 ahn61 vdd vbneu dneuron
Vwih_p_0_62 wih_p_0_62 0 0.396045251038619
Vwih_n_0_62 wih_n_0_62 0 0.603954748961381
Vwih_p_1_62 wih_p_1_62 0 0.7359676798071855
Vwih_n_1_62 wih_n_1_62 0 0.3
Vwih_p_2_62 wih_p_2_62 0 0.6735870524733172
Vwih_n_2_62 wih_n_2_62 0 0.3264129475266829
Xcm_xh62 xhp62 xhn62 vdd cmld
Rnd_xh62 xhp62 xhn62 20k
Cxh62p xhp62 0 1e-13
Cxh62n xhn62 0 1e-13
Xih_0_62 a_xp0 a_xn0 wih_p_0_62 wih_n_0_62 xhp62 xhn62 vdd vbsyn gsyn
Xih_1_62 a_xp1 a_xn1 wih_p_1_62 wih_n_1_62 xhp62 xhn62 vdd vbsyn gsyn
Xih_2_62 a_xp2 a_xn2 wih_p_2_62 wih_n_2_62 xhp62 xhn62 vdd vbsyn gsyn
Xn62 xhp62 xhn62 ahp62 ahn62 vdd vbneu dneuron
Vwih_p_0_63 wih_p_0_63 0 0.3
Vwih_n_0_63 wih_n_0_63 0 0.735298199843392
Vwih_p_1_63 wih_p_1_63 0 0.633196922220755
Vwih_n_1_63 wih_n_1_63 0 0.366803077779245
Vwih_p_2_63 wih_p_2_63 0 0.3
Vwih_n_2_63 wih_n_2_63 0 0.7342643877772693
Xcm_xh63 xhp63 xhn63 vdd cmld
Rnd_xh63 xhp63 xhn63 20k
Cxh63p xhp63 0 1e-13
Cxh63n xhn63 0 1e-13
Xih_0_63 a_xp0 a_xn0 wih_p_0_63 wih_n_0_63 xhp63 xhn63 vdd vbsyn gsyn
Xih_1_63 a_xp1 a_xn1 wih_p_1_63 wih_n_1_63 xhp63 xhn63 vdd vbsyn gsyn
Xih_2_63 a_xp2 a_xn2 wih_p_2_63 wih_n_2_63 xhp63 xhn63 vdd vbsyn gsyn
Xn63 xhp63 xhn63 ahp63 ahn63 vdd vbneu dneuron
Vwih_p_0_64 wih_p_0_64 0 0.5602183953454851
Vwih_n_0_64 wih_n_0_64 0 0.43978160465451493
Vwih_p_1_64 wih_p_1_64 0 0.3
Vwih_n_1_64 wih_n_1_64 0 0.7235913196502048
Vwih_p_2_64 wih_p_2_64 0 0.5437808033296915
Vwih_n_2_64 wih_n_2_64 0 0.4562191966703085
Xcm_xh64 xhp64 xhn64 vdd cmld
Rnd_xh64 xhp64 xhn64 20k
Cxh64p xhp64 0 1e-13
Cxh64n xhn64 0 1e-13
Xih_0_64 a_xp0 a_xn0 wih_p_0_64 wih_n_0_64 xhp64 xhn64 vdd vbsyn gsyn
Xih_1_64 a_xp1 a_xn1 wih_p_1_64 wih_n_1_64 xhp64 xhn64 vdd vbsyn gsyn
Xih_2_64 a_xp2 a_xn2 wih_p_2_64 wih_n_2_64 xhp64 xhn64 vdd vbsyn gsyn
Xn64 xhp64 xhn64 ahp64 ahn64 vdd vbneu dneuron
Vwih_p_0_65 wih_p_0_65 0 0.9
Vwih_n_0_65 wih_n_0_65 0 0.3
Vwih_p_1_65 wih_p_1_65 0 0.3
Vwih_n_1_65 wih_n_1_65 0 0.7942511403665681
Vwih_p_2_65 wih_p_2_65 0 0.3
Vwih_n_2_65 wih_n_2_65 0 0.9
Xcm_xh65 xhp65 xhn65 vdd cmld
Rnd_xh65 xhp65 xhn65 20k
Cxh65p xhp65 0 1e-13
Cxh65n xhn65 0 1e-13
Xih_0_65 a_xp0 a_xn0 wih_p_0_65 wih_n_0_65 xhp65 xhn65 vdd vbsyn gsyn
Xih_1_65 a_xp1 a_xn1 wih_p_1_65 wih_n_1_65 xhp65 xhn65 vdd vbsyn gsyn
Xih_2_65 a_xp2 a_xn2 wih_p_2_65 wih_n_2_65 xhp65 xhn65 vdd vbsyn gsyn
Xn65 xhp65 xhn65 ahp65 ahn65 vdd vbneu dneuron
Vwih_p_0_66 wih_p_0_66 0 0.9
Vwih_n_0_66 wih_n_0_66 0 0.3
Vwih_p_1_66 wih_p_1_66 0 0.631599982283025
Vwih_n_1_66 wih_n_1_66 0 0.36840001771697495
Vwih_p_2_66 wih_p_2_66 0 0.3
Vwih_n_2_66 wih_n_2_66 0 0.7927763830436771
Xcm_xh66 xhp66 xhn66 vdd cmld
Rnd_xh66 xhp66 xhn66 20k
Cxh66p xhp66 0 1e-13
Cxh66n xhn66 0 1e-13
Xih_0_66 a_xp0 a_xn0 wih_p_0_66 wih_n_0_66 xhp66 xhn66 vdd vbsyn gsyn
Xih_1_66 a_xp1 a_xn1 wih_p_1_66 wih_n_1_66 xhp66 xhn66 vdd vbsyn gsyn
Xih_2_66 a_xp2 a_xn2 wih_p_2_66 wih_n_2_66 xhp66 xhn66 vdd vbsyn gsyn
Xn66 xhp66 xhn66 ahp66 ahn66 vdd vbneu dneuron
Vwih_p_0_67 wih_p_0_67 0 0.3876575304831905
Vwih_n_0_67 wih_n_0_67 0 0.6123424695168095
Vwih_p_1_67 wih_p_1_67 0 0.3
Vwih_n_1_67 wih_n_1_67 0 0.9
Vwih_p_2_67 wih_p_2_67 0 0.9
Vwih_n_2_67 wih_n_2_67 0 0.3
Xcm_xh67 xhp67 xhn67 vdd cmld
Rnd_xh67 xhp67 xhn67 20k
Cxh67p xhp67 0 1e-13
Cxh67n xhn67 0 1e-13
Xih_0_67 a_xp0 a_xn0 wih_p_0_67 wih_n_0_67 xhp67 xhn67 vdd vbsyn gsyn
Xih_1_67 a_xp1 a_xn1 wih_p_1_67 wih_n_1_67 xhp67 xhn67 vdd vbsyn gsyn
Xih_2_67 a_xp2 a_xn2 wih_p_2_67 wih_n_2_67 xhp67 xhn67 vdd vbsyn gsyn
Xn67 xhp67 xhn67 ahp67 ahn67 vdd vbneu dneuron
Vwih_p_0_68 wih_p_0_68 0 0.821002553716585
Vwih_n_0_68 wih_n_0_68 0 0.3
Vwih_p_1_68 wih_p_1_68 0 0.7828575608769237
Vwih_n_1_68 wih_n_1_68 0 0.3
Vwih_p_2_68 wih_p_2_68 0 0.599091542473873
Vwih_n_2_68 wih_n_2_68 0 0.4009084575261271
Xcm_xh68 xhp68 xhn68 vdd cmld
Rnd_xh68 xhp68 xhn68 20k
Cxh68p xhp68 0 1e-13
Cxh68n xhn68 0 1e-13
Xih_0_68 a_xp0 a_xn0 wih_p_0_68 wih_n_0_68 xhp68 xhn68 vdd vbsyn gsyn
Xih_1_68 a_xp1 a_xn1 wih_p_1_68 wih_n_1_68 xhp68 xhn68 vdd vbsyn gsyn
Xih_2_68 a_xp2 a_xn2 wih_p_2_68 wih_n_2_68 xhp68 xhn68 vdd vbsyn gsyn
Xn68 xhp68 xhn68 ahp68 ahn68 vdd vbneu dneuron
Vwih_p_0_69 wih_p_0_69 0 0.3
Vwih_n_0_69 wih_n_0_69 0 0.9
Vwih_p_1_69 wih_p_1_69 0 0.3
Vwih_n_1_69 wih_n_1_69 0 0.9
Vwih_p_2_69 wih_p_2_69 0 0.6279801382249126
Vwih_n_2_69 wih_n_2_69 0 0.37201986177508733
Xcm_xh69 xhp69 xhn69 vdd cmld
Rnd_xh69 xhp69 xhn69 20k
Cxh69p xhp69 0 1e-13
Cxh69n xhn69 0 1e-13
Xih_0_69 a_xp0 a_xn0 wih_p_0_69 wih_n_0_69 xhp69 xhn69 vdd vbsyn gsyn
Xih_1_69 a_xp1 a_xn1 wih_p_1_69 wih_n_1_69 xhp69 xhn69 vdd vbsyn gsyn
Xih_2_69 a_xp2 a_xn2 wih_p_2_69 wih_n_2_69 xhp69 xhn69 vdd vbsyn gsyn
Xn69 xhp69 xhn69 ahp69 ahn69 vdd vbneu dneuron
Vwih_p_0_70 wih_p_0_70 0 0.3
Vwih_n_0_70 wih_n_0_70 0 0.9
Vwih_p_1_70 wih_p_1_70 0 0.4643349733951503
Vwih_n_1_70 wih_n_1_70 0 0.5356650266048497
Vwih_p_2_70 wih_p_2_70 0 0.3
Vwih_n_2_70 wih_n_2_70 0 0.9
Xcm_xh70 xhp70 xhn70 vdd cmld
Rnd_xh70 xhp70 xhn70 20k
Cxh70p xhp70 0 1e-13
Cxh70n xhn70 0 1e-13
Xih_0_70 a_xp0 a_xn0 wih_p_0_70 wih_n_0_70 xhp70 xhn70 vdd vbsyn gsyn
Xih_1_70 a_xp1 a_xn1 wih_p_1_70 wih_n_1_70 xhp70 xhn70 vdd vbsyn gsyn
Xih_2_70 a_xp2 a_xn2 wih_p_2_70 wih_n_2_70 xhp70 xhn70 vdd vbsyn gsyn
Xn70 xhp70 xhn70 ahp70 ahn70 vdd vbneu dneuron
Vwih_p_0_71 wih_p_0_71 0 0.78498216519408
Vwih_n_0_71 wih_n_0_71 0 0.3
Vwih_p_1_71 wih_p_1_71 0 0.41152937880293566
Vwih_n_1_71 wih_n_1_71 0 0.5884706211970643
Vwih_p_2_71 wih_p_2_71 0 0.9
Vwih_n_2_71 wih_n_2_71 0 0.3
Xcm_xh71 xhp71 xhn71 vdd cmld
Rnd_xh71 xhp71 xhn71 20k
Cxh71p xhp71 0 1e-13
Cxh71n xhn71 0 1e-13
Xih_0_71 a_xp0 a_xn0 wih_p_0_71 wih_n_0_71 xhp71 xhn71 vdd vbsyn gsyn
Xih_1_71 a_xp1 a_xn1 wih_p_1_71 wih_n_1_71 xhp71 xhn71 vdd vbsyn gsyn
Xih_2_71 a_xp2 a_xn2 wih_p_2_71 wih_n_2_71 xhp71 xhn71 vdd vbsyn gsyn
Xn71 xhp71 xhn71 ahp71 ahn71 vdd vbneu dneuron
Vwih_p_0_72 wih_p_0_72 0 0.651944601241626
Vwih_n_0_72 wih_n_0_72 0 0.348055398758374
Vwih_p_1_72 wih_p_1_72 0 0.5511869384109384
Vwih_n_1_72 wih_n_1_72 0 0.44881306158906165
Vwih_p_2_72 wih_p_2_72 0 0.3
Vwih_n_2_72 wih_n_2_72 0 0.9
Xcm_xh72 xhp72 xhn72 vdd cmld
Rnd_xh72 xhp72 xhn72 20k
Cxh72p xhp72 0 1e-13
Cxh72n xhn72 0 1e-13
Xih_0_72 a_xp0 a_xn0 wih_p_0_72 wih_n_0_72 xhp72 xhn72 vdd vbsyn gsyn
Xih_1_72 a_xp1 a_xn1 wih_p_1_72 wih_n_1_72 xhp72 xhn72 vdd vbsyn gsyn
Xih_2_72 a_xp2 a_xn2 wih_p_2_72 wih_n_2_72 xhp72 xhn72 vdd vbsyn gsyn
Xn72 xhp72 xhn72 ahp72 ahn72 vdd vbneu dneuron
Vwih_p_0_73 wih_p_0_73 0 0.7824688796911659
Vwih_n_0_73 wih_n_0_73 0 0.3
Vwih_p_1_73 wih_p_1_73 0 0.9
Vwih_n_1_73 wih_n_1_73 0 0.3
Vwih_p_2_73 wih_p_2_73 0 0.3
Vwih_n_2_73 wih_n_2_73 0 0.9
Xcm_xh73 xhp73 xhn73 vdd cmld
Rnd_xh73 xhp73 xhn73 20k
Cxh73p xhp73 0 1e-13
Cxh73n xhn73 0 1e-13
Xih_0_73 a_xp0 a_xn0 wih_p_0_73 wih_n_0_73 xhp73 xhn73 vdd vbsyn gsyn
Xih_1_73 a_xp1 a_xn1 wih_p_1_73 wih_n_1_73 xhp73 xhn73 vdd vbsyn gsyn
Xih_2_73 a_xp2 a_xn2 wih_p_2_73 wih_n_2_73 xhp73 xhn73 vdd vbsyn gsyn
Xn73 xhp73 xhn73 ahp73 ahn73 vdd vbneu dneuron
Vwih_p_0_74 wih_p_0_74 0 0.3
Vwih_n_0_74 wih_n_0_74 0 0.9
Vwih_p_1_74 wih_p_1_74 0 0.9
Vwih_n_1_74 wih_n_1_74 0 0.3
Vwih_p_2_74 wih_p_2_74 0 0.7303060542638511
Vwih_n_2_74 wih_n_2_74 0 0.3
Xcm_xh74 xhp74 xhn74 vdd cmld
Rnd_xh74 xhp74 xhn74 20k
Cxh74p xhp74 0 1e-13
Cxh74n xhn74 0 1e-13
Xih_0_74 a_xp0 a_xn0 wih_p_0_74 wih_n_0_74 xhp74 xhn74 vdd vbsyn gsyn
Xih_1_74 a_xp1 a_xn1 wih_p_1_74 wih_n_1_74 xhp74 xhn74 vdd vbsyn gsyn
Xih_2_74 a_xp2 a_xn2 wih_p_2_74 wih_n_2_74 xhp74 xhn74 vdd vbsyn gsyn
Xn74 xhp74 xhn74 ahp74 ahn74 vdd vbneu dneuron
Vwih_p_0_75 wih_p_0_75 0 0.36683167125987515
Vwih_n_0_75 wih_n_0_75 0 0.6331683287401249
Vwih_p_1_75 wih_p_1_75 0 0.8518902926107772
Vwih_n_1_75 wih_n_1_75 0 0.3
Vwih_p_2_75 wih_p_2_75 0 0.6496214462825567
Vwih_n_2_75 wih_n_2_75 0 0.35037855371744325
Xcm_xh75 xhp75 xhn75 vdd cmld
Rnd_xh75 xhp75 xhn75 20k
Cxh75p xhp75 0 1e-13
Cxh75n xhn75 0 1e-13
Xih_0_75 a_xp0 a_xn0 wih_p_0_75 wih_n_0_75 xhp75 xhn75 vdd vbsyn gsyn
Xih_1_75 a_xp1 a_xn1 wih_p_1_75 wih_n_1_75 xhp75 xhn75 vdd vbsyn gsyn
Xih_2_75 a_xp2 a_xn2 wih_p_2_75 wih_n_2_75 xhp75 xhn75 vdd vbsyn gsyn
Xn75 xhp75 xhn75 ahp75 ahn75 vdd vbneu dneuron
Vwih_p_0_76 wih_p_0_76 0 0.3
Vwih_n_0_76 wih_n_0_76 0 0.7936798744500322
Vwih_p_1_76 wih_p_1_76 0 0.3
Vwih_n_1_76 wih_n_1_76 0 0.8007309102957241
Vwih_p_2_76 wih_p_2_76 0 0.8848738712216193
Vwih_n_2_76 wih_n_2_76 0 0.3
Xcm_xh76 xhp76 xhn76 vdd cmld
Rnd_xh76 xhp76 xhn76 20k
Cxh76p xhp76 0 1e-13
Cxh76n xhn76 0 1e-13
Xih_0_76 a_xp0 a_xn0 wih_p_0_76 wih_n_0_76 xhp76 xhn76 vdd vbsyn gsyn
Xih_1_76 a_xp1 a_xn1 wih_p_1_76 wih_n_1_76 xhp76 xhn76 vdd vbsyn gsyn
Xih_2_76 a_xp2 a_xn2 wih_p_2_76 wih_n_2_76 xhp76 xhn76 vdd vbsyn gsyn
Xn76 xhp76 xhn76 ahp76 ahn76 vdd vbneu dneuron
Vwih_p_0_77 wih_p_0_77 0 0.6544871235054666
Vwih_n_0_77 wih_n_0_77 0 0.34551287649453344
Vwih_p_1_77 wih_p_1_77 0 0.9
Vwih_n_1_77 wih_n_1_77 0 0.3
Vwih_p_2_77 wih_p_2_77 0 0.794201336385751
Vwih_n_2_77 wih_n_2_77 0 0.3
Xcm_xh77 xhp77 xhn77 vdd cmld
Rnd_xh77 xhp77 xhn77 20k
Cxh77p xhp77 0 1e-13
Cxh77n xhn77 0 1e-13
Xih_0_77 a_xp0 a_xn0 wih_p_0_77 wih_n_0_77 xhp77 xhn77 vdd vbsyn gsyn
Xih_1_77 a_xp1 a_xn1 wih_p_1_77 wih_n_1_77 xhp77 xhn77 vdd vbsyn gsyn
Xih_2_77 a_xp2 a_xn2 wih_p_2_77 wih_n_2_77 xhp77 xhn77 vdd vbsyn gsyn
Xn77 xhp77 xhn77 ahp77 ahn77 vdd vbneu dneuron
Vwih_p_0_78 wih_p_0_78 0 0.3
Vwih_n_0_78 wih_n_0_78 0 0.776297890578276
Vwih_p_1_78 wih_p_1_78 0 0.9
Vwih_n_1_78 wih_n_1_78 0 0.3
Vwih_p_2_78 wih_p_2_78 0 0.3
Vwih_n_2_78 wih_n_2_78 0 0.9
Xcm_xh78 xhp78 xhn78 vdd cmld
Rnd_xh78 xhp78 xhn78 20k
Cxh78p xhp78 0 1e-13
Cxh78n xhn78 0 1e-13
Xih_0_78 a_xp0 a_xn0 wih_p_0_78 wih_n_0_78 xhp78 xhn78 vdd vbsyn gsyn
Xih_1_78 a_xp1 a_xn1 wih_p_1_78 wih_n_1_78 xhp78 xhn78 vdd vbsyn gsyn
Xih_2_78 a_xp2 a_xn2 wih_p_2_78 wih_n_2_78 xhp78 xhn78 vdd vbsyn gsyn
Xn78 xhp78 xhn78 ahp78 ahn78 vdd vbneu dneuron
Vwih_p_0_79 wih_p_0_79 0 0.3
Vwih_n_0_79 wih_n_0_79 0 0.7039827843982683
Vwih_p_1_79 wih_p_1_79 0 0.3
Vwih_n_1_79 wih_n_1_79 0 0.8522519723595754
Vwih_p_2_79 wih_p_2_79 0 0.3
Vwih_n_2_79 wih_n_2_79 0 0.9
Xcm_xh79 xhp79 xhn79 vdd cmld
Rnd_xh79 xhp79 xhn79 20k
Cxh79p xhp79 0 1e-13
Cxh79n xhn79 0 1e-13
Xih_0_79 a_xp0 a_xn0 wih_p_0_79 wih_n_0_79 xhp79 xhn79 vdd vbsyn gsyn
Xih_1_79 a_xp1 a_xn1 wih_p_1_79 wih_n_1_79 xhp79 xhn79 vdd vbsyn gsyn
Xih_2_79 a_xp2 a_xn2 wih_p_2_79 wih_n_2_79 xhp79 xhn79 vdd vbsyn gsyn
Xn79 xhp79 xhn79 ahp79 ahn79 vdd vbneu dneuron
Vwih_p_0_80 wih_p_0_80 0 0.7801671486226868
Vwih_n_0_80 wih_n_0_80 0 0.3
Vwih_p_1_80 wih_p_1_80 0 0.3
Vwih_n_1_80 wih_n_1_80 0 0.9
Vwih_p_2_80 wih_p_2_80 0 0.3
Vwih_n_2_80 wih_n_2_80 0 0.8079011791417701
Xcm_xh80 xhp80 xhn80 vdd cmld
Rnd_xh80 xhp80 xhn80 20k
Cxh80p xhp80 0 1e-13
Cxh80n xhn80 0 1e-13
Xih_0_80 a_xp0 a_xn0 wih_p_0_80 wih_n_0_80 xhp80 xhn80 vdd vbsyn gsyn
Xih_1_80 a_xp1 a_xn1 wih_p_1_80 wih_n_1_80 xhp80 xhn80 vdd vbsyn gsyn
Xih_2_80 a_xp2 a_xn2 wih_p_2_80 wih_n_2_80 xhp80 xhn80 vdd vbsyn gsyn
Xn80 xhp80 xhn80 ahp80 ahn80 vdd vbneu dneuron
Vwih_p_0_81 wih_p_0_81 0 0.9
Vwih_n_0_81 wih_n_0_81 0 0.3
Vwih_p_1_81 wih_p_1_81 0 0.8893459174132171
Vwih_n_1_81 wih_n_1_81 0 0.3
Vwih_p_2_81 wih_p_2_81 0 0.3
Vwih_n_2_81 wih_n_2_81 0 0.7796408961545083
Xcm_xh81 xhp81 xhn81 vdd cmld
Rnd_xh81 xhp81 xhn81 20k
Cxh81p xhp81 0 1e-13
Cxh81n xhn81 0 1e-13
Xih_0_81 a_xp0 a_xn0 wih_p_0_81 wih_n_0_81 xhp81 xhn81 vdd vbsyn gsyn
Xih_1_81 a_xp1 a_xn1 wih_p_1_81 wih_n_1_81 xhp81 xhn81 vdd vbsyn gsyn
Xih_2_81 a_xp2 a_xn2 wih_p_2_81 wih_n_2_81 xhp81 xhn81 vdd vbsyn gsyn
Xn81 xhp81 xhn81 ahp81 ahn81 vdd vbneu dneuron
Vwih_p_0_82 wih_p_0_82 0 0.3
Vwih_n_0_82 wih_n_0_82 0 0.9
Vwih_p_1_82 wih_p_1_82 0 0.45308585741143476
Vwih_n_1_82 wih_n_1_82 0 0.5469141425885652
Vwih_p_2_82 wih_p_2_82 0 0.3
Vwih_n_2_82 wih_n_2_82 0 0.9
Xcm_xh82 xhp82 xhn82 vdd cmld
Rnd_xh82 xhp82 xhn82 20k
Cxh82p xhp82 0 1e-13
Cxh82n xhn82 0 1e-13
Xih_0_82 a_xp0 a_xn0 wih_p_0_82 wih_n_0_82 xhp82 xhn82 vdd vbsyn gsyn
Xih_1_82 a_xp1 a_xn1 wih_p_1_82 wih_n_1_82 xhp82 xhn82 vdd vbsyn gsyn
Xih_2_82 a_xp2 a_xn2 wih_p_2_82 wih_n_2_82 xhp82 xhn82 vdd vbsyn gsyn
Xn82 xhp82 xhn82 ahp82 ahn82 vdd vbneu dneuron
Vwih_p_0_83 wih_p_0_83 0 0.3
Vwih_n_0_83 wih_n_0_83 0 0.9
Vwih_p_1_83 wih_p_1_83 0 0.32550066575108905
Vwih_n_1_83 wih_n_1_83 0 0.674499334248911
Vwih_p_2_83 wih_p_2_83 0 0.42884139940214183
Vwih_n_2_83 wih_n_2_83 0 0.5711586005978582
Xcm_xh83 xhp83 xhn83 vdd cmld
Rnd_xh83 xhp83 xhn83 20k
Cxh83p xhp83 0 1e-13
Cxh83n xhn83 0 1e-13
Xih_0_83 a_xp0 a_xn0 wih_p_0_83 wih_n_0_83 xhp83 xhn83 vdd vbsyn gsyn
Xih_1_83 a_xp1 a_xn1 wih_p_1_83 wih_n_1_83 xhp83 xhn83 vdd vbsyn gsyn
Xih_2_83 a_xp2 a_xn2 wih_p_2_83 wih_n_2_83 xhp83 xhn83 vdd vbsyn gsyn
Xn83 xhp83 xhn83 ahp83 ahn83 vdd vbneu dneuron
Vwih_p_0_84 wih_p_0_84 0 0.3
Vwih_n_0_84 wih_n_0_84 0 0.7498535952522232
Vwih_p_1_84 wih_p_1_84 0 0.4345947943515782
Vwih_n_1_84 wih_n_1_84 0 0.5654052056484218
Vwih_p_2_84 wih_p_2_84 0 0.9
Vwih_n_2_84 wih_n_2_84 0 0.3
Xcm_xh84 xhp84 xhn84 vdd cmld
Rnd_xh84 xhp84 xhn84 20k
Cxh84p xhp84 0 1e-13
Cxh84n xhn84 0 1e-13
Xih_0_84 a_xp0 a_xn0 wih_p_0_84 wih_n_0_84 xhp84 xhn84 vdd vbsyn gsyn
Xih_1_84 a_xp1 a_xn1 wih_p_1_84 wih_n_1_84 xhp84 xhn84 vdd vbsyn gsyn
Xih_2_84 a_xp2 a_xn2 wih_p_2_84 wih_n_2_84 xhp84 xhn84 vdd vbsyn gsyn
Xn84 xhp84 xhn84 ahp84 ahn84 vdd vbneu dneuron
Vwih_p_0_85 wih_p_0_85 0 0.7822067728362844
Vwih_n_0_85 wih_n_0_85 0 0.3
Vwih_p_1_85 wih_p_1_85 0 0.9
Vwih_n_1_85 wih_n_1_85 0 0.3
Vwih_p_2_85 wih_p_2_85 0 0.9
Vwih_n_2_85 wih_n_2_85 0 0.3
Xcm_xh85 xhp85 xhn85 vdd cmld
Rnd_xh85 xhp85 xhn85 20k
Cxh85p xhp85 0 1e-13
Cxh85n xhn85 0 1e-13
Xih_0_85 a_xp0 a_xn0 wih_p_0_85 wih_n_0_85 xhp85 xhn85 vdd vbsyn gsyn
Xih_1_85 a_xp1 a_xn1 wih_p_1_85 wih_n_1_85 xhp85 xhn85 vdd vbsyn gsyn
Xih_2_85 a_xp2 a_xn2 wih_p_2_85 wih_n_2_85 xhp85 xhn85 vdd vbsyn gsyn
Xn85 xhp85 xhn85 ahp85 ahn85 vdd vbneu dneuron
Vwih_p_0_86 wih_p_0_86 0 0.6043917510137378
Vwih_n_0_86 wih_n_0_86 0 0.39560824898626223
Vwih_p_1_86 wih_p_1_86 0 0.3
Vwih_n_1_86 wih_n_1_86 0 0.9
Vwih_p_2_86 wih_p_2_86 0 0.3
Vwih_n_2_86 wih_n_2_86 0 0.9
Xcm_xh86 xhp86 xhn86 vdd cmld
Rnd_xh86 xhp86 xhn86 20k
Cxh86p xhp86 0 1e-13
Cxh86n xhn86 0 1e-13
Xih_0_86 a_xp0 a_xn0 wih_p_0_86 wih_n_0_86 xhp86 xhn86 vdd vbsyn gsyn
Xih_1_86 a_xp1 a_xn1 wih_p_1_86 wih_n_1_86 xhp86 xhn86 vdd vbsyn gsyn
Xih_2_86 a_xp2 a_xn2 wih_p_2_86 wih_n_2_86 xhp86 xhn86 vdd vbsyn gsyn
Xn86 xhp86 xhn86 ahp86 ahn86 vdd vbneu dneuron
Vwih_p_0_87 wih_p_0_87 0 0.49073662466003626
Vwih_n_0_87 wih_n_0_87 0 0.5092633753399637
Vwih_p_1_87 wih_p_1_87 0 0.31612657346926276
Vwih_n_1_87 wih_n_1_87 0 0.6838734265307372
Vwih_p_2_87 wih_p_2_87 0 0.3
Vwih_n_2_87 wih_n_2_87 0 0.9
Xcm_xh87 xhp87 xhn87 vdd cmld
Rnd_xh87 xhp87 xhn87 20k
Cxh87p xhp87 0 1e-13
Cxh87n xhn87 0 1e-13
Xih_0_87 a_xp0 a_xn0 wih_p_0_87 wih_n_0_87 xhp87 xhn87 vdd vbsyn gsyn
Xih_1_87 a_xp1 a_xn1 wih_p_1_87 wih_n_1_87 xhp87 xhn87 vdd vbsyn gsyn
Xih_2_87 a_xp2 a_xn2 wih_p_2_87 wih_n_2_87 xhp87 xhn87 vdd vbsyn gsyn
Xn87 xhp87 xhn87 ahp87 ahn87 vdd vbneu dneuron
Vwih_p_0_88 wih_p_0_88 0 0.6843670758274714
Vwih_n_0_88 wih_n_0_88 0 0.31563292417252864
Vwih_p_1_88 wih_p_1_88 0 0.9
Vwih_n_1_88 wih_n_1_88 0 0.3
Vwih_p_2_88 wih_p_2_88 0 0.4693606317825398
Vwih_n_2_88 wih_n_2_88 0 0.5306393682174602
Xcm_xh88 xhp88 xhn88 vdd cmld
Rnd_xh88 xhp88 xhn88 20k
Cxh88p xhp88 0 1e-13
Cxh88n xhn88 0 1e-13
Xih_0_88 a_xp0 a_xn0 wih_p_0_88 wih_n_0_88 xhp88 xhn88 vdd vbsyn gsyn
Xih_1_88 a_xp1 a_xn1 wih_p_1_88 wih_n_1_88 xhp88 xhn88 vdd vbsyn gsyn
Xih_2_88 a_xp2 a_xn2 wih_p_2_88 wih_n_2_88 xhp88 xhn88 vdd vbsyn gsyn
Xn88 xhp88 xhn88 ahp88 ahn88 vdd vbneu dneuron
Vwih_p_0_89 wih_p_0_89 0 0.5386260016584656
Vwih_n_0_89 wih_n_0_89 0 0.46137399834153436
Vwih_p_1_89 wih_p_1_89 0 0.3
Vwih_n_1_89 wih_n_1_89 0 0.7461341906072892
Vwih_p_2_89 wih_p_2_89 0 0.3
Vwih_n_2_89 wih_n_2_89 0 0.8095734084185162
Xcm_xh89 xhp89 xhn89 vdd cmld
Rnd_xh89 xhp89 xhn89 20k
Cxh89p xhp89 0 1e-13
Cxh89n xhn89 0 1e-13
Xih_0_89 a_xp0 a_xn0 wih_p_0_89 wih_n_0_89 xhp89 xhn89 vdd vbsyn gsyn
Xih_1_89 a_xp1 a_xn1 wih_p_1_89 wih_n_1_89 xhp89 xhn89 vdd vbsyn gsyn
Xih_2_89 a_xp2 a_xn2 wih_p_2_89 wih_n_2_89 xhp89 xhn89 vdd vbsyn gsyn
Xn89 xhp89 xhn89 ahp89 ahn89 vdd vbneu dneuron
Vwih_p_0_90 wih_p_0_90 0 0.9
Vwih_n_0_90 wih_n_0_90 0 0.3
Vwih_p_1_90 wih_p_1_90 0 0.3
Vwih_n_1_90 wih_n_1_90 0 0.9
Vwih_p_2_90 wih_p_2_90 0 0.42744890061700674
Vwih_n_2_90 wih_n_2_90 0 0.5725510993829932
Xcm_xh90 xhp90 xhn90 vdd cmld
Rnd_xh90 xhp90 xhn90 20k
Cxh90p xhp90 0 1e-13
Cxh90n xhn90 0 1e-13
Xih_0_90 a_xp0 a_xn0 wih_p_0_90 wih_n_0_90 xhp90 xhn90 vdd vbsyn gsyn
Xih_1_90 a_xp1 a_xn1 wih_p_1_90 wih_n_1_90 xhp90 xhn90 vdd vbsyn gsyn
Xih_2_90 a_xp2 a_xn2 wih_p_2_90 wih_n_2_90 xhp90 xhn90 vdd vbsyn gsyn
Xn90 xhp90 xhn90 ahp90 ahn90 vdd vbneu dneuron
Vwih_p_0_91 wih_p_0_91 0 0.3
Vwih_n_0_91 wih_n_0_91 0 0.7012130665758787
Vwih_p_1_91 wih_p_1_91 0 0.4505487645405833
Vwih_n_1_91 wih_n_1_91 0 0.5494512354594168
Vwih_p_2_91 wih_p_2_91 0 0.9
Vwih_n_2_91 wih_n_2_91 0 0.3
Xcm_xh91 xhp91 xhn91 vdd cmld
Rnd_xh91 xhp91 xhn91 20k
Cxh91p xhp91 0 1e-13
Cxh91n xhn91 0 1e-13
Xih_0_91 a_xp0 a_xn0 wih_p_0_91 wih_n_0_91 xhp91 xhn91 vdd vbsyn gsyn
Xih_1_91 a_xp1 a_xn1 wih_p_1_91 wih_n_1_91 xhp91 xhn91 vdd vbsyn gsyn
Xih_2_91 a_xp2 a_xn2 wih_p_2_91 wih_n_2_91 xhp91 xhn91 vdd vbsyn gsyn
Xn91 xhp91 xhn91 ahp91 ahn91 vdd vbneu dneuron
Vwih_p_0_92 wih_p_0_92 0 0.9
Vwih_n_0_92 wih_n_0_92 0 0.3
Vwih_p_1_92 wih_p_1_92 0 0.4369496010995045
Vwih_n_1_92 wih_n_1_92 0 0.5630503989004956
Vwih_p_2_92 wih_p_2_92 0 0.9
Vwih_n_2_92 wih_n_2_92 0 0.3
Xcm_xh92 xhp92 xhn92 vdd cmld
Rnd_xh92 xhp92 xhn92 20k
Cxh92p xhp92 0 1e-13
Cxh92n xhn92 0 1e-13
Xih_0_92 a_xp0 a_xn0 wih_p_0_92 wih_n_0_92 xhp92 xhn92 vdd vbsyn gsyn
Xih_1_92 a_xp1 a_xn1 wih_p_1_92 wih_n_1_92 xhp92 xhn92 vdd vbsyn gsyn
Xih_2_92 a_xp2 a_xn2 wih_p_2_92 wih_n_2_92 xhp92 xhn92 vdd vbsyn gsyn
Xn92 xhp92 xhn92 ahp92 ahn92 vdd vbneu dneuron
Vwih_p_0_93 wih_p_0_93 0 0.3
Vwih_n_0_93 wih_n_0_93 0 0.844946227535341
Vwih_p_1_93 wih_p_1_93 0 0.6600547004918792
Vwih_n_1_93 wih_n_1_93 0 0.3399452995081208
Vwih_p_2_93 wih_p_2_93 0 0.9
Vwih_n_2_93 wih_n_2_93 0 0.3
Xcm_xh93 xhp93 xhn93 vdd cmld
Rnd_xh93 xhp93 xhn93 20k
Cxh93p xhp93 0 1e-13
Cxh93n xhn93 0 1e-13
Xih_0_93 a_xp0 a_xn0 wih_p_0_93 wih_n_0_93 xhp93 xhn93 vdd vbsyn gsyn
Xih_1_93 a_xp1 a_xn1 wih_p_1_93 wih_n_1_93 xhp93 xhn93 vdd vbsyn gsyn
Xih_2_93 a_xp2 a_xn2 wih_p_2_93 wih_n_2_93 xhp93 xhn93 vdd vbsyn gsyn
Xn93 xhp93 xhn93 ahp93 ahn93 vdd vbneu dneuron
Vwih_p_0_94 wih_p_0_94 0 0.3
Vwih_n_0_94 wih_n_0_94 0 0.7599145726886986
Vwih_p_1_94 wih_p_1_94 0 0.5923028333170683
Vwih_n_1_94 wih_n_1_94 0 0.40769716668293166
Vwih_p_2_94 wih_p_2_94 0 0.9
Vwih_n_2_94 wih_n_2_94 0 0.3
Xcm_xh94 xhp94 xhn94 vdd cmld
Rnd_xh94 xhp94 xhn94 20k
Cxh94p xhp94 0 1e-13
Cxh94n xhn94 0 1e-13
Xih_0_94 a_xp0 a_xn0 wih_p_0_94 wih_n_0_94 xhp94 xhn94 vdd vbsyn gsyn
Xih_1_94 a_xp1 a_xn1 wih_p_1_94 wih_n_1_94 xhp94 xhn94 vdd vbsyn gsyn
Xih_2_94 a_xp2 a_xn2 wih_p_2_94 wih_n_2_94 xhp94 xhn94 vdd vbsyn gsyn
Xn94 xhp94 xhn94 ahp94 ahn94 vdd vbneu dneuron
Vwih_p_0_95 wih_p_0_95 0 0.3
Vwih_n_0_95 wih_n_0_95 0 0.879114898888907
Vwih_p_1_95 wih_p_1_95 0 0.5289463154929819
Vwih_n_1_95 wih_n_1_95 0 0.47105368450701807
Vwih_p_2_95 wih_p_2_95 0 0.35833983199520714
Vwih_n_2_95 wih_n_2_95 0 0.6416601680047929
Xcm_xh95 xhp95 xhn95 vdd cmld
Rnd_xh95 xhp95 xhn95 20k
Cxh95p xhp95 0 1e-13
Cxh95n xhn95 0 1e-13
Xih_0_95 a_xp0 a_xn0 wih_p_0_95 wih_n_0_95 xhp95 xhn95 vdd vbsyn gsyn
Xih_1_95 a_xp1 a_xn1 wih_p_1_95 wih_n_1_95 xhp95 xhn95 vdd vbsyn gsyn
Xih_2_95 a_xp2 a_xn2 wih_p_2_95 wih_n_2_95 xhp95 xhn95 vdd vbsyn gsyn
Xn95 xhp95 xhn95 ahp95 ahn95 vdd vbneu dneuron
Vahb_p ahbias_p 0 0.8
Vahb_n ahbias_n 0 0.2
Xcm_mo0 mop0 mon0 vdd cmldW
Rmo0 mop0 mon0 20k
Cmo0p mop0 0 1e-13
Cmo0n mon0 0 1e-13
Cwp_0_0 who_p_0_0 0 40p
Cwn_0_0 who_n_0_0 0 40p
Rwp_0_0 who_p_0_0 wcm 2g
Rwn_0_0 who_n_0_0 wcm 2g
Xsyn_0_0 ahp0 ahn0 who_p_0_0 who_n_0_0 mop0 mon0 vdd vbsyn gsynR
Cwp_1_0 who_p_1_0 0 40p
Cwn_1_0 who_n_1_0 0 40p
Rwp_1_0 who_p_1_0 wcm 2g
Rwn_1_0 who_n_1_0 wcm 2g
Xsyn_1_0 ahp1 ahn1 who_p_1_0 who_n_1_0 mop0 mon0 vdd vbsyn gsynR
Cwp_2_0 who_p_2_0 0 40p
Cwn_2_0 who_n_2_0 0 40p
Rwp_2_0 who_p_2_0 wcm 2g
Rwn_2_0 who_n_2_0 wcm 2g
Xsyn_2_0 ahp2 ahn2 who_p_2_0 who_n_2_0 mop0 mon0 vdd vbsyn gsynR
Cwp_3_0 who_p_3_0 0 40p
Cwn_3_0 who_n_3_0 0 40p
Rwp_3_0 who_p_3_0 wcm 2g
Rwn_3_0 who_n_3_0 wcm 2g
Xsyn_3_0 ahp3 ahn3 who_p_3_0 who_n_3_0 mop0 mon0 vdd vbsyn gsynR
Cwp_4_0 who_p_4_0 0 40p
Cwn_4_0 who_n_4_0 0 40p
Rwp_4_0 who_p_4_0 wcm 2g
Rwn_4_0 who_n_4_0 wcm 2g
Xsyn_4_0 ahp4 ahn4 who_p_4_0 who_n_4_0 mop0 mon0 vdd vbsyn gsynR
Cwp_5_0 who_p_5_0 0 40p
Cwn_5_0 who_n_5_0 0 40p
Rwp_5_0 who_p_5_0 wcm 2g
Rwn_5_0 who_n_5_0 wcm 2g
Xsyn_5_0 ahp5 ahn5 who_p_5_0 who_n_5_0 mop0 mon0 vdd vbsyn gsynR
Cwp_6_0 who_p_6_0 0 40p
Cwn_6_0 who_n_6_0 0 40p
Rwp_6_0 who_p_6_0 wcm 2g
Rwn_6_0 who_n_6_0 wcm 2g
Xsyn_6_0 ahp6 ahn6 who_p_6_0 who_n_6_0 mop0 mon0 vdd vbsyn gsynR
Cwp_7_0 who_p_7_0 0 40p
Cwn_7_0 who_n_7_0 0 40p
Rwp_7_0 who_p_7_0 wcm 2g
Rwn_7_0 who_n_7_0 wcm 2g
Xsyn_7_0 ahp7 ahn7 who_p_7_0 who_n_7_0 mop0 mon0 vdd vbsyn gsynR
Cwp_8_0 who_p_8_0 0 40p
Cwn_8_0 who_n_8_0 0 40p
Rwp_8_0 who_p_8_0 wcm 2g
Rwn_8_0 who_n_8_0 wcm 2g
Xsyn_8_0 ahp8 ahn8 who_p_8_0 who_n_8_0 mop0 mon0 vdd vbsyn gsynR
Cwp_9_0 who_p_9_0 0 40p
Cwn_9_0 who_n_9_0 0 40p
Rwp_9_0 who_p_9_0 wcm 2g
Rwn_9_0 who_n_9_0 wcm 2g
Xsyn_9_0 ahp9 ahn9 who_p_9_0 who_n_9_0 mop0 mon0 vdd vbsyn gsynR
Cwp_10_0 who_p_10_0 0 40p
Cwn_10_0 who_n_10_0 0 40p
Rwp_10_0 who_p_10_0 wcm 2g
Rwn_10_0 who_n_10_0 wcm 2g
Xsyn_10_0 ahp10 ahn10 who_p_10_0 who_n_10_0 mop0 mon0 vdd vbsyn gsynR
Cwp_11_0 who_p_11_0 0 40p
Cwn_11_0 who_n_11_0 0 40p
Rwp_11_0 who_p_11_0 wcm 2g
Rwn_11_0 who_n_11_0 wcm 2g
Xsyn_11_0 ahp11 ahn11 who_p_11_0 who_n_11_0 mop0 mon0 vdd vbsyn gsynR
Cwp_12_0 who_p_12_0 0 40p
Cwn_12_0 who_n_12_0 0 40p
Rwp_12_0 who_p_12_0 wcm 2g
Rwn_12_0 who_n_12_0 wcm 2g
Xsyn_12_0 ahp12 ahn12 who_p_12_0 who_n_12_0 mop0 mon0 vdd vbsyn gsynR
Cwp_13_0 who_p_13_0 0 40p
Cwn_13_0 who_n_13_0 0 40p
Rwp_13_0 who_p_13_0 wcm 2g
Rwn_13_0 who_n_13_0 wcm 2g
Xsyn_13_0 ahp13 ahn13 who_p_13_0 who_n_13_0 mop0 mon0 vdd vbsyn gsynR
Cwp_14_0 who_p_14_0 0 40p
Cwn_14_0 who_n_14_0 0 40p
Rwp_14_0 who_p_14_0 wcm 2g
Rwn_14_0 who_n_14_0 wcm 2g
Xsyn_14_0 ahp14 ahn14 who_p_14_0 who_n_14_0 mop0 mon0 vdd vbsyn gsynR
Cwp_15_0 who_p_15_0 0 40p
Cwn_15_0 who_n_15_0 0 40p
Rwp_15_0 who_p_15_0 wcm 2g
Rwn_15_0 who_n_15_0 wcm 2g
Xsyn_15_0 ahp15 ahn15 who_p_15_0 who_n_15_0 mop0 mon0 vdd vbsyn gsynR
Cwp_16_0 who_p_16_0 0 40p
Cwn_16_0 who_n_16_0 0 40p
Rwp_16_0 who_p_16_0 wcm 2g
Rwn_16_0 who_n_16_0 wcm 2g
Xsyn_16_0 ahp16 ahn16 who_p_16_0 who_n_16_0 mop0 mon0 vdd vbsyn gsynR
Cwp_17_0 who_p_17_0 0 40p
Cwn_17_0 who_n_17_0 0 40p
Rwp_17_0 who_p_17_0 wcm 2g
Rwn_17_0 who_n_17_0 wcm 2g
Xsyn_17_0 ahp17 ahn17 who_p_17_0 who_n_17_0 mop0 mon0 vdd vbsyn gsynR
Cwp_18_0 who_p_18_0 0 40p
Cwn_18_0 who_n_18_0 0 40p
Rwp_18_0 who_p_18_0 wcm 2g
Rwn_18_0 who_n_18_0 wcm 2g
Xsyn_18_0 ahp18 ahn18 who_p_18_0 who_n_18_0 mop0 mon0 vdd vbsyn gsynR
Cwp_19_0 who_p_19_0 0 40p
Cwn_19_0 who_n_19_0 0 40p
Rwp_19_0 who_p_19_0 wcm 2g
Rwn_19_0 who_n_19_0 wcm 2g
Xsyn_19_0 ahp19 ahn19 who_p_19_0 who_n_19_0 mop0 mon0 vdd vbsyn gsynR
Cwp_20_0 who_p_20_0 0 40p
Cwn_20_0 who_n_20_0 0 40p
Rwp_20_0 who_p_20_0 wcm 2g
Rwn_20_0 who_n_20_0 wcm 2g
Xsyn_20_0 ahp20 ahn20 who_p_20_0 who_n_20_0 mop0 mon0 vdd vbsyn gsynR
Cwp_21_0 who_p_21_0 0 40p
Cwn_21_0 who_n_21_0 0 40p
Rwp_21_0 who_p_21_0 wcm 2g
Rwn_21_0 who_n_21_0 wcm 2g
Xsyn_21_0 ahp21 ahn21 who_p_21_0 who_n_21_0 mop0 mon0 vdd vbsyn gsynR
Cwp_22_0 who_p_22_0 0 40p
Cwn_22_0 who_n_22_0 0 40p
Rwp_22_0 who_p_22_0 wcm 2g
Rwn_22_0 who_n_22_0 wcm 2g
Xsyn_22_0 ahp22 ahn22 who_p_22_0 who_n_22_0 mop0 mon0 vdd vbsyn gsynR
Cwp_23_0 who_p_23_0 0 40p
Cwn_23_0 who_n_23_0 0 40p
Rwp_23_0 who_p_23_0 wcm 2g
Rwn_23_0 who_n_23_0 wcm 2g
Xsyn_23_0 ahp23 ahn23 who_p_23_0 who_n_23_0 mop0 mon0 vdd vbsyn gsynR
Cwp_24_0 who_p_24_0 0 40p
Cwn_24_0 who_n_24_0 0 40p
Rwp_24_0 who_p_24_0 wcm 2g
Rwn_24_0 who_n_24_0 wcm 2g
Xsyn_24_0 ahp24 ahn24 who_p_24_0 who_n_24_0 mop0 mon0 vdd vbsyn gsynR
Cwp_25_0 who_p_25_0 0 40p
Cwn_25_0 who_n_25_0 0 40p
Rwp_25_0 who_p_25_0 wcm 2g
Rwn_25_0 who_n_25_0 wcm 2g
Xsyn_25_0 ahp25 ahn25 who_p_25_0 who_n_25_0 mop0 mon0 vdd vbsyn gsynR
Cwp_26_0 who_p_26_0 0 40p
Cwn_26_0 who_n_26_0 0 40p
Rwp_26_0 who_p_26_0 wcm 2g
Rwn_26_0 who_n_26_0 wcm 2g
Xsyn_26_0 ahp26 ahn26 who_p_26_0 who_n_26_0 mop0 mon0 vdd vbsyn gsynR
Cwp_27_0 who_p_27_0 0 40p
Cwn_27_0 who_n_27_0 0 40p
Rwp_27_0 who_p_27_0 wcm 2g
Rwn_27_0 who_n_27_0 wcm 2g
Xsyn_27_0 ahp27 ahn27 who_p_27_0 who_n_27_0 mop0 mon0 vdd vbsyn gsynR
Cwp_28_0 who_p_28_0 0 40p
Cwn_28_0 who_n_28_0 0 40p
Rwp_28_0 who_p_28_0 wcm 2g
Rwn_28_0 who_n_28_0 wcm 2g
Xsyn_28_0 ahp28 ahn28 who_p_28_0 who_n_28_0 mop0 mon0 vdd vbsyn gsynR
Cwp_29_0 who_p_29_0 0 40p
Cwn_29_0 who_n_29_0 0 40p
Rwp_29_0 who_p_29_0 wcm 2g
Rwn_29_0 who_n_29_0 wcm 2g
Xsyn_29_0 ahp29 ahn29 who_p_29_0 who_n_29_0 mop0 mon0 vdd vbsyn gsynR
Cwp_30_0 who_p_30_0 0 40p
Cwn_30_0 who_n_30_0 0 40p
Rwp_30_0 who_p_30_0 wcm 2g
Rwn_30_0 who_n_30_0 wcm 2g
Xsyn_30_0 ahp30 ahn30 who_p_30_0 who_n_30_0 mop0 mon0 vdd vbsyn gsynR
Cwp_31_0 who_p_31_0 0 40p
Cwn_31_0 who_n_31_0 0 40p
Rwp_31_0 who_p_31_0 wcm 2g
Rwn_31_0 who_n_31_0 wcm 2g
Xsyn_31_0 ahp31 ahn31 who_p_31_0 who_n_31_0 mop0 mon0 vdd vbsyn gsynR
Cwp_32_0 who_p_32_0 0 40p
Cwn_32_0 who_n_32_0 0 40p
Rwp_32_0 who_p_32_0 wcm 2g
Rwn_32_0 who_n_32_0 wcm 2g
Xsyn_32_0 ahp32 ahn32 who_p_32_0 who_n_32_0 mop0 mon0 vdd vbsyn gsynR
Cwp_33_0 who_p_33_0 0 40p
Cwn_33_0 who_n_33_0 0 40p
Rwp_33_0 who_p_33_0 wcm 2g
Rwn_33_0 who_n_33_0 wcm 2g
Xsyn_33_0 ahp33 ahn33 who_p_33_0 who_n_33_0 mop0 mon0 vdd vbsyn gsynR
Cwp_34_0 who_p_34_0 0 40p
Cwn_34_0 who_n_34_0 0 40p
Rwp_34_0 who_p_34_0 wcm 2g
Rwn_34_0 who_n_34_0 wcm 2g
Xsyn_34_0 ahp34 ahn34 who_p_34_0 who_n_34_0 mop0 mon0 vdd vbsyn gsynR
Cwp_35_0 who_p_35_0 0 40p
Cwn_35_0 who_n_35_0 0 40p
Rwp_35_0 who_p_35_0 wcm 2g
Rwn_35_0 who_n_35_0 wcm 2g
Xsyn_35_0 ahp35 ahn35 who_p_35_0 who_n_35_0 mop0 mon0 vdd vbsyn gsynR
Cwp_36_0 who_p_36_0 0 40p
Cwn_36_0 who_n_36_0 0 40p
Rwp_36_0 who_p_36_0 wcm 2g
Rwn_36_0 who_n_36_0 wcm 2g
Xsyn_36_0 ahp36 ahn36 who_p_36_0 who_n_36_0 mop0 mon0 vdd vbsyn gsynR
Cwp_37_0 who_p_37_0 0 40p
Cwn_37_0 who_n_37_0 0 40p
Rwp_37_0 who_p_37_0 wcm 2g
Rwn_37_0 who_n_37_0 wcm 2g
Xsyn_37_0 ahp37 ahn37 who_p_37_0 who_n_37_0 mop0 mon0 vdd vbsyn gsynR
Cwp_38_0 who_p_38_0 0 40p
Cwn_38_0 who_n_38_0 0 40p
Rwp_38_0 who_p_38_0 wcm 2g
Rwn_38_0 who_n_38_0 wcm 2g
Xsyn_38_0 ahp38 ahn38 who_p_38_0 who_n_38_0 mop0 mon0 vdd vbsyn gsynR
Cwp_39_0 who_p_39_0 0 40p
Cwn_39_0 who_n_39_0 0 40p
Rwp_39_0 who_p_39_0 wcm 2g
Rwn_39_0 who_n_39_0 wcm 2g
Xsyn_39_0 ahp39 ahn39 who_p_39_0 who_n_39_0 mop0 mon0 vdd vbsyn gsynR
Cwp_40_0 who_p_40_0 0 40p
Cwn_40_0 who_n_40_0 0 40p
Rwp_40_0 who_p_40_0 wcm 2g
Rwn_40_0 who_n_40_0 wcm 2g
Xsyn_40_0 ahp40 ahn40 who_p_40_0 who_n_40_0 mop0 mon0 vdd vbsyn gsynR
Cwp_41_0 who_p_41_0 0 40p
Cwn_41_0 who_n_41_0 0 40p
Rwp_41_0 who_p_41_0 wcm 2g
Rwn_41_0 who_n_41_0 wcm 2g
Xsyn_41_0 ahp41 ahn41 who_p_41_0 who_n_41_0 mop0 mon0 vdd vbsyn gsynR
Cwp_42_0 who_p_42_0 0 40p
Cwn_42_0 who_n_42_0 0 40p
Rwp_42_0 who_p_42_0 wcm 2g
Rwn_42_0 who_n_42_0 wcm 2g
Xsyn_42_0 ahp42 ahn42 who_p_42_0 who_n_42_0 mop0 mon0 vdd vbsyn gsynR
Cwp_43_0 who_p_43_0 0 40p
Cwn_43_0 who_n_43_0 0 40p
Rwp_43_0 who_p_43_0 wcm 2g
Rwn_43_0 who_n_43_0 wcm 2g
Xsyn_43_0 ahp43 ahn43 who_p_43_0 who_n_43_0 mop0 mon0 vdd vbsyn gsynR
Cwp_44_0 who_p_44_0 0 40p
Cwn_44_0 who_n_44_0 0 40p
Rwp_44_0 who_p_44_0 wcm 2g
Rwn_44_0 who_n_44_0 wcm 2g
Xsyn_44_0 ahp44 ahn44 who_p_44_0 who_n_44_0 mop0 mon0 vdd vbsyn gsynR
Cwp_45_0 who_p_45_0 0 40p
Cwn_45_0 who_n_45_0 0 40p
Rwp_45_0 who_p_45_0 wcm 2g
Rwn_45_0 who_n_45_0 wcm 2g
Xsyn_45_0 ahp45 ahn45 who_p_45_0 who_n_45_0 mop0 mon0 vdd vbsyn gsynR
Cwp_46_0 who_p_46_0 0 40p
Cwn_46_0 who_n_46_0 0 40p
Rwp_46_0 who_p_46_0 wcm 2g
Rwn_46_0 who_n_46_0 wcm 2g
Xsyn_46_0 ahp46 ahn46 who_p_46_0 who_n_46_0 mop0 mon0 vdd vbsyn gsynR
Cwp_47_0 who_p_47_0 0 40p
Cwn_47_0 who_n_47_0 0 40p
Rwp_47_0 who_p_47_0 wcm 2g
Rwn_47_0 who_n_47_0 wcm 2g
Xsyn_47_0 ahp47 ahn47 who_p_47_0 who_n_47_0 mop0 mon0 vdd vbsyn gsynR
Cwp_48_0 who_p_48_0 0 40p
Cwn_48_0 who_n_48_0 0 40p
Rwp_48_0 who_p_48_0 wcm 2g
Rwn_48_0 who_n_48_0 wcm 2g
Xsyn_48_0 ahp48 ahn48 who_p_48_0 who_n_48_0 mop0 mon0 vdd vbsyn gsynR
Cwp_49_0 who_p_49_0 0 40p
Cwn_49_0 who_n_49_0 0 40p
Rwp_49_0 who_p_49_0 wcm 2g
Rwn_49_0 who_n_49_0 wcm 2g
Xsyn_49_0 ahp49 ahn49 who_p_49_0 who_n_49_0 mop0 mon0 vdd vbsyn gsynR
Cwp_50_0 who_p_50_0 0 40p
Cwn_50_0 who_n_50_0 0 40p
Rwp_50_0 who_p_50_0 wcm 2g
Rwn_50_0 who_n_50_0 wcm 2g
Xsyn_50_0 ahp50 ahn50 who_p_50_0 who_n_50_0 mop0 mon0 vdd vbsyn gsynR
Cwp_51_0 who_p_51_0 0 40p
Cwn_51_0 who_n_51_0 0 40p
Rwp_51_0 who_p_51_0 wcm 2g
Rwn_51_0 who_n_51_0 wcm 2g
Xsyn_51_0 ahp51 ahn51 who_p_51_0 who_n_51_0 mop0 mon0 vdd vbsyn gsynR
Cwp_52_0 who_p_52_0 0 40p
Cwn_52_0 who_n_52_0 0 40p
Rwp_52_0 who_p_52_0 wcm 2g
Rwn_52_0 who_n_52_0 wcm 2g
Xsyn_52_0 ahp52 ahn52 who_p_52_0 who_n_52_0 mop0 mon0 vdd vbsyn gsynR
Cwp_53_0 who_p_53_0 0 40p
Cwn_53_0 who_n_53_0 0 40p
Rwp_53_0 who_p_53_0 wcm 2g
Rwn_53_0 who_n_53_0 wcm 2g
Xsyn_53_0 ahp53 ahn53 who_p_53_0 who_n_53_0 mop0 mon0 vdd vbsyn gsynR
Cwp_54_0 who_p_54_0 0 40p
Cwn_54_0 who_n_54_0 0 40p
Rwp_54_0 who_p_54_0 wcm 2g
Rwn_54_0 who_n_54_0 wcm 2g
Xsyn_54_0 ahp54 ahn54 who_p_54_0 who_n_54_0 mop0 mon0 vdd vbsyn gsynR
Cwp_55_0 who_p_55_0 0 40p
Cwn_55_0 who_n_55_0 0 40p
Rwp_55_0 who_p_55_0 wcm 2g
Rwn_55_0 who_n_55_0 wcm 2g
Xsyn_55_0 ahp55 ahn55 who_p_55_0 who_n_55_0 mop0 mon0 vdd vbsyn gsynR
Cwp_56_0 who_p_56_0 0 40p
Cwn_56_0 who_n_56_0 0 40p
Rwp_56_0 who_p_56_0 wcm 2g
Rwn_56_0 who_n_56_0 wcm 2g
Xsyn_56_0 ahp56 ahn56 who_p_56_0 who_n_56_0 mop0 mon0 vdd vbsyn gsynR
Cwp_57_0 who_p_57_0 0 40p
Cwn_57_0 who_n_57_0 0 40p
Rwp_57_0 who_p_57_0 wcm 2g
Rwn_57_0 who_n_57_0 wcm 2g
Xsyn_57_0 ahp57 ahn57 who_p_57_0 who_n_57_0 mop0 mon0 vdd vbsyn gsynR
Cwp_58_0 who_p_58_0 0 40p
Cwn_58_0 who_n_58_0 0 40p
Rwp_58_0 who_p_58_0 wcm 2g
Rwn_58_0 who_n_58_0 wcm 2g
Xsyn_58_0 ahp58 ahn58 who_p_58_0 who_n_58_0 mop0 mon0 vdd vbsyn gsynR
Cwp_59_0 who_p_59_0 0 40p
Cwn_59_0 who_n_59_0 0 40p
Rwp_59_0 who_p_59_0 wcm 2g
Rwn_59_0 who_n_59_0 wcm 2g
Xsyn_59_0 ahp59 ahn59 who_p_59_0 who_n_59_0 mop0 mon0 vdd vbsyn gsynR
Cwp_60_0 who_p_60_0 0 40p
Cwn_60_0 who_n_60_0 0 40p
Rwp_60_0 who_p_60_0 wcm 2g
Rwn_60_0 who_n_60_0 wcm 2g
Xsyn_60_0 ahp60 ahn60 who_p_60_0 who_n_60_0 mop0 mon0 vdd vbsyn gsynR
Cwp_61_0 who_p_61_0 0 40p
Cwn_61_0 who_n_61_0 0 40p
Rwp_61_0 who_p_61_0 wcm 2g
Rwn_61_0 who_n_61_0 wcm 2g
Xsyn_61_0 ahp61 ahn61 who_p_61_0 who_n_61_0 mop0 mon0 vdd vbsyn gsynR
Cwp_62_0 who_p_62_0 0 40p
Cwn_62_0 who_n_62_0 0 40p
Rwp_62_0 who_p_62_0 wcm 2g
Rwn_62_0 who_n_62_0 wcm 2g
Xsyn_62_0 ahp62 ahn62 who_p_62_0 who_n_62_0 mop0 mon0 vdd vbsyn gsynR
Cwp_63_0 who_p_63_0 0 40p
Cwn_63_0 who_n_63_0 0 40p
Rwp_63_0 who_p_63_0 wcm 2g
Rwn_63_0 who_n_63_0 wcm 2g
Xsyn_63_0 ahp63 ahn63 who_p_63_0 who_n_63_0 mop0 mon0 vdd vbsyn gsynR
Cwp_64_0 who_p_64_0 0 40p
Cwn_64_0 who_n_64_0 0 40p
Rwp_64_0 who_p_64_0 wcm 2g
Rwn_64_0 who_n_64_0 wcm 2g
Xsyn_64_0 ahp64 ahn64 who_p_64_0 who_n_64_0 mop0 mon0 vdd vbsyn gsynR
Cwp_65_0 who_p_65_0 0 40p
Cwn_65_0 who_n_65_0 0 40p
Rwp_65_0 who_p_65_0 wcm 2g
Rwn_65_0 who_n_65_0 wcm 2g
Xsyn_65_0 ahp65 ahn65 who_p_65_0 who_n_65_0 mop0 mon0 vdd vbsyn gsynR
Cwp_66_0 who_p_66_0 0 40p
Cwn_66_0 who_n_66_0 0 40p
Rwp_66_0 who_p_66_0 wcm 2g
Rwn_66_0 who_n_66_0 wcm 2g
Xsyn_66_0 ahp66 ahn66 who_p_66_0 who_n_66_0 mop0 mon0 vdd vbsyn gsynR
Cwp_67_0 who_p_67_0 0 40p
Cwn_67_0 who_n_67_0 0 40p
Rwp_67_0 who_p_67_0 wcm 2g
Rwn_67_0 who_n_67_0 wcm 2g
Xsyn_67_0 ahp67 ahn67 who_p_67_0 who_n_67_0 mop0 mon0 vdd vbsyn gsynR
Cwp_68_0 who_p_68_0 0 40p
Cwn_68_0 who_n_68_0 0 40p
Rwp_68_0 who_p_68_0 wcm 2g
Rwn_68_0 who_n_68_0 wcm 2g
Xsyn_68_0 ahp68 ahn68 who_p_68_0 who_n_68_0 mop0 mon0 vdd vbsyn gsynR
Cwp_69_0 who_p_69_0 0 40p
Cwn_69_0 who_n_69_0 0 40p
Rwp_69_0 who_p_69_0 wcm 2g
Rwn_69_0 who_n_69_0 wcm 2g
Xsyn_69_0 ahp69 ahn69 who_p_69_0 who_n_69_0 mop0 mon0 vdd vbsyn gsynR
Cwp_70_0 who_p_70_0 0 40p
Cwn_70_0 who_n_70_0 0 40p
Rwp_70_0 who_p_70_0 wcm 2g
Rwn_70_0 who_n_70_0 wcm 2g
Xsyn_70_0 ahp70 ahn70 who_p_70_0 who_n_70_0 mop0 mon0 vdd vbsyn gsynR
Cwp_71_0 who_p_71_0 0 40p
Cwn_71_0 who_n_71_0 0 40p
Rwp_71_0 who_p_71_0 wcm 2g
Rwn_71_0 who_n_71_0 wcm 2g
Xsyn_71_0 ahp71 ahn71 who_p_71_0 who_n_71_0 mop0 mon0 vdd vbsyn gsynR
Cwp_72_0 who_p_72_0 0 40p
Cwn_72_0 who_n_72_0 0 40p
Rwp_72_0 who_p_72_0 wcm 2g
Rwn_72_0 who_n_72_0 wcm 2g
Xsyn_72_0 ahp72 ahn72 who_p_72_0 who_n_72_0 mop0 mon0 vdd vbsyn gsynR
Cwp_73_0 who_p_73_0 0 40p
Cwn_73_0 who_n_73_0 0 40p
Rwp_73_0 who_p_73_0 wcm 2g
Rwn_73_0 who_n_73_0 wcm 2g
Xsyn_73_0 ahp73 ahn73 who_p_73_0 who_n_73_0 mop0 mon0 vdd vbsyn gsynR
Cwp_74_0 who_p_74_0 0 40p
Cwn_74_0 who_n_74_0 0 40p
Rwp_74_0 who_p_74_0 wcm 2g
Rwn_74_0 who_n_74_0 wcm 2g
Xsyn_74_0 ahp74 ahn74 who_p_74_0 who_n_74_0 mop0 mon0 vdd vbsyn gsynR
Cwp_75_0 who_p_75_0 0 40p
Cwn_75_0 who_n_75_0 0 40p
Rwp_75_0 who_p_75_0 wcm 2g
Rwn_75_0 who_n_75_0 wcm 2g
Xsyn_75_0 ahp75 ahn75 who_p_75_0 who_n_75_0 mop0 mon0 vdd vbsyn gsynR
Cwp_76_0 who_p_76_0 0 40p
Cwn_76_0 who_n_76_0 0 40p
Rwp_76_0 who_p_76_0 wcm 2g
Rwn_76_0 who_n_76_0 wcm 2g
Xsyn_76_0 ahp76 ahn76 who_p_76_0 who_n_76_0 mop0 mon0 vdd vbsyn gsynR
Cwp_77_0 who_p_77_0 0 40p
Cwn_77_0 who_n_77_0 0 40p
Rwp_77_0 who_p_77_0 wcm 2g
Rwn_77_0 who_n_77_0 wcm 2g
Xsyn_77_0 ahp77 ahn77 who_p_77_0 who_n_77_0 mop0 mon0 vdd vbsyn gsynR
Cwp_78_0 who_p_78_0 0 40p
Cwn_78_0 who_n_78_0 0 40p
Rwp_78_0 who_p_78_0 wcm 2g
Rwn_78_0 who_n_78_0 wcm 2g
Xsyn_78_0 ahp78 ahn78 who_p_78_0 who_n_78_0 mop0 mon0 vdd vbsyn gsynR
Cwp_79_0 who_p_79_0 0 40p
Cwn_79_0 who_n_79_0 0 40p
Rwp_79_0 who_p_79_0 wcm 2g
Rwn_79_0 who_n_79_0 wcm 2g
Xsyn_79_0 ahp79 ahn79 who_p_79_0 who_n_79_0 mop0 mon0 vdd vbsyn gsynR
Cwp_80_0 who_p_80_0 0 40p
Cwn_80_0 who_n_80_0 0 40p
Rwp_80_0 who_p_80_0 wcm 2g
Rwn_80_0 who_n_80_0 wcm 2g
Xsyn_80_0 ahp80 ahn80 who_p_80_0 who_n_80_0 mop0 mon0 vdd vbsyn gsynR
Cwp_81_0 who_p_81_0 0 40p
Cwn_81_0 who_n_81_0 0 40p
Rwp_81_0 who_p_81_0 wcm 2g
Rwn_81_0 who_n_81_0 wcm 2g
Xsyn_81_0 ahp81 ahn81 who_p_81_0 who_n_81_0 mop0 mon0 vdd vbsyn gsynR
Cwp_82_0 who_p_82_0 0 40p
Cwn_82_0 who_n_82_0 0 40p
Rwp_82_0 who_p_82_0 wcm 2g
Rwn_82_0 who_n_82_0 wcm 2g
Xsyn_82_0 ahp82 ahn82 who_p_82_0 who_n_82_0 mop0 mon0 vdd vbsyn gsynR
Cwp_83_0 who_p_83_0 0 40p
Cwn_83_0 who_n_83_0 0 40p
Rwp_83_0 who_p_83_0 wcm 2g
Rwn_83_0 who_n_83_0 wcm 2g
Xsyn_83_0 ahp83 ahn83 who_p_83_0 who_n_83_0 mop0 mon0 vdd vbsyn gsynR
Cwp_84_0 who_p_84_0 0 40p
Cwn_84_0 who_n_84_0 0 40p
Rwp_84_0 who_p_84_0 wcm 2g
Rwn_84_0 who_n_84_0 wcm 2g
Xsyn_84_0 ahp84 ahn84 who_p_84_0 who_n_84_0 mop0 mon0 vdd vbsyn gsynR
Cwp_85_0 who_p_85_0 0 40p
Cwn_85_0 who_n_85_0 0 40p
Rwp_85_0 who_p_85_0 wcm 2g
Rwn_85_0 who_n_85_0 wcm 2g
Xsyn_85_0 ahp85 ahn85 who_p_85_0 who_n_85_0 mop0 mon0 vdd vbsyn gsynR
Cwp_86_0 who_p_86_0 0 40p
Cwn_86_0 who_n_86_0 0 40p
Rwp_86_0 who_p_86_0 wcm 2g
Rwn_86_0 who_n_86_0 wcm 2g
Xsyn_86_0 ahp86 ahn86 who_p_86_0 who_n_86_0 mop0 mon0 vdd vbsyn gsynR
Cwp_87_0 who_p_87_0 0 40p
Cwn_87_0 who_n_87_0 0 40p
Rwp_87_0 who_p_87_0 wcm 2g
Rwn_87_0 who_n_87_0 wcm 2g
Xsyn_87_0 ahp87 ahn87 who_p_87_0 who_n_87_0 mop0 mon0 vdd vbsyn gsynR
Cwp_88_0 who_p_88_0 0 40p
Cwn_88_0 who_n_88_0 0 40p
Rwp_88_0 who_p_88_0 wcm 2g
Rwn_88_0 who_n_88_0 wcm 2g
Xsyn_88_0 ahp88 ahn88 who_p_88_0 who_n_88_0 mop0 mon0 vdd vbsyn gsynR
Cwp_89_0 who_p_89_0 0 40p
Cwn_89_0 who_n_89_0 0 40p
Rwp_89_0 who_p_89_0 wcm 2g
Rwn_89_0 who_n_89_0 wcm 2g
Xsyn_89_0 ahp89 ahn89 who_p_89_0 who_n_89_0 mop0 mon0 vdd vbsyn gsynR
Cwp_90_0 who_p_90_0 0 40p
Cwn_90_0 who_n_90_0 0 40p
Rwp_90_0 who_p_90_0 wcm 2g
Rwn_90_0 who_n_90_0 wcm 2g
Xsyn_90_0 ahp90 ahn90 who_p_90_0 who_n_90_0 mop0 mon0 vdd vbsyn gsynR
Cwp_91_0 who_p_91_0 0 40p
Cwn_91_0 who_n_91_0 0 40p
Rwp_91_0 who_p_91_0 wcm 2g
Rwn_91_0 who_n_91_0 wcm 2g
Xsyn_91_0 ahp91 ahn91 who_p_91_0 who_n_91_0 mop0 mon0 vdd vbsyn gsynR
Cwp_92_0 who_p_92_0 0 40p
Cwn_92_0 who_n_92_0 0 40p
Rwp_92_0 who_p_92_0 wcm 2g
Rwn_92_0 who_n_92_0 wcm 2g
Xsyn_92_0 ahp92 ahn92 who_p_92_0 who_n_92_0 mop0 mon0 vdd vbsyn gsynR
Cwp_93_0 who_p_93_0 0 40p
Cwn_93_0 who_n_93_0 0 40p
Rwp_93_0 who_p_93_0 wcm 2g
Rwn_93_0 who_n_93_0 wcm 2g
Xsyn_93_0 ahp93 ahn93 who_p_93_0 who_n_93_0 mop0 mon0 vdd vbsyn gsynR
Cwp_94_0 who_p_94_0 0 40p
Cwn_94_0 who_n_94_0 0 40p
Rwp_94_0 who_p_94_0 wcm 2g
Rwn_94_0 who_n_94_0 wcm 2g
Xsyn_94_0 ahp94 ahn94 who_p_94_0 who_n_94_0 mop0 mon0 vdd vbsyn gsynR
Cwp_95_0 who_p_95_0 0 40p
Cwn_95_0 who_n_95_0 0 40p
Rwp_95_0 who_p_95_0 wcm 2g
Rwn_95_0 who_n_95_0 wcm 2g
Xsyn_95_0 ahp95 ahn95 who_p_95_0 who_n_95_0 mop0 mon0 vdd vbsyn gsynR
Cwp_96_0 who_p_96_0 0 40p
Cwn_96_0 who_n_96_0 0 40p
Rwp_96_0 who_p_96_0 wcm 2g
Rwn_96_0 who_n_96_0 wcm 2g
Xsyn_96_0 ahbias_p ahbias_n who_p_96_0 who_n_96_0 mop0 mon0 vdd vbsyn gsynR
Xeo0 xop0 xon0 mop0 mon0 eop0 eon0 vdd gm esub
Xcm_mo1 mop1 mon1 vdd cmldW
Rmo1 mop1 mon1 20k
Cmo1p mop1 0 1e-13
Cmo1n mon1 0 1e-13
Cwp_0_1 who_p_0_1 0 40p
Cwn_0_1 who_n_0_1 0 40p
Rwp_0_1 who_p_0_1 wcm 2g
Rwn_0_1 who_n_0_1 wcm 2g
Xsyn_0_1 ahp0 ahn0 who_p_0_1 who_n_0_1 mop1 mon1 vdd vbsyn gsynR
Cwp_1_1 who_p_1_1 0 40p
Cwn_1_1 who_n_1_1 0 40p
Rwp_1_1 who_p_1_1 wcm 2g
Rwn_1_1 who_n_1_1 wcm 2g
Xsyn_1_1 ahp1 ahn1 who_p_1_1 who_n_1_1 mop1 mon1 vdd vbsyn gsynR
Cwp_2_1 who_p_2_1 0 40p
Cwn_2_1 who_n_2_1 0 40p
Rwp_2_1 who_p_2_1 wcm 2g
Rwn_2_1 who_n_2_1 wcm 2g
Xsyn_2_1 ahp2 ahn2 who_p_2_1 who_n_2_1 mop1 mon1 vdd vbsyn gsynR
Cwp_3_1 who_p_3_1 0 40p
Cwn_3_1 who_n_3_1 0 40p
Rwp_3_1 who_p_3_1 wcm 2g
Rwn_3_1 who_n_3_1 wcm 2g
Xsyn_3_1 ahp3 ahn3 who_p_3_1 who_n_3_1 mop1 mon1 vdd vbsyn gsynR
Cwp_4_1 who_p_4_1 0 40p
Cwn_4_1 who_n_4_1 0 40p
Rwp_4_1 who_p_4_1 wcm 2g
Rwn_4_1 who_n_4_1 wcm 2g
Xsyn_4_1 ahp4 ahn4 who_p_4_1 who_n_4_1 mop1 mon1 vdd vbsyn gsynR
Cwp_5_1 who_p_5_1 0 40p
Cwn_5_1 who_n_5_1 0 40p
Rwp_5_1 who_p_5_1 wcm 2g
Rwn_5_1 who_n_5_1 wcm 2g
Xsyn_5_1 ahp5 ahn5 who_p_5_1 who_n_5_1 mop1 mon1 vdd vbsyn gsynR
Cwp_6_1 who_p_6_1 0 40p
Cwn_6_1 who_n_6_1 0 40p
Rwp_6_1 who_p_6_1 wcm 2g
Rwn_6_1 who_n_6_1 wcm 2g
Xsyn_6_1 ahp6 ahn6 who_p_6_1 who_n_6_1 mop1 mon1 vdd vbsyn gsynR
Cwp_7_1 who_p_7_1 0 40p
Cwn_7_1 who_n_7_1 0 40p
Rwp_7_1 who_p_7_1 wcm 2g
Rwn_7_1 who_n_7_1 wcm 2g
Xsyn_7_1 ahp7 ahn7 who_p_7_1 who_n_7_1 mop1 mon1 vdd vbsyn gsynR
Cwp_8_1 who_p_8_1 0 40p
Cwn_8_1 who_n_8_1 0 40p
Rwp_8_1 who_p_8_1 wcm 2g
Rwn_8_1 who_n_8_1 wcm 2g
Xsyn_8_1 ahp8 ahn8 who_p_8_1 who_n_8_1 mop1 mon1 vdd vbsyn gsynR
Cwp_9_1 who_p_9_1 0 40p
Cwn_9_1 who_n_9_1 0 40p
Rwp_9_1 who_p_9_1 wcm 2g
Rwn_9_1 who_n_9_1 wcm 2g
Xsyn_9_1 ahp9 ahn9 who_p_9_1 who_n_9_1 mop1 mon1 vdd vbsyn gsynR
Cwp_10_1 who_p_10_1 0 40p
Cwn_10_1 who_n_10_1 0 40p
Rwp_10_1 who_p_10_1 wcm 2g
Rwn_10_1 who_n_10_1 wcm 2g
Xsyn_10_1 ahp10 ahn10 who_p_10_1 who_n_10_1 mop1 mon1 vdd vbsyn gsynR
Cwp_11_1 who_p_11_1 0 40p
Cwn_11_1 who_n_11_1 0 40p
Rwp_11_1 who_p_11_1 wcm 2g
Rwn_11_1 who_n_11_1 wcm 2g
Xsyn_11_1 ahp11 ahn11 who_p_11_1 who_n_11_1 mop1 mon1 vdd vbsyn gsynR
Cwp_12_1 who_p_12_1 0 40p
Cwn_12_1 who_n_12_1 0 40p
Rwp_12_1 who_p_12_1 wcm 2g
Rwn_12_1 who_n_12_1 wcm 2g
Xsyn_12_1 ahp12 ahn12 who_p_12_1 who_n_12_1 mop1 mon1 vdd vbsyn gsynR
Cwp_13_1 who_p_13_1 0 40p
Cwn_13_1 who_n_13_1 0 40p
Rwp_13_1 who_p_13_1 wcm 2g
Rwn_13_1 who_n_13_1 wcm 2g
Xsyn_13_1 ahp13 ahn13 who_p_13_1 who_n_13_1 mop1 mon1 vdd vbsyn gsynR
Cwp_14_1 who_p_14_1 0 40p
Cwn_14_1 who_n_14_1 0 40p
Rwp_14_1 who_p_14_1 wcm 2g
Rwn_14_1 who_n_14_1 wcm 2g
Xsyn_14_1 ahp14 ahn14 who_p_14_1 who_n_14_1 mop1 mon1 vdd vbsyn gsynR
Cwp_15_1 who_p_15_1 0 40p
Cwn_15_1 who_n_15_1 0 40p
Rwp_15_1 who_p_15_1 wcm 2g
Rwn_15_1 who_n_15_1 wcm 2g
Xsyn_15_1 ahp15 ahn15 who_p_15_1 who_n_15_1 mop1 mon1 vdd vbsyn gsynR
Cwp_16_1 who_p_16_1 0 40p
Cwn_16_1 who_n_16_1 0 40p
Rwp_16_1 who_p_16_1 wcm 2g
Rwn_16_1 who_n_16_1 wcm 2g
Xsyn_16_1 ahp16 ahn16 who_p_16_1 who_n_16_1 mop1 mon1 vdd vbsyn gsynR
Cwp_17_1 who_p_17_1 0 40p
Cwn_17_1 who_n_17_1 0 40p
Rwp_17_1 who_p_17_1 wcm 2g
Rwn_17_1 who_n_17_1 wcm 2g
Xsyn_17_1 ahp17 ahn17 who_p_17_1 who_n_17_1 mop1 mon1 vdd vbsyn gsynR
Cwp_18_1 who_p_18_1 0 40p
Cwn_18_1 who_n_18_1 0 40p
Rwp_18_1 who_p_18_1 wcm 2g
Rwn_18_1 who_n_18_1 wcm 2g
Xsyn_18_1 ahp18 ahn18 who_p_18_1 who_n_18_1 mop1 mon1 vdd vbsyn gsynR
Cwp_19_1 who_p_19_1 0 40p
Cwn_19_1 who_n_19_1 0 40p
Rwp_19_1 who_p_19_1 wcm 2g
Rwn_19_1 who_n_19_1 wcm 2g
Xsyn_19_1 ahp19 ahn19 who_p_19_1 who_n_19_1 mop1 mon1 vdd vbsyn gsynR
Cwp_20_1 who_p_20_1 0 40p
Cwn_20_1 who_n_20_1 0 40p
Rwp_20_1 who_p_20_1 wcm 2g
Rwn_20_1 who_n_20_1 wcm 2g
Xsyn_20_1 ahp20 ahn20 who_p_20_1 who_n_20_1 mop1 mon1 vdd vbsyn gsynR
Cwp_21_1 who_p_21_1 0 40p
Cwn_21_1 who_n_21_1 0 40p
Rwp_21_1 who_p_21_1 wcm 2g
Rwn_21_1 who_n_21_1 wcm 2g
Xsyn_21_1 ahp21 ahn21 who_p_21_1 who_n_21_1 mop1 mon1 vdd vbsyn gsynR
Cwp_22_1 who_p_22_1 0 40p
Cwn_22_1 who_n_22_1 0 40p
Rwp_22_1 who_p_22_1 wcm 2g
Rwn_22_1 who_n_22_1 wcm 2g
Xsyn_22_1 ahp22 ahn22 who_p_22_1 who_n_22_1 mop1 mon1 vdd vbsyn gsynR
Cwp_23_1 who_p_23_1 0 40p
Cwn_23_1 who_n_23_1 0 40p
Rwp_23_1 who_p_23_1 wcm 2g
Rwn_23_1 who_n_23_1 wcm 2g
Xsyn_23_1 ahp23 ahn23 who_p_23_1 who_n_23_1 mop1 mon1 vdd vbsyn gsynR
Cwp_24_1 who_p_24_1 0 40p
Cwn_24_1 who_n_24_1 0 40p
Rwp_24_1 who_p_24_1 wcm 2g
Rwn_24_1 who_n_24_1 wcm 2g
Xsyn_24_1 ahp24 ahn24 who_p_24_1 who_n_24_1 mop1 mon1 vdd vbsyn gsynR
Cwp_25_1 who_p_25_1 0 40p
Cwn_25_1 who_n_25_1 0 40p
Rwp_25_1 who_p_25_1 wcm 2g
Rwn_25_1 who_n_25_1 wcm 2g
Xsyn_25_1 ahp25 ahn25 who_p_25_1 who_n_25_1 mop1 mon1 vdd vbsyn gsynR
Cwp_26_1 who_p_26_1 0 40p
Cwn_26_1 who_n_26_1 0 40p
Rwp_26_1 who_p_26_1 wcm 2g
Rwn_26_1 who_n_26_1 wcm 2g
Xsyn_26_1 ahp26 ahn26 who_p_26_1 who_n_26_1 mop1 mon1 vdd vbsyn gsynR
Cwp_27_1 who_p_27_1 0 40p
Cwn_27_1 who_n_27_1 0 40p
Rwp_27_1 who_p_27_1 wcm 2g
Rwn_27_1 who_n_27_1 wcm 2g
Xsyn_27_1 ahp27 ahn27 who_p_27_1 who_n_27_1 mop1 mon1 vdd vbsyn gsynR
Cwp_28_1 who_p_28_1 0 40p
Cwn_28_1 who_n_28_1 0 40p
Rwp_28_1 who_p_28_1 wcm 2g
Rwn_28_1 who_n_28_1 wcm 2g
Xsyn_28_1 ahp28 ahn28 who_p_28_1 who_n_28_1 mop1 mon1 vdd vbsyn gsynR
Cwp_29_1 who_p_29_1 0 40p
Cwn_29_1 who_n_29_1 0 40p
Rwp_29_1 who_p_29_1 wcm 2g
Rwn_29_1 who_n_29_1 wcm 2g
Xsyn_29_1 ahp29 ahn29 who_p_29_1 who_n_29_1 mop1 mon1 vdd vbsyn gsynR
Cwp_30_1 who_p_30_1 0 40p
Cwn_30_1 who_n_30_1 0 40p
Rwp_30_1 who_p_30_1 wcm 2g
Rwn_30_1 who_n_30_1 wcm 2g
Xsyn_30_1 ahp30 ahn30 who_p_30_1 who_n_30_1 mop1 mon1 vdd vbsyn gsynR
Cwp_31_1 who_p_31_1 0 40p
Cwn_31_1 who_n_31_1 0 40p
Rwp_31_1 who_p_31_1 wcm 2g
Rwn_31_1 who_n_31_1 wcm 2g
Xsyn_31_1 ahp31 ahn31 who_p_31_1 who_n_31_1 mop1 mon1 vdd vbsyn gsynR
Cwp_32_1 who_p_32_1 0 40p
Cwn_32_1 who_n_32_1 0 40p
Rwp_32_1 who_p_32_1 wcm 2g
Rwn_32_1 who_n_32_1 wcm 2g
Xsyn_32_1 ahp32 ahn32 who_p_32_1 who_n_32_1 mop1 mon1 vdd vbsyn gsynR
Cwp_33_1 who_p_33_1 0 40p
Cwn_33_1 who_n_33_1 0 40p
Rwp_33_1 who_p_33_1 wcm 2g
Rwn_33_1 who_n_33_1 wcm 2g
Xsyn_33_1 ahp33 ahn33 who_p_33_1 who_n_33_1 mop1 mon1 vdd vbsyn gsynR
Cwp_34_1 who_p_34_1 0 40p
Cwn_34_1 who_n_34_1 0 40p
Rwp_34_1 who_p_34_1 wcm 2g
Rwn_34_1 who_n_34_1 wcm 2g
Xsyn_34_1 ahp34 ahn34 who_p_34_1 who_n_34_1 mop1 mon1 vdd vbsyn gsynR
Cwp_35_1 who_p_35_1 0 40p
Cwn_35_1 who_n_35_1 0 40p
Rwp_35_1 who_p_35_1 wcm 2g
Rwn_35_1 who_n_35_1 wcm 2g
Xsyn_35_1 ahp35 ahn35 who_p_35_1 who_n_35_1 mop1 mon1 vdd vbsyn gsynR
Cwp_36_1 who_p_36_1 0 40p
Cwn_36_1 who_n_36_1 0 40p
Rwp_36_1 who_p_36_1 wcm 2g
Rwn_36_1 who_n_36_1 wcm 2g
Xsyn_36_1 ahp36 ahn36 who_p_36_1 who_n_36_1 mop1 mon1 vdd vbsyn gsynR
Cwp_37_1 who_p_37_1 0 40p
Cwn_37_1 who_n_37_1 0 40p
Rwp_37_1 who_p_37_1 wcm 2g
Rwn_37_1 who_n_37_1 wcm 2g
Xsyn_37_1 ahp37 ahn37 who_p_37_1 who_n_37_1 mop1 mon1 vdd vbsyn gsynR
Cwp_38_1 who_p_38_1 0 40p
Cwn_38_1 who_n_38_1 0 40p
Rwp_38_1 who_p_38_1 wcm 2g
Rwn_38_1 who_n_38_1 wcm 2g
Xsyn_38_1 ahp38 ahn38 who_p_38_1 who_n_38_1 mop1 mon1 vdd vbsyn gsynR
Cwp_39_1 who_p_39_1 0 40p
Cwn_39_1 who_n_39_1 0 40p
Rwp_39_1 who_p_39_1 wcm 2g
Rwn_39_1 who_n_39_1 wcm 2g
Xsyn_39_1 ahp39 ahn39 who_p_39_1 who_n_39_1 mop1 mon1 vdd vbsyn gsynR
Cwp_40_1 who_p_40_1 0 40p
Cwn_40_1 who_n_40_1 0 40p
Rwp_40_1 who_p_40_1 wcm 2g
Rwn_40_1 who_n_40_1 wcm 2g
Xsyn_40_1 ahp40 ahn40 who_p_40_1 who_n_40_1 mop1 mon1 vdd vbsyn gsynR
Cwp_41_1 who_p_41_1 0 40p
Cwn_41_1 who_n_41_1 0 40p
Rwp_41_1 who_p_41_1 wcm 2g
Rwn_41_1 who_n_41_1 wcm 2g
Xsyn_41_1 ahp41 ahn41 who_p_41_1 who_n_41_1 mop1 mon1 vdd vbsyn gsynR
Cwp_42_1 who_p_42_1 0 40p
Cwn_42_1 who_n_42_1 0 40p
Rwp_42_1 who_p_42_1 wcm 2g
Rwn_42_1 who_n_42_1 wcm 2g
Xsyn_42_1 ahp42 ahn42 who_p_42_1 who_n_42_1 mop1 mon1 vdd vbsyn gsynR
Cwp_43_1 who_p_43_1 0 40p
Cwn_43_1 who_n_43_1 0 40p
Rwp_43_1 who_p_43_1 wcm 2g
Rwn_43_1 who_n_43_1 wcm 2g
Xsyn_43_1 ahp43 ahn43 who_p_43_1 who_n_43_1 mop1 mon1 vdd vbsyn gsynR
Cwp_44_1 who_p_44_1 0 40p
Cwn_44_1 who_n_44_1 0 40p
Rwp_44_1 who_p_44_1 wcm 2g
Rwn_44_1 who_n_44_1 wcm 2g
Xsyn_44_1 ahp44 ahn44 who_p_44_1 who_n_44_1 mop1 mon1 vdd vbsyn gsynR
Cwp_45_1 who_p_45_1 0 40p
Cwn_45_1 who_n_45_1 0 40p
Rwp_45_1 who_p_45_1 wcm 2g
Rwn_45_1 who_n_45_1 wcm 2g
Xsyn_45_1 ahp45 ahn45 who_p_45_1 who_n_45_1 mop1 mon1 vdd vbsyn gsynR
Cwp_46_1 who_p_46_1 0 40p
Cwn_46_1 who_n_46_1 0 40p
Rwp_46_1 who_p_46_1 wcm 2g
Rwn_46_1 who_n_46_1 wcm 2g
Xsyn_46_1 ahp46 ahn46 who_p_46_1 who_n_46_1 mop1 mon1 vdd vbsyn gsynR
Cwp_47_1 who_p_47_1 0 40p
Cwn_47_1 who_n_47_1 0 40p
Rwp_47_1 who_p_47_1 wcm 2g
Rwn_47_1 who_n_47_1 wcm 2g
Xsyn_47_1 ahp47 ahn47 who_p_47_1 who_n_47_1 mop1 mon1 vdd vbsyn gsynR
Cwp_48_1 who_p_48_1 0 40p
Cwn_48_1 who_n_48_1 0 40p
Rwp_48_1 who_p_48_1 wcm 2g
Rwn_48_1 who_n_48_1 wcm 2g
Xsyn_48_1 ahp48 ahn48 who_p_48_1 who_n_48_1 mop1 mon1 vdd vbsyn gsynR
Cwp_49_1 who_p_49_1 0 40p
Cwn_49_1 who_n_49_1 0 40p
Rwp_49_1 who_p_49_1 wcm 2g
Rwn_49_1 who_n_49_1 wcm 2g
Xsyn_49_1 ahp49 ahn49 who_p_49_1 who_n_49_1 mop1 mon1 vdd vbsyn gsynR
Cwp_50_1 who_p_50_1 0 40p
Cwn_50_1 who_n_50_1 0 40p
Rwp_50_1 who_p_50_1 wcm 2g
Rwn_50_1 who_n_50_1 wcm 2g
Xsyn_50_1 ahp50 ahn50 who_p_50_1 who_n_50_1 mop1 mon1 vdd vbsyn gsynR
Cwp_51_1 who_p_51_1 0 40p
Cwn_51_1 who_n_51_1 0 40p
Rwp_51_1 who_p_51_1 wcm 2g
Rwn_51_1 who_n_51_1 wcm 2g
Xsyn_51_1 ahp51 ahn51 who_p_51_1 who_n_51_1 mop1 mon1 vdd vbsyn gsynR
Cwp_52_1 who_p_52_1 0 40p
Cwn_52_1 who_n_52_1 0 40p
Rwp_52_1 who_p_52_1 wcm 2g
Rwn_52_1 who_n_52_1 wcm 2g
Xsyn_52_1 ahp52 ahn52 who_p_52_1 who_n_52_1 mop1 mon1 vdd vbsyn gsynR
Cwp_53_1 who_p_53_1 0 40p
Cwn_53_1 who_n_53_1 0 40p
Rwp_53_1 who_p_53_1 wcm 2g
Rwn_53_1 who_n_53_1 wcm 2g
Xsyn_53_1 ahp53 ahn53 who_p_53_1 who_n_53_1 mop1 mon1 vdd vbsyn gsynR
Cwp_54_1 who_p_54_1 0 40p
Cwn_54_1 who_n_54_1 0 40p
Rwp_54_1 who_p_54_1 wcm 2g
Rwn_54_1 who_n_54_1 wcm 2g
Xsyn_54_1 ahp54 ahn54 who_p_54_1 who_n_54_1 mop1 mon1 vdd vbsyn gsynR
Cwp_55_1 who_p_55_1 0 40p
Cwn_55_1 who_n_55_1 0 40p
Rwp_55_1 who_p_55_1 wcm 2g
Rwn_55_1 who_n_55_1 wcm 2g
Xsyn_55_1 ahp55 ahn55 who_p_55_1 who_n_55_1 mop1 mon1 vdd vbsyn gsynR
Cwp_56_1 who_p_56_1 0 40p
Cwn_56_1 who_n_56_1 0 40p
Rwp_56_1 who_p_56_1 wcm 2g
Rwn_56_1 who_n_56_1 wcm 2g
Xsyn_56_1 ahp56 ahn56 who_p_56_1 who_n_56_1 mop1 mon1 vdd vbsyn gsynR
Cwp_57_1 who_p_57_1 0 40p
Cwn_57_1 who_n_57_1 0 40p
Rwp_57_1 who_p_57_1 wcm 2g
Rwn_57_1 who_n_57_1 wcm 2g
Xsyn_57_1 ahp57 ahn57 who_p_57_1 who_n_57_1 mop1 mon1 vdd vbsyn gsynR
Cwp_58_1 who_p_58_1 0 40p
Cwn_58_1 who_n_58_1 0 40p
Rwp_58_1 who_p_58_1 wcm 2g
Rwn_58_1 who_n_58_1 wcm 2g
Xsyn_58_1 ahp58 ahn58 who_p_58_1 who_n_58_1 mop1 mon1 vdd vbsyn gsynR
Cwp_59_1 who_p_59_1 0 40p
Cwn_59_1 who_n_59_1 0 40p
Rwp_59_1 who_p_59_1 wcm 2g
Rwn_59_1 who_n_59_1 wcm 2g
Xsyn_59_1 ahp59 ahn59 who_p_59_1 who_n_59_1 mop1 mon1 vdd vbsyn gsynR
Cwp_60_1 who_p_60_1 0 40p
Cwn_60_1 who_n_60_1 0 40p
Rwp_60_1 who_p_60_1 wcm 2g
Rwn_60_1 who_n_60_1 wcm 2g
Xsyn_60_1 ahp60 ahn60 who_p_60_1 who_n_60_1 mop1 mon1 vdd vbsyn gsynR
Cwp_61_1 who_p_61_1 0 40p
Cwn_61_1 who_n_61_1 0 40p
Rwp_61_1 who_p_61_1 wcm 2g
Rwn_61_1 who_n_61_1 wcm 2g
Xsyn_61_1 ahp61 ahn61 who_p_61_1 who_n_61_1 mop1 mon1 vdd vbsyn gsynR
Cwp_62_1 who_p_62_1 0 40p
Cwn_62_1 who_n_62_1 0 40p
Rwp_62_1 who_p_62_1 wcm 2g
Rwn_62_1 who_n_62_1 wcm 2g
Xsyn_62_1 ahp62 ahn62 who_p_62_1 who_n_62_1 mop1 mon1 vdd vbsyn gsynR
Cwp_63_1 who_p_63_1 0 40p
Cwn_63_1 who_n_63_1 0 40p
Rwp_63_1 who_p_63_1 wcm 2g
Rwn_63_1 who_n_63_1 wcm 2g
Xsyn_63_1 ahp63 ahn63 who_p_63_1 who_n_63_1 mop1 mon1 vdd vbsyn gsynR
Cwp_64_1 who_p_64_1 0 40p
Cwn_64_1 who_n_64_1 0 40p
Rwp_64_1 who_p_64_1 wcm 2g
Rwn_64_1 who_n_64_1 wcm 2g
Xsyn_64_1 ahp64 ahn64 who_p_64_1 who_n_64_1 mop1 mon1 vdd vbsyn gsynR
Cwp_65_1 who_p_65_1 0 40p
Cwn_65_1 who_n_65_1 0 40p
Rwp_65_1 who_p_65_1 wcm 2g
Rwn_65_1 who_n_65_1 wcm 2g
Xsyn_65_1 ahp65 ahn65 who_p_65_1 who_n_65_1 mop1 mon1 vdd vbsyn gsynR
Cwp_66_1 who_p_66_1 0 40p
Cwn_66_1 who_n_66_1 0 40p
Rwp_66_1 who_p_66_1 wcm 2g
Rwn_66_1 who_n_66_1 wcm 2g
Xsyn_66_1 ahp66 ahn66 who_p_66_1 who_n_66_1 mop1 mon1 vdd vbsyn gsynR
Cwp_67_1 who_p_67_1 0 40p
Cwn_67_1 who_n_67_1 0 40p
Rwp_67_1 who_p_67_1 wcm 2g
Rwn_67_1 who_n_67_1 wcm 2g
Xsyn_67_1 ahp67 ahn67 who_p_67_1 who_n_67_1 mop1 mon1 vdd vbsyn gsynR
Cwp_68_1 who_p_68_1 0 40p
Cwn_68_1 who_n_68_1 0 40p
Rwp_68_1 who_p_68_1 wcm 2g
Rwn_68_1 who_n_68_1 wcm 2g
Xsyn_68_1 ahp68 ahn68 who_p_68_1 who_n_68_1 mop1 mon1 vdd vbsyn gsynR
Cwp_69_1 who_p_69_1 0 40p
Cwn_69_1 who_n_69_1 0 40p
Rwp_69_1 who_p_69_1 wcm 2g
Rwn_69_1 who_n_69_1 wcm 2g
Xsyn_69_1 ahp69 ahn69 who_p_69_1 who_n_69_1 mop1 mon1 vdd vbsyn gsynR
Cwp_70_1 who_p_70_1 0 40p
Cwn_70_1 who_n_70_1 0 40p
Rwp_70_1 who_p_70_1 wcm 2g
Rwn_70_1 who_n_70_1 wcm 2g
Xsyn_70_1 ahp70 ahn70 who_p_70_1 who_n_70_1 mop1 mon1 vdd vbsyn gsynR
Cwp_71_1 who_p_71_1 0 40p
Cwn_71_1 who_n_71_1 0 40p
Rwp_71_1 who_p_71_1 wcm 2g
Rwn_71_1 who_n_71_1 wcm 2g
Xsyn_71_1 ahp71 ahn71 who_p_71_1 who_n_71_1 mop1 mon1 vdd vbsyn gsynR
Cwp_72_1 who_p_72_1 0 40p
Cwn_72_1 who_n_72_1 0 40p
Rwp_72_1 who_p_72_1 wcm 2g
Rwn_72_1 who_n_72_1 wcm 2g
Xsyn_72_1 ahp72 ahn72 who_p_72_1 who_n_72_1 mop1 mon1 vdd vbsyn gsynR
Cwp_73_1 who_p_73_1 0 40p
Cwn_73_1 who_n_73_1 0 40p
Rwp_73_1 who_p_73_1 wcm 2g
Rwn_73_1 who_n_73_1 wcm 2g
Xsyn_73_1 ahp73 ahn73 who_p_73_1 who_n_73_1 mop1 mon1 vdd vbsyn gsynR
Cwp_74_1 who_p_74_1 0 40p
Cwn_74_1 who_n_74_1 0 40p
Rwp_74_1 who_p_74_1 wcm 2g
Rwn_74_1 who_n_74_1 wcm 2g
Xsyn_74_1 ahp74 ahn74 who_p_74_1 who_n_74_1 mop1 mon1 vdd vbsyn gsynR
Cwp_75_1 who_p_75_1 0 40p
Cwn_75_1 who_n_75_1 0 40p
Rwp_75_1 who_p_75_1 wcm 2g
Rwn_75_1 who_n_75_1 wcm 2g
Xsyn_75_1 ahp75 ahn75 who_p_75_1 who_n_75_1 mop1 mon1 vdd vbsyn gsynR
Cwp_76_1 who_p_76_1 0 40p
Cwn_76_1 who_n_76_1 0 40p
Rwp_76_1 who_p_76_1 wcm 2g
Rwn_76_1 who_n_76_1 wcm 2g
Xsyn_76_1 ahp76 ahn76 who_p_76_1 who_n_76_1 mop1 mon1 vdd vbsyn gsynR
Cwp_77_1 who_p_77_1 0 40p
Cwn_77_1 who_n_77_1 0 40p
Rwp_77_1 who_p_77_1 wcm 2g
Rwn_77_1 who_n_77_1 wcm 2g
Xsyn_77_1 ahp77 ahn77 who_p_77_1 who_n_77_1 mop1 mon1 vdd vbsyn gsynR
Cwp_78_1 who_p_78_1 0 40p
Cwn_78_1 who_n_78_1 0 40p
Rwp_78_1 who_p_78_1 wcm 2g
Rwn_78_1 who_n_78_1 wcm 2g
Xsyn_78_1 ahp78 ahn78 who_p_78_1 who_n_78_1 mop1 mon1 vdd vbsyn gsynR
Cwp_79_1 who_p_79_1 0 40p
Cwn_79_1 who_n_79_1 0 40p
Rwp_79_1 who_p_79_1 wcm 2g
Rwn_79_1 who_n_79_1 wcm 2g
Xsyn_79_1 ahp79 ahn79 who_p_79_1 who_n_79_1 mop1 mon1 vdd vbsyn gsynR
Cwp_80_1 who_p_80_1 0 40p
Cwn_80_1 who_n_80_1 0 40p
Rwp_80_1 who_p_80_1 wcm 2g
Rwn_80_1 who_n_80_1 wcm 2g
Xsyn_80_1 ahp80 ahn80 who_p_80_1 who_n_80_1 mop1 mon1 vdd vbsyn gsynR
Cwp_81_1 who_p_81_1 0 40p
Cwn_81_1 who_n_81_1 0 40p
Rwp_81_1 who_p_81_1 wcm 2g
Rwn_81_1 who_n_81_1 wcm 2g
Xsyn_81_1 ahp81 ahn81 who_p_81_1 who_n_81_1 mop1 mon1 vdd vbsyn gsynR
Cwp_82_1 who_p_82_1 0 40p
Cwn_82_1 who_n_82_1 0 40p
Rwp_82_1 who_p_82_1 wcm 2g
Rwn_82_1 who_n_82_1 wcm 2g
Xsyn_82_1 ahp82 ahn82 who_p_82_1 who_n_82_1 mop1 mon1 vdd vbsyn gsynR
Cwp_83_1 who_p_83_1 0 40p
Cwn_83_1 who_n_83_1 0 40p
Rwp_83_1 who_p_83_1 wcm 2g
Rwn_83_1 who_n_83_1 wcm 2g
Xsyn_83_1 ahp83 ahn83 who_p_83_1 who_n_83_1 mop1 mon1 vdd vbsyn gsynR
Cwp_84_1 who_p_84_1 0 40p
Cwn_84_1 who_n_84_1 0 40p
Rwp_84_1 who_p_84_1 wcm 2g
Rwn_84_1 who_n_84_1 wcm 2g
Xsyn_84_1 ahp84 ahn84 who_p_84_1 who_n_84_1 mop1 mon1 vdd vbsyn gsynR
Cwp_85_1 who_p_85_1 0 40p
Cwn_85_1 who_n_85_1 0 40p
Rwp_85_1 who_p_85_1 wcm 2g
Rwn_85_1 who_n_85_1 wcm 2g
Xsyn_85_1 ahp85 ahn85 who_p_85_1 who_n_85_1 mop1 mon1 vdd vbsyn gsynR
Cwp_86_1 who_p_86_1 0 40p
Cwn_86_1 who_n_86_1 0 40p
Rwp_86_1 who_p_86_1 wcm 2g
Rwn_86_1 who_n_86_1 wcm 2g
Xsyn_86_1 ahp86 ahn86 who_p_86_1 who_n_86_1 mop1 mon1 vdd vbsyn gsynR
Cwp_87_1 who_p_87_1 0 40p
Cwn_87_1 who_n_87_1 0 40p
Rwp_87_1 who_p_87_1 wcm 2g
Rwn_87_1 who_n_87_1 wcm 2g
Xsyn_87_1 ahp87 ahn87 who_p_87_1 who_n_87_1 mop1 mon1 vdd vbsyn gsynR
Cwp_88_1 who_p_88_1 0 40p
Cwn_88_1 who_n_88_1 0 40p
Rwp_88_1 who_p_88_1 wcm 2g
Rwn_88_1 who_n_88_1 wcm 2g
Xsyn_88_1 ahp88 ahn88 who_p_88_1 who_n_88_1 mop1 mon1 vdd vbsyn gsynR
Cwp_89_1 who_p_89_1 0 40p
Cwn_89_1 who_n_89_1 0 40p
Rwp_89_1 who_p_89_1 wcm 2g
Rwn_89_1 who_n_89_1 wcm 2g
Xsyn_89_1 ahp89 ahn89 who_p_89_1 who_n_89_1 mop1 mon1 vdd vbsyn gsynR
Cwp_90_1 who_p_90_1 0 40p
Cwn_90_1 who_n_90_1 0 40p
Rwp_90_1 who_p_90_1 wcm 2g
Rwn_90_1 who_n_90_1 wcm 2g
Xsyn_90_1 ahp90 ahn90 who_p_90_1 who_n_90_1 mop1 mon1 vdd vbsyn gsynR
Cwp_91_1 who_p_91_1 0 40p
Cwn_91_1 who_n_91_1 0 40p
Rwp_91_1 who_p_91_1 wcm 2g
Rwn_91_1 who_n_91_1 wcm 2g
Xsyn_91_1 ahp91 ahn91 who_p_91_1 who_n_91_1 mop1 mon1 vdd vbsyn gsynR
Cwp_92_1 who_p_92_1 0 40p
Cwn_92_1 who_n_92_1 0 40p
Rwp_92_1 who_p_92_1 wcm 2g
Rwn_92_1 who_n_92_1 wcm 2g
Xsyn_92_1 ahp92 ahn92 who_p_92_1 who_n_92_1 mop1 mon1 vdd vbsyn gsynR
Cwp_93_1 who_p_93_1 0 40p
Cwn_93_1 who_n_93_1 0 40p
Rwp_93_1 who_p_93_1 wcm 2g
Rwn_93_1 who_n_93_1 wcm 2g
Xsyn_93_1 ahp93 ahn93 who_p_93_1 who_n_93_1 mop1 mon1 vdd vbsyn gsynR
Cwp_94_1 who_p_94_1 0 40p
Cwn_94_1 who_n_94_1 0 40p
Rwp_94_1 who_p_94_1 wcm 2g
Rwn_94_1 who_n_94_1 wcm 2g
Xsyn_94_1 ahp94 ahn94 who_p_94_1 who_n_94_1 mop1 mon1 vdd vbsyn gsynR
Cwp_95_1 who_p_95_1 0 40p
Cwn_95_1 who_n_95_1 0 40p
Rwp_95_1 who_p_95_1 wcm 2g
Rwn_95_1 who_n_95_1 wcm 2g
Xsyn_95_1 ahp95 ahn95 who_p_95_1 who_n_95_1 mop1 mon1 vdd vbsyn gsynR
Cwp_96_1 who_p_96_1 0 40p
Cwn_96_1 who_n_96_1 0 40p
Rwp_96_1 who_p_96_1 wcm 2g
Rwn_96_1 who_n_96_1 wcm 2g
Xsyn_96_1 ahbias_p ahbias_n who_p_96_1 who_n_96_1 mop1 mon1 vdd vbsyn gsynR
Xeo1 xop1 xon1 mop1 mon1 eop1 eon1 vdd gm esub
Xsc0 xop0 xon0 mop0 mon0 sop son vdd vbsyn gsyn
Xsc1 xop1 xon1 mop1 mon1 sop son vdd vbsyn gsyn
Xcm_s sop son vdd cmld
Rs sop son 40k
Vth sref 0 PWL(0.0n 0.95000 129.9n 0.95000 130.0n 0.95000 259.9n 0.95000 260.0n 0.95000 389.9n 0.95000 390.0n 0.95000 519.9n 0.95000 520.0n 0.95000 649.9n 0.95000 650.0n 0.95000 779.9n 0.95000 780.0n 0.95000 909.9n 0.95000 910.0n 0.95000 1039.9n 0.95000 1040.0n 0.95000 1169.9n 0.95000 1170.0n 0.95000 1299.9n 0.95000 1300.0n 0.95000 1429.9n 0.95000 1430.0n 0.95000 1559.9n 0.95000 1560.0n 0.95000 1689.9n 0.95000 1690.0n 0.95000 1819.9n 0.95000 1820.0n 0.95000 1949.9n 0.95000 1950.0n 0.95000 2079.9n 0.95000 2080.0n 0.95000 2209.9n 0.95000 2210.0n 0.95000 2339.9n 0.95000 2340.0n 0.95000 2469.9n 0.95000 2470.0n 0.95000 2599.9n 0.95000 2600.0n 0.95000 2729.9n 0.95000 2730.0n 0.95000 2859.9n 0.95000 2860.0n 0.95000 2989.9n 0.95000 2990.0n 0.95000 3119.9n 0.95000 3120.0n 0.95000 3249.9n 0.95000 3250.0n 0.95000 3379.9n 0.95000 3380.0n 0.95000 3509.9n 0.95000 3510.0n 0.95000 3639.9n 0.95000 3640.0n 0.95000 3769.9n 0.95000 3770.0n 0.95000 3899.9n 0.95000 3900.0n 0.95000 4029.9n 0.95000 4030.0n 0.95000 4159.9n 0.95000 4160.0n 0.95000 4289.9n 0.95000 4290.0n 0.95000 4419.9n 0.95000 4420.0n 0.95000 4549.9n 0.95000 4550.0n 0.95000 4679.9n 0.95000 4680.0n 0.95000 4809.9n 0.95000 4810.0n 0.95000 4939.9n 0.95000 4940.0n 0.95000 5069.9n 0.95000 5070.0n 0.95000 5199.9n 0.95000 5200.0n 0.95000 5329.9n 0.95000 5330.0n 0.95000 5459.9n 0.95000 5460.0n 0.95000 5589.9n 0.95000 5590.0n 0.95000 5719.9n 0.95000 5720.0n 0.95000 5849.9n 0.95000 5850.0n 0.95000 5979.9n 0.95000 5980.0n 0.95000 6109.9n 0.95000 6110.0n 0.95000 6239.9n 0.95000 6240.0n 0.95000 6369.9n 0.95000 6370.0n 0.95000 6499.9n 0.95000 6500.0n 0.95000 6629.9n 0.95000 6630.0n 0.95000 6759.9n 0.95000 6760.0n 0.95000 6889.9n 0.95000 6890.0n 0.95000 7019.9n 0.95000 7020.0n 0.95000 7149.9n 0.95000 7150.0n 0.95000 7279.9n 0.95000 7280.0n 0.95000 7409.9n 0.95000 7410.0n 0.95000 7539.9n 0.95000 7540.0n 0.95000 7669.9n 0.95000 7670.0n 0.95000 7799.9n 0.95000 7800.0n 0.95000 7929.9n 0.95000 7930.0n 0.95000 8059.9n 0.95000 8060.0n 0.95000 8189.9n 0.95000 8190.0n 0.95000 8319.9n 0.95000 8320.0n 0.95000 8449.9n 0.95000 8450.0n 0.95000 8579.9n 0.95000 8580.0n 0.95000 8709.9n 0.95000 8710.0n 0.95000 8839.9n 0.95000 8840.0n 0.95000 8969.9n 0.95000 8970.0n 0.95000 9099.9n 0.95000 9100.0n 0.95000 9229.9n 0.95000 9230.0n 0.95000 9359.9n 0.95000 9360.0n 0.95000 9489.9n 0.95000 9490.0n 0.95000 9619.9n 0.95000 9620.0n 0.95000 9749.9n 0.95000 9750.0n 0.95000 9879.9n 0.95000 9880.0n 0.95000 10009.9n 0.95000 10010.0n 0.95000 10139.9n 0.95000 10140.0n 0.95000 10269.9n 0.95000 10270.0n 0.95000 10399.9n 0.95000 10400.0n 0.95000 10529.9n 0.95000 10530.0n 0.95000 10659.9n 0.95000 10660.0n 0.95000 10789.9n 0.95000 10790.0n 0.95000 10919.9n 0.95000 10920.0n 0.95000 11049.9n 0.95000 11050.0n 0.95000 11179.9n 0.95000 11180.0n 0.95000 11309.9n 0.95000 11310.0n 0.95000 11439.9n 0.95000 11440.0n 0.95000 11569.9n 0.95000 11570.0n 0.95000 11699.9n 0.95000 11700.0n 0.95000 11829.9n 0.95000 11830.0n 0.95000 11959.9n 0.95000 11960.0n 0.95000 12089.9n 0.95000 12090.0n 0.95000 12219.9n 0.95000 12220.0n 0.95000 12349.9n 0.95000 12350.0n 0.95000 12479.9n 0.95000 12480.0n 0.95000 12609.9n 0.95000 12610.0n 0.95000 12739.9n 0.95000 12740.0n 0.95000 12869.9n 0.95000 12870.0n 0.95000 12999.9n 0.95000 13000.0n 0.95000 13129.9n 0.95000 13130.0n 0.95000 13259.9n 0.95000 13260.0n 0.95000 13389.9n 0.95000 13390.0n 0.95000 13519.9n 0.95000 13520.0n 0.95000 13649.9n 0.95000 13650.0n 0.95000 13779.9n 0.95000 13780.0n 0.95000 13909.9n 0.95000 13910.0n 0.95000 14039.9n 0.95000 14040.0n 0.95000 14169.9n 0.95000 14170.0n 0.95000 14299.9n 0.95000 14300.0n 0.95000 14429.9n 0.95000 14430.0n 0.95000 14559.9n 0.95000 14560.0n 0.95000 14689.9n 0.95000 14690.0n 0.95000 14819.9n 0.95000 14820.0n 0.95000 14949.9n 0.95000 14950.0n 0.95000 15079.9n 0.95000 15080.0n 0.95000 15209.9n 0.95000 15210.0n 0.95000 15339.9n 0.95000 15340.0n 0.95000 15469.9n 0.95000 15470.0n 0.95000 15599.9n 0.95000 15600.0n 0.95000 15729.9n 0.95000 15730.0n 0.95000 15859.9n 0.95000 15860.0n 0.95000 15989.9n 0.95000 15990.0n 0.95000 16119.9n 0.95000 16120.0n 0.95000 16249.9n 0.95000 16250.0n 0.95000 16379.9n 0.95000 16380.0n 0.95000 16509.9n 0.95000 16510.0n 0.95000 16639.9n 0.95000 16640.0n 0.95000 16769.9n 0.95000 16770.0n 0.95000 16899.9n 0.95000 16900.0n 0.95000 17029.9n 0.95000 17030.0n 0.95000 17159.9n 0.95000 17160.0n 0.95000 17289.9n 0.95000 17290.0n 0.95000 17419.9n 0.95000 17420.0n 0.95000 17549.9n 0.95000 17550.0n 0.95000 17679.9n 0.95000 17680.0n 0.95000 17809.9n 0.95000 17810.0n 0.95000 17939.9n 0.95000 17940.0n 0.95000 18069.9n 0.95000 18070.0n 0.95000 18199.9n 0.95000 18200.0n 0.95000 18329.9n 0.95000 18330.0n 0.95000 18459.9n 0.95000 18460.0n 0.95000 18589.9n 0.95000 18590.0n 0.95000 18719.9n 0.95000 18720.0n 0.95000 18849.9n 0.95000 18850.0n 0.95000 18979.9n 0.95000 18980.0n 0.95000 19109.9n 0.95000 19110.0n 0.95000 19239.9n 0.95000 19240.0n 0.95000 19369.9n 0.95000 19370.0n 0.95000 19499.9n 0.95000 19500.0n 0.95000 19629.9n 0.95000 19630.0n 0.95000 19759.9n 0.95000 19760.0n 0.95000 19889.9n 0.95000 19890.0n 0.95000 20019.9n 0.95000 20020.0n 0.95000 20149.9n 0.95000 20150.0n 0.95000 20279.9n 0.95000 20280.0n 0.95000 20409.9n 0.95000 20410.0n 0.95000 20539.9n 0.95000 20540.0n 0.95000 20669.9n 0.95000 20670.0n 0.95000 20799.9n 0.95000 20800.0n 0.95000 20929.9n 0.95000 20930.0n 0.95000 21059.9n 0.95000 21060.0n 0.95000 21189.9n 0.95000 21190.0n 0.95000 21319.9n 0.95000 21320.0n 0.95000 21449.9n 0.95000 21450.0n 0.95000 21579.9n 0.95000 21580.0n 0.95000 21709.9n 0.95000 21710.0n 0.95000 21839.9n 0.95000 21840.0n 0.95000 21969.9n 0.95000 21970.0n 0.95000 22099.9n 0.95000 22100.0n 0.95000 22229.9n 0.95000 22230.0n 0.95000 22359.9n 0.95000 22360.0n 0.95000 22489.9n 0.95000 22490.0n 0.95000 22619.9n 0.95000 22620.0n 0.95000 22749.9n 0.95000 22750.0n 0.95000 22879.9n 0.95000 22880.0n 0.95000 23009.9n 0.95000 23010.0n 0.95000 23139.9n 0.95000 23140.0n 0.95000 23269.9n 0.95000 23270.0n 0.95000 23399.9n 0.95000 23400.0n 0.95000 23529.9n 0.95000 23530.0n 0.95000 23659.9n 0.95000 23660.0n 0.95000 23789.9n 0.95000 23790.0n 0.95000 23919.9n 0.95000 23920.0n 0.95000 24049.9n 0.95000 24050.0n 0.95000 24179.9n 0.95000 24180.0n 0.95000 24309.9n 0.95000 24310.0n 0.95000 24439.9n 0.95000 24440.0n 0.95000 24569.9n 0.95000 24570.0n 0.95000 24699.9n 0.95000 24700.0n 0.95000 24829.9n 0.95000 24830.0n 0.95000 24959.9n 0.95000 24960.0n 0.95000 25089.9n 0.95000 25090.0n 0.95000 25219.9n 0.95000 25220.0n 0.95000 25349.9n 0.95000 25350.0n 0.95000 25479.9n 0.95000 25480.0n 0.95000 25609.9n 0.95000 25610.0n 0.95000 25739.9n 0.95000 25740.0n 0.95000 25869.9n 0.95000 25870.0n 0.95000 25999.9n 0.95000 26000.0n 0.95000 26129.9n 0.95000 26130.0n 0.95000 26259.9n 0.95000 26260.0n 0.95000 26389.9n 0.95000 26390.0n 0.95000 26519.9n 0.95000 26520.0n 0.95000 26649.9n 0.95000 26650.0n 0.95000 26779.9n 0.95000 26780.0n 0.95000 26909.9n 0.95000 26910.0n 0.95000 27039.9n 0.95000 27040.0n 0.95000 27169.9n 0.95000 27170.0n 0.95000 27299.9n 0.95000 27300.0n 0.95000 27429.9n 0.95000 27430.0n 0.95000 27559.9n 0.95000 27560.0n 0.95000 27689.9n 0.95000 27690.0n 0.95000 27819.9n 0.95000 27820.0n 0.95000 27949.9n 0.95000 27950.0n 0.95000 28079.9n 0.95000 28080.0n 0.95000 28209.9n 0.95000 28210.0n 0.95000 28339.9n 0.95000 28340.0n 0.95000 28469.9n 0.95000 28470.0n 0.95000 28599.9n 0.95000 28600.0n 0.95000 28729.9n 0.95000 28730.0n 0.95000 28859.9n 0.95000 28860.0n 0.95000 28989.9n 0.95000 28990.0n 0.95000 29119.9n 0.95000 29120.0n 0.95000 29249.9n 0.95000 29250.0n 0.95000 29379.9n 0.95000 29380.0n 0.95000 29509.9n 0.95000 29510.0n 0.95000 29639.9n 0.95000 29640.0n 0.95000 29769.9n 0.95000 29770.0n 0.95000 29899.9n 0.95000 29900.0n 0.95000 30029.9n 0.95000 30030.0n 0.95000 30159.9n 0.95000 30160.0n 0.95000 30289.9n 0.95000 30290.0n 0.95000 30419.9n 0.95000 30420.0n 0.95000 30549.9n 0.95000 30550.0n 0.95000 30679.9n 0.95000 30680.0n 0.95000 30809.9n 0.95000 30810.0n 0.95000 30939.9n 0.95000 30940.0n 0.95000 31069.9n 0.95000 31070.0n 0.95000 31199.9n 0.95000 31200.0n 0.95000 31329.9n 0.95000 31330.0n 0.95000 31459.9n 0.95000 31460.0n 0.95000 31589.9n 0.95000 31590.0n 0.95000 31719.9n 0.95000 31720.0n 0.95000 31849.9n 0.95000 31850.0n 0.95000 31979.9n 0.95000 31980.0n 0.95000 32109.9n 0.95000 32110.0n 0.95000 32239.9n 0.95000 32240.0n 0.95000 32369.9n 0.95000 32370.0n 0.95000 32499.9n 0.95000 32500.0n 0.95000 32629.9n 0.95000 32630.0n 0.95000 32759.9n 0.95000 32760.0n 0.95000 32889.9n 0.95000 32890.0n 0.95000 33019.9n 0.95000 33020.0n 0.95000 33149.9n 0.95000 33150.0n 0.95000 33279.9n 0.95000 33280.0n 0.95000 33409.9n 0.95000 33410.0n 0.95000 33539.9n 0.95000 33540.0n 0.95000 33669.9n 0.95000 33670.0n 0.95000 33799.9n 0.95000 33800.0n 0.95000 33929.9n 0.95000 33930.0n 0.95000 34059.9n 0.95000 34060.0n 0.95000 34189.9n 0.95000 34190.0n 0.95000 34319.9n 0.95000 34320.0n 0.95000 34449.9n 0.95000 34450.0n 0.95000 34579.9n 0.95000 34580.0n 0.95000 34709.9n 0.95000 34710.0n 0.95000 34839.9n 0.95000 34840.0n 0.95000 34969.9n 0.95000 34970.0n 0.95000 35099.9n 0.95000 35100.0n 0.95000 35229.9n 0.95000 35230.0n 0.95000 35359.9n 0.95000 35360.0n 0.95000 35489.9n 0.95000 35490.0n 0.95000 35619.9n 0.95000 35620.0n 0.95000 35749.9n 0.95000 35750.0n 0.95000 35879.9n 0.95000 35880.0n 0.95000 36009.9n 0.95000 36010.0n 0.95000 36139.9n 0.95000 36140.0n 0.95000 36269.9n 0.95000 36270.0n 0.95000 36399.9n 0.95000 36400.0n 0.95000 36529.9n 0.95000 36530.0n 0.95000 36659.9n 0.95000 36660.0n 0.95000 36789.9n 0.95000 36790.0n 0.95000 36919.9n 0.95000 36920.0n 0.95000 37049.9n 0.95000 37050.0n 0.95000 37179.9n 0.95000 37180.0n 0.95000 37309.9n 0.95000 37310.0n 0.95000 37439.9n 0.95000 37440.0n 0.95000 37569.9n 0.95000 37570.0n 0.95000 37699.9n 0.95000 37700.0n 0.95000 37829.9n 0.95000 37830.0n 0.95000 37959.9n 0.95000 37960.0n 0.95000 38089.9n 0.95000 38090.0n 0.95000 38219.9n 0.95000 38220.0n 0.95000 38349.9n 0.95000 38350.0n 0.95000 38479.9n 0.95000 38480.0n 0.95000 38609.9n 0.95000 38610.0n 0.95000 38739.9n 0.95000 38740.0n 0.95000 38869.9n 0.95000 38870.0n 0.95000 38999.9n 0.95000 39000.0n 0.95000 39129.9n 0.95000 39130.0n 0.95000 39259.9n 0.95000 39260.0n 0.95000 39389.9n 0.95000 39390.0n 0.95000 39519.9n 0.95000 39520.0n 0.95000 39649.9n 0.95000 39650.0n 0.95000 39779.9n 0.95000 39780.0n 0.95000 39909.9n 0.95000 39910.0n 0.95000 40039.9n 0.95000 40040.0n 0.95000 40169.9n 0.95000 40170.0n 0.95000 40299.9n 0.95000 40300.0n 0.95000 40429.9n 0.95000 40430.0n 0.95000 40559.9n 0.95000 40560.0n 0.95000 40689.9n 0.95000 40690.0n 0.95000 40819.9n 0.95000 40820.0n 0.95000 40949.9n 0.95000 40950.0n 0.95000 41079.9n 0.95000 41080.0n 0.95000 41209.9n 0.95000 41210.0n 0.95000 41339.9n 0.95000 41340.0n 0.95000 41469.9n 0.95000 41470.0n 0.95000 41599.9n 0.95000 41600.0n 0.95000 41729.9n 0.95000 41730.0n 0.95000 41859.9n 0.95000 41860.0n 0.95000 41989.9n 0.95000 41990.0n 0.95000 42119.9n 0.95000 42120.0n 0.95000 42249.9n 0.95000 42250.0n 0.95000 42379.9n 0.95000 42380.0n 0.95000 42509.9n 0.95000 42510.0n 0.95000 42639.9n 0.95000 42640.0n 0.95000 42769.9n 0.95000 42770.0n 0.95000 42899.9n 0.95000 42900.0n 0.95000 43029.9n 0.95000 43030.0n 0.95000 43159.9n 0.95000 43160.0n 0.95000 43289.9n 0.95000 43290.0n 0.95000 43419.9n 0.95000 43420.0n 0.95000 43549.9n 0.95000 43550.0n 0.95000 43679.9n 0.95000 43680.0n 0.95000 43809.9n 0.95000 43810.0n 0.95000 43939.9n 0.95000 43940.0n 0.95000 44069.9n 0.95000 44070.0n 0.95000 44199.9n 0.95000 44200.0n 0.95000 44329.9n 0.95000 44330.0n 0.95000 44459.9n 0.95000 44460.0n 0.95000 44589.9n 0.95000 44590.0n 0.95000 44719.9n 0.95000 44720.0n 0.95000 44849.9n 0.95000 44850.0n 0.95000 44979.9n 0.95000 44980.0n 0.95000 45109.9n 0.95000 45110.0n 0.95000 45239.9n 0.95000 45240.0n 0.95000 45369.9n 0.95000 45370.0n 0.95000 45499.9n 0.95000 45500.0n 0.95000 45629.9n 0.95000 45630.0n 0.95000 45759.9n 0.95000 45760.0n 0.95000 45889.9n 0.95000 45890.0n 0.95000 46019.9n 0.95000 46020.0n 0.95000 46149.9n 0.95000 46150.0n 0.95000 46279.9n 0.95000 46280.0n 0.95000 46409.9n 0.95000 46410.0n 0.95000 46539.9n 0.95000 46540.0n 0.95000 46669.9n 0.95000 46670.0n 0.95000 46799.9n 0.95000 46800.0n 0.95000 46929.9n 0.95000 46930.0n 0.95000 47059.9n 0.95000 47060.0n 0.95000 47189.9n 0.95000 47190.0n 0.95000 47319.9n 0.95000 47320.0n 0.95000 47449.9n 0.95000 47450.0n 0.95000 47579.9n 0.95000 47580.0n 0.95000 47709.9n 0.95000 47710.0n 0.95000 47839.9n 0.95000 47840.0n 0.95000 47969.9n 0.95000 47970.0n 0.95000 48099.9n 0.95000 48100.0n 0.95000 48229.9n 0.95000 48230.0n 0.95000 48359.9n 0.95000 48360.0n 0.95000 48489.9n 0.95000 48490.0n 0.95000 48619.9n 0.95000 48620.0n 0.95000 48749.9n 0.95000 48750.0n 0.95000 48879.9n 0.95000 48880.0n 0.95000 49009.9n 0.95000 49010.0n 0.95000 49139.9n 0.95000 49140.0n 0.95000 49269.9n 0.95000 49270.0n 0.95000 49399.9n 0.95000 49400.0n 0.95000 49529.9n 0.95000 49530.0n 0.95000 49659.9n 0.95000 49660.0n 0.95000 49789.9n 0.95000 49790.0n 0.95000 49919.9n 0.95000 49920.0n 0.95000 50049.9n 0.95000 50050.0n 0.95000 50179.9n 0.95000 50180.0n 0.95000 50309.9n 0.95000 50310.0n 0.95000 50439.9n 0.95000 50440.0n 0.95000 50569.9n 0.95000 50570.0n 0.51500 50699.9n 0.51500 50700.0n 0.51500 50829.9n 0.51500 50830.0n 0.51500 50959.9n 0.51500 50960.0n 0.51500 51089.9n 0.51500 51090.0n 0.51500 51219.9n 0.51500 51220.0n 0.51500 51349.9n 0.51500 51350.0n 0.51500 51479.9n 0.51500 51480.0n 0.51500 51609.9n 0.51500 51610.0n 0.51500 51739.9n 0.51500 51740.0n 0.51500 51869.9n 0.51500 51870.0n 0.51500 51999.9n 0.51500 52000.0n 0.51500 52129.9n 0.51500 52130.0n 0.51500 52259.9n 0.51500 52260.0n 0.51500 52389.9n 0.51500 52390.0n 0.51500 52519.9n 0.51500 52520.0n 0.51500 52649.9n 0.51500 52650.0n 0.51500 52779.9n 0.51500 52780.0n 0.51500 52909.9n 0.51500 52910.0n 0.51500 53039.9n 0.51500 53040.0n 0.51500 53169.9n 0.51500 53170.0n 0.51500 53299.9n 0.51500 53300.0n 0.51500 53429.9n 0.51500 53430.0n 0.51500 53559.9n 0.51500 53560.0n 0.51500 53689.9n 0.51500 53690.0n 0.51500 53819.9n 0.51500 53820.0n 0.51500 53949.9n 0.51500 53950.0n 0.51500 54079.9n 0.51500 54080.0n 0.51500 54209.9n 0.51500 54210.0n 0.51500 54339.9n 0.51500 54340.0n 0.51500 54469.9n 0.51500 54470.0n 0.51500 54599.9n 0.51500 54600.0n 0.51500 54729.9n 0.51500 54730.0n 0.51500 54859.9n 0.51500 54860.0n 0.51500 54989.9n 0.51500 54990.0n 0.51500 55119.9n 0.51500 55120.0n 0.51500 55249.9n 0.51500 55250.0n 0.51500 55379.9n 0.51500 55380.0n 0.51500 55509.9n 0.51500 55510.0n 0.51500 55639.9n 0.51500 55640.0n 0.51500 55769.9n 0.51500 55770.0n 0.51500 55899.9n 0.51500 55900.0n 0.51500 56029.9n 0.51500 56030.0n 0.51500 56159.9n 0.51500 56160.0n 0.51500 56289.9n 0.51500 56290.0n 0.51500 56419.9n 0.51500 56420.0n 0.51500 56549.9n 0.51500 56550.0n 0.51500 56679.9n 0.51500 56680.0n 0.51500 56809.9n 0.51500 56810.0n 0.51500 56939.9n 0.51500 56940.0n 0.51500 57069.9n 0.51500 57070.0n 0.51500 57199.9n 0.51500 57200.0n 0.51500 57329.9n 0.51500 57330.0n 0.51500 57459.9n 0.51500 57460.0n 0.51500 57589.9n 0.51500 57590.0n 0.51500 57719.9n 0.51500 57720.0n 0.51500 57849.9n 0.51500 57850.0n 0.51500 57979.9n 0.51500 57980.0n 0.51500 58109.9n 0.51500 58110.0n 0.51500 58239.9n 0.51500 58240.0n 0.51500 58369.9n 0.51500 58370.0n 0.51500 58499.9n 0.51500 58500.0n 0.51500 58629.9n 0.51500 58630.0n 0.51500 58759.9n 0.51500 58760.0n 0.51500 58889.9n 0.51500 58890.0n 0.51500 59019.9n 0.51500 59020.0n 0.51500 59149.9n 0.51500 59150.0n 0.51500 59279.9n 0.51500 59280.0n 0.51500 59409.9n 0.51500 59410.0n 0.51500 59539.9n 0.51500 59540.0n 0.51500 59669.9n 0.51500 59670.0n 0.51500 59799.9n 0.51500 59800.0n 0.51500 59929.9n 0.51500 59930.0n 0.51500 60059.9n 0.51500 60060.0n 0.51500 60189.9n 0.51500 60190.0n 0.51500 60319.9n 0.51500 60320.0n 0.51500 60449.9n 0.51500 60450.0n 0.51500 60579.9n 0.51500 60580.0n 0.51500 60709.9n 0.51500 60710.0n 0.51500 60839.9n 0.51500 60840.0n 0.51500 60969.9n 0.51500 60970.0n 0.51500 61099.9n 0.51500 61100.0n 0.51500 61229.9n 0.51500 61230.0n 0.51500 61359.9n 0.51500 61360.0n 0.51500 61489.9n 0.51500 61490.0n 0.51500 61619.9n 0.51500 61620.0n 0.51500 61749.9n 0.51500 61750.0n 0.51500 61879.9n 0.51500 61880.0n 0.51500 62009.9n 0.51500 62010.0n 0.51500 62139.9n 0.51500 62140.0n 0.51500 62269.9n 0.51500 62270.0n 0.51500 62399.9n 0.51500 62400.0n 0.51500 62529.9n 0.51500 62530.0n 0.51500 62659.9n 0.51500 62660.0n 0.51500 62789.9n 0.51500 62790.0n 0.51500 62919.9n 0.51500 62920.0n 0.51500 63049.9n 0.51500 63050.0n 0.51500 63179.9n 0.51500 63180.0n 0.51500 63309.9n 0.51500 63310.0n 0.51500 63439.9n 0.51500 63440.0n 0.51500 63569.9n 0.51500 63570.0n 0.51500 63699.9n 0.51500 63700.0n 0.51500 63829.9n 0.51500 63830.0n 0.51500 63959.9n 0.51500 63960.0n 0.51500 64089.9n 0.51500 64090.0n 0.51500 64219.9n 0.51500 64220.0n 0.51500 64349.9n 0.51500 64350.0n 0.51500 64479.9n 0.51500 64480.0n 0.51500 64609.9n 0.51500 64610.0n 0.51500 64739.9n 0.51500 64740.0n 0.51500 64869.9n 0.51500 64870.0n 0.51500 64999.9n 0.51500 65000.0n 0.51500 65129.9n 0.51500 65130.0n 0.51500 65259.9n 0.51500 65260.0n 0.51500 65389.9n 0.51500 65390.0n 0.51500 65519.9n 0.51500 65520.0n 0.51500 65649.9n 0.51500 65650.0n 0.51500 65779.9n 0.51500 65780.0n 0.51500 65909.9n 0.51500 65910.0n 0.51500 66039.9n 0.51500 66040.0n 0.51500 66169.9n 0.51500 66170.0n 0.51500 66299.9n 0.51500 66300.0n 0.51500 66429.9n 0.51500 66430.0n 0.51500 66559.9n 0.51500 66560.0n 0.51500 66689.9n 0.51500 66690.0n 0.51500 66819.9n 0.51500 66820.0n 0.51500 66949.9n 0.51500 66950.0n 0.51500 67079.9n 0.51500 67080.0n 0.51500 67209.9n 0.51500 67210.0n 0.51500 67339.9n 0.51500 67340.0n 0.51500 67469.9n 0.51500 67470.0n 0.51500 67599.9n 0.51500 67600.0n 0.51500 67729.9n 0.51500 67730.0n 0.51500 67859.9n 0.51500 67860.0n 0.51500 67989.9n 0.51500 67990.0n 0.51500 68119.9n 0.51500 68120.0n 0.51500 68249.9n 0.51500 68250.0n 0.51500 68379.9n 0.51500 68380.0n 0.51500 68509.9n 0.51500 68510.0n 0.51500 68639.9n 0.51500 68640.0n 0.51500 68769.9n 0.51500 68770.0n 0.51500 68899.9n 0.51500 68900.0n 0.51500 69029.9n 0.51500 69030.0n 0.51500 69159.9n 0.51500 69160.0n 0.51500 69289.9n 0.51500 69290.0n 0.51500 69419.9n 0.51500 69420.0n 0.51500 69549.9n 0.51500 69550.0n 0.51500 69679.9n 0.51500 69680.0n 0.51500 69809.9n 0.51500 69810.0n 0.51500 69939.9n 0.51500 69940.0n 0.51500 70069.9n 0.51500 70070.0n 0.51500 70199.9n 0.51500 70200.0n 0.51500 70329.9n 0.51500 70330.0n 0.51500 70459.9n 0.51500 70460.0n 0.51500 70589.9n 0.51500 70590.0n 0.51500 70719.9n 0.51500 70720.0n 0.51500 70849.9n 0.51500 70850.0n 0.51500 70979.9n 0.51500 70980.0n 0.51500 71109.9n 0.51500 71110.0n 0.51500 71239.9n 0.51500 71240.0n 0.51500 71369.9n 0.51500 71370.0n 0.51500 71499.9n 0.51500 71500.0n 0.51500 71629.9n 0.51500 71630.0n 0.51500 71759.9n 0.51500 71760.0n 0.51500 71889.9n 0.51500 71890.0n 0.51500 72019.9n 0.51500 72020.0n 0.51500 72149.9n 0.51500 72150.0n 0.51500 72279.9n 0.51500 72280.0n 0.51500 72409.9n 0.51500 72410.0n 0.51500 72539.9n 0.51500 72540.0n 0.51500 72669.9n 0.51500 72670.0n 0.51500 72799.9n 0.51500 72800.0n 0.51500 72929.9n 0.51500 72930.0n 0.51500 73059.9n 0.51500 73060.0n 0.51500 73189.9n 0.51500 73190.0n 0.51500 73319.9n 0.51500 73320.0n 0.51500 73449.9n 0.51500 73450.0n 0.51500 73579.9n 0.51500 73580.0n 0.51500 73709.9n 0.51500 73710.0n 0.51500 73839.9n 0.51500 73840.0n 0.51500 73969.9n 0.51500 73970.0n 0.51500 74099.9n 0.51500 74100.0n 0.51500 74229.9n 0.51500 74230.0n 0.51500 74359.9n 0.51500 74360.0n 0.51500 74489.9n 0.51500 74490.0n 0.51500 74619.9n 0.51500 74620.0n 0.51500 74749.9n 0.51500 74750.0n 0.51500 74879.9n 0.51500 74880.0n 0.51500 75009.9n 0.51500 75010.0n 0.51500 75139.9n 0.51500 75140.0n 0.51500 75269.9n 0.51500 75270.0n 0.51500 75399.9n 0.51500 75400.0n 0.51500 75529.9n 0.51500 75530.0n 0.51500 75659.9n 0.51500 75660.0n 0.51500 75789.9n 0.51500 75790.0n 0.51500 75919.9n 0.51500 75920.0n 0.51500 76049.9n 0.51500 76050.0n 0.51500 76179.9n 0.51500 76180.0n 0.51500 76309.9n 0.51500 76310.0n 0.51500 76439.9n 0.51500 76440.0n 0.51500 76569.9n 0.51500 76570.0n 0.51500 76699.9n 0.51500 76700.0n 0.51500 76829.9n 0.51500 76830.0n 0.51500 76959.9n 0.51500 76960.0n 0.51500 77089.9n 0.51500 77090.0n 0.51500 77219.9n 0.51500 77220.0n 0.51500 77349.9n 0.51500 77350.0n 0.51500 77479.9n 0.51500 77480.0n 0.51500 77609.9n 0.51500 77610.0n 0.51500 77739.9n 0.51500 77740.0n 0.51500 77869.9n 0.51500 77870.0n 0.51500 77999.9n 0.51500 78000.0n 0.51500 78129.9n 0.51500 78130.0n 0.51500 78259.9n 0.51500 78260.0n 0.51500 78389.9n 0.51500 78390.0n 0.51500 78519.9n 0.51500 78520.0n 0.51500 78649.9n 0.51500 78650.0n 0.51500 78779.9n 0.51500 78780.0n 0.51500 78909.9n 0.51500 78910.0n 0.51500 79039.9n 0.51500 79040.0n 0.51500 79169.9n 0.51500 79170.0n 0.51500 79299.9n 0.51500 79300.0n 0.51500 79429.9n 0.51500 79430.0n 0.51500 79559.9n 0.51500 79560.0n 0.51500 79689.9n 0.51500 79690.0n 0.51500 79819.9n 0.51500 79820.0n 0.51500 79949.9n 0.51500 79950.0n 0.51500 80079.9n 0.51500 80080.0n 0.51500 80209.9n 0.51500 80210.0n 0.51500 80339.9n 0.51500 80340.0n 0.51500 80469.9n 0.51500 80470.0n 0.51500 80599.9n 0.51500 80600.0n 0.51500 80729.9n 0.51500 80730.0n 0.51500 80859.9n 0.51500 80860.0n 0.51500 80989.9n 0.51500 80990.0n 0.51500 81119.9n 0.51500 81120.0n 0.51500 81249.9n 0.51500 81250.0n 0.51500 81379.9n 0.51500 81380.0n 0.51500 81509.9n 0.51500 81510.0n 0.51500 81639.9n 0.51500 81640.0n 0.51500 81769.9n 0.51500 81770.0n 0.51500 81899.9n 0.51500 81900.0n 0.51500 82029.9n 0.51500 82030.0n 0.51500 82159.9n 0.51500 82160.0n 0.51500 82289.9n 0.51500 82290.0n 0.51500 82419.9n 0.51500 82420.0n 0.51500 82549.9n 0.51500 82550.0n 0.51500 82679.9n 0.51500 82680.0n 0.51500 82809.9n 0.51500 82810.0n 0.51500 82939.9n 0.51500 82940.0n 0.51500 83069.9n 0.51500 83070.0n 0.51500 83199.9n 0.51500 83200.0n 0.51500 83329.9n 0.51500 83330.0n 0.51500 83459.9n 0.51500 83460.0n 0.51500 83589.9n 0.51500 83590.0n 0.51500 83719.9n 0.51500 83720.0n 0.51500 83849.9n 0.51500 83850.0n 0.51500 83979.9n 0.51500 83980.0n 0.51500 84109.9n 0.51500 84110.0n 0.51500 84239.9n 0.51500 84240.0n 0.51500 84369.9n 0.51500 84370.0n 0.51500 84499.9n 0.51500 84500.0n 0.51500 84629.9n 0.51500 84630.0n 0.51500 84759.9n 0.51500 84760.0n 0.51500 84889.9n 0.51500 84890.0n 0.51500 85019.9n 0.51500 85020.0n 0.51500 85149.9n 0.51500 85150.0n 0.51500 85279.9n 0.51500 85280.0n 0.51500 85409.9n 0.51500 85410.0n 0.51500 85539.9n 0.51500 85540.0n 0.51500 85669.9n 0.51500 85670.0n 0.51500 85799.9n 0.51500 85800.0n 0.51500 85929.9n 0.51500 85930.0n 0.51500 86059.9n 0.51500 86060.0n 0.51500 86189.9n 0.51500 86190.0n 0.51500 86319.9n 0.51500 86320.0n 0.51500 86449.9n 0.51500 86450.0n 0.51500 86579.9n 0.51500 86580.0n 0.51500 86709.9n 0.51500 86710.0n 0.51500 86839.9n 0.51500 86840.0n 0.51500 86969.9n 0.51500 86970.0n 0.51500 87099.9n 0.51500 87100.0n 0.51500 87229.9n 0.51500 87230.0n 0.51500 87359.9n 0.51500 87360.0n 0.51500 87489.9n 0.51500 87490.0n 0.51500 87619.9n 0.51500 87620.0n 0.51500 87749.9n 0.51500 87750.0n 0.51500 87879.9n 0.51500 87880.0n 0.51500 88009.9n 0.51500 88010.0n 0.51500 88139.9n 0.51500 88140.0n 0.51500 88269.9n 0.51500 88270.0n 0.51500 88399.9n 0.51500 88400.0n 0.51500 88529.9n 0.51500 88530.0n 0.51500 88659.9n 0.51500 88660.0n 0.51500 88789.9n 0.51500 88790.0n 0.51500 88919.9n 0.51500 88920.0n 0.51500 89049.9n 0.51500 89050.0n 0.51500 89179.9n 0.51500 89180.0n 0.51500 89309.9n 0.51500 89310.0n 0.51500 89439.9n 0.51500 89440.0n 0.51500 89569.9n 0.51500 89570.0n 0.51500 89699.9n 0.51500 89700.0n 0.51500 89829.9n 0.51500 89830.0n 0.51500 89959.9n 0.51500 89960.0n 0.51500 90089.9n 0.51500 90090.0n 0.51500 90219.9n 0.51500 90220.0n 0.51500 90349.9n 0.51500 90350.0n 0.51500 90479.9n 0.51500 90480.0n 0.51500 90609.9n 0.51500 90610.0n 0.51500 90739.9n 0.51500 90740.0n 0.51500 90869.9n 0.51500 90870.0n 0.51500 90999.9n 0.51500 91000.0n 0.51500 91129.9n 0.51500 91130.0n 0.51500 91259.9n 0.51500 91260.0n 0.51500 91389.9n 0.51500 91390.0n 0.51500 91519.9n 0.51500 91520.0n 0.51500 91649.9n 0.51500 91650.0n 0.51500 91779.9n 0.51500 91780.0n 0.51500 91909.9n 0.51500 91910.0n 0.51500 92039.9n 0.51500 92040.0n 0.51500 92169.9n 0.51500 92170.0n 0.51500 92299.9n 0.51500 92300.0n 0.51500 92429.9n 0.51500 92430.0n 0.51500 92559.9n 0.51500 92560.0n 0.51500 92689.9n 0.51500 92690.0n 0.51500 92819.9n 0.51500 92820.0n 0.51500 92949.9n 0.51500 92950.0n 0.51500 93079.9n 0.51500 93080.0n 0.51500 93209.9n 0.51500 93210.0n 0.51500 93339.9n 0.51500 93340.0n 0.51500 93469.9n 0.51500 93470.0n 0.51500 93599.9n 0.51500 93600.0n 0.51500 93729.9n 0.51500 93730.0n 0.51500 93859.9n 0.51500 93860.0n 0.51500 93989.9n 0.51500 93990.0n 0.51500 94119.9n 0.51500 94120.0n 0.51500 94249.9n 0.51500 94250.0n 0.51500 94379.9n 0.51500 94380.0n 0.51500 94509.9n 0.51500 94510.0n 0.51500 94639.9n 0.51500 94640.0n 0.51500 94769.9n 0.51500 94770.0n 0.51500 94899.9n 0.51500 94900.0n 0.51500 95029.9n 0.51500 95030.0n 0.51500 95159.9n 0.51500 95160.0n 0.51500 95289.9n 0.51500 95290.0n 0.51500 95419.9n 0.51500 95420.0n 0.51500 95549.9n 0.51500 95550.0n 0.51500 95679.9n 0.51500 95680.0n 0.51500 95809.9n 0.51500 95810.0n 0.51500 95939.9n 0.51500 95940.0n 0.51500 96069.9n 0.51500 96070.0n 0.51500 96199.9n 0.51500 96200.0n 0.51500 96329.9n 0.51500 96330.0n 0.51500 96459.9n 0.51500 96460.0n 0.51500 96589.9n 0.51500 96590.0n 0.51500 96719.9n 0.51500 96720.0n 0.51500 96849.9n 0.51500 96850.0n 0.51500 96979.9n 0.51500 96980.0n 0.51500 97109.9n 0.51500 97110.0n 0.51500 97239.9n 0.51500 97240.0n 0.51500 97369.9n 0.51500 97370.0n 0.51500 97499.9n 0.51500 97500.0n 0.51500 97629.9n 0.51500 97630.0n 0.51500 97759.9n 0.51500 97760.0n 0.51500 97889.9n 0.51500 97890.0n 0.51500 98019.9n 0.51500 98020.0n 0.51500 98149.9n 0.51500 98150.0n 0.51500 98279.9n 0.51500 98280.0n 0.51500 98409.9n 0.51500 98410.0n 0.51500 98539.9n 0.51500 98540.0n 0.51500 98669.9n 0.51500 98670.0n 0.51500 98799.9n 0.51500 98800.0n 0.51500 98929.9n 0.51500 98930.0n 0.51500 99059.9n 0.51500 99060.0n 0.51500 99189.9n 0.51500 99190.0n 0.51500 99319.9n 0.51500 99320.0n 0.51500 99449.9n 0.51500 99450.0n 0.51500 99579.9n 0.51500 99580.0n 0.51500 99709.9n 0.51500 99710.0n 0.51500 99839.9n 0.51500 99840.0n 0.51500 99969.9n 0.51500 99970.0n 0.51500 100099.9n 0.51500 100100.0n 0.51500 100229.9n 0.51500 100230.0n 0.51500 100359.9n 0.51500 100360.0n 0.51500 100489.9n 0.51500 100490.0n 0.51500 100619.9n 0.51500 100620.0n 0.51500 100749.9n 0.51500 100750.0n 0.51500 100879.9n 0.51500 100880.0n 0.51500 101009.9n 0.51500 101010.0n 0.51500 101139.9n 0.51500 101140.0n 0.51500 101269.9n 0.51500 101270.0n 0.51500 101399.9n 0.51500 101400.0n 0.51500 101529.9n 0.51500 101530.0n 0.51500 101659.9n 0.51500 101660.0n 0.51500 101789.9n 0.51500 101790.0n 0.51500 101919.9n 0.51500 101920.0n 0.51500 102049.9n 0.51500 102050.0n 0.51500 102179.9n 0.51500 102180.0n 0.51500 102309.9n 0.51500 102310.0n 0.51500 102439.9n 0.51500 102440.0n 0.51500 102569.9n 0.51500 102570.0n 0.51500 102699.9n 0.51500 102700.0n 0.51500 102829.9n 0.51500 102830.0n 0.51500 102959.9n 0.51500 102960.0n 0.51500 103089.9n 0.51500 103090.0n 0.51500 103219.9n 0.51500 103220.0n 0.51500 103349.9n 0.51500 103350.0n 0.51500 103479.9n 0.51500 103480.0n 0.51500 103609.9n 0.51500 103610.0n 0.51500 103739.9n 0.51500 103740.0n 0.51500 103869.9n 0.51500 103870.0n 0.51500 103999.9n 0.51500 104000.0n 0.51500 104129.9n 0.51500 104130.0n 0.51500 104259.9n 0.51500 104260.0n 0.51500 104389.9n 0.51500 104390.0n 0.51500 104519.9n 0.51500 104520.0n 0.51500 104649.9n 0.51500 104650.0n 0.51500 104779.9n 0.51500 104780.0n 0.51500 104909.9n 0.51500 104910.0n 0.51500 105039.9n 0.51500 105040.0n 0.51500 105169.9n 0.51500 105170.0n 0.51500 105299.9n 0.51500 105300.0n 0.51500 105429.9n 0.51500 105430.0n 0.51500 105559.9n 0.51500 105560.0n 0.51500 105689.9n 0.51500 105690.0n 0.51500 105819.9n 0.51500 105820.0n 0.51500 105949.9n 0.51500 105950.0n 0.51500 106079.9n 0.51500 106080.0n 0.51500 106209.9n 0.51500 106210.0n 0.51500 106339.9n 0.51500 106340.0n 0.51500 106469.9n 0.51500 106470.0n 0.51500 106599.9n 0.51500 106600.0n 0.51500 106729.9n 0.51500 106730.0n 0.51500 106859.9n 0.51500 106860.0n 0.51500 106989.9n 0.51500 106990.0n 0.51500 107119.9n 0.51500 107120.0n 0.51500 107249.9n 0.51500 107250.0n 0.51500 107379.9n 0.51500 107380.0n 0.51500 107509.9n 0.51500 107510.0n 0.51500 107639.9n 0.51500 107640.0n 0.51500 107769.9n 0.51500 107770.0n 0.51500 107899.9n 0.51500 107900.0n 0.51500 108029.9n 0.51500 108030.0n 0.51500 108159.9n 0.51500 108160.0n 0.51500 108289.9n 0.51500 108290.0n 0.51500 108419.9n 0.51500 108420.0n 0.51500 108549.9n 0.51500 108550.0n 0.51500 108679.9n 0.51500 108680.0n 0.51500 108809.9n 0.51500 108810.0n 0.51500 108939.9n 0.51500 108940.0n 0.51500 109069.9n 0.51500 109070.0n 0.51500 109199.9n 0.51500 109200.0n 0.51500 109329.9n 0.51500 109330.0n 0.51500 109459.9n 0.51500 109460.0n 0.51500 109589.9n 0.51500 109590.0n 0.51500 109719.9n 0.51500 109720.0n 0.51500 109849.9n 0.51500 109850.0n 0.51500 109979.9n 0.51500 109980.0n 0.51500 110109.9n 0.51500 110110.0n 0.51500 110239.9n 0.51500 110240.0n 0.51500 110369.9n 0.51500 110370.0n 0.51500 110499.9n 0.51500 110500.0n 0.51500 110629.9n 0.51500 110630.0n 0.51500 110759.9n 0.51500 110760.0n 0.51500 110889.9n 0.51500 110890.0n 0.51500 111019.9n 0.51500 111020.0n 0.51500 111149.9n 0.51500 111150.0n 0.51500 111279.9n 0.51500 111280.0n 0.51500 111409.9n 0.51500 111410.0n 0.51500 111539.9n 0.51500 111540.0n 0.51500 111669.9n 0.51500 111670.0n 0.51500 111799.9n 0.51500 111800.0n 0.51500 111929.9n 0.51500 111930.0n 0.51500 112059.9n 0.51500 112060.0n 0.51500 112189.9n 0.51500 112190.0n 0.51500 112319.9n 0.51500 112320.0n 0.51500 112449.9n 0.51500 112450.0n 0.51500 112579.9n 0.51500 112580.0n 0.51500 112709.9n 0.51500 112710.0n 0.51500 112839.9n 0.51500 112840.0n 0.51500 112969.9n 0.51500 112970.0n 0.51500 113099.9n 0.51500 113100.0n 0.51500 113229.9n 0.51500 113230.0n 0.51500 113359.9n 0.51500 113360.0n 0.51500 113489.9n 0.51500 113490.0n 0.51500 113619.9n 0.51500 113620.0n 0.51500 113749.9n 0.51500 113750.0n 0.51500 113879.9n 0.51500 113880.0n 0.51500 114009.9n 0.51500 114010.0n 0.51500 114139.9n 0.51500 114140.0n 0.51500 114269.9n 0.51500 114270.0n 0.51500 114399.9n 0.51500 114400.0n 0.51500 114529.9n 0.51500 114530.0n 0.51500 114659.9n 0.51500 114660.0n 0.51500 114789.9n 0.51500 114790.0n 0.51500 114919.9n 0.51500 114920.0n 0.51500 115049.9n 0.51500 115050.0n 0.51500 115179.9n 0.51500 115180.0n 0.51500 115309.9n 0.51500 115310.0n 0.51500 115439.9n 0.51500 115440.0n 0.51500 115569.9n 0.51500 115570.0n 0.51500 115699.9n 0.51500 115700.0n 0.51500 115829.9n 0.51500 115830.0n 0.51500 115959.9n 0.51500 115960.0n 0.51500 116089.9n 0.51500 116090.0n 0.51500 116219.9n 0.51500 116220.0n 0.51500 116349.9n 0.51500 116350.0n 0.51500 116479.9n 0.51500 116480.0n 0.51500 116609.9n 0.51500 116610.0n 0.51500 116739.9n 0.51500 116740.0n 0.51500 116869.9n 0.51500 116870.0n 0.51500 116999.9n 0.51500 117000.0n 0.51500 117129.9n 0.51500 117130.0n 0.51500 117259.9n 0.51500 117260.0n 0.51500 117389.9n 0.51500 117390.0n 0.51500 117519.9n 0.51500 117520.0n 0.51500 117649.9n 0.51500 117650.0n 0.51500 117779.9n 0.51500 117780.0n 0.51500 117909.9n 0.51500 117910.0n 0.51500 118039.9n 0.51500 118040.0n 0.51500 118169.9n 0.51500 118170.0n 0.51500 118299.9n 0.51500 118300.0n 0.51500 118429.9n 0.51500 118430.0n 0.51500 118559.9n 0.51500 118560.0n 0.51500 118689.9n 0.51500 118690.0n 0.51500 118819.9n 0.51500 118820.0n 0.51500 118949.9n 0.51500 118950.0n 0.51500 119079.9n 0.51500 119080.0n 0.51500 119209.9n 0.51500 119210.0n 0.51500 119339.9n 0.51500 119340.0n 0.51500 119469.9n 0.51500 119470.0n 0.51500 119599.9n 0.51500 119600.0n 0.51500 119729.9n 0.51500 119730.0n 0.51500 119859.9n 0.51500 119860.0n 0.51500 119989.9n 0.51500 119990.0n 0.51500 120119.9n 0.51500 120120.0n 0.51500 120249.9n 0.51500 120250.0n 0.51500 120379.9n 0.51500 120380.0n 0.51500 120509.9n 0.51500 120510.0n 0.51500 120639.9n 0.51500 120640.0n 0.51500 120769.9n 0.51500 120770.0n 0.51500 120899.9n 0.51500 120900.0n 0.51500 121029.9n 0.51500 121030.0n 0.51500 121159.9n 0.51500 121160.0n 0.51500 121289.9n 0.51500 121290.0n 0.51500 121419.9n 0.51500 121420.0n 0.51500 121549.9n 0.51500 121550.0n 0.51500 121679.9n 0.51500 121680.0n 0.51500 121809.9n 0.51500 121810.0n 0.51500 121939.9n 0.51500 121940.0n 0.51500 122069.9n 0.51500 122070.0n 0.51500 122199.9n 0.51500 122200.0n 0.51500 122329.9n 0.51500 122330.0n 0.51500 122459.9n 0.51500 122460.0n 0.51500 122589.9n 0.51500 122590.0n 0.51500 122719.9n 0.51500 122720.0n 0.51500 122849.9n 0.51500 122850.0n 0.51500 122979.9n 0.51500 122980.0n 0.51500 123109.9n 0.51500 123110.0n 0.51500 123239.9n 0.51500 123240.0n 0.51500 123369.9n 0.51500 123370.0n 0.51500 123499.9n 0.51500 123500.0n 0.51500 123629.9n 0.51500 123630.0n 0.51500 123759.9n 0.51500 123760.0n 0.51500 123889.9n 0.51500 123890.0n 0.51500 124019.9n 0.51500 124020.0n 0.51500 124149.9n 0.51500 124150.0n 0.51500 124279.9n 0.51500 124280.0n 0.51500 124409.9n 0.51500 124410.0n 0.51500 124539.9n 0.51500 124540.0n 0.51500 124669.9n 0.51500 124670.0n 0.51500 124799.9n 0.51500 124800.0n 0.51500 124929.9n 0.51500 124930.0n 0.51500 125059.9n 0.51500 125060.0n 0.51500 125189.9n 0.51500 125190.0n 0.51500 125319.9n 0.51500 125320.0n 0.51500 125449.9n 0.51500 125450.0n 0.51500 125579.9n 0.51500 125580.0n 0.51500 125709.9n 0.51500 125710.0n 0.51500 125839.9n 0.51500 125840.0n 0.51500 125969.9n 0.51500 125970.0n 0.51500 126099.9n 0.51500 126100.0n 0.51500 126229.9n 0.51500 126230.0n 0.51500 126359.9n 0.51500 126360.0n 0.51500 126489.9n 0.51500 126490.0n 0.51500 126619.9n 0.51500 126620.0n 0.51500 126749.9n 0.51500 126750.0n 0.51500 126879.9n 0.51500 126880.0n 0.51500 127009.9n 0.51500 127010.0n 0.51500 127139.9n 0.51500 127140.0n 0.51500 127269.9n 0.51500 127270.0n 0.51500 127399.9n 0.51500 127400.0n 0.51500 127529.9n 0.51500 127530.0n 0.51500 127659.9n 0.51500 127660.0n 0.51500 127789.9n 0.51500 127790.0n 0.51500 127919.9n 0.51500 127920.0n 0.51500 128049.9n 0.51500 128050.0n 0.51500 128179.9n 0.51500 128180.0n 0.51500 128309.9n 0.51500 128310.0n 0.51500 128439.9n 0.51500 128440.0n 0.51500 128569.9n 0.51500 128570.0n 0.51500 128699.9n 0.51500 128700.0n 0.51500 128829.9n 0.51500 128830.0n 0.51500 128959.9n 0.51500 128960.0n 0.51500 129089.9n 0.51500 129090.0n 0.51500 129219.9n 0.51500 129220.0n 0.51500 129349.9n 0.51500 129350.0n 0.51500 129479.9n 0.51500 129480.0n 0.51500 129609.9n 0.51500 129610.0n 0.51500 129739.9n 0.51500 129740.0n 0.51500 129869.9n 0.51500 129870.0n 0.51500 129999.9n 0.51500 130000.0n 0.51500 130129.9n 0.51500 130130.0n 0.51500 130259.9n 0.51500 130260.0n 0.51500 130389.9n 0.51500 130390.0n 0.51500 130519.9n 0.51500 130520.0n 0.51500 130649.9n 0.51500 130650.0n 0.51500 130779.9n 0.51500 130780.0n 0.51500 130909.9n 0.51500 130910.0n 0.51500 131039.9n 0.51500 131040.0n 0.51500 131169.9n 0.51500 131170.0n 0.51500 131299.9n 0.51500 131300.0n 0.51500 131429.9n 0.51500 131430.0n 0.51500 131559.9n 0.51500 131560.0n 0.51500 131689.9n 0.51500 131690.0n 0.51500 131819.9n 0.51500 131820.0n 0.51500 131949.9n 0.51500 131950.0n 0.51500 132079.9n 0.51500 132080.0n 0.51500 132209.9n 0.51500 132210.0n 0.51500 132339.9n 0.51500 132340.0n 0.51500 132469.9n 0.51500 132470.0n 0.51500 132599.9n 0.51500 132600.0n 0.51500 132729.9n 0.51500 132730.0n 0.51500 132859.9n 0.51500 132860.0n 0.51500 132989.9n 0.51500 132990.0n 0.51500 133119.9n 0.51500 133120.0n 0.51500 133249.9n 0.51500 133250.0n 0.51500 133379.9n 0.51500 133380.0n 0.51500 133509.9n 0.51500 133510.0n 0.51500 133639.9n 0.51500 133640.0n 0.51500 133769.9n 0.51500 133770.0n 0.51500 133899.9n 0.51500 133900.0n 0.51500 134029.9n 0.51500 134030.0n 0.51500 134159.9n 0.51500 134160.0n 0.51500 134289.9n 0.51500 134290.0n 0.51500 134419.9n 0.51500 134420.0n 0.51500 134549.9n 0.51500 134550.0n 0.51500 134679.9n 0.51500 134680.0n 0.51500 134809.9n 0.51500 134810.0n 0.51500 134939.9n 0.51500 134940.0n 0.51500 135069.9n 0.51500 135070.0n 0.51500 135199.9n 0.51500 135200.0n 0.51500 135329.9n 0.51500 135330.0n 0.51500 135459.9n 0.51500 135460.0n 0.51500 135589.9n 0.51500 135590.0n 0.51500 135719.9n 0.51500 135720.0n 0.51500 135849.9n 0.51500 135850.0n 0.51500 135979.9n 0.51500 135980.0n 0.51500 136109.9n 0.51500 136110.0n 0.51500 136239.9n 0.51500 136240.0n 0.51500 136369.9n 0.51500 136370.0n 0.51500 136499.9n 0.51500 136500.0n 0.51500 136629.9n 0.51500 136630.0n 0.51500 136759.9n 0.51500 136760.0n 0.51500 136889.9n 0.51500 136890.0n 0.51500 137019.9n 0.51500 137020.0n 0.51500 137149.9n 0.51500 137150.0n 0.51500 137279.9n 0.51500 137280.0n 0.51500 137409.9n 0.51500 137410.0n 0.51500 137539.9n 0.51500 137540.0n 0.51500 137669.9n 0.51500 137670.0n 0.51500 137799.9n 0.51500 137800.0n 0.51500 137929.9n 0.51500 137930.0n 0.51500 138059.9n 0.51500 138060.0n 0.51500 138189.9n 0.51500 138190.0n 0.51500 138319.9n 0.51500 138320.0n 0.51500 138449.9n 0.51500 138450.0n 0.51500 138579.9n 0.51500 138580.0n 0.51500 138709.9n 0.51500 138710.0n 0.51500 138839.9n 0.51500 138840.0n 0.51500 138969.9n 0.51500 138970.0n 0.51500 139099.9n 0.51500 139100.0n 0.51500 139229.9n 0.51500 139230.0n 0.51500 139359.9n 0.51500 139360.0n 0.51500 139489.9n 0.51500 139490.0n 0.51500 139619.9n 0.51500 139620.0n 0.51500 139749.9n 0.51500 139750.0n 0.51500 139879.9n 0.51500 139880.0n 0.51500 140009.9n 0.51500 140010.0n 0.51500 140139.9n 0.51500 140140.0n 0.51500 140269.9n 0.51500 140270.0n 0.51500 140399.9n 0.51500 140400.0n 0.51500 140529.9n 0.51500 140530.0n 0.51500 140659.9n 0.51500 140660.0n 0.51500 140789.9n 0.51500 140790.0n 0.51500 140919.9n 0.51500 140920.0n 0.51500 141049.9n 0.51500 141050.0n 0.51500 141179.9n 0.51500 141180.0n 0.51500 141309.9n 0.51500 141310.0n 0.51500 141439.9n 0.51500 141440.0n 0.51500 141569.9n 0.51500 141570.0n 0.51500 141699.9n 0.51500 141700.0n 0.51500 141829.9n 0.51500 141830.0n 0.51500 141959.9n 0.51500 141960.0n 0.51500 142089.9n 0.51500 142090.0n 0.51500 142219.9n 0.51500 142220.0n 0.51500 142349.9n 0.51500 142350.0n 0.51500 142479.9n 0.51500 142480.0n 0.51500 142609.9n 0.51500 142610.0n 0.51500 142739.9n 0.51500 142740.0n 0.51500 142869.9n 0.51500 142870.0n 0.51500 142999.9n 0.51500 143000.0n 0.51500 143129.9n 0.51500 143130.0n 0.51500 143259.9n 0.51500 143260.0n 0.51500 143389.9n 0.51500 143390.0n 0.51500 143519.9n 0.51500 143520.0n 0.51500 143649.9n 0.51500 143650.0n 0.51500 143779.9n 0.51500 143780.0n 0.51500 143909.9n 0.51500 143910.0n 0.51500 144039.9n 0.51500 144040.0n 0.51500 144169.9n 0.51500 144170.0n 0.51500 144299.9n 0.51500 144300.0n 0.51500 144429.9n 0.51500 144430.0n 0.51500 144559.9n 0.51500 144560.0n 0.51500 144689.9n 0.51500 144690.0n 0.51500 144819.9n 0.51500 144820.0n 0.51500 144949.9n 0.51500 144950.0n 0.51500 145079.9n 0.51500 145080.0n 0.51500 145209.9n 0.51500 145210.0n 0.51500 145339.9n 0.51500 145340.0n 0.51500 145469.9n 0.51500 145470.0n 0.51500 145599.9n 0.51500 145600.0n 0.51500 145729.9n 0.51500 145730.0n 0.51500 145859.9n 0.51500 145860.0n 0.51500 145989.9n 0.51500 145990.0n 0.51500 146119.9n 0.51500 146120.0n 0.51500 146249.9n 0.51500 146250.0n 0.51500 146379.9n 0.51500 146380.0n 0.51500 146509.9n 0.51500 146510.0n 0.51500 146639.9n 0.51500 146640.0n 0.51500 146769.9n 0.51500 146770.0n 0.51500 146899.9n 0.51500 146900.0n 0.51500 147029.9n 0.51500 147030.0n 0.51500 147159.9n 0.51500 147160.0n 0.51500 147289.9n 0.51500 147290.0n 0.51500 147419.9n 0.51500 147420.0n 0.51500 147549.9n 0.51500 147550.0n 0.51500 147679.9n 0.51500 147680.0n 0.51500 147809.9n 0.51500 147810.0n 0.51500 147939.9n 0.51500 147940.0n 0.51500 148069.9n 0.51500 148070.0n 0.51500 148199.9n 0.51500 148200.0n 0.51500 148329.9n 0.51500 148330.0n 0.51500 148459.9n 0.51500 148460.0n 0.51500 148589.9n 0.51500 148590.0n 0.51500 148719.9n 0.51500 148720.0n 0.51500 148849.9n 0.51500 148850.0n 0.51500 148979.9n 0.51500 148980.0n 0.51500 149109.9n 0.51500 149110.0n 0.51500 149239.9n 0.51500 149240.0n 0.51500 149369.9n 0.51500 149370.0n 0.51500 149499.9n 0.51500 149500.0n 0.51500 149629.9n 0.51500 149630.0n 0.51500 149759.9n 0.51500 149760.0n 0.51500 149889.9n 0.51500 149890.0n 0.51500 150019.9n 0.51500 150020.0n 0.51500 150149.9n 0.51500 150150.0n 0.51500 150279.9n 0.51500 150280.0n 0.51500 150409.9n 0.51500 150410.0n 0.51500 150539.9n 0.51500 150540.0n 0.51500 150669.9n 0.51500 150670.0n 0.51500 150799.9n 0.51500 150800.0n 0.51500 150929.9n 0.51500 150930.0n 0.51500 151059.9n 0.51500 151060.0n 0.51500 151189.9n 0.51500 151190.0n 0.51500 151319.9n 0.51500 151320.0n 0.51500 151449.9n 0.51500 151450.0n 0.51500 151579.9n 0.51500 151580.0n 0.51500 151709.9n 0.51500 151710.0n 0.51500 151839.9n 0.51500 151840.0n 0.51500 151969.9n 0.51500 151970.0n 0.51500 152099.9n 0.51500 152100.0n 0.51500 152229.9n 0.51500 152230.0n 0.51500 152359.9n 0.51500 152360.0n 0.51500 152489.9n 0.51500 152490.0n 0.51500 152619.9n 0.51500 152620.0n 0.51500 152749.9n 0.51500 152750.0n 0.51500 152879.9n 0.51500 152880.0n 0.51500 153009.9n 0.51500 153010.0n 0.51500 153139.9n 0.51500 153140.0n 0.51500 153269.9n 0.51500 153270.0n 0.51500 153399.9n 0.51500 153400.0n 0.51500 153529.9n 0.51500 153530.0n 0.51500 153659.9n 0.51500 153660.0n 0.51500 153789.9n 0.51500 153790.0n 0.51500 153919.9n 0.51500 153920.0n 0.51500 154049.9n 0.51500 154050.0n 0.51500 154179.9n 0.51500 154180.0n 0.51500 154309.9n 0.51500 154310.0n 0.51500 154439.9n 0.51500 154440.0n 0.51500 154569.9n 0.51500 154570.0n 0.51500 154699.9n 0.51500 154700.0n 0.51500 154829.9n 0.51500 154830.0n 0.51500 154959.9n 0.51500 154960.0n 0.51500 155089.9n 0.51500 155090.0n 0.51500 155219.9n 0.51500 155220.0n 0.51500 155349.9n 0.51500 155350.0n 0.51500 155479.9n 0.51500 155480.0n 0.51500 155609.9n 0.51500 155610.0n 0.51500 155739.9n 0.51500 155740.0n 0.51500 155869.9n 0.51500 155870.0n 0.51500 155999.9n 0.51500 156000.0n 0.51500 156129.9n 0.51500 156130.0n 0.51500 156259.9n 0.51500 156260.0n 0.51500 156389.9n 0.51500 156390.0n 0.51500 156519.9n 0.51500 156520.0n 0.51500 156649.9n 0.51500 156650.0n 0.51500 156779.9n 0.51500 156780.0n 0.51500 156909.9n 0.51500 156910.0n 0.51500 157039.9n 0.51500 157040.0n 0.51500 157169.9n 0.51500 157170.0n 0.51500 157299.9n 0.51500 157300.0n 0.51500 157429.9n 0.51500 157430.0n 0.51500 157559.9n 0.51500 157560.0n 0.51500 157689.9n 0.51500 157690.0n 0.51500 157819.9n 0.51500 157820.0n 0.51500 157949.9n 0.51500 157950.0n 0.51500 158079.9n 0.51500 158080.0n 0.51500 158209.9n 0.51500 158210.0n 0.51500 158339.9n 0.51500 158340.0n 0.51500 158469.9n 0.51500 158470.0n 0.51500 158599.9n 0.51500 158600.0n 0.51500 158729.9n 0.51500 158730.0n 0.51500 158859.9n 0.51500 158860.0n 0.51500 158989.9n 0.51500 158990.0n 0.51500 159119.9n 0.51500 159120.0n 0.51500 159249.9n 0.51500 159250.0n 0.51500 159379.9n 0.51500 159380.0n 0.51500 159509.9n 0.51500 159510.0n 0.51500 159639.9n 0.51500 159640.0n 0.51500 159769.9n 0.51500 159770.0n 0.51500 159899.9n 0.51500 159900.0n 0.51500 160029.9n 0.51500 160030.0n 0.51500 160159.9n 0.51500 160160.0n 0.51500 160289.9n 0.51500 160290.0n 0.51500 160419.9n 0.51500 160420.0n 0.51500 160549.9n 0.51500 160550.0n 0.51500 160679.9n 0.51500 160680.0n 0.51500 160809.9n 0.51500 160810.0n 0.51500 160939.9n 0.51500 160940.0n 0.51500 161069.9n 0.51500 161070.0n 0.51500 161199.9n 0.51500 161200.0n 0.51500 161329.9n 0.51500 161330.0n 0.51500 161459.9n 0.51500 161460.0n 0.51500 161589.9n 0.51500 161590.0n 0.51500 161719.9n 0.51500 161720.0n 0.51500 161849.9n 0.51500 161850.0n 0.51500 161979.9n 0.51500 161980.0n 0.51500 162109.9n 0.51500 162110.0n 0.51500 162239.9n 0.51500 162240.0n 0.51500 162369.9n 0.51500 162370.0n 0.51500 162499.9n 0.51500 162500.0n 0.51500 162629.9n 0.51500 162630.0n 0.51500 162759.9n 0.51500 162760.0n 0.51500 162889.9n 0.51500 162890.0n 0.51500 163019.9n 0.51500 163020.0n 0.51500 163149.9n 0.51500 163150.0n 0.51500 163279.9n 0.51500 163280.0n 0.51500 163409.9n 0.51500 163410.0n 0.51500 163539.9n 0.51500 163540.0n 0.51500 163669.9n 0.51500 163670.0n 0.51500 163799.9n 0.51500 163800.0n 0.51500 163929.9n 0.51500 163930.0n 0.51500 164059.9n 0.51500 164060.0n 0.51500 164189.9n 0.51500 164190.0n 0.51500 164319.9n 0.51500 164320.0n 0.51500 164449.9n 0.51500 164450.0n 0.51500 164579.9n 0.51500 164580.0n 0.51500 164709.9n 0.51500 164710.0n 0.51500 164839.9n 0.51500 164840.0n 0.51500 164969.9n 0.51500 164970.0n 0.51500 165099.9n 0.51500 165100.0n 0.51500 165229.9n 0.51500 165230.0n 0.51500 165359.9n 0.51500 165360.0n 0.51500 165489.9n 0.51500 165490.0n 0.51500 165619.9n 0.51500 165620.0n 0.51500 165749.9n 0.51500 165750.0n 0.51500 165879.9n 0.51500 165880.0n 0.51500 166009.9n 0.51500 166010.0n 0.51500 166139.9n 0.51500 166140.0n 0.51500 166269.9n 0.51500 166270.0n 0.51500 166399.9n 0.51500 166400.0n 0.51500 166529.9n 0.51500 166530.0n 0.51500 166659.9n 0.51500 166660.0n 0.51500 166789.9n 0.51500 166790.0n 0.51500 166919.9n 0.51500 166920.0n 0.51500 167049.9n 0.51500 167050.0n 0.51500 167179.9n 0.51500 167180.0n 0.51500 167309.9n 0.51500 167310.0n 0.51500 167439.9n 0.51500 167440.0n 0.51500 167569.9n 0.51500 167570.0n 0.51500 167699.9n 0.51500 167700.0n 0.51500 167829.9n 0.51500 167830.0n 0.51500 167959.9n 0.51500 167960.0n 0.51500 168089.9n 0.51500 168090.0n 0.51500 168219.9n 0.51500 168220.0n 0.51500 168349.9n 0.51500 168350.0n 0.51500)
Xcomp sref sop cdum conf vdd vbneu dneuron
Rgbl gbl gblg 30k
Vmsrc msrc 0 0.18
Mgate gblg conf msrc 0 NNR W=600u L=100u
Cconf conf 0 2p
Csop sop 0 2p
Cgblg gblg 0 2p
Xlrn_0_0 eop0 eon0 ahp0 ahn0 who_p_0_0 who_n_0_0 vdd gblg gprod
Xlrn_1_0 eop0 eon0 ahp1 ahn1 who_p_1_0 who_n_1_0 vdd gblg gprod
Xlrn_2_0 eop0 eon0 ahp2 ahn2 who_p_2_0 who_n_2_0 vdd gblg gprod
Xlrn_3_0 eop0 eon0 ahp3 ahn3 who_p_3_0 who_n_3_0 vdd gblg gprod
Xlrn_4_0 eop0 eon0 ahp4 ahn4 who_p_4_0 who_n_4_0 vdd gblg gprod
Xlrn_5_0 eop0 eon0 ahp5 ahn5 who_p_5_0 who_n_5_0 vdd gblg gprod
Xlrn_6_0 eop0 eon0 ahp6 ahn6 who_p_6_0 who_n_6_0 vdd gblg gprod
Xlrn_7_0 eop0 eon0 ahp7 ahn7 who_p_7_0 who_n_7_0 vdd gblg gprod
Xlrn_8_0 eop0 eon0 ahp8 ahn8 who_p_8_0 who_n_8_0 vdd gblg gprod
Xlrn_9_0 eop0 eon0 ahp9 ahn9 who_p_9_0 who_n_9_0 vdd gblg gprod
Xlrn_10_0 eop0 eon0 ahp10 ahn10 who_p_10_0 who_n_10_0 vdd gblg gprod
Xlrn_11_0 eop0 eon0 ahp11 ahn11 who_p_11_0 who_n_11_0 vdd gblg gprod
Xlrn_12_0 eop0 eon0 ahp12 ahn12 who_p_12_0 who_n_12_0 vdd gblg gprod
Xlrn_13_0 eop0 eon0 ahp13 ahn13 who_p_13_0 who_n_13_0 vdd gblg gprod
Xlrn_14_0 eop0 eon0 ahp14 ahn14 who_p_14_0 who_n_14_0 vdd gblg gprod
Xlrn_15_0 eop0 eon0 ahp15 ahn15 who_p_15_0 who_n_15_0 vdd gblg gprod
Xlrn_16_0 eop0 eon0 ahp16 ahn16 who_p_16_0 who_n_16_0 vdd gblg gprod
Xlrn_17_0 eop0 eon0 ahp17 ahn17 who_p_17_0 who_n_17_0 vdd gblg gprod
Xlrn_18_0 eop0 eon0 ahp18 ahn18 who_p_18_0 who_n_18_0 vdd gblg gprod
Xlrn_19_0 eop0 eon0 ahp19 ahn19 who_p_19_0 who_n_19_0 vdd gblg gprod
Xlrn_20_0 eop0 eon0 ahp20 ahn20 who_p_20_0 who_n_20_0 vdd gblg gprod
Xlrn_21_0 eop0 eon0 ahp21 ahn21 who_p_21_0 who_n_21_0 vdd gblg gprod
Xlrn_22_0 eop0 eon0 ahp22 ahn22 who_p_22_0 who_n_22_0 vdd gblg gprod
Xlrn_23_0 eop0 eon0 ahp23 ahn23 who_p_23_0 who_n_23_0 vdd gblg gprod
Xlrn_24_0 eop0 eon0 ahp24 ahn24 who_p_24_0 who_n_24_0 vdd gblg gprod
Xlrn_25_0 eop0 eon0 ahp25 ahn25 who_p_25_0 who_n_25_0 vdd gblg gprod
Xlrn_26_0 eop0 eon0 ahp26 ahn26 who_p_26_0 who_n_26_0 vdd gblg gprod
Xlrn_27_0 eop0 eon0 ahp27 ahn27 who_p_27_0 who_n_27_0 vdd gblg gprod
Xlrn_28_0 eop0 eon0 ahp28 ahn28 who_p_28_0 who_n_28_0 vdd gblg gprod
Xlrn_29_0 eop0 eon0 ahp29 ahn29 who_p_29_0 who_n_29_0 vdd gblg gprod
Xlrn_30_0 eop0 eon0 ahp30 ahn30 who_p_30_0 who_n_30_0 vdd gblg gprod
Xlrn_31_0 eop0 eon0 ahp31 ahn31 who_p_31_0 who_n_31_0 vdd gblg gprod
Xlrn_32_0 eop0 eon0 ahp32 ahn32 who_p_32_0 who_n_32_0 vdd gblg gprod
Xlrn_33_0 eop0 eon0 ahp33 ahn33 who_p_33_0 who_n_33_0 vdd gblg gprod
Xlrn_34_0 eop0 eon0 ahp34 ahn34 who_p_34_0 who_n_34_0 vdd gblg gprod
Xlrn_35_0 eop0 eon0 ahp35 ahn35 who_p_35_0 who_n_35_0 vdd gblg gprod
Xlrn_36_0 eop0 eon0 ahp36 ahn36 who_p_36_0 who_n_36_0 vdd gblg gprod
Xlrn_37_0 eop0 eon0 ahp37 ahn37 who_p_37_0 who_n_37_0 vdd gblg gprod
Xlrn_38_0 eop0 eon0 ahp38 ahn38 who_p_38_0 who_n_38_0 vdd gblg gprod
Xlrn_39_0 eop0 eon0 ahp39 ahn39 who_p_39_0 who_n_39_0 vdd gblg gprod
Xlrn_40_0 eop0 eon0 ahp40 ahn40 who_p_40_0 who_n_40_0 vdd gblg gprod
Xlrn_41_0 eop0 eon0 ahp41 ahn41 who_p_41_0 who_n_41_0 vdd gblg gprod
Xlrn_42_0 eop0 eon0 ahp42 ahn42 who_p_42_0 who_n_42_0 vdd gblg gprod
Xlrn_43_0 eop0 eon0 ahp43 ahn43 who_p_43_0 who_n_43_0 vdd gblg gprod
Xlrn_44_0 eop0 eon0 ahp44 ahn44 who_p_44_0 who_n_44_0 vdd gblg gprod
Xlrn_45_0 eop0 eon0 ahp45 ahn45 who_p_45_0 who_n_45_0 vdd gblg gprod
Xlrn_46_0 eop0 eon0 ahp46 ahn46 who_p_46_0 who_n_46_0 vdd gblg gprod
Xlrn_47_0 eop0 eon0 ahp47 ahn47 who_p_47_0 who_n_47_0 vdd gblg gprod
Xlrn_48_0 eop0 eon0 ahp48 ahn48 who_p_48_0 who_n_48_0 vdd gblg gprod
Xlrn_49_0 eop0 eon0 ahp49 ahn49 who_p_49_0 who_n_49_0 vdd gblg gprod
Xlrn_50_0 eop0 eon0 ahp50 ahn50 who_p_50_0 who_n_50_0 vdd gblg gprod
Xlrn_51_0 eop0 eon0 ahp51 ahn51 who_p_51_0 who_n_51_0 vdd gblg gprod
Xlrn_52_0 eop0 eon0 ahp52 ahn52 who_p_52_0 who_n_52_0 vdd gblg gprod
Xlrn_53_0 eop0 eon0 ahp53 ahn53 who_p_53_0 who_n_53_0 vdd gblg gprod
Xlrn_54_0 eop0 eon0 ahp54 ahn54 who_p_54_0 who_n_54_0 vdd gblg gprod
Xlrn_55_0 eop0 eon0 ahp55 ahn55 who_p_55_0 who_n_55_0 vdd gblg gprod
Xlrn_56_0 eop0 eon0 ahp56 ahn56 who_p_56_0 who_n_56_0 vdd gblg gprod
Xlrn_57_0 eop0 eon0 ahp57 ahn57 who_p_57_0 who_n_57_0 vdd gblg gprod
Xlrn_58_0 eop0 eon0 ahp58 ahn58 who_p_58_0 who_n_58_0 vdd gblg gprod
Xlrn_59_0 eop0 eon0 ahp59 ahn59 who_p_59_0 who_n_59_0 vdd gblg gprod
Xlrn_60_0 eop0 eon0 ahp60 ahn60 who_p_60_0 who_n_60_0 vdd gblg gprod
Xlrn_61_0 eop0 eon0 ahp61 ahn61 who_p_61_0 who_n_61_0 vdd gblg gprod
Xlrn_62_0 eop0 eon0 ahp62 ahn62 who_p_62_0 who_n_62_0 vdd gblg gprod
Xlrn_63_0 eop0 eon0 ahp63 ahn63 who_p_63_0 who_n_63_0 vdd gblg gprod
Xlrn_64_0 eop0 eon0 ahp64 ahn64 who_p_64_0 who_n_64_0 vdd gblg gprod
Xlrn_65_0 eop0 eon0 ahp65 ahn65 who_p_65_0 who_n_65_0 vdd gblg gprod
Xlrn_66_0 eop0 eon0 ahp66 ahn66 who_p_66_0 who_n_66_0 vdd gblg gprod
Xlrn_67_0 eop0 eon0 ahp67 ahn67 who_p_67_0 who_n_67_0 vdd gblg gprod
Xlrn_68_0 eop0 eon0 ahp68 ahn68 who_p_68_0 who_n_68_0 vdd gblg gprod
Xlrn_69_0 eop0 eon0 ahp69 ahn69 who_p_69_0 who_n_69_0 vdd gblg gprod
Xlrn_70_0 eop0 eon0 ahp70 ahn70 who_p_70_0 who_n_70_0 vdd gblg gprod
Xlrn_71_0 eop0 eon0 ahp71 ahn71 who_p_71_0 who_n_71_0 vdd gblg gprod
Xlrn_72_0 eop0 eon0 ahp72 ahn72 who_p_72_0 who_n_72_0 vdd gblg gprod
Xlrn_73_0 eop0 eon0 ahp73 ahn73 who_p_73_0 who_n_73_0 vdd gblg gprod
Xlrn_74_0 eop0 eon0 ahp74 ahn74 who_p_74_0 who_n_74_0 vdd gblg gprod
Xlrn_75_0 eop0 eon0 ahp75 ahn75 who_p_75_0 who_n_75_0 vdd gblg gprod
Xlrn_76_0 eop0 eon0 ahp76 ahn76 who_p_76_0 who_n_76_0 vdd gblg gprod
Xlrn_77_0 eop0 eon0 ahp77 ahn77 who_p_77_0 who_n_77_0 vdd gblg gprod
Xlrn_78_0 eop0 eon0 ahp78 ahn78 who_p_78_0 who_n_78_0 vdd gblg gprod
Xlrn_79_0 eop0 eon0 ahp79 ahn79 who_p_79_0 who_n_79_0 vdd gblg gprod
Xlrn_80_0 eop0 eon0 ahp80 ahn80 who_p_80_0 who_n_80_0 vdd gblg gprod
Xlrn_81_0 eop0 eon0 ahp81 ahn81 who_p_81_0 who_n_81_0 vdd gblg gprod
Xlrn_82_0 eop0 eon0 ahp82 ahn82 who_p_82_0 who_n_82_0 vdd gblg gprod
Xlrn_83_0 eop0 eon0 ahp83 ahn83 who_p_83_0 who_n_83_0 vdd gblg gprod
Xlrn_84_0 eop0 eon0 ahp84 ahn84 who_p_84_0 who_n_84_0 vdd gblg gprod
Xlrn_85_0 eop0 eon0 ahp85 ahn85 who_p_85_0 who_n_85_0 vdd gblg gprod
Xlrn_86_0 eop0 eon0 ahp86 ahn86 who_p_86_0 who_n_86_0 vdd gblg gprod
Xlrn_87_0 eop0 eon0 ahp87 ahn87 who_p_87_0 who_n_87_0 vdd gblg gprod
Xlrn_88_0 eop0 eon0 ahp88 ahn88 who_p_88_0 who_n_88_0 vdd gblg gprod
Xlrn_89_0 eop0 eon0 ahp89 ahn89 who_p_89_0 who_n_89_0 vdd gblg gprod
Xlrn_90_0 eop0 eon0 ahp90 ahn90 who_p_90_0 who_n_90_0 vdd gblg gprod
Xlrn_91_0 eop0 eon0 ahp91 ahn91 who_p_91_0 who_n_91_0 vdd gblg gprod
Xlrn_92_0 eop0 eon0 ahp92 ahn92 who_p_92_0 who_n_92_0 vdd gblg gprod
Xlrn_93_0 eop0 eon0 ahp93 ahn93 who_p_93_0 who_n_93_0 vdd gblg gprod
Xlrn_94_0 eop0 eon0 ahp94 ahn94 who_p_94_0 who_n_94_0 vdd gblg gprod
Xlrn_95_0 eop0 eon0 ahp95 ahn95 who_p_95_0 who_n_95_0 vdd gblg gprod
Xlrn_96_0 eop0 eon0 ahbias_p ahbias_n who_p_96_0 who_n_96_0 vdd gblg gprod
Xlrn_0_1 eop1 eon1 ahp0 ahn0 who_p_0_1 who_n_0_1 vdd gblg gprod
Xlrn_1_1 eop1 eon1 ahp1 ahn1 who_p_1_1 who_n_1_1 vdd gblg gprod
Xlrn_2_1 eop1 eon1 ahp2 ahn2 who_p_2_1 who_n_2_1 vdd gblg gprod
Xlrn_3_1 eop1 eon1 ahp3 ahn3 who_p_3_1 who_n_3_1 vdd gblg gprod
Xlrn_4_1 eop1 eon1 ahp4 ahn4 who_p_4_1 who_n_4_1 vdd gblg gprod
Xlrn_5_1 eop1 eon1 ahp5 ahn5 who_p_5_1 who_n_5_1 vdd gblg gprod
Xlrn_6_1 eop1 eon1 ahp6 ahn6 who_p_6_1 who_n_6_1 vdd gblg gprod
Xlrn_7_1 eop1 eon1 ahp7 ahn7 who_p_7_1 who_n_7_1 vdd gblg gprod
Xlrn_8_1 eop1 eon1 ahp8 ahn8 who_p_8_1 who_n_8_1 vdd gblg gprod
Xlrn_9_1 eop1 eon1 ahp9 ahn9 who_p_9_1 who_n_9_1 vdd gblg gprod
Xlrn_10_1 eop1 eon1 ahp10 ahn10 who_p_10_1 who_n_10_1 vdd gblg gprod
Xlrn_11_1 eop1 eon1 ahp11 ahn11 who_p_11_1 who_n_11_1 vdd gblg gprod
Xlrn_12_1 eop1 eon1 ahp12 ahn12 who_p_12_1 who_n_12_1 vdd gblg gprod
Xlrn_13_1 eop1 eon1 ahp13 ahn13 who_p_13_1 who_n_13_1 vdd gblg gprod
Xlrn_14_1 eop1 eon1 ahp14 ahn14 who_p_14_1 who_n_14_1 vdd gblg gprod
Xlrn_15_1 eop1 eon1 ahp15 ahn15 who_p_15_1 who_n_15_1 vdd gblg gprod
Xlrn_16_1 eop1 eon1 ahp16 ahn16 who_p_16_1 who_n_16_1 vdd gblg gprod
Xlrn_17_1 eop1 eon1 ahp17 ahn17 who_p_17_1 who_n_17_1 vdd gblg gprod
Xlrn_18_1 eop1 eon1 ahp18 ahn18 who_p_18_1 who_n_18_1 vdd gblg gprod
Xlrn_19_1 eop1 eon1 ahp19 ahn19 who_p_19_1 who_n_19_1 vdd gblg gprod
Xlrn_20_1 eop1 eon1 ahp20 ahn20 who_p_20_1 who_n_20_1 vdd gblg gprod
Xlrn_21_1 eop1 eon1 ahp21 ahn21 who_p_21_1 who_n_21_1 vdd gblg gprod
Xlrn_22_1 eop1 eon1 ahp22 ahn22 who_p_22_1 who_n_22_1 vdd gblg gprod
Xlrn_23_1 eop1 eon1 ahp23 ahn23 who_p_23_1 who_n_23_1 vdd gblg gprod
Xlrn_24_1 eop1 eon1 ahp24 ahn24 who_p_24_1 who_n_24_1 vdd gblg gprod
Xlrn_25_1 eop1 eon1 ahp25 ahn25 who_p_25_1 who_n_25_1 vdd gblg gprod
Xlrn_26_1 eop1 eon1 ahp26 ahn26 who_p_26_1 who_n_26_1 vdd gblg gprod
Xlrn_27_1 eop1 eon1 ahp27 ahn27 who_p_27_1 who_n_27_1 vdd gblg gprod
Xlrn_28_1 eop1 eon1 ahp28 ahn28 who_p_28_1 who_n_28_1 vdd gblg gprod
Xlrn_29_1 eop1 eon1 ahp29 ahn29 who_p_29_1 who_n_29_1 vdd gblg gprod
Xlrn_30_1 eop1 eon1 ahp30 ahn30 who_p_30_1 who_n_30_1 vdd gblg gprod
Xlrn_31_1 eop1 eon1 ahp31 ahn31 who_p_31_1 who_n_31_1 vdd gblg gprod
Xlrn_32_1 eop1 eon1 ahp32 ahn32 who_p_32_1 who_n_32_1 vdd gblg gprod
Xlrn_33_1 eop1 eon1 ahp33 ahn33 who_p_33_1 who_n_33_1 vdd gblg gprod
Xlrn_34_1 eop1 eon1 ahp34 ahn34 who_p_34_1 who_n_34_1 vdd gblg gprod
Xlrn_35_1 eop1 eon1 ahp35 ahn35 who_p_35_1 who_n_35_1 vdd gblg gprod
Xlrn_36_1 eop1 eon1 ahp36 ahn36 who_p_36_1 who_n_36_1 vdd gblg gprod
Xlrn_37_1 eop1 eon1 ahp37 ahn37 who_p_37_1 who_n_37_1 vdd gblg gprod
Xlrn_38_1 eop1 eon1 ahp38 ahn38 who_p_38_1 who_n_38_1 vdd gblg gprod
Xlrn_39_1 eop1 eon1 ahp39 ahn39 who_p_39_1 who_n_39_1 vdd gblg gprod
Xlrn_40_1 eop1 eon1 ahp40 ahn40 who_p_40_1 who_n_40_1 vdd gblg gprod
Xlrn_41_1 eop1 eon1 ahp41 ahn41 who_p_41_1 who_n_41_1 vdd gblg gprod
Xlrn_42_1 eop1 eon1 ahp42 ahn42 who_p_42_1 who_n_42_1 vdd gblg gprod
Xlrn_43_1 eop1 eon1 ahp43 ahn43 who_p_43_1 who_n_43_1 vdd gblg gprod
Xlrn_44_1 eop1 eon1 ahp44 ahn44 who_p_44_1 who_n_44_1 vdd gblg gprod
Xlrn_45_1 eop1 eon1 ahp45 ahn45 who_p_45_1 who_n_45_1 vdd gblg gprod
Xlrn_46_1 eop1 eon1 ahp46 ahn46 who_p_46_1 who_n_46_1 vdd gblg gprod
Xlrn_47_1 eop1 eon1 ahp47 ahn47 who_p_47_1 who_n_47_1 vdd gblg gprod
Xlrn_48_1 eop1 eon1 ahp48 ahn48 who_p_48_1 who_n_48_1 vdd gblg gprod
Xlrn_49_1 eop1 eon1 ahp49 ahn49 who_p_49_1 who_n_49_1 vdd gblg gprod
Xlrn_50_1 eop1 eon1 ahp50 ahn50 who_p_50_1 who_n_50_1 vdd gblg gprod
Xlrn_51_1 eop1 eon1 ahp51 ahn51 who_p_51_1 who_n_51_1 vdd gblg gprod
Xlrn_52_1 eop1 eon1 ahp52 ahn52 who_p_52_1 who_n_52_1 vdd gblg gprod
Xlrn_53_1 eop1 eon1 ahp53 ahn53 who_p_53_1 who_n_53_1 vdd gblg gprod
Xlrn_54_1 eop1 eon1 ahp54 ahn54 who_p_54_1 who_n_54_1 vdd gblg gprod
Xlrn_55_1 eop1 eon1 ahp55 ahn55 who_p_55_1 who_n_55_1 vdd gblg gprod
Xlrn_56_1 eop1 eon1 ahp56 ahn56 who_p_56_1 who_n_56_1 vdd gblg gprod
Xlrn_57_1 eop1 eon1 ahp57 ahn57 who_p_57_1 who_n_57_1 vdd gblg gprod
Xlrn_58_1 eop1 eon1 ahp58 ahn58 who_p_58_1 who_n_58_1 vdd gblg gprod
Xlrn_59_1 eop1 eon1 ahp59 ahn59 who_p_59_1 who_n_59_1 vdd gblg gprod
Xlrn_60_1 eop1 eon1 ahp60 ahn60 who_p_60_1 who_n_60_1 vdd gblg gprod
Xlrn_61_1 eop1 eon1 ahp61 ahn61 who_p_61_1 who_n_61_1 vdd gblg gprod
Xlrn_62_1 eop1 eon1 ahp62 ahn62 who_p_62_1 who_n_62_1 vdd gblg gprod
Xlrn_63_1 eop1 eon1 ahp63 ahn63 who_p_63_1 who_n_63_1 vdd gblg gprod
Xlrn_64_1 eop1 eon1 ahp64 ahn64 who_p_64_1 who_n_64_1 vdd gblg gprod
Xlrn_65_1 eop1 eon1 ahp65 ahn65 who_p_65_1 who_n_65_1 vdd gblg gprod
Xlrn_66_1 eop1 eon1 ahp66 ahn66 who_p_66_1 who_n_66_1 vdd gblg gprod
Xlrn_67_1 eop1 eon1 ahp67 ahn67 who_p_67_1 who_n_67_1 vdd gblg gprod
Xlrn_68_1 eop1 eon1 ahp68 ahn68 who_p_68_1 who_n_68_1 vdd gblg gprod
Xlrn_69_1 eop1 eon1 ahp69 ahn69 who_p_69_1 who_n_69_1 vdd gblg gprod
Xlrn_70_1 eop1 eon1 ahp70 ahn70 who_p_70_1 who_n_70_1 vdd gblg gprod
Xlrn_71_1 eop1 eon1 ahp71 ahn71 who_p_71_1 who_n_71_1 vdd gblg gprod
Xlrn_72_1 eop1 eon1 ahp72 ahn72 who_p_72_1 who_n_72_1 vdd gblg gprod
Xlrn_73_1 eop1 eon1 ahp73 ahn73 who_p_73_1 who_n_73_1 vdd gblg gprod
Xlrn_74_1 eop1 eon1 ahp74 ahn74 who_p_74_1 who_n_74_1 vdd gblg gprod
Xlrn_75_1 eop1 eon1 ahp75 ahn75 who_p_75_1 who_n_75_1 vdd gblg gprod
Xlrn_76_1 eop1 eon1 ahp76 ahn76 who_p_76_1 who_n_76_1 vdd gblg gprod
Xlrn_77_1 eop1 eon1 ahp77 ahn77 who_p_77_1 who_n_77_1 vdd gblg gprod
Xlrn_78_1 eop1 eon1 ahp78 ahn78 who_p_78_1 who_n_78_1 vdd gblg gprod
Xlrn_79_1 eop1 eon1 ahp79 ahn79 who_p_79_1 who_n_79_1 vdd gblg gprod
Xlrn_80_1 eop1 eon1 ahp80 ahn80 who_p_80_1 who_n_80_1 vdd gblg gprod
Xlrn_81_1 eop1 eon1 ahp81 ahn81 who_p_81_1 who_n_81_1 vdd gblg gprod
Xlrn_82_1 eop1 eon1 ahp82 ahn82 who_p_82_1 who_n_82_1 vdd gblg gprod
Xlrn_83_1 eop1 eon1 ahp83 ahn83 who_p_83_1 who_n_83_1 vdd gblg gprod
Xlrn_84_1 eop1 eon1 ahp84 ahn84 who_p_84_1 who_n_84_1 vdd gblg gprod
Xlrn_85_1 eop1 eon1 ahp85 ahn85 who_p_85_1 who_n_85_1 vdd gblg gprod
Xlrn_86_1 eop1 eon1 ahp86 ahn86 who_p_86_1 who_n_86_1 vdd gblg gprod
Xlrn_87_1 eop1 eon1 ahp87 ahn87 who_p_87_1 who_n_87_1 vdd gblg gprod
Xlrn_88_1 eop1 eon1 ahp88 ahn88 who_p_88_1 who_n_88_1 vdd gblg gprod
Xlrn_89_1 eop1 eon1 ahp89 ahn89 who_p_89_1 who_n_89_1 vdd gblg gprod
Xlrn_90_1 eop1 eon1 ahp90 ahn90 who_p_90_1 who_n_90_1 vdd gblg gprod
Xlrn_91_1 eop1 eon1 ahp91 ahn91 who_p_91_1 who_n_91_1 vdd gblg gprod
Xlrn_92_1 eop1 eon1 ahp92 ahn92 who_p_92_1 who_n_92_1 vdd gblg gprod
Xlrn_93_1 eop1 eon1 ahp93 ahn93 who_p_93_1 who_n_93_1 vdd gblg gprod
Xlrn_94_1 eop1 eon1 ahp94 ahn94 who_p_94_1 who_n_94_1 vdd gblg gprod
Xlrn_95_1 eop1 eon1 ahp95 ahn95 who_p_95_1 who_n_95_1 vdd gblg gprod
Xlrn_96_1 eop1 eon1 ahbias_p ahbias_n who_p_96_1 who_n_96_1 vdd gblg gprod
.ic v(who_p_0_0)=0.5 v(who_n_0_0)=0.5
.ic v(who_p_1_0)=0.5 v(who_n_1_0)=0.5
.ic v(who_p_2_0)=0.5 v(who_n_2_0)=0.5
.ic v(who_p_3_0)=0.5 v(who_n_3_0)=0.5
.ic v(who_p_4_0)=0.5 v(who_n_4_0)=0.5
.ic v(who_p_5_0)=0.5 v(who_n_5_0)=0.5
.ic v(who_p_6_0)=0.5 v(who_n_6_0)=0.5
.ic v(who_p_7_0)=0.5 v(who_n_7_0)=0.5
.ic v(who_p_8_0)=0.5 v(who_n_8_0)=0.5
.ic v(who_p_9_0)=0.5 v(who_n_9_0)=0.5
.ic v(who_p_10_0)=0.5 v(who_n_10_0)=0.5
.ic v(who_p_11_0)=0.5 v(who_n_11_0)=0.5
.ic v(who_p_12_0)=0.5 v(who_n_12_0)=0.5
.ic v(who_p_13_0)=0.5 v(who_n_13_0)=0.5
.ic v(who_p_14_0)=0.5 v(who_n_14_0)=0.5
.ic v(who_p_15_0)=0.5 v(who_n_15_0)=0.5
.ic v(who_p_16_0)=0.5 v(who_n_16_0)=0.5
.ic v(who_p_17_0)=0.5 v(who_n_17_0)=0.5
.ic v(who_p_18_0)=0.5 v(who_n_18_0)=0.5
.ic v(who_p_19_0)=0.5 v(who_n_19_0)=0.5
.ic v(who_p_20_0)=0.5 v(who_n_20_0)=0.5
.ic v(who_p_21_0)=0.5 v(who_n_21_0)=0.5
.ic v(who_p_22_0)=0.5 v(who_n_22_0)=0.5
.ic v(who_p_23_0)=0.5 v(who_n_23_0)=0.5
.ic v(who_p_24_0)=0.5 v(who_n_24_0)=0.5
.ic v(who_p_25_0)=0.5 v(who_n_25_0)=0.5
.ic v(who_p_26_0)=0.5 v(who_n_26_0)=0.5
.ic v(who_p_27_0)=0.5 v(who_n_27_0)=0.5
.ic v(who_p_28_0)=0.5 v(who_n_28_0)=0.5
.ic v(who_p_29_0)=0.5 v(who_n_29_0)=0.5
.ic v(who_p_30_0)=0.5 v(who_n_30_0)=0.5
.ic v(who_p_31_0)=0.5 v(who_n_31_0)=0.5
.ic v(who_p_32_0)=0.5 v(who_n_32_0)=0.5
.ic v(who_p_33_0)=0.5 v(who_n_33_0)=0.5
.ic v(who_p_34_0)=0.5 v(who_n_34_0)=0.5
.ic v(who_p_35_0)=0.5 v(who_n_35_0)=0.5
.ic v(who_p_36_0)=0.5 v(who_n_36_0)=0.5
.ic v(who_p_37_0)=0.5 v(who_n_37_0)=0.5
.ic v(who_p_38_0)=0.5 v(who_n_38_0)=0.5
.ic v(who_p_39_0)=0.5 v(who_n_39_0)=0.5
.ic v(who_p_40_0)=0.5 v(who_n_40_0)=0.5
.ic v(who_p_41_0)=0.5 v(who_n_41_0)=0.5
.ic v(who_p_42_0)=0.5 v(who_n_42_0)=0.5
.ic v(who_p_43_0)=0.5 v(who_n_43_0)=0.5
.ic v(who_p_44_0)=0.5 v(who_n_44_0)=0.5
.ic v(who_p_45_0)=0.5 v(who_n_45_0)=0.5
.ic v(who_p_46_0)=0.5 v(who_n_46_0)=0.5
.ic v(who_p_47_0)=0.5 v(who_n_47_0)=0.5
.ic v(who_p_48_0)=0.5 v(who_n_48_0)=0.5
.ic v(who_p_49_0)=0.5 v(who_n_49_0)=0.5
.ic v(who_p_50_0)=0.5 v(who_n_50_0)=0.5
.ic v(who_p_51_0)=0.5 v(who_n_51_0)=0.5
.ic v(who_p_52_0)=0.5 v(who_n_52_0)=0.5
.ic v(who_p_53_0)=0.5 v(who_n_53_0)=0.5
.ic v(who_p_54_0)=0.5 v(who_n_54_0)=0.5
.ic v(who_p_55_0)=0.5 v(who_n_55_0)=0.5
.ic v(who_p_56_0)=0.5 v(who_n_56_0)=0.5
.ic v(who_p_57_0)=0.5 v(who_n_57_0)=0.5
.ic v(who_p_58_0)=0.5 v(who_n_58_0)=0.5
.ic v(who_p_59_0)=0.5 v(who_n_59_0)=0.5
.ic v(who_p_60_0)=0.5 v(who_n_60_0)=0.5
.ic v(who_p_61_0)=0.5 v(who_n_61_0)=0.5
.ic v(who_p_62_0)=0.5 v(who_n_62_0)=0.5
.ic v(who_p_63_0)=0.5 v(who_n_63_0)=0.5
.ic v(who_p_64_0)=0.5 v(who_n_64_0)=0.5
.ic v(who_p_65_0)=0.5 v(who_n_65_0)=0.5
.ic v(who_p_66_0)=0.5 v(who_n_66_0)=0.5
.ic v(who_p_67_0)=0.5 v(who_n_67_0)=0.5
.ic v(who_p_68_0)=0.5 v(who_n_68_0)=0.5
.ic v(who_p_69_0)=0.5 v(who_n_69_0)=0.5
.ic v(who_p_70_0)=0.5 v(who_n_70_0)=0.5
.ic v(who_p_71_0)=0.5 v(who_n_71_0)=0.5
.ic v(who_p_72_0)=0.5 v(who_n_72_0)=0.5
.ic v(who_p_73_0)=0.5 v(who_n_73_0)=0.5
.ic v(who_p_74_0)=0.5 v(who_n_74_0)=0.5
.ic v(who_p_75_0)=0.5 v(who_n_75_0)=0.5
.ic v(who_p_76_0)=0.5 v(who_n_76_0)=0.5
.ic v(who_p_77_0)=0.5 v(who_n_77_0)=0.5
.ic v(who_p_78_0)=0.5 v(who_n_78_0)=0.5
.ic v(who_p_79_0)=0.5 v(who_n_79_0)=0.5
.ic v(who_p_80_0)=0.5 v(who_n_80_0)=0.5
.ic v(who_p_81_0)=0.5 v(who_n_81_0)=0.5
.ic v(who_p_82_0)=0.5 v(who_n_82_0)=0.5
.ic v(who_p_83_0)=0.5 v(who_n_83_0)=0.5
.ic v(who_p_84_0)=0.5 v(who_n_84_0)=0.5
.ic v(who_p_85_0)=0.5 v(who_n_85_0)=0.5
.ic v(who_p_86_0)=0.5 v(who_n_86_0)=0.5
.ic v(who_p_87_0)=0.5 v(who_n_87_0)=0.5
.ic v(who_p_88_0)=0.5 v(who_n_88_0)=0.5
.ic v(who_p_89_0)=0.5 v(who_n_89_0)=0.5
.ic v(who_p_90_0)=0.5 v(who_n_90_0)=0.5
.ic v(who_p_91_0)=0.5 v(who_n_91_0)=0.5
.ic v(who_p_92_0)=0.5 v(who_n_92_0)=0.5
.ic v(who_p_93_0)=0.5 v(who_n_93_0)=0.5
.ic v(who_p_94_0)=0.5 v(who_n_94_0)=0.5
.ic v(who_p_95_0)=0.5 v(who_n_95_0)=0.5
.ic v(who_p_96_0)=0.5 v(who_n_96_0)=0.5
.ic v(who_p_0_1)=0.5 v(who_n_0_1)=0.5
.ic v(who_p_1_1)=0.5 v(who_n_1_1)=0.5
.ic v(who_p_2_1)=0.5 v(who_n_2_1)=0.5
.ic v(who_p_3_1)=0.5 v(who_n_3_1)=0.5
.ic v(who_p_4_1)=0.5 v(who_n_4_1)=0.5
.ic v(who_p_5_1)=0.5 v(who_n_5_1)=0.5
.ic v(who_p_6_1)=0.5 v(who_n_6_1)=0.5
.ic v(who_p_7_1)=0.5 v(who_n_7_1)=0.5
.ic v(who_p_8_1)=0.5 v(who_n_8_1)=0.5
.ic v(who_p_9_1)=0.5 v(who_n_9_1)=0.5
.ic v(who_p_10_1)=0.5 v(who_n_10_1)=0.5
.ic v(who_p_11_1)=0.5 v(who_n_11_1)=0.5
.ic v(who_p_12_1)=0.5 v(who_n_12_1)=0.5
.ic v(who_p_13_1)=0.5 v(who_n_13_1)=0.5
.ic v(who_p_14_1)=0.5 v(who_n_14_1)=0.5
.ic v(who_p_15_1)=0.5 v(who_n_15_1)=0.5
.ic v(who_p_16_1)=0.5 v(who_n_16_1)=0.5
.ic v(who_p_17_1)=0.5 v(who_n_17_1)=0.5
.ic v(who_p_18_1)=0.5 v(who_n_18_1)=0.5
.ic v(who_p_19_1)=0.5 v(who_n_19_1)=0.5
.ic v(who_p_20_1)=0.5 v(who_n_20_1)=0.5
.ic v(who_p_21_1)=0.5 v(who_n_21_1)=0.5
.ic v(who_p_22_1)=0.5 v(who_n_22_1)=0.5
.ic v(who_p_23_1)=0.5 v(who_n_23_1)=0.5
.ic v(who_p_24_1)=0.5 v(who_n_24_1)=0.5
.ic v(who_p_25_1)=0.5 v(who_n_25_1)=0.5
.ic v(who_p_26_1)=0.5 v(who_n_26_1)=0.5
.ic v(who_p_27_1)=0.5 v(who_n_27_1)=0.5
.ic v(who_p_28_1)=0.5 v(who_n_28_1)=0.5
.ic v(who_p_29_1)=0.5 v(who_n_29_1)=0.5
.ic v(who_p_30_1)=0.5 v(who_n_30_1)=0.5
.ic v(who_p_31_1)=0.5 v(who_n_31_1)=0.5
.ic v(who_p_32_1)=0.5 v(who_n_32_1)=0.5
.ic v(who_p_33_1)=0.5 v(who_n_33_1)=0.5
.ic v(who_p_34_1)=0.5 v(who_n_34_1)=0.5
.ic v(who_p_35_1)=0.5 v(who_n_35_1)=0.5
.ic v(who_p_36_1)=0.5 v(who_n_36_1)=0.5
.ic v(who_p_37_1)=0.5 v(who_n_37_1)=0.5
.ic v(who_p_38_1)=0.5 v(who_n_38_1)=0.5
.ic v(who_p_39_1)=0.5 v(who_n_39_1)=0.5
.ic v(who_p_40_1)=0.5 v(who_n_40_1)=0.5
.ic v(who_p_41_1)=0.5 v(who_n_41_1)=0.5
.ic v(who_p_42_1)=0.5 v(who_n_42_1)=0.5
.ic v(who_p_43_1)=0.5 v(who_n_43_1)=0.5
.ic v(who_p_44_1)=0.5 v(who_n_44_1)=0.5
.ic v(who_p_45_1)=0.5 v(who_n_45_1)=0.5
.ic v(who_p_46_1)=0.5 v(who_n_46_1)=0.5
.ic v(who_p_47_1)=0.5 v(who_n_47_1)=0.5
.ic v(who_p_48_1)=0.5 v(who_n_48_1)=0.5
.ic v(who_p_49_1)=0.5 v(who_n_49_1)=0.5
.ic v(who_p_50_1)=0.5 v(who_n_50_1)=0.5
.ic v(who_p_51_1)=0.5 v(who_n_51_1)=0.5
.ic v(who_p_52_1)=0.5 v(who_n_52_1)=0.5
.ic v(who_p_53_1)=0.5 v(who_n_53_1)=0.5
.ic v(who_p_54_1)=0.5 v(who_n_54_1)=0.5
.ic v(who_p_55_1)=0.5 v(who_n_55_1)=0.5
.ic v(who_p_56_1)=0.5 v(who_n_56_1)=0.5
.ic v(who_p_57_1)=0.5 v(who_n_57_1)=0.5
.ic v(who_p_58_1)=0.5 v(who_n_58_1)=0.5
.ic v(who_p_59_1)=0.5 v(who_n_59_1)=0.5
.ic v(who_p_60_1)=0.5 v(who_n_60_1)=0.5
.ic v(who_p_61_1)=0.5 v(who_n_61_1)=0.5
.ic v(who_p_62_1)=0.5 v(who_n_62_1)=0.5
.ic v(who_p_63_1)=0.5 v(who_n_63_1)=0.5
.ic v(who_p_64_1)=0.5 v(who_n_64_1)=0.5
.ic v(who_p_65_1)=0.5 v(who_n_65_1)=0.5
.ic v(who_p_66_1)=0.5 v(who_n_66_1)=0.5
.ic v(who_p_67_1)=0.5 v(who_n_67_1)=0.5
.ic v(who_p_68_1)=0.5 v(who_n_68_1)=0.5
.ic v(who_p_69_1)=0.5 v(who_n_69_1)=0.5
.ic v(who_p_70_1)=0.5 v(who_n_70_1)=0.5
.ic v(who_p_71_1)=0.5 v(who_n_71_1)=0.5
.ic v(who_p_72_1)=0.5 v(who_n_72_1)=0.5
.ic v(who_p_73_1)=0.5 v(who_n_73_1)=0.5
.ic v(who_p_74_1)=0.5 v(who_n_74_1)=0.5
.ic v(who_p_75_1)=0.5 v(who_n_75_1)=0.5
.ic v(who_p_76_1)=0.5 v(who_n_76_1)=0.5
.ic v(who_p_77_1)=0.5 v(who_n_77_1)=0.5
.ic v(who_p_78_1)=0.5 v(who_n_78_1)=0.5
.ic v(who_p_79_1)=0.5 v(who_n_79_1)=0.5
.ic v(who_p_80_1)=0.5 v(who_n_80_1)=0.5
.ic v(who_p_81_1)=0.5 v(who_n_81_1)=0.5
.ic v(who_p_82_1)=0.5 v(who_n_82_1)=0.5
.ic v(who_p_83_1)=0.5 v(who_n_83_1)=0.5
.ic v(who_p_84_1)=0.5 v(who_n_84_1)=0.5
.ic v(who_p_85_1)=0.5 v(who_n_85_1)=0.5
.ic v(who_p_86_1)=0.5 v(who_n_86_1)=0.5
.ic v(who_p_87_1)=0.5 v(who_n_87_1)=0.5
.ic v(who_p_88_1)=0.5 v(who_n_88_1)=0.5
.ic v(who_p_89_1)=0.5 v(who_n_89_1)=0.5
.ic v(who_p_90_1)=0.5 v(who_n_90_1)=0.5
.ic v(who_p_91_1)=0.5 v(who_n_91_1)=0.5
.ic v(who_p_92_1)=0.5 v(who_n_92_1)=0.5
.ic v(who_p_93_1)=0.5 v(who_n_93_1)=0.5
.ic v(who_p_94_1)=0.5 v(who_n_94_1)=0.5
.ic v(who_p_95_1)=0.5 v(who_n_95_1)=0.5
.ic v(who_p_96_1)=0.5 v(who_n_96_1)=0.5
.options gmin=1e-10 reltol=2e-3 cshunt=1e-14 method=gear
.control
save mop0 mon0 mop1 mon1
tran 2n 168480n uic
wrdata ps_h96.dat v(mop0) v(mon0) v(mop1) v(mon1)
.endc
.end
