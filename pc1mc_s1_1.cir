single-layer multi-class continuous PC
.model NNR NMOS (LEVEL=1 VTO=0.2 KP=120u LAMBDA=0.02 GAMMA=0 PHI=0.7)
.model PNR PMOS (LEVEL=1 VTO=-0.2 KP=40u LAMBDA=0.02 GAMMA=0 PHI=0.7)
.subckt gsyn inp inn wp wn outp outn vdd vbn
Mtail nt vbn 0 0 NNR W=400u L=100u
M5 na wp nt 0 NNR W=200u L=100u
M6 nb wn nt 0 NNR W=200u L=100u
M1 outp inp na 0 NNR W=200u L=100u
M2 outn inn na 0 NNR W=200u L=100u
M3 outn inp nb 0 NNR W=200u L=100u
M4 outp inn nb 0 NNR W=200u L=100u
.ends
.subckt cmld p n vdd
Rcs1 p cmx 300k
Rcs2 n cmx 300k
MLp p cmx vdd vdd PNR W=1000u L=100u
MLn n cmx vdd vdd PNR W=1000u L=100u
.ends
.subckt esub xp xn mp mn ep en vdd vbn
Mt nt vbn 0 0 NNR W=400u L=100u
M1x ep xn nt 0 NNR W=200u L=100u
M2x en xp nt 0 NNR W=200u L=100u
M1m ep mp nt 0 NNR W=200u L=100u
M2m en mn nt 0 NNR W=200u L=100u
RLp vdd ep 50k
RLn vdd en 50k
.ends
.subckt gprod xp xn yp yn wp wn vdd vbn
Mtail nt vbn 0 0 NNR W=400u L=100u
M5 na yp nt 0 NNR W=200u L=100u
M6 nb yn nt 0 NNR W=200u L=100u
M1 iop xp na 0 NNR W=200u L=100u
M2 ion xn na 0 NNR W=200u L=100u
M3 ion xp nb 0 NNR W=200u L=100u
M4 iop xn nb 0 NNR W=200u L=100u
Mlp iop iop vdd vdd PNR W=200u L=100u
Mln ion ion vdd vdd PNR W=200u L=100u
Mpu_wp wp iop vdd vdd PNR W=200u L=100u
MpRn nrn ion vdd vdd PNR W=200u L=100u
MnRn nrn nrn 0 0 NNR W=200u L=100u
Mpd_wp wp nrn 0 0 NNR W=200u L=100u
Mpu_wn wn ion vdd vdd PNR W=200u L=100u
MpRp nrp iop vdd vdd PNR W=200u L=100u
MnRp nrp nrp 0 0 NNR W=200u L=100u
Mpd_wn wn nrp 0 0 NNR W=200u L=100u
.ends
Vdd vdd 0 1.0
Vbsyn vbsyn 0 0.6
Vgm gm 0 0.6
Vgbl gbl 0 PWL(0.0n 0.9000 299.9n 0.9000 300.0n 0.9000 599.9n 0.9000 600.0n 0.9000 899.9n 0.9000 900.0n 0.9000 1199.9n 0.9000 1200.0n 0.9000 1499.9n 0.9000 1500.0n 0.9000 1799.9n 0.9000 1800.0n 0.9000 2099.9n 0.9000 2100.0n 0.9000 2399.9n 0.9000 2400.0n 0.9000 2699.9n 0.9000 2700.0n 0.9000 2999.9n 0.9000 3000.0n 0.9000 3299.9n 0.9000 3300.0n 0.9000 3599.9n 0.9000 3600.0n 0.9000 3899.9n 0.9000 3900.0n 0.9000 4199.9n 0.9000 4200.0n 0.9000 4499.9n 0.9000 4500.0n 0.9000 4799.9n 0.9000 4800.0n 0.9000 5099.9n 0.9000 5100.0n 0.9000 5399.9n 0.9000 5400.0n 0.9000 5699.9n 0.9000 5700.0n 0.9000 5999.9n 0.9000 6000.0n 0.9000 6299.9n 0.9000 6300.0n 0.9000 6599.9n 0.9000 6600.0n 0.9000 6899.9n 0.9000 6900.0n 0.9000 7199.9n 0.9000 7200.0n 0.9000 7499.9n 0.9000 7500.0n 0.9000 7799.9n 0.9000 7800.0n 0.9000 8099.9n 0.9000 8100.0n 0.9000 8399.9n 0.9000 8400.0n 0.9000 8699.9n 0.9000 8700.0n 0.9000 8999.9n 0.9000 9000.0n 0.9000 9299.9n 0.9000 9300.0n 0.9000 9599.9n 0.9000 9600.0n 0.9000 9899.9n 0.9000 9900.0n 0.9000 10199.9n 0.9000 10200.0n 0.9000 10499.9n 0.9000 10500.0n 0.9000 10799.9n 0.9000 10800.0n 0.9000 11099.9n 0.9000 11100.0n 0.9000 11399.9n 0.9000 11400.0n 0.9000 11699.9n 0.9000 11700.0n 0.9000 11999.9n 0.9000 12000.0n 0.9000 12299.9n 0.9000 12300.0n 0.9000 12599.9n 0.9000 12600.0n 0.9000 12899.9n 0.9000 12900.0n 0.9000 13199.9n 0.9000 13200.0n 0.9000 13499.9n 0.9000 13500.0n 0.9000 13799.9n 0.9000 13800.0n 0.9000 14099.9n 0.9000 14100.0n 0.9000 14399.9n 0.9000 14400.0n 0.9000 14699.9n 0.9000 14700.0n 0.9000 14999.9n 0.9000 15000.0n 0.9000 15299.9n 0.9000 15300.0n 0.9000 15599.9n 0.9000 15600.0n 0.9000 15899.9n 0.9000 15900.0n 0.9000 16199.9n 0.9000 16200.0n 0.9000 16499.9n 0.9000 16500.0n 0.9000 16799.9n 0.9000 16800.0n 0.9000 17099.9n 0.9000 17100.0n 0.9000 17399.9n 0.9000 17400.0n 0.9000 17699.9n 0.9000 17700.0n 0.9000 17999.9n 0.9000 18000.0n 0.9000 18299.9n 0.9000 18300.0n 0.9000 18599.9n 0.9000 18600.0n 0.9000 18899.9n 0.9000 18900.0n 0.9000 19199.9n 0.9000 19200.0n 0.9000 19499.9n 0.9000 19500.0n 0.9000 19799.9n 0.9000 19800.0n 0.9000 20099.9n 0.9000 20100.0n 0.9000 20399.9n 0.9000 20400.0n 0.9000 20699.9n 0.9000 20700.0n 0.9000 20999.9n 0.9000 21000.0n 0.9000 21299.9n 0.9000 21300.0n 0.9000 21599.9n 0.9000 21600.0n 0.9000 21899.9n 0.9000 21900.0n 0.9000 22199.9n 0.9000 22200.0n 0.9000 22499.9n 0.9000 22500.0n 0.9000 22799.9n 0.9000 22800.0n 0.9000 23099.9n 0.9000 23100.0n 0.9000 23399.9n 0.9000 23400.0n 0.9000 23699.9n 0.9000 23700.0n 0.9000 23999.9n 0.9000 24000.0n 0.9000 24299.9n 0.9000 24300.0n 0.9000 24599.9n 0.9000 24600.0n 0.9000 24899.9n 0.9000 24900.0n 0.9000 25199.9n 0.9000 25200.0n 0.9000 25499.9n 0.9000 25500.0n 0.9000 25799.9n 0.9000 25800.0n 0.9000 26099.9n 0.9000 26100.0n 0.9000 26399.9n 0.9000 26400.0n 0.9000 26699.9n 0.9000 26700.0n 0.9000 26999.9n 0.9000 27000.0n 0.9000 27299.9n 0.9000 27300.0n 0.9000 27599.9n 0.9000 27600.0n 0.9000 27899.9n 0.9000 27900.0n 0.9000 28199.9n 0.9000 28200.0n 0.9000 28499.9n 0.9000 28500.0n 0.9000 28799.9n 0.9000 28800.0n 0.9000 29099.9n 0.9000 29100.0n 0.9000 29399.9n 0.9000 29400.0n 0.9000 29699.9n 0.9000 29700.0n 0.9000 29999.9n 0.9000 30000.0n 0.9000 30299.9n 0.9000 30300.0n 0.9000 30599.9n 0.9000 30600.0n 0.9000 30899.9n 0.9000 30900.0n 0.9000 31199.9n 0.9000 31200.0n 0.9000 31499.9n 0.9000 31500.0n 0.9000 31799.9n 0.9000 31800.0n 0.9000 32099.9n 0.9000 32100.0n 0.9000 32399.9n 0.9000 32400.0n 0.9000 32699.9n 0.9000 32700.0n 0.9000 32999.9n 0.9000 33000.0n 0.9000 33299.9n 0.9000 33300.0n 0.9000 33599.9n 0.9000 33600.0n 0.9000 33899.9n 0.9000 33900.0n 0.9000 34199.9n 0.9000 34200.0n 0.9000 34499.9n 0.9000 34500.0n 0.9000 34799.9n 0.9000 34800.0n 0.9000 35099.9n 0.9000 35100.0n 0.9000 35399.9n 0.9000 35400.0n 0.9000 35699.9n 0.9000 35700.0n 0.9000 35999.9n 0.9000 36000.0n 0.9000 36299.9n 0.9000 36300.0n 0.9000 36599.9n 0.9000 36600.0n 0.9000 36899.9n 0.9000 36900.0n 0.9000 37199.9n 0.9000 37200.0n 0.9000 37499.9n 0.9000 37500.0n 0.9000 37799.9n 0.9000 37800.0n 0.9000 38099.9n 0.9000 38100.0n 0.9000 38399.9n 0.9000 38400.0n 0.9000 38699.9n 0.9000 38700.0n 0.9000 38999.9n 0.9000 39000.0n 0.9000 39299.9n 0.9000 39300.0n 0.9000 39599.9n 0.9000 39600.0n 0.9000 39899.9n 0.9000 39900.0n 0.9000 40199.9n 0.9000 40200.0n 0.9000 40499.9n 0.9000 40500.0n 0.9000 40799.9n 0.9000 40800.0n 0.9000 41099.9n 0.9000 41100.0n 0.9000 41399.9n 0.9000 41400.0n 0.9000 41699.9n 0.9000 41700.0n 0.9000 41999.9n 0.9000 42000.0n 0.9000 42299.9n 0.9000 42300.0n 0.9000 42599.9n 0.9000 42600.0n 0.9000 42899.9n 0.9000 42900.0n 0.9000 43199.9n 0.9000 43200.0n 0.9000 43499.9n 0.9000 43500.0n 0.9000 43799.9n 0.9000 43800.0n 0.9000 44099.9n 0.9000 44100.0n 0.9000 44399.9n 0.9000 44400.0n 0.9000 44699.9n 0.9000 44700.0n 0.9000 44999.9n 0.9000 45000.0n 0.9000 45299.9n 0.9000 45300.0n 0.9000 45599.9n 0.9000 45600.0n 0.9000 45899.9n 0.9000 45900.0n 0.9000 46199.9n 0.9000 46200.0n 0.9000 46499.9n 0.9000 46500.0n 0.9000 46799.9n 0.9000 46800.0n 0.9000 47099.9n 0.9000 47100.0n 0.9000 47399.9n 0.9000 47400.0n 0.9000 47699.9n 0.9000 47700.0n 0.9000 47999.9n 0.9000 48000.0n 0.9000 48299.9n 0.9000 48300.0n 0.9000 48599.9n 0.9000 48600.0n 0.9000 48899.9n 0.9000 48900.0n 0.9000 49199.9n 0.9000 49200.0n 0.9000 49499.9n 0.9000 49500.0n 0.9000 49799.9n 0.9000 49800.0n 0.9000 50099.9n 0.9000 50100.0n 0.9000 50399.9n 0.9000 50400.0n 0.9000 50699.9n 0.9000 50700.0n 0.9000 50999.9n 0.9000 51000.0n 0.9000 51299.9n 0.9000 51300.0n 0.9000 51599.9n 0.9000 51600.0n 0.9000 51899.9n 0.9000 51900.0n 0.9000 52199.9n 0.9000 52200.0n 0.9000 52499.9n 0.9000 52500.0n 0.9000 52799.9n 0.9000 52800.0n 0.9000 53099.9n 0.9000 53100.0n 0.9000 53399.9n 0.9000 53400.0n 0.9000 53699.9n 0.9000 53700.0n 0.9000 53999.9n 0.9000 54000.0n 0.3000 54299.9n 0.3000 54300.0n 0.3000 54599.9n 0.3000 54600.0n 0.3000 54899.9n 0.3000 54900.0n 0.3000 55199.9n 0.3000 55200.0n 0.3000 55499.9n 0.3000 55500.0n 0.3000 55799.9n 0.3000 55800.0n 0.3000 56099.9n 0.3000 56100.0n 0.3000 56399.9n 0.3000 56400.0n 0.3000 56699.9n 0.3000 56700.0n 0.3000 56999.9n 0.3000 57000.0n 0.3000 57299.9n 0.3000 57300.0n 0.3000 57599.9n 0.3000 57600.0n 0.3000 57899.9n 0.3000 57900.0n 0.3000 58199.9n 0.3000 58200.0n 0.3000 58499.9n 0.3000 58500.0n 0.3000 58799.9n 0.3000 58800.0n 0.3000 59099.9n 0.3000 59100.0n 0.3000)
Vwcm wcm 0 0.5
Vxp0 a_xp0 0 PWL(0.0n 0.5000 299.9n 0.5000 300.0n 0.5000 599.9n 0.5000 600.0n 0.5000 899.9n 0.5000 900.0n 0.5000 1199.9n 0.5000 1200.0n 0.5000 1499.9n 0.5000 1500.0n 0.5000 1799.9n 0.5000 1800.0n 0.5000 2099.9n 0.5000 2100.0n 0.5000 2399.9n 0.5000 2400.0n 0.5000 2699.9n 0.5000 2700.0n 0.5000 2999.9n 0.5000 3000.0n 0.5000 3299.9n 0.5000 3300.0n 0.5000 3599.9n 0.5000 3600.0n 0.5000 3899.9n 0.5000 3900.0n 0.5000 4199.9n 0.5000 4200.0n 0.5000 4499.9n 0.5000 4500.0n 0.5000 4799.9n 0.5000 4800.0n 0.5000 5099.9n 0.5000 5100.0n 0.5000 5399.9n 0.5000 5400.0n 0.5000 5699.9n 0.5000 5700.0n 0.5000 5999.9n 0.5000 6000.0n 0.5000 6299.9n 0.5000 6300.0n 0.5000 6599.9n 0.5000 6600.0n 0.5000 6899.9n 0.5000 6900.0n 0.5000 7199.9n 0.5000 7200.0n 0.5000 7499.9n 0.5000 7500.0n 0.5000 7799.9n 0.5000 7800.0n 0.5000 8099.9n 0.5000 8100.0n 0.5000 8399.9n 0.5000 8400.0n 0.5000 8699.9n 0.5000 8700.0n 0.5000 8999.9n 0.5000 9000.0n 0.5000 9299.9n 0.5000 9300.0n 0.5000 9599.9n 0.5000 9600.0n 0.5000 9899.9n 0.5000 9900.0n 0.5000 10199.9n 0.5000 10200.0n 0.5000 10499.9n 0.5000 10500.0n 0.5000 10799.9n 0.5000 10800.0n 0.5000 11099.9n 0.5000 11100.0n 0.5000 11399.9n 0.5000 11400.0n 0.5000 11699.9n 0.5000 11700.0n 0.5000 11999.9n 0.5000 12000.0n 0.5000 12299.9n 0.5000 12300.0n 0.5000 12599.9n 0.5000 12600.0n 0.5000 12899.9n 0.5000 12900.0n 0.5000 13199.9n 0.5000 13200.0n 0.5000 13499.9n 0.5000 13500.0n 0.5000 13799.9n 0.5000 13800.0n 0.5000 14099.9n 0.5000 14100.0n 0.5000 14399.9n 0.5000 14400.0n 0.5000 14699.9n 0.5000 14700.0n 0.5000 14999.9n 0.5000 15000.0n 0.5000 15299.9n 0.5000 15300.0n 0.5000 15599.9n 0.5000 15600.0n 0.5000 15899.9n 0.5000 15900.0n 0.5000 16199.9n 0.5000 16200.0n 0.5000 16499.9n 0.5000 16500.0n 0.5000 16799.9n 0.5000 16800.0n 0.5000 17099.9n 0.5000 17100.0n 0.5000 17399.9n 0.5000 17400.0n 0.5000 17699.9n 0.5000 17700.0n 0.5000 17999.9n 0.5000 18000.0n 0.5000 18299.9n 0.5000 18300.0n 0.5000 18599.9n 0.5000 18600.0n 0.5000 18899.9n 0.5000 18900.0n 0.5000 19199.9n 0.5000 19200.0n 0.5000 19499.9n 0.5000 19500.0n 0.5000 19799.9n 0.5000 19800.0n 0.5000 20099.9n 0.5000 20100.0n 0.5000 20399.9n 0.5000 20400.0n 0.5000 20699.9n 0.5000 20700.0n 0.5000 20999.9n 0.5000 21000.0n 0.5000 21299.9n 0.5000 21300.0n 0.5000 21599.9n 0.5000 21600.0n 0.5000 21899.9n 0.5000 21900.0n 0.5000 22199.9n 0.5000 22200.0n 0.5000 22499.9n 0.5000 22500.0n 0.5000 22799.9n 0.5000 22800.0n 0.5000 23099.9n 0.5000 23100.0n 0.5000 23399.9n 0.5000 23400.0n 0.5000 23699.9n 0.5000 23700.0n 0.5000 23999.9n 0.5000 24000.0n 0.5000 24299.9n 0.5000 24300.0n 0.5000 24599.9n 0.5000 24600.0n 0.5000 24899.9n 0.5000 24900.0n 0.5000 25199.9n 0.5000 25200.0n 0.5000 25499.9n 0.5000 25500.0n 0.5000 25799.9n 0.5000 25800.0n 0.5000 26099.9n 0.5000 26100.0n 0.5000 26399.9n 0.5000 26400.0n 0.5000 26699.9n 0.5000 26700.0n 0.5000 26999.9n 0.5000 27000.0n 0.5000 27299.9n 0.5000 27300.0n 0.5000 27599.9n 0.5000 27600.0n 0.5000 27899.9n 0.5000 27900.0n 0.5000 28199.9n 0.5000 28200.0n 0.5000 28499.9n 0.5000 28500.0n 0.5000 28799.9n 0.5000 28800.0n 0.5000 29099.9n 0.5000 29100.0n 0.5000 29399.9n 0.5000 29400.0n 0.5000 29699.9n 0.5000 29700.0n 0.5000 29999.9n 0.5000 30000.0n 0.5000 30299.9n 0.5000 30300.0n 0.5000 30599.9n 0.5000 30600.0n 0.5000 30899.9n 0.5000 30900.0n 0.5000 31199.9n 0.5000 31200.0n 0.5000 31499.9n 0.5000 31500.0n 0.5000 31799.9n 0.5000 31800.0n 0.5000 32099.9n 0.5000 32100.0n 0.5000 32399.9n 0.5000 32400.0n 0.5000 32699.9n 0.5000 32700.0n 0.5000 32999.9n 0.5000 33000.0n 0.5000 33299.9n 0.5000 33300.0n 0.5000 33599.9n 0.5000 33600.0n 0.5000 33899.9n 0.5000 33900.0n 0.5000 34199.9n 0.5000 34200.0n 0.5000 34499.9n 0.5000 34500.0n 0.5000 34799.9n 0.5000 34800.0n 0.5000 35099.9n 0.5000 35100.0n 0.5000 35399.9n 0.5000 35400.0n 0.5000 35699.9n 0.5000 35700.0n 0.5000 35999.9n 0.5000 36000.0n 0.5000 36299.9n 0.5000 36300.0n 0.5000 36599.9n 0.5000 36600.0n 0.5000 36899.9n 0.5000 36900.0n 0.5000 37199.9n 0.5000 37200.0n 0.5000 37499.9n 0.5000 37500.0n 0.5000 37799.9n 0.5000 37800.0n 0.5000 38099.9n 0.5000 38100.0n 0.5000 38399.9n 0.5000 38400.0n 0.5000 38699.9n 0.5000 38700.0n 0.5000 38999.9n 0.5000 39000.0n 0.5000 39299.9n 0.5000 39300.0n 0.5000 39599.9n 0.5000 39600.0n 0.5000 39899.9n 0.5000 39900.0n 0.5000 40199.9n 0.5000 40200.0n 0.5000 40499.9n 0.5000 40500.0n 0.5000 40799.9n 0.5000 40800.0n 0.5000 41099.9n 0.5000 41100.0n 0.5000 41399.9n 0.5000 41400.0n 0.5000 41699.9n 0.5000 41700.0n 0.5000 41999.9n 0.5000 42000.0n 0.5000 42299.9n 0.5000 42300.0n 0.5000 42599.9n 0.5000 42600.0n 0.5000 42899.9n 0.5000 42900.0n 0.5000 43199.9n 0.5000 43200.0n 0.5000 43499.9n 0.5000 43500.0n 0.5000 43799.9n 0.5000 43800.0n 0.5000 44099.9n 0.5000 44100.0n 0.5000 44399.9n 0.5000 44400.0n 0.5000 44699.9n 0.5000 44700.0n 0.5000 44999.9n 0.5000 45000.0n 0.5000 45299.9n 0.5000 45300.0n 0.5000 45599.9n 0.5000 45600.0n 0.5000 45899.9n 0.5000 45900.0n 0.5000 46199.9n 0.5000 46200.0n 0.5000 46499.9n 0.5000 46500.0n 0.5000 46799.9n 0.5000 46800.0n 0.5000 47099.9n 0.5000 47100.0n 0.5000 47399.9n 0.5000 47400.0n 0.5000 47699.9n 0.5000 47700.0n 0.5000 47999.9n 0.5000 48000.0n 0.5000 48299.9n 0.5000 48300.0n 0.5000 48599.9n 0.5000 48600.0n 0.5000 48899.9n 0.5000 48900.0n 0.5000 49199.9n 0.5000 49200.0n 0.5000 49499.9n 0.5000 49500.0n 0.5000 49799.9n 0.5000 49800.0n 0.5000 50099.9n 0.5000 50100.0n 0.5000 50399.9n 0.5000 50400.0n 0.5000 50699.9n 0.5000 50700.0n 0.5000 50999.9n 0.5000 51000.0n 0.5000 51299.9n 0.5000 51300.0n 0.5000 51599.9n 0.5000 51600.0n 0.5000 51899.9n 0.5000 51900.0n 0.5000 52199.9n 0.5000 52200.0n 0.5000 52499.9n 0.5000 52500.0n 0.5000 52799.9n 0.5000 52800.0n 0.5000 53099.9n 0.5000 53100.0n 0.5000 53399.9n 0.5000 53400.0n 0.5000 53699.9n 0.5000 53700.0n 0.5000 53999.9n 0.5000 54000.0n 0.5000 54299.9n 0.5000 54300.0n 0.5000 54599.9n 0.5000 54600.0n 0.5000 54899.9n 0.5000 54900.0n 0.5000 55199.9n 0.5000 55200.0n 0.5000 55499.9n 0.5000 55500.0n 0.5000 55799.9n 0.5000 55800.0n 0.5000 56099.9n 0.5000 56100.0n 0.5000 56399.9n 0.5000 56400.0n 0.5000 56699.9n 0.5000 56700.0n 0.5000 56999.9n 0.5000 57000.0n 0.5000 57299.9n 0.5000 57300.0n 0.5000 57599.9n 0.5000 57600.0n 0.5000 57899.9n 0.5000 57900.0n 0.5000 58199.9n 0.5000 58200.0n 0.5000 58499.9n 0.5000 58500.0n 0.5000 58799.9n 0.5000 58800.0n 0.5000 59099.9n 0.5000 59100.0n 0.5000)
Vxn0 a_xn0 0 PWL(0.0n 0.5000 299.9n 0.5000 300.0n 0.5000 599.9n 0.5000 600.0n 0.5000 899.9n 0.5000 900.0n 0.5000 1199.9n 0.5000 1200.0n 0.5000 1499.9n 0.5000 1500.0n 0.5000 1799.9n 0.5000 1800.0n 0.5000 2099.9n 0.5000 2100.0n 0.5000 2399.9n 0.5000 2400.0n 0.5000 2699.9n 0.5000 2700.0n 0.5000 2999.9n 0.5000 3000.0n 0.5000 3299.9n 0.5000 3300.0n 0.5000 3599.9n 0.5000 3600.0n 0.5000 3899.9n 0.5000 3900.0n 0.5000 4199.9n 0.5000 4200.0n 0.5000 4499.9n 0.5000 4500.0n 0.5000 4799.9n 0.5000 4800.0n 0.5000 5099.9n 0.5000 5100.0n 0.5000 5399.9n 0.5000 5400.0n 0.5000 5699.9n 0.5000 5700.0n 0.5000 5999.9n 0.5000 6000.0n 0.5000 6299.9n 0.5000 6300.0n 0.5000 6599.9n 0.5000 6600.0n 0.5000 6899.9n 0.5000 6900.0n 0.5000 7199.9n 0.5000 7200.0n 0.5000 7499.9n 0.5000 7500.0n 0.5000 7799.9n 0.5000 7800.0n 0.5000 8099.9n 0.5000 8100.0n 0.5000 8399.9n 0.5000 8400.0n 0.5000 8699.9n 0.5000 8700.0n 0.5000 8999.9n 0.5000 9000.0n 0.5000 9299.9n 0.5000 9300.0n 0.5000 9599.9n 0.5000 9600.0n 0.5000 9899.9n 0.5000 9900.0n 0.5000 10199.9n 0.5000 10200.0n 0.5000 10499.9n 0.5000 10500.0n 0.5000 10799.9n 0.5000 10800.0n 0.5000 11099.9n 0.5000 11100.0n 0.5000 11399.9n 0.5000 11400.0n 0.5000 11699.9n 0.5000 11700.0n 0.5000 11999.9n 0.5000 12000.0n 0.5000 12299.9n 0.5000 12300.0n 0.5000 12599.9n 0.5000 12600.0n 0.5000 12899.9n 0.5000 12900.0n 0.5000 13199.9n 0.5000 13200.0n 0.5000 13499.9n 0.5000 13500.0n 0.5000 13799.9n 0.5000 13800.0n 0.5000 14099.9n 0.5000 14100.0n 0.5000 14399.9n 0.5000 14400.0n 0.5000 14699.9n 0.5000 14700.0n 0.5000 14999.9n 0.5000 15000.0n 0.5000 15299.9n 0.5000 15300.0n 0.5000 15599.9n 0.5000 15600.0n 0.5000 15899.9n 0.5000 15900.0n 0.5000 16199.9n 0.5000 16200.0n 0.5000 16499.9n 0.5000 16500.0n 0.5000 16799.9n 0.5000 16800.0n 0.5000 17099.9n 0.5000 17100.0n 0.5000 17399.9n 0.5000 17400.0n 0.5000 17699.9n 0.5000 17700.0n 0.5000 17999.9n 0.5000 18000.0n 0.5000 18299.9n 0.5000 18300.0n 0.5000 18599.9n 0.5000 18600.0n 0.5000 18899.9n 0.5000 18900.0n 0.5000 19199.9n 0.5000 19200.0n 0.5000 19499.9n 0.5000 19500.0n 0.5000 19799.9n 0.5000 19800.0n 0.5000 20099.9n 0.5000 20100.0n 0.5000 20399.9n 0.5000 20400.0n 0.5000 20699.9n 0.5000 20700.0n 0.5000 20999.9n 0.5000 21000.0n 0.5000 21299.9n 0.5000 21300.0n 0.5000 21599.9n 0.5000 21600.0n 0.5000 21899.9n 0.5000 21900.0n 0.5000 22199.9n 0.5000 22200.0n 0.5000 22499.9n 0.5000 22500.0n 0.5000 22799.9n 0.5000 22800.0n 0.5000 23099.9n 0.5000 23100.0n 0.5000 23399.9n 0.5000 23400.0n 0.5000 23699.9n 0.5000 23700.0n 0.5000 23999.9n 0.5000 24000.0n 0.5000 24299.9n 0.5000 24300.0n 0.5000 24599.9n 0.5000 24600.0n 0.5000 24899.9n 0.5000 24900.0n 0.5000 25199.9n 0.5000 25200.0n 0.5000 25499.9n 0.5000 25500.0n 0.5000 25799.9n 0.5000 25800.0n 0.5000 26099.9n 0.5000 26100.0n 0.5000 26399.9n 0.5000 26400.0n 0.5000 26699.9n 0.5000 26700.0n 0.5000 26999.9n 0.5000 27000.0n 0.5000 27299.9n 0.5000 27300.0n 0.5000 27599.9n 0.5000 27600.0n 0.5000 27899.9n 0.5000 27900.0n 0.5000 28199.9n 0.5000 28200.0n 0.5000 28499.9n 0.5000 28500.0n 0.5000 28799.9n 0.5000 28800.0n 0.5000 29099.9n 0.5000 29100.0n 0.5000 29399.9n 0.5000 29400.0n 0.5000 29699.9n 0.5000 29700.0n 0.5000 29999.9n 0.5000 30000.0n 0.5000 30299.9n 0.5000 30300.0n 0.5000 30599.9n 0.5000 30600.0n 0.5000 30899.9n 0.5000 30900.0n 0.5000 31199.9n 0.5000 31200.0n 0.5000 31499.9n 0.5000 31500.0n 0.5000 31799.9n 0.5000 31800.0n 0.5000 32099.9n 0.5000 32100.0n 0.5000 32399.9n 0.5000 32400.0n 0.5000 32699.9n 0.5000 32700.0n 0.5000 32999.9n 0.5000 33000.0n 0.5000 33299.9n 0.5000 33300.0n 0.5000 33599.9n 0.5000 33600.0n 0.5000 33899.9n 0.5000 33900.0n 0.5000 34199.9n 0.5000 34200.0n 0.5000 34499.9n 0.5000 34500.0n 0.5000 34799.9n 0.5000 34800.0n 0.5000 35099.9n 0.5000 35100.0n 0.5000 35399.9n 0.5000 35400.0n 0.5000 35699.9n 0.5000 35700.0n 0.5000 35999.9n 0.5000 36000.0n 0.5000 36299.9n 0.5000 36300.0n 0.5000 36599.9n 0.5000 36600.0n 0.5000 36899.9n 0.5000 36900.0n 0.5000 37199.9n 0.5000 37200.0n 0.5000 37499.9n 0.5000 37500.0n 0.5000 37799.9n 0.5000 37800.0n 0.5000 38099.9n 0.5000 38100.0n 0.5000 38399.9n 0.5000 38400.0n 0.5000 38699.9n 0.5000 38700.0n 0.5000 38999.9n 0.5000 39000.0n 0.5000 39299.9n 0.5000 39300.0n 0.5000 39599.9n 0.5000 39600.0n 0.5000 39899.9n 0.5000 39900.0n 0.5000 40199.9n 0.5000 40200.0n 0.5000 40499.9n 0.5000 40500.0n 0.5000 40799.9n 0.5000 40800.0n 0.5000 41099.9n 0.5000 41100.0n 0.5000 41399.9n 0.5000 41400.0n 0.5000 41699.9n 0.5000 41700.0n 0.5000 41999.9n 0.5000 42000.0n 0.5000 42299.9n 0.5000 42300.0n 0.5000 42599.9n 0.5000 42600.0n 0.5000 42899.9n 0.5000 42900.0n 0.5000 43199.9n 0.5000 43200.0n 0.5000 43499.9n 0.5000 43500.0n 0.5000 43799.9n 0.5000 43800.0n 0.5000 44099.9n 0.5000 44100.0n 0.5000 44399.9n 0.5000 44400.0n 0.5000 44699.9n 0.5000 44700.0n 0.5000 44999.9n 0.5000 45000.0n 0.5000 45299.9n 0.5000 45300.0n 0.5000 45599.9n 0.5000 45600.0n 0.5000 45899.9n 0.5000 45900.0n 0.5000 46199.9n 0.5000 46200.0n 0.5000 46499.9n 0.5000 46500.0n 0.5000 46799.9n 0.5000 46800.0n 0.5000 47099.9n 0.5000 47100.0n 0.5000 47399.9n 0.5000 47400.0n 0.5000 47699.9n 0.5000 47700.0n 0.5000 47999.9n 0.5000 48000.0n 0.5000 48299.9n 0.5000 48300.0n 0.5000 48599.9n 0.5000 48600.0n 0.5000 48899.9n 0.5000 48900.0n 0.5000 49199.9n 0.5000 49200.0n 0.5000 49499.9n 0.5000 49500.0n 0.5000 49799.9n 0.5000 49800.0n 0.5000 50099.9n 0.5000 50100.0n 0.5000 50399.9n 0.5000 50400.0n 0.5000 50699.9n 0.5000 50700.0n 0.5000 50999.9n 0.5000 51000.0n 0.5000 51299.9n 0.5000 51300.0n 0.5000 51599.9n 0.5000 51600.0n 0.5000 51899.9n 0.5000 51900.0n 0.5000 52199.9n 0.5000 52200.0n 0.5000 52499.9n 0.5000 52500.0n 0.5000 52799.9n 0.5000 52800.0n 0.5000 53099.9n 0.5000 53100.0n 0.5000 53399.9n 0.5000 53400.0n 0.5000 53699.9n 0.5000 53700.0n 0.5000 53999.9n 0.5000 54000.0n 0.5000 54299.9n 0.5000 54300.0n 0.5000 54599.9n 0.5000 54600.0n 0.5000 54899.9n 0.5000 54900.0n 0.5000 55199.9n 0.5000 55200.0n 0.5000 55499.9n 0.5000 55500.0n 0.5000 55799.9n 0.5000 55800.0n 0.5000 56099.9n 0.5000 56100.0n 0.5000 56399.9n 0.5000 56400.0n 0.5000 56699.9n 0.5000 56700.0n 0.5000 56999.9n 0.5000 57000.0n 0.5000 57299.9n 0.5000 57300.0n 0.5000 57599.9n 0.5000 57600.0n 0.5000 57899.9n 0.5000 57900.0n 0.5000 58199.9n 0.5000 58200.0n 0.5000 58499.9n 0.5000 58500.0n 0.5000 58799.9n 0.5000 58800.0n 0.5000 59099.9n 0.5000 59100.0n 0.5000)
Vxp1 a_xp1 0 PWL(0.0n 0.4665 299.9n 0.4665 300.0n 0.4665 599.9n 0.4665 600.0n 0.4665 899.9n 0.4665 900.0n 0.4665 1199.9n 0.4665 1200.0n 0.4665 1499.9n 0.4665 1500.0n 0.4665 1799.9n 0.4665 1800.0n 0.4665 2099.9n 0.4665 2100.0n 0.4665 2399.9n 0.4665 2400.0n 0.6870 2699.9n 0.6870 2700.0n 0.4665 2999.9n 0.4665 3000.0n 0.6870 3299.9n 0.6870 3300.0n 0.4665 3599.9n 0.4665 3600.0n 0.4665 3899.9n 0.4665 3900.0n 0.4665 4199.9n 0.4665 4200.0n 0.8000 4499.9n 0.8000 4500.0n 0.5768 4799.9n 0.5768 4800.0n 0.4665 5099.9n 0.4665 5100.0n 0.4665 5399.9n 0.4665 5400.0n 0.4665 5699.9n 0.4665 5700.0n 0.4665 5999.9n 0.4665 6000.0n 0.4665 6299.9n 0.4665 6300.0n 0.4665 6599.9n 0.4665 6600.0n 0.4665 6899.9n 0.4665 6900.0n 0.4665 7199.9n 0.4665 7200.0n 0.4665 7499.9n 0.4665 7500.0n 0.4665 7799.9n 0.4665 7800.0n 0.6870 8099.9n 0.6870 8100.0n 0.4665 8399.9n 0.4665 8400.0n 0.6870 8699.9n 0.6870 8700.0n 0.4665 8999.9n 0.4665 9000.0n 0.4665 9299.9n 0.4665 9300.0n 0.4665 9599.9n 0.4665 9600.0n 0.8000 9899.9n 0.8000 9900.0n 0.5768 10199.9n 0.5768 10200.0n 0.4665 10499.9n 0.4665 10500.0n 0.4665 10799.9n 0.4665 10800.0n 0.4665 11099.9n 0.4665 11100.0n 0.4665 11399.9n 0.4665 11400.0n 0.4665 11699.9n 0.4665 11700.0n 0.4665 11999.9n 0.4665 12000.0n 0.4665 12299.9n 0.4665 12300.0n 0.4665 12599.9n 0.4665 12600.0n 0.4665 12899.9n 0.4665 12900.0n 0.4665 13199.9n 0.4665 13200.0n 0.6870 13499.9n 0.6870 13500.0n 0.4665 13799.9n 0.4665 13800.0n 0.6870 14099.9n 0.6870 14100.0n 0.4665 14399.9n 0.4665 14400.0n 0.4665 14699.9n 0.4665 14700.0n 0.4665 14999.9n 0.4665 15000.0n 0.8000 15299.9n 0.8000 15300.0n 0.5768 15599.9n 0.5768 15600.0n 0.4665 15899.9n 0.4665 15900.0n 0.4665 16199.9n 0.4665 16200.0n 0.4665 16499.9n 0.4665 16500.0n 0.4665 16799.9n 0.4665 16800.0n 0.4665 17099.9n 0.4665 17100.0n 0.4665 17399.9n 0.4665 17400.0n 0.4665 17699.9n 0.4665 17700.0n 0.4665 17999.9n 0.4665 18000.0n 0.4665 18299.9n 0.4665 18300.0n 0.4665 18599.9n 0.4665 18600.0n 0.6870 18899.9n 0.6870 18900.0n 0.4665 19199.9n 0.4665 19200.0n 0.6870 19499.9n 0.6870 19500.0n 0.4665 19799.9n 0.4665 19800.0n 0.4665 20099.9n 0.4665 20100.0n 0.4665 20399.9n 0.4665 20400.0n 0.8000 20699.9n 0.8000 20700.0n 0.5768 20999.9n 0.5768 21000.0n 0.4665 21299.9n 0.4665 21300.0n 0.4665 21599.9n 0.4665 21600.0n 0.4665 21899.9n 0.4665 21900.0n 0.4665 22199.9n 0.4665 22200.0n 0.4665 22499.9n 0.4665 22500.0n 0.4665 22799.9n 0.4665 22800.0n 0.4665 23099.9n 0.4665 23100.0n 0.4665 23399.9n 0.4665 23400.0n 0.4665 23699.9n 0.4665 23700.0n 0.4665 23999.9n 0.4665 24000.0n 0.6870 24299.9n 0.6870 24300.0n 0.4665 24599.9n 0.4665 24600.0n 0.6870 24899.9n 0.6870 24900.0n 0.4665 25199.9n 0.4665 25200.0n 0.4665 25499.9n 0.4665 25500.0n 0.4665 25799.9n 0.4665 25800.0n 0.8000 26099.9n 0.8000 26100.0n 0.5768 26399.9n 0.5768 26400.0n 0.4665 26699.9n 0.4665 26700.0n 0.4665 26999.9n 0.4665 27000.0n 0.4665 27299.9n 0.4665 27300.0n 0.4665 27599.9n 0.4665 27600.0n 0.4665 27899.9n 0.4665 27900.0n 0.4665 28199.9n 0.4665 28200.0n 0.4665 28499.9n 0.4665 28500.0n 0.4665 28799.9n 0.4665 28800.0n 0.4665 29099.9n 0.4665 29100.0n 0.4665 29399.9n 0.4665 29400.0n 0.6870 29699.9n 0.6870 29700.0n 0.4665 29999.9n 0.4665 30000.0n 0.6870 30299.9n 0.6870 30300.0n 0.4665 30599.9n 0.4665 30600.0n 0.4665 30899.9n 0.4665 30900.0n 0.4665 31199.9n 0.4665 31200.0n 0.8000 31499.9n 0.8000 31500.0n 0.5768 31799.9n 0.5768 31800.0n 0.4665 32099.9n 0.4665 32100.0n 0.4665 32399.9n 0.4665 32400.0n 0.4665 32699.9n 0.4665 32700.0n 0.4665 32999.9n 0.4665 33000.0n 0.4665 33299.9n 0.4665 33300.0n 0.4665 33599.9n 0.4665 33600.0n 0.4665 33899.9n 0.4665 33900.0n 0.4665 34199.9n 0.4665 34200.0n 0.4665 34499.9n 0.4665 34500.0n 0.4665 34799.9n 0.4665 34800.0n 0.6870 35099.9n 0.6870 35100.0n 0.4665 35399.9n 0.4665 35400.0n 0.6870 35699.9n 0.6870 35700.0n 0.4665 35999.9n 0.4665 36000.0n 0.4665 36299.9n 0.4665 36300.0n 0.4665 36599.9n 0.4665 36600.0n 0.8000 36899.9n 0.8000 36900.0n 0.5768 37199.9n 0.5768 37200.0n 0.4665 37499.9n 0.4665 37500.0n 0.4665 37799.9n 0.4665 37800.0n 0.4665 38099.9n 0.4665 38100.0n 0.4665 38399.9n 0.4665 38400.0n 0.4665 38699.9n 0.4665 38700.0n 0.4665 38999.9n 0.4665 39000.0n 0.4665 39299.9n 0.4665 39300.0n 0.4665 39599.9n 0.4665 39600.0n 0.4665 39899.9n 0.4665 39900.0n 0.4665 40199.9n 0.4665 40200.0n 0.6870 40499.9n 0.6870 40500.0n 0.4665 40799.9n 0.4665 40800.0n 0.6870 41099.9n 0.6870 41100.0n 0.4665 41399.9n 0.4665 41400.0n 0.4665 41699.9n 0.4665 41700.0n 0.4665 41999.9n 0.4665 42000.0n 0.8000 42299.9n 0.8000 42300.0n 0.5768 42599.9n 0.5768 42600.0n 0.4665 42899.9n 0.4665 42900.0n 0.4665 43199.9n 0.4665 43200.0n 0.4665 43499.9n 0.4665 43500.0n 0.4665 43799.9n 0.4665 43800.0n 0.4665 44099.9n 0.4665 44100.0n 0.4665 44399.9n 0.4665 44400.0n 0.4665 44699.9n 0.4665 44700.0n 0.4665 44999.9n 0.4665 45000.0n 0.4665 45299.9n 0.4665 45300.0n 0.4665 45599.9n 0.4665 45600.0n 0.6870 45899.9n 0.6870 45900.0n 0.4665 46199.9n 0.4665 46200.0n 0.6870 46499.9n 0.6870 46500.0n 0.4665 46799.9n 0.4665 46800.0n 0.4665 47099.9n 0.4665 47100.0n 0.4665 47399.9n 0.4665 47400.0n 0.8000 47699.9n 0.8000 47700.0n 0.5768 47999.9n 0.5768 48000.0n 0.4665 48299.9n 0.4665 48300.0n 0.4665 48599.9n 0.4665 48600.0n 0.4665 48899.9n 0.4665 48900.0n 0.4665 49199.9n 0.4665 49200.0n 0.4665 49499.9n 0.4665 49500.0n 0.4665 49799.9n 0.4665 49800.0n 0.4665 50099.9n 0.4665 50100.0n 0.4665 50399.9n 0.4665 50400.0n 0.4665 50699.9n 0.4665 50700.0n 0.4665 50999.9n 0.4665 51000.0n 0.6870 51299.9n 0.6870 51300.0n 0.4665 51599.9n 0.4665 51600.0n 0.6870 51899.9n 0.6870 51900.0n 0.4665 52199.9n 0.4665 52200.0n 0.4665 52499.9n 0.4665 52500.0n 0.4665 52799.9n 0.4665 52800.0n 0.8000 53099.9n 0.8000 53100.0n 0.5768 53399.9n 0.5768 53400.0n 0.4665 53699.9n 0.4665 53700.0n 0.4665 53999.9n 0.4665 54000.0n 0.4665 54299.9n 0.4665 54300.0n 0.4665 54599.9n 0.4665 54600.0n 0.4665 54899.9n 0.4665 54900.0n 0.4665 55199.9n 0.4665 55200.0n 0.4665 55499.9n 0.4665 55500.0n 0.4665 55799.9n 0.4665 55800.0n 0.4665 56099.9n 0.4665 56100.0n 0.4665 56399.9n 0.4665 56400.0n 0.4665 56699.9n 0.4665 56700.0n 0.4665 56999.9n 0.4665 57000.0n 0.4665 57299.9n 0.4665 57300.0n 0.4665 57599.9n 0.4665 57600.0n 0.5768 57899.9n 0.5768 57900.0n 0.6870 58199.9n 0.6870 58200.0n 0.4665 58499.9n 0.4665 58500.0n 0.6870 58799.9n 0.6870 58800.0n 0.7973 59099.9n 0.7973 59100.0n 0.5768)
Vxn1 a_xn1 0 PWL(0.0n 0.5335 299.9n 0.5335 300.0n 0.5335 599.9n 0.5335 600.0n 0.5335 899.9n 0.5335 900.0n 0.5335 1199.9n 0.5335 1200.0n 0.5335 1499.9n 0.5335 1500.0n 0.5335 1799.9n 0.5335 1800.0n 0.5335 2099.9n 0.5335 2100.0n 0.5335 2399.9n 0.5335 2400.0n 0.3130 2699.9n 0.3130 2700.0n 0.5335 2999.9n 0.5335 3000.0n 0.3130 3299.9n 0.3130 3300.0n 0.5335 3599.9n 0.5335 3600.0n 0.5335 3899.9n 0.5335 3900.0n 0.5335 4199.9n 0.5335 4200.0n 0.2000 4499.9n 0.2000 4500.0n 0.4232 4799.9n 0.4232 4800.0n 0.5335 5099.9n 0.5335 5100.0n 0.5335 5399.9n 0.5335 5400.0n 0.5335 5699.9n 0.5335 5700.0n 0.5335 5999.9n 0.5335 6000.0n 0.5335 6299.9n 0.5335 6300.0n 0.5335 6599.9n 0.5335 6600.0n 0.5335 6899.9n 0.5335 6900.0n 0.5335 7199.9n 0.5335 7200.0n 0.5335 7499.9n 0.5335 7500.0n 0.5335 7799.9n 0.5335 7800.0n 0.3130 8099.9n 0.3130 8100.0n 0.5335 8399.9n 0.5335 8400.0n 0.3130 8699.9n 0.3130 8700.0n 0.5335 8999.9n 0.5335 9000.0n 0.5335 9299.9n 0.5335 9300.0n 0.5335 9599.9n 0.5335 9600.0n 0.2000 9899.9n 0.2000 9900.0n 0.4232 10199.9n 0.4232 10200.0n 0.5335 10499.9n 0.5335 10500.0n 0.5335 10799.9n 0.5335 10800.0n 0.5335 11099.9n 0.5335 11100.0n 0.5335 11399.9n 0.5335 11400.0n 0.5335 11699.9n 0.5335 11700.0n 0.5335 11999.9n 0.5335 12000.0n 0.5335 12299.9n 0.5335 12300.0n 0.5335 12599.9n 0.5335 12600.0n 0.5335 12899.9n 0.5335 12900.0n 0.5335 13199.9n 0.5335 13200.0n 0.3130 13499.9n 0.3130 13500.0n 0.5335 13799.9n 0.5335 13800.0n 0.3130 14099.9n 0.3130 14100.0n 0.5335 14399.9n 0.5335 14400.0n 0.5335 14699.9n 0.5335 14700.0n 0.5335 14999.9n 0.5335 15000.0n 0.2000 15299.9n 0.2000 15300.0n 0.4232 15599.9n 0.4232 15600.0n 0.5335 15899.9n 0.5335 15900.0n 0.5335 16199.9n 0.5335 16200.0n 0.5335 16499.9n 0.5335 16500.0n 0.5335 16799.9n 0.5335 16800.0n 0.5335 17099.9n 0.5335 17100.0n 0.5335 17399.9n 0.5335 17400.0n 0.5335 17699.9n 0.5335 17700.0n 0.5335 17999.9n 0.5335 18000.0n 0.5335 18299.9n 0.5335 18300.0n 0.5335 18599.9n 0.5335 18600.0n 0.3130 18899.9n 0.3130 18900.0n 0.5335 19199.9n 0.5335 19200.0n 0.3130 19499.9n 0.3130 19500.0n 0.5335 19799.9n 0.5335 19800.0n 0.5335 20099.9n 0.5335 20100.0n 0.5335 20399.9n 0.5335 20400.0n 0.2000 20699.9n 0.2000 20700.0n 0.4232 20999.9n 0.4232 21000.0n 0.5335 21299.9n 0.5335 21300.0n 0.5335 21599.9n 0.5335 21600.0n 0.5335 21899.9n 0.5335 21900.0n 0.5335 22199.9n 0.5335 22200.0n 0.5335 22499.9n 0.5335 22500.0n 0.5335 22799.9n 0.5335 22800.0n 0.5335 23099.9n 0.5335 23100.0n 0.5335 23399.9n 0.5335 23400.0n 0.5335 23699.9n 0.5335 23700.0n 0.5335 23999.9n 0.5335 24000.0n 0.3130 24299.9n 0.3130 24300.0n 0.5335 24599.9n 0.5335 24600.0n 0.3130 24899.9n 0.3130 24900.0n 0.5335 25199.9n 0.5335 25200.0n 0.5335 25499.9n 0.5335 25500.0n 0.5335 25799.9n 0.5335 25800.0n 0.2000 26099.9n 0.2000 26100.0n 0.4232 26399.9n 0.4232 26400.0n 0.5335 26699.9n 0.5335 26700.0n 0.5335 26999.9n 0.5335 27000.0n 0.5335 27299.9n 0.5335 27300.0n 0.5335 27599.9n 0.5335 27600.0n 0.5335 27899.9n 0.5335 27900.0n 0.5335 28199.9n 0.5335 28200.0n 0.5335 28499.9n 0.5335 28500.0n 0.5335 28799.9n 0.5335 28800.0n 0.5335 29099.9n 0.5335 29100.0n 0.5335 29399.9n 0.5335 29400.0n 0.3130 29699.9n 0.3130 29700.0n 0.5335 29999.9n 0.5335 30000.0n 0.3130 30299.9n 0.3130 30300.0n 0.5335 30599.9n 0.5335 30600.0n 0.5335 30899.9n 0.5335 30900.0n 0.5335 31199.9n 0.5335 31200.0n 0.2000 31499.9n 0.2000 31500.0n 0.4232 31799.9n 0.4232 31800.0n 0.5335 32099.9n 0.5335 32100.0n 0.5335 32399.9n 0.5335 32400.0n 0.5335 32699.9n 0.5335 32700.0n 0.5335 32999.9n 0.5335 33000.0n 0.5335 33299.9n 0.5335 33300.0n 0.5335 33599.9n 0.5335 33600.0n 0.5335 33899.9n 0.5335 33900.0n 0.5335 34199.9n 0.5335 34200.0n 0.5335 34499.9n 0.5335 34500.0n 0.5335 34799.9n 0.5335 34800.0n 0.3130 35099.9n 0.3130 35100.0n 0.5335 35399.9n 0.5335 35400.0n 0.3130 35699.9n 0.3130 35700.0n 0.5335 35999.9n 0.5335 36000.0n 0.5335 36299.9n 0.5335 36300.0n 0.5335 36599.9n 0.5335 36600.0n 0.2000 36899.9n 0.2000 36900.0n 0.4232 37199.9n 0.4232 37200.0n 0.5335 37499.9n 0.5335 37500.0n 0.5335 37799.9n 0.5335 37800.0n 0.5335 38099.9n 0.5335 38100.0n 0.5335 38399.9n 0.5335 38400.0n 0.5335 38699.9n 0.5335 38700.0n 0.5335 38999.9n 0.5335 39000.0n 0.5335 39299.9n 0.5335 39300.0n 0.5335 39599.9n 0.5335 39600.0n 0.5335 39899.9n 0.5335 39900.0n 0.5335 40199.9n 0.5335 40200.0n 0.3130 40499.9n 0.3130 40500.0n 0.5335 40799.9n 0.5335 40800.0n 0.3130 41099.9n 0.3130 41100.0n 0.5335 41399.9n 0.5335 41400.0n 0.5335 41699.9n 0.5335 41700.0n 0.5335 41999.9n 0.5335 42000.0n 0.2000 42299.9n 0.2000 42300.0n 0.4232 42599.9n 0.4232 42600.0n 0.5335 42899.9n 0.5335 42900.0n 0.5335 43199.9n 0.5335 43200.0n 0.5335 43499.9n 0.5335 43500.0n 0.5335 43799.9n 0.5335 43800.0n 0.5335 44099.9n 0.5335 44100.0n 0.5335 44399.9n 0.5335 44400.0n 0.5335 44699.9n 0.5335 44700.0n 0.5335 44999.9n 0.5335 45000.0n 0.5335 45299.9n 0.5335 45300.0n 0.5335 45599.9n 0.5335 45600.0n 0.3130 45899.9n 0.3130 45900.0n 0.5335 46199.9n 0.5335 46200.0n 0.3130 46499.9n 0.3130 46500.0n 0.5335 46799.9n 0.5335 46800.0n 0.5335 47099.9n 0.5335 47100.0n 0.5335 47399.9n 0.5335 47400.0n 0.2000 47699.9n 0.2000 47700.0n 0.4232 47999.9n 0.4232 48000.0n 0.5335 48299.9n 0.5335 48300.0n 0.5335 48599.9n 0.5335 48600.0n 0.5335 48899.9n 0.5335 48900.0n 0.5335 49199.9n 0.5335 49200.0n 0.5335 49499.9n 0.5335 49500.0n 0.5335 49799.9n 0.5335 49800.0n 0.5335 50099.9n 0.5335 50100.0n 0.5335 50399.9n 0.5335 50400.0n 0.5335 50699.9n 0.5335 50700.0n 0.5335 50999.9n 0.5335 51000.0n 0.3130 51299.9n 0.3130 51300.0n 0.5335 51599.9n 0.5335 51600.0n 0.3130 51899.9n 0.3130 51900.0n 0.5335 52199.9n 0.5335 52200.0n 0.5335 52499.9n 0.5335 52500.0n 0.5335 52799.9n 0.5335 52800.0n 0.2000 53099.9n 0.2000 53100.0n 0.4232 53399.9n 0.4232 53400.0n 0.5335 53699.9n 0.5335 53700.0n 0.5335 53999.9n 0.5335 54000.0n 0.5335 54299.9n 0.5335 54300.0n 0.5335 54599.9n 0.5335 54600.0n 0.5335 54899.9n 0.5335 54900.0n 0.5335 55199.9n 0.5335 55200.0n 0.5335 55499.9n 0.5335 55500.0n 0.5335 55799.9n 0.5335 55800.0n 0.5335 56099.9n 0.5335 56100.0n 0.5335 56399.9n 0.5335 56400.0n 0.5335 56699.9n 0.5335 56700.0n 0.5335 56999.9n 0.5335 57000.0n 0.5335 57299.9n 0.5335 57300.0n 0.5335 57599.9n 0.5335 57600.0n 0.4232 57899.9n 0.4232 57900.0n 0.3130 58199.9n 0.3130 58200.0n 0.5335 58499.9n 0.5335 58500.0n 0.3130 58799.9n 0.3130 58800.0n 0.2027 59099.9n 0.2027 59100.0n 0.4232)
Vxp2 a_xp2 0 PWL(0.0n 0.3905 299.9n 0.3905 300.0n 0.4326 599.9n 0.4326 600.0n 0.5167 899.9n 0.5167 900.0n 0.4326 1199.9n 0.4326 1200.0n 0.3905 1499.9n 0.3905 1500.0n 0.4957 1799.9n 0.4957 1800.0n 0.5167 2099.9n 0.5167 2100.0n 0.3905 2399.9n 0.3905 2400.0n 0.7061 2699.9n 0.7061 2700.0n 0.5378 2999.9n 0.5378 3000.0n 0.7061 3299.9n 0.7061 3300.0n 0.6640 3599.9n 0.6640 3600.0n 0.3905 3899.9n 0.3905 3900.0n 0.3905 4199.9n 0.3905 4200.0n 0.7271 4499.9n 0.7271 4500.0n 0.7061 4799.9n 0.7061 4800.0n 0.4536 5099.9n 0.4536 5100.0n 0.3905 5399.9n 0.3905 5400.0n 0.3905 5699.9n 0.3905 5700.0n 0.4326 5999.9n 0.4326 6000.0n 0.5167 6299.9n 0.5167 6300.0n 0.4326 6599.9n 0.4326 6600.0n 0.3905 6899.9n 0.3905 6900.0n 0.4957 7199.9n 0.4957 7200.0n 0.5167 7499.9n 0.5167 7500.0n 0.3905 7799.9n 0.3905 7800.0n 0.7061 8099.9n 0.7061 8100.0n 0.5378 8399.9n 0.5378 8400.0n 0.7061 8699.9n 0.7061 8700.0n 0.6640 8999.9n 0.6640 9000.0n 0.3905 9299.9n 0.3905 9300.0n 0.3905 9599.9n 0.3905 9600.0n 0.7271 9899.9n 0.7271 9900.0n 0.7061 10199.9n 0.7061 10200.0n 0.4536 10499.9n 0.4536 10500.0n 0.3905 10799.9n 0.3905 10800.0n 0.3905 11099.9n 0.3905 11100.0n 0.4326 11399.9n 0.4326 11400.0n 0.5167 11699.9n 0.5167 11700.0n 0.4326 11999.9n 0.4326 12000.0n 0.3905 12299.9n 0.3905 12300.0n 0.4957 12599.9n 0.4957 12600.0n 0.5167 12899.9n 0.5167 12900.0n 0.3905 13199.9n 0.3905 13200.0n 0.7061 13499.9n 0.7061 13500.0n 0.5378 13799.9n 0.5378 13800.0n 0.7061 14099.9n 0.7061 14100.0n 0.6640 14399.9n 0.6640 14400.0n 0.3905 14699.9n 0.3905 14700.0n 0.3905 14999.9n 0.3905 15000.0n 0.7271 15299.9n 0.7271 15300.0n 0.7061 15599.9n 0.7061 15600.0n 0.4536 15899.9n 0.4536 15900.0n 0.3905 16199.9n 0.3905 16200.0n 0.3905 16499.9n 0.3905 16500.0n 0.4326 16799.9n 0.4326 16800.0n 0.5167 17099.9n 0.5167 17100.0n 0.4326 17399.9n 0.4326 17400.0n 0.3905 17699.9n 0.3905 17700.0n 0.4957 17999.9n 0.4957 18000.0n 0.5167 18299.9n 0.5167 18300.0n 0.3905 18599.9n 0.3905 18600.0n 0.7061 18899.9n 0.7061 18900.0n 0.5378 19199.9n 0.5378 19200.0n 0.7061 19499.9n 0.7061 19500.0n 0.6640 19799.9n 0.6640 19800.0n 0.3905 20099.9n 0.3905 20100.0n 0.3905 20399.9n 0.3905 20400.0n 0.7271 20699.9n 0.7271 20700.0n 0.7061 20999.9n 0.7061 21000.0n 0.4536 21299.9n 0.4536 21300.0n 0.3905 21599.9n 0.3905 21600.0n 0.3905 21899.9n 0.3905 21900.0n 0.4326 22199.9n 0.4326 22200.0n 0.5167 22499.9n 0.5167 22500.0n 0.4326 22799.9n 0.4326 22800.0n 0.3905 23099.9n 0.3905 23100.0n 0.4957 23399.9n 0.4957 23400.0n 0.5167 23699.9n 0.5167 23700.0n 0.3905 23999.9n 0.3905 24000.0n 0.7061 24299.9n 0.7061 24300.0n 0.5378 24599.9n 0.5378 24600.0n 0.7061 24899.9n 0.7061 24900.0n 0.6640 25199.9n 0.6640 25200.0n 0.3905 25499.9n 0.3905 25500.0n 0.3905 25799.9n 0.3905 25800.0n 0.7271 26099.9n 0.7271 26100.0n 0.7061 26399.9n 0.7061 26400.0n 0.4536 26699.9n 0.4536 26700.0n 0.3905 26999.9n 0.3905 27000.0n 0.3905 27299.9n 0.3905 27300.0n 0.4326 27599.9n 0.4326 27600.0n 0.5167 27899.9n 0.5167 27900.0n 0.4326 28199.9n 0.4326 28200.0n 0.3905 28499.9n 0.3905 28500.0n 0.4957 28799.9n 0.4957 28800.0n 0.5167 29099.9n 0.5167 29100.0n 0.3905 29399.9n 0.3905 29400.0n 0.7061 29699.9n 0.7061 29700.0n 0.5378 29999.9n 0.5378 30000.0n 0.7061 30299.9n 0.7061 30300.0n 0.6640 30599.9n 0.6640 30600.0n 0.3905 30899.9n 0.3905 30900.0n 0.3905 31199.9n 0.3905 31200.0n 0.7271 31499.9n 0.7271 31500.0n 0.7061 31799.9n 0.7061 31800.0n 0.4536 32099.9n 0.4536 32100.0n 0.3905 32399.9n 0.3905 32400.0n 0.3905 32699.9n 0.3905 32700.0n 0.4326 32999.9n 0.4326 33000.0n 0.5167 33299.9n 0.5167 33300.0n 0.4326 33599.9n 0.4326 33600.0n 0.3905 33899.9n 0.3905 33900.0n 0.4957 34199.9n 0.4957 34200.0n 0.5167 34499.9n 0.5167 34500.0n 0.3905 34799.9n 0.3905 34800.0n 0.7061 35099.9n 0.7061 35100.0n 0.5378 35399.9n 0.5378 35400.0n 0.7061 35699.9n 0.7061 35700.0n 0.6640 35999.9n 0.6640 36000.0n 0.3905 36299.9n 0.3905 36300.0n 0.3905 36599.9n 0.3905 36600.0n 0.7271 36899.9n 0.7271 36900.0n 0.7061 37199.9n 0.7061 37200.0n 0.4536 37499.9n 0.4536 37500.0n 0.3905 37799.9n 0.3905 37800.0n 0.3905 38099.9n 0.3905 38100.0n 0.4326 38399.9n 0.4326 38400.0n 0.5167 38699.9n 0.5167 38700.0n 0.4326 38999.9n 0.4326 39000.0n 0.3905 39299.9n 0.3905 39300.0n 0.4957 39599.9n 0.4957 39600.0n 0.5167 39899.9n 0.5167 39900.0n 0.3905 40199.9n 0.3905 40200.0n 0.7061 40499.9n 0.7061 40500.0n 0.5378 40799.9n 0.5378 40800.0n 0.7061 41099.9n 0.7061 41100.0n 0.6640 41399.9n 0.6640 41400.0n 0.3905 41699.9n 0.3905 41700.0n 0.3905 41999.9n 0.3905 42000.0n 0.7271 42299.9n 0.7271 42300.0n 0.7061 42599.9n 0.7061 42600.0n 0.4536 42899.9n 0.4536 42900.0n 0.3905 43199.9n 0.3905 43200.0n 0.3905 43499.9n 0.3905 43500.0n 0.4326 43799.9n 0.4326 43800.0n 0.5167 44099.9n 0.5167 44100.0n 0.4326 44399.9n 0.4326 44400.0n 0.3905 44699.9n 0.3905 44700.0n 0.4957 44999.9n 0.4957 45000.0n 0.5167 45299.9n 0.5167 45300.0n 0.3905 45599.9n 0.3905 45600.0n 0.7061 45899.9n 0.7061 45900.0n 0.5378 46199.9n 0.5378 46200.0n 0.7061 46499.9n 0.7061 46500.0n 0.6640 46799.9n 0.6640 46800.0n 0.3905 47099.9n 0.3905 47100.0n 0.3905 47399.9n 0.3905 47400.0n 0.7271 47699.9n 0.7271 47700.0n 0.7061 47999.9n 0.7061 48000.0n 0.4536 48299.9n 0.4536 48300.0n 0.3905 48599.9n 0.3905 48600.0n 0.3905 48899.9n 0.3905 48900.0n 0.4326 49199.9n 0.4326 49200.0n 0.5167 49499.9n 0.5167 49500.0n 0.4326 49799.9n 0.4326 49800.0n 0.3905 50099.9n 0.3905 50100.0n 0.4957 50399.9n 0.4957 50400.0n 0.5167 50699.9n 0.5167 50700.0n 0.3905 50999.9n 0.3905 51000.0n 0.7061 51299.9n 0.7061 51300.0n 0.5378 51599.9n 0.5378 51600.0n 0.7061 51899.9n 0.7061 51900.0n 0.6640 52199.9n 0.6640 52200.0n 0.3905 52499.9n 0.3905 52500.0n 0.3905 52799.9n 0.3905 52800.0n 0.7271 53099.9n 0.7271 53100.0n 0.7061 53399.9n 0.7061 53400.0n 0.4536 53699.9n 0.4536 53700.0n 0.3905 53999.9n 0.3905 54000.0n 0.4326 54299.9n 0.4326 54300.0n 0.4326 54599.9n 0.4326 54600.0n 0.4326 54899.9n 0.4326 54900.0n 0.4747 55199.9n 0.4747 55200.0n 0.4536 55499.9n 0.4536 55500.0n 0.4326 55799.9n 0.4326 55800.0n 0.3905 56099.9n 0.3905 56100.0n 0.4115 56399.9n 0.4115 56400.0n 0.3905 56699.9n 0.3905 56700.0n 0.4326 56999.9n 0.4326 57000.0n 0.3905 57299.9n 0.3905 57300.0n 0.4326 57599.9n 0.4326 57600.0n 0.7061 57899.9n 0.7061 57900.0n 0.6219 58199.9n 0.6219 58200.0n 0.5167 58499.9n 0.5167 58500.0n 0.7061 58799.9n 0.7061 58800.0n 0.7061 59099.9n 0.7061 59100.0n 0.6640)
Vxn2 a_xn2 0 PWL(0.0n 0.6095 299.9n 0.6095 300.0n 0.5674 599.9n 0.5674 600.0n 0.4833 899.9n 0.4833 900.0n 0.5674 1199.9n 0.5674 1200.0n 0.6095 1499.9n 0.6095 1500.0n 0.5043 1799.9n 0.5043 1800.0n 0.4833 2099.9n 0.4833 2100.0n 0.6095 2399.9n 0.6095 2400.0n 0.2939 2699.9n 0.2939 2700.0n 0.4622 2999.9n 0.4622 3000.0n 0.2939 3299.9n 0.2939 3300.0n 0.3360 3599.9n 0.3360 3600.0n 0.6095 3899.9n 0.6095 3900.0n 0.6095 4199.9n 0.6095 4200.0n 0.2729 4499.9n 0.2729 4500.0n 0.2939 4799.9n 0.2939 4800.0n 0.5464 5099.9n 0.5464 5100.0n 0.6095 5399.9n 0.6095 5400.0n 0.6095 5699.9n 0.6095 5700.0n 0.5674 5999.9n 0.5674 6000.0n 0.4833 6299.9n 0.4833 6300.0n 0.5674 6599.9n 0.5674 6600.0n 0.6095 6899.9n 0.6095 6900.0n 0.5043 7199.9n 0.5043 7200.0n 0.4833 7499.9n 0.4833 7500.0n 0.6095 7799.9n 0.6095 7800.0n 0.2939 8099.9n 0.2939 8100.0n 0.4622 8399.9n 0.4622 8400.0n 0.2939 8699.9n 0.2939 8700.0n 0.3360 8999.9n 0.3360 9000.0n 0.6095 9299.9n 0.6095 9300.0n 0.6095 9599.9n 0.6095 9600.0n 0.2729 9899.9n 0.2729 9900.0n 0.2939 10199.9n 0.2939 10200.0n 0.5464 10499.9n 0.5464 10500.0n 0.6095 10799.9n 0.6095 10800.0n 0.6095 11099.9n 0.6095 11100.0n 0.5674 11399.9n 0.5674 11400.0n 0.4833 11699.9n 0.4833 11700.0n 0.5674 11999.9n 0.5674 12000.0n 0.6095 12299.9n 0.6095 12300.0n 0.5043 12599.9n 0.5043 12600.0n 0.4833 12899.9n 0.4833 12900.0n 0.6095 13199.9n 0.6095 13200.0n 0.2939 13499.9n 0.2939 13500.0n 0.4622 13799.9n 0.4622 13800.0n 0.2939 14099.9n 0.2939 14100.0n 0.3360 14399.9n 0.3360 14400.0n 0.6095 14699.9n 0.6095 14700.0n 0.6095 14999.9n 0.6095 15000.0n 0.2729 15299.9n 0.2729 15300.0n 0.2939 15599.9n 0.2939 15600.0n 0.5464 15899.9n 0.5464 15900.0n 0.6095 16199.9n 0.6095 16200.0n 0.6095 16499.9n 0.6095 16500.0n 0.5674 16799.9n 0.5674 16800.0n 0.4833 17099.9n 0.4833 17100.0n 0.5674 17399.9n 0.5674 17400.0n 0.6095 17699.9n 0.6095 17700.0n 0.5043 17999.9n 0.5043 18000.0n 0.4833 18299.9n 0.4833 18300.0n 0.6095 18599.9n 0.6095 18600.0n 0.2939 18899.9n 0.2939 18900.0n 0.4622 19199.9n 0.4622 19200.0n 0.2939 19499.9n 0.2939 19500.0n 0.3360 19799.9n 0.3360 19800.0n 0.6095 20099.9n 0.6095 20100.0n 0.6095 20399.9n 0.6095 20400.0n 0.2729 20699.9n 0.2729 20700.0n 0.2939 20999.9n 0.2939 21000.0n 0.5464 21299.9n 0.5464 21300.0n 0.6095 21599.9n 0.6095 21600.0n 0.6095 21899.9n 0.6095 21900.0n 0.5674 22199.9n 0.5674 22200.0n 0.4833 22499.9n 0.4833 22500.0n 0.5674 22799.9n 0.5674 22800.0n 0.6095 23099.9n 0.6095 23100.0n 0.5043 23399.9n 0.5043 23400.0n 0.4833 23699.9n 0.4833 23700.0n 0.6095 23999.9n 0.6095 24000.0n 0.2939 24299.9n 0.2939 24300.0n 0.4622 24599.9n 0.4622 24600.0n 0.2939 24899.9n 0.2939 24900.0n 0.3360 25199.9n 0.3360 25200.0n 0.6095 25499.9n 0.6095 25500.0n 0.6095 25799.9n 0.6095 25800.0n 0.2729 26099.9n 0.2729 26100.0n 0.2939 26399.9n 0.2939 26400.0n 0.5464 26699.9n 0.5464 26700.0n 0.6095 26999.9n 0.6095 27000.0n 0.6095 27299.9n 0.6095 27300.0n 0.5674 27599.9n 0.5674 27600.0n 0.4833 27899.9n 0.4833 27900.0n 0.5674 28199.9n 0.5674 28200.0n 0.6095 28499.9n 0.6095 28500.0n 0.5043 28799.9n 0.5043 28800.0n 0.4833 29099.9n 0.4833 29100.0n 0.6095 29399.9n 0.6095 29400.0n 0.2939 29699.9n 0.2939 29700.0n 0.4622 29999.9n 0.4622 30000.0n 0.2939 30299.9n 0.2939 30300.0n 0.3360 30599.9n 0.3360 30600.0n 0.6095 30899.9n 0.6095 30900.0n 0.6095 31199.9n 0.6095 31200.0n 0.2729 31499.9n 0.2729 31500.0n 0.2939 31799.9n 0.2939 31800.0n 0.5464 32099.9n 0.5464 32100.0n 0.6095 32399.9n 0.6095 32400.0n 0.6095 32699.9n 0.6095 32700.0n 0.5674 32999.9n 0.5674 33000.0n 0.4833 33299.9n 0.4833 33300.0n 0.5674 33599.9n 0.5674 33600.0n 0.6095 33899.9n 0.6095 33900.0n 0.5043 34199.9n 0.5043 34200.0n 0.4833 34499.9n 0.4833 34500.0n 0.6095 34799.9n 0.6095 34800.0n 0.2939 35099.9n 0.2939 35100.0n 0.4622 35399.9n 0.4622 35400.0n 0.2939 35699.9n 0.2939 35700.0n 0.3360 35999.9n 0.3360 36000.0n 0.6095 36299.9n 0.6095 36300.0n 0.6095 36599.9n 0.6095 36600.0n 0.2729 36899.9n 0.2729 36900.0n 0.2939 37199.9n 0.2939 37200.0n 0.5464 37499.9n 0.5464 37500.0n 0.6095 37799.9n 0.6095 37800.0n 0.6095 38099.9n 0.6095 38100.0n 0.5674 38399.9n 0.5674 38400.0n 0.4833 38699.9n 0.4833 38700.0n 0.5674 38999.9n 0.5674 39000.0n 0.6095 39299.9n 0.6095 39300.0n 0.5043 39599.9n 0.5043 39600.0n 0.4833 39899.9n 0.4833 39900.0n 0.6095 40199.9n 0.6095 40200.0n 0.2939 40499.9n 0.2939 40500.0n 0.4622 40799.9n 0.4622 40800.0n 0.2939 41099.9n 0.2939 41100.0n 0.3360 41399.9n 0.3360 41400.0n 0.6095 41699.9n 0.6095 41700.0n 0.6095 41999.9n 0.6095 42000.0n 0.2729 42299.9n 0.2729 42300.0n 0.2939 42599.9n 0.2939 42600.0n 0.5464 42899.9n 0.5464 42900.0n 0.6095 43199.9n 0.6095 43200.0n 0.6095 43499.9n 0.6095 43500.0n 0.5674 43799.9n 0.5674 43800.0n 0.4833 44099.9n 0.4833 44100.0n 0.5674 44399.9n 0.5674 44400.0n 0.6095 44699.9n 0.6095 44700.0n 0.5043 44999.9n 0.5043 45000.0n 0.4833 45299.9n 0.4833 45300.0n 0.6095 45599.9n 0.6095 45600.0n 0.2939 45899.9n 0.2939 45900.0n 0.4622 46199.9n 0.4622 46200.0n 0.2939 46499.9n 0.2939 46500.0n 0.3360 46799.9n 0.3360 46800.0n 0.6095 47099.9n 0.6095 47100.0n 0.6095 47399.9n 0.6095 47400.0n 0.2729 47699.9n 0.2729 47700.0n 0.2939 47999.9n 0.2939 48000.0n 0.5464 48299.9n 0.5464 48300.0n 0.6095 48599.9n 0.6095 48600.0n 0.6095 48899.9n 0.6095 48900.0n 0.5674 49199.9n 0.5674 49200.0n 0.4833 49499.9n 0.4833 49500.0n 0.5674 49799.9n 0.5674 49800.0n 0.6095 50099.9n 0.6095 50100.0n 0.5043 50399.9n 0.5043 50400.0n 0.4833 50699.9n 0.4833 50700.0n 0.6095 50999.9n 0.6095 51000.0n 0.2939 51299.9n 0.2939 51300.0n 0.4622 51599.9n 0.4622 51600.0n 0.2939 51899.9n 0.2939 51900.0n 0.3360 52199.9n 0.3360 52200.0n 0.6095 52499.9n 0.6095 52500.0n 0.6095 52799.9n 0.6095 52800.0n 0.2729 53099.9n 0.2729 53100.0n 0.2939 53399.9n 0.2939 53400.0n 0.5464 53699.9n 0.5464 53700.0n 0.6095 53999.9n 0.6095 54000.0n 0.5674 54299.9n 0.5674 54300.0n 0.5674 54599.9n 0.5674 54600.0n 0.5674 54899.9n 0.5674 54900.0n 0.5253 55199.9n 0.5253 55200.0n 0.5464 55499.9n 0.5464 55500.0n 0.5674 55799.9n 0.5674 55800.0n 0.6095 56099.9n 0.6095 56100.0n 0.5885 56399.9n 0.5885 56400.0n 0.6095 56699.9n 0.6095 56700.0n 0.5674 56999.9n 0.5674 57000.0n 0.6095 57299.9n 0.6095 57300.0n 0.5674 57599.9n 0.5674 57600.0n 0.2939 57899.9n 0.2939 57900.0n 0.3781 58199.9n 0.3781 58200.0n 0.4833 58499.9n 0.4833 58500.0n 0.2939 58799.9n 0.2939 58800.0n 0.2939 59099.9n 0.2939 59100.0n 0.3360)
Vxp3 a_xp3 0 PWL(0.0n 0.2214 299.9n 0.2214 300.0n 0.4803 599.9n 0.4803 600.0n 0.5980 899.9n 0.5980 900.0n 0.5274 1199.9n 0.5274 1200.0n 0.2214 1499.9n 0.2214 1500.0n 0.5039 1799.9n 0.5039 1800.0n 0.5509 2099.9n 0.5509 2100.0n 0.2214 2399.9n 0.2214 2400.0n 0.5980 2699.9n 0.5980 2700.0n 0.5745 2999.9n 0.5745 3000.0n 0.5745 3299.9n 0.5745 3300.0n 0.5509 3599.9n 0.5509 3600.0n 0.3155 3899.9n 0.3155 3900.0n 0.5509 4199.9n 0.5509 4200.0n 0.5745 4499.9n 0.5745 4500.0n 0.5980 4799.9n 0.5980 4800.0n 0.5039 5099.9n 0.5039 5100.0n 0.2214 5399.9n 0.2214 5400.0n 0.2214 5699.9n 0.2214 5700.0n 0.4803 5999.9n 0.4803 6000.0n 0.5980 6299.9n 0.5980 6300.0n 0.5274 6599.9n 0.5274 6600.0n 0.2214 6899.9n 0.2214 6900.0n 0.5039 7199.9n 0.5039 7200.0n 0.5509 7499.9n 0.5509 7500.0n 0.2214 7799.9n 0.2214 7800.0n 0.5980 8099.9n 0.5980 8100.0n 0.5745 8399.9n 0.5745 8400.0n 0.5745 8699.9n 0.5745 8700.0n 0.5509 8999.9n 0.5509 9000.0n 0.3155 9299.9n 0.3155 9300.0n 0.5509 9599.9n 0.5509 9600.0n 0.5745 9899.9n 0.5745 9900.0n 0.5980 10199.9n 0.5980 10200.0n 0.5039 10499.9n 0.5039 10500.0n 0.2214 10799.9n 0.2214 10800.0n 0.2214 11099.9n 0.2214 11100.0n 0.4803 11399.9n 0.4803 11400.0n 0.5980 11699.9n 0.5980 11700.0n 0.5274 11999.9n 0.5274 12000.0n 0.2214 12299.9n 0.2214 12300.0n 0.5039 12599.9n 0.5039 12600.0n 0.5509 12899.9n 0.5509 12900.0n 0.2214 13199.9n 0.2214 13200.0n 0.5980 13499.9n 0.5980 13500.0n 0.5745 13799.9n 0.5745 13800.0n 0.5745 14099.9n 0.5745 14100.0n 0.5509 14399.9n 0.5509 14400.0n 0.3155 14699.9n 0.3155 14700.0n 0.5509 14999.9n 0.5509 15000.0n 0.5745 15299.9n 0.5745 15300.0n 0.5980 15599.9n 0.5980 15600.0n 0.5039 15899.9n 0.5039 15900.0n 0.2214 16199.9n 0.2214 16200.0n 0.2214 16499.9n 0.2214 16500.0n 0.4803 16799.9n 0.4803 16800.0n 0.5980 17099.9n 0.5980 17100.0n 0.5274 17399.9n 0.5274 17400.0n 0.2214 17699.9n 0.2214 17700.0n 0.5039 17999.9n 0.5039 18000.0n 0.5509 18299.9n 0.5509 18300.0n 0.2214 18599.9n 0.2214 18600.0n 0.5980 18899.9n 0.5980 18900.0n 0.5745 19199.9n 0.5745 19200.0n 0.5745 19499.9n 0.5745 19500.0n 0.5509 19799.9n 0.5509 19800.0n 0.3155 20099.9n 0.3155 20100.0n 0.5509 20399.9n 0.5509 20400.0n 0.5745 20699.9n 0.5745 20700.0n 0.5980 20999.9n 0.5980 21000.0n 0.5039 21299.9n 0.5039 21300.0n 0.2214 21599.9n 0.2214 21600.0n 0.2214 21899.9n 0.2214 21900.0n 0.4803 22199.9n 0.4803 22200.0n 0.5980 22499.9n 0.5980 22500.0n 0.5274 22799.9n 0.5274 22800.0n 0.2214 23099.9n 0.2214 23100.0n 0.5039 23399.9n 0.5039 23400.0n 0.5509 23699.9n 0.5509 23700.0n 0.2214 23999.9n 0.2214 24000.0n 0.5980 24299.9n 0.5980 24300.0n 0.5745 24599.9n 0.5745 24600.0n 0.5745 24899.9n 0.5745 24900.0n 0.5509 25199.9n 0.5509 25200.0n 0.3155 25499.9n 0.3155 25500.0n 0.5509 25799.9n 0.5509 25800.0n 0.5745 26099.9n 0.5745 26100.0n 0.5980 26399.9n 0.5980 26400.0n 0.5039 26699.9n 0.5039 26700.0n 0.2214 26999.9n 0.2214 27000.0n 0.2214 27299.9n 0.2214 27300.0n 0.4803 27599.9n 0.4803 27600.0n 0.5980 27899.9n 0.5980 27900.0n 0.5274 28199.9n 0.5274 28200.0n 0.2214 28499.9n 0.2214 28500.0n 0.5039 28799.9n 0.5039 28800.0n 0.5509 29099.9n 0.5509 29100.0n 0.2214 29399.9n 0.2214 29400.0n 0.5980 29699.9n 0.5980 29700.0n 0.5745 29999.9n 0.5745 30000.0n 0.5745 30299.9n 0.5745 30300.0n 0.5509 30599.9n 0.5509 30600.0n 0.3155 30899.9n 0.3155 30900.0n 0.5509 31199.9n 0.5509 31200.0n 0.5745 31499.9n 0.5745 31500.0n 0.5980 31799.9n 0.5980 31800.0n 0.5039 32099.9n 0.5039 32100.0n 0.2214 32399.9n 0.2214 32400.0n 0.2214 32699.9n 0.2214 32700.0n 0.4803 32999.9n 0.4803 33000.0n 0.5980 33299.9n 0.5980 33300.0n 0.5274 33599.9n 0.5274 33600.0n 0.2214 33899.9n 0.2214 33900.0n 0.5039 34199.9n 0.5039 34200.0n 0.5509 34499.9n 0.5509 34500.0n 0.2214 34799.9n 0.2214 34800.0n 0.5980 35099.9n 0.5980 35100.0n 0.5745 35399.9n 0.5745 35400.0n 0.5745 35699.9n 0.5745 35700.0n 0.5509 35999.9n 0.5509 36000.0n 0.3155 36299.9n 0.3155 36300.0n 0.5509 36599.9n 0.5509 36600.0n 0.5745 36899.9n 0.5745 36900.0n 0.5980 37199.9n 0.5980 37200.0n 0.5039 37499.9n 0.5039 37500.0n 0.2214 37799.9n 0.2214 37800.0n 0.2214 38099.9n 0.2214 38100.0n 0.4803 38399.9n 0.4803 38400.0n 0.5980 38699.9n 0.5980 38700.0n 0.5274 38999.9n 0.5274 39000.0n 0.2214 39299.9n 0.2214 39300.0n 0.5039 39599.9n 0.5039 39600.0n 0.5509 39899.9n 0.5509 39900.0n 0.2214 40199.9n 0.2214 40200.0n 0.5980 40499.9n 0.5980 40500.0n 0.5745 40799.9n 0.5745 40800.0n 0.5745 41099.9n 0.5745 41100.0n 0.5509 41399.9n 0.5509 41400.0n 0.3155 41699.9n 0.3155 41700.0n 0.5509 41999.9n 0.5509 42000.0n 0.5745 42299.9n 0.5745 42300.0n 0.5980 42599.9n 0.5980 42600.0n 0.5039 42899.9n 0.5039 42900.0n 0.2214 43199.9n 0.2214 43200.0n 0.2214 43499.9n 0.2214 43500.0n 0.4803 43799.9n 0.4803 43800.0n 0.5980 44099.9n 0.5980 44100.0n 0.5274 44399.9n 0.5274 44400.0n 0.2214 44699.9n 0.2214 44700.0n 0.5039 44999.9n 0.5039 45000.0n 0.5509 45299.9n 0.5509 45300.0n 0.2214 45599.9n 0.2214 45600.0n 0.5980 45899.9n 0.5980 45900.0n 0.5745 46199.9n 0.5745 46200.0n 0.5745 46499.9n 0.5745 46500.0n 0.5509 46799.9n 0.5509 46800.0n 0.3155 47099.9n 0.3155 47100.0n 0.5509 47399.9n 0.5509 47400.0n 0.5745 47699.9n 0.5745 47700.0n 0.5980 47999.9n 0.5980 48000.0n 0.5039 48299.9n 0.5039 48300.0n 0.2214 48599.9n 0.2214 48600.0n 0.2214 48899.9n 0.2214 48900.0n 0.4803 49199.9n 0.4803 49200.0n 0.5980 49499.9n 0.5980 49500.0n 0.5274 49799.9n 0.5274 49800.0n 0.2214 50099.9n 0.2214 50100.0n 0.5039 50399.9n 0.5039 50400.0n 0.5509 50699.9n 0.5509 50700.0n 0.2214 50999.9n 0.2214 51000.0n 0.5980 51299.9n 0.5980 51300.0n 0.5745 51599.9n 0.5745 51600.0n 0.5745 51899.9n 0.5745 51900.0n 0.5509 52199.9n 0.5509 52200.0n 0.3155 52499.9n 0.3155 52500.0n 0.5509 52799.9n 0.5509 52800.0n 0.5745 53099.9n 0.5745 53100.0n 0.5980 53399.9n 0.5980 53400.0n 0.5039 53699.9n 0.5039 53700.0n 0.2214 53999.9n 0.2214 54000.0n 0.5509 54299.9n 0.5509 54300.0n 0.5745 54599.9n 0.5745 54600.0n 0.5509 54899.9n 0.5509 54900.0n 0.5039 55199.9n 0.5039 55200.0n 0.4803 55499.9n 0.4803 55500.0n 0.4568 55799.9n 0.4568 55800.0n 0.5980 56099.9n 0.5980 56100.0n 0.5039 56399.9n 0.5039 56400.0n 0.2214 56699.9n 0.2214 56700.0n 0.5980 56999.9n 0.5980 57000.0n 0.2449 57299.9n 0.2449 57300.0n 0.5509 57599.9n 0.5509 57600.0n 0.5745 57899.9n 0.5745 57900.0n 0.5980 58199.9n 0.5980 58200.0n 0.5509 58499.9n 0.5509 58500.0n 0.5980 58799.9n 0.5980 58800.0n 0.5980 59099.9n 0.5980 59100.0n 0.5980)
Vxn3 a_xn3 0 PWL(0.0n 0.7786 299.9n 0.7786 300.0n 0.5197 599.9n 0.5197 600.0n 0.4020 899.9n 0.4020 900.0n 0.4726 1199.9n 0.4726 1200.0n 0.7786 1499.9n 0.7786 1500.0n 0.4961 1799.9n 0.4961 1800.0n 0.4491 2099.9n 0.4491 2100.0n 0.7786 2399.9n 0.7786 2400.0n 0.4020 2699.9n 0.4020 2700.0n 0.4255 2999.9n 0.4255 3000.0n 0.4255 3299.9n 0.4255 3300.0n 0.4491 3599.9n 0.4491 3600.0n 0.6845 3899.9n 0.6845 3900.0n 0.4491 4199.9n 0.4491 4200.0n 0.4255 4499.9n 0.4255 4500.0n 0.4020 4799.9n 0.4020 4800.0n 0.4961 5099.9n 0.4961 5100.0n 0.7786 5399.9n 0.7786 5400.0n 0.7786 5699.9n 0.7786 5700.0n 0.5197 5999.9n 0.5197 6000.0n 0.4020 6299.9n 0.4020 6300.0n 0.4726 6599.9n 0.4726 6600.0n 0.7786 6899.9n 0.7786 6900.0n 0.4961 7199.9n 0.4961 7200.0n 0.4491 7499.9n 0.4491 7500.0n 0.7786 7799.9n 0.7786 7800.0n 0.4020 8099.9n 0.4020 8100.0n 0.4255 8399.9n 0.4255 8400.0n 0.4255 8699.9n 0.4255 8700.0n 0.4491 8999.9n 0.4491 9000.0n 0.6845 9299.9n 0.6845 9300.0n 0.4491 9599.9n 0.4491 9600.0n 0.4255 9899.9n 0.4255 9900.0n 0.4020 10199.9n 0.4020 10200.0n 0.4961 10499.9n 0.4961 10500.0n 0.7786 10799.9n 0.7786 10800.0n 0.7786 11099.9n 0.7786 11100.0n 0.5197 11399.9n 0.5197 11400.0n 0.4020 11699.9n 0.4020 11700.0n 0.4726 11999.9n 0.4726 12000.0n 0.7786 12299.9n 0.7786 12300.0n 0.4961 12599.9n 0.4961 12600.0n 0.4491 12899.9n 0.4491 12900.0n 0.7786 13199.9n 0.7786 13200.0n 0.4020 13499.9n 0.4020 13500.0n 0.4255 13799.9n 0.4255 13800.0n 0.4255 14099.9n 0.4255 14100.0n 0.4491 14399.9n 0.4491 14400.0n 0.6845 14699.9n 0.6845 14700.0n 0.4491 14999.9n 0.4491 15000.0n 0.4255 15299.9n 0.4255 15300.0n 0.4020 15599.9n 0.4020 15600.0n 0.4961 15899.9n 0.4961 15900.0n 0.7786 16199.9n 0.7786 16200.0n 0.7786 16499.9n 0.7786 16500.0n 0.5197 16799.9n 0.5197 16800.0n 0.4020 17099.9n 0.4020 17100.0n 0.4726 17399.9n 0.4726 17400.0n 0.7786 17699.9n 0.7786 17700.0n 0.4961 17999.9n 0.4961 18000.0n 0.4491 18299.9n 0.4491 18300.0n 0.7786 18599.9n 0.7786 18600.0n 0.4020 18899.9n 0.4020 18900.0n 0.4255 19199.9n 0.4255 19200.0n 0.4255 19499.9n 0.4255 19500.0n 0.4491 19799.9n 0.4491 19800.0n 0.6845 20099.9n 0.6845 20100.0n 0.4491 20399.9n 0.4491 20400.0n 0.4255 20699.9n 0.4255 20700.0n 0.4020 20999.9n 0.4020 21000.0n 0.4961 21299.9n 0.4961 21300.0n 0.7786 21599.9n 0.7786 21600.0n 0.7786 21899.9n 0.7786 21900.0n 0.5197 22199.9n 0.5197 22200.0n 0.4020 22499.9n 0.4020 22500.0n 0.4726 22799.9n 0.4726 22800.0n 0.7786 23099.9n 0.7786 23100.0n 0.4961 23399.9n 0.4961 23400.0n 0.4491 23699.9n 0.4491 23700.0n 0.7786 23999.9n 0.7786 24000.0n 0.4020 24299.9n 0.4020 24300.0n 0.4255 24599.9n 0.4255 24600.0n 0.4255 24899.9n 0.4255 24900.0n 0.4491 25199.9n 0.4491 25200.0n 0.6845 25499.9n 0.6845 25500.0n 0.4491 25799.9n 0.4491 25800.0n 0.4255 26099.9n 0.4255 26100.0n 0.4020 26399.9n 0.4020 26400.0n 0.4961 26699.9n 0.4961 26700.0n 0.7786 26999.9n 0.7786 27000.0n 0.7786 27299.9n 0.7786 27300.0n 0.5197 27599.9n 0.5197 27600.0n 0.4020 27899.9n 0.4020 27900.0n 0.4726 28199.9n 0.4726 28200.0n 0.7786 28499.9n 0.7786 28500.0n 0.4961 28799.9n 0.4961 28800.0n 0.4491 29099.9n 0.4491 29100.0n 0.7786 29399.9n 0.7786 29400.0n 0.4020 29699.9n 0.4020 29700.0n 0.4255 29999.9n 0.4255 30000.0n 0.4255 30299.9n 0.4255 30300.0n 0.4491 30599.9n 0.4491 30600.0n 0.6845 30899.9n 0.6845 30900.0n 0.4491 31199.9n 0.4491 31200.0n 0.4255 31499.9n 0.4255 31500.0n 0.4020 31799.9n 0.4020 31800.0n 0.4961 32099.9n 0.4961 32100.0n 0.7786 32399.9n 0.7786 32400.0n 0.7786 32699.9n 0.7786 32700.0n 0.5197 32999.9n 0.5197 33000.0n 0.4020 33299.9n 0.4020 33300.0n 0.4726 33599.9n 0.4726 33600.0n 0.7786 33899.9n 0.7786 33900.0n 0.4961 34199.9n 0.4961 34200.0n 0.4491 34499.9n 0.4491 34500.0n 0.7786 34799.9n 0.7786 34800.0n 0.4020 35099.9n 0.4020 35100.0n 0.4255 35399.9n 0.4255 35400.0n 0.4255 35699.9n 0.4255 35700.0n 0.4491 35999.9n 0.4491 36000.0n 0.6845 36299.9n 0.6845 36300.0n 0.4491 36599.9n 0.4491 36600.0n 0.4255 36899.9n 0.4255 36900.0n 0.4020 37199.9n 0.4020 37200.0n 0.4961 37499.9n 0.4961 37500.0n 0.7786 37799.9n 0.7786 37800.0n 0.7786 38099.9n 0.7786 38100.0n 0.5197 38399.9n 0.5197 38400.0n 0.4020 38699.9n 0.4020 38700.0n 0.4726 38999.9n 0.4726 39000.0n 0.7786 39299.9n 0.7786 39300.0n 0.4961 39599.9n 0.4961 39600.0n 0.4491 39899.9n 0.4491 39900.0n 0.7786 40199.9n 0.7786 40200.0n 0.4020 40499.9n 0.4020 40500.0n 0.4255 40799.9n 0.4255 40800.0n 0.4255 41099.9n 0.4255 41100.0n 0.4491 41399.9n 0.4491 41400.0n 0.6845 41699.9n 0.6845 41700.0n 0.4491 41999.9n 0.4491 42000.0n 0.4255 42299.9n 0.4255 42300.0n 0.4020 42599.9n 0.4020 42600.0n 0.4961 42899.9n 0.4961 42900.0n 0.7786 43199.9n 0.7786 43200.0n 0.7786 43499.9n 0.7786 43500.0n 0.5197 43799.9n 0.5197 43800.0n 0.4020 44099.9n 0.4020 44100.0n 0.4726 44399.9n 0.4726 44400.0n 0.7786 44699.9n 0.7786 44700.0n 0.4961 44999.9n 0.4961 45000.0n 0.4491 45299.9n 0.4491 45300.0n 0.7786 45599.9n 0.7786 45600.0n 0.4020 45899.9n 0.4020 45900.0n 0.4255 46199.9n 0.4255 46200.0n 0.4255 46499.9n 0.4255 46500.0n 0.4491 46799.9n 0.4491 46800.0n 0.6845 47099.9n 0.6845 47100.0n 0.4491 47399.9n 0.4491 47400.0n 0.4255 47699.9n 0.4255 47700.0n 0.4020 47999.9n 0.4020 48000.0n 0.4961 48299.9n 0.4961 48300.0n 0.7786 48599.9n 0.7786 48600.0n 0.7786 48899.9n 0.7786 48900.0n 0.5197 49199.9n 0.5197 49200.0n 0.4020 49499.9n 0.4020 49500.0n 0.4726 49799.9n 0.4726 49800.0n 0.7786 50099.9n 0.7786 50100.0n 0.4961 50399.9n 0.4961 50400.0n 0.4491 50699.9n 0.4491 50700.0n 0.7786 50999.9n 0.7786 51000.0n 0.4020 51299.9n 0.4020 51300.0n 0.4255 51599.9n 0.4255 51600.0n 0.4255 51899.9n 0.4255 51900.0n 0.4491 52199.9n 0.4491 52200.0n 0.6845 52499.9n 0.6845 52500.0n 0.4491 52799.9n 0.4491 52800.0n 0.4255 53099.9n 0.4255 53100.0n 0.4020 53399.9n 0.4020 53400.0n 0.4961 53699.9n 0.4961 53700.0n 0.7786 53999.9n 0.7786 54000.0n 0.4491 54299.9n 0.4491 54300.0n 0.4255 54599.9n 0.4255 54600.0n 0.4491 54899.9n 0.4491 54900.0n 0.4961 55199.9n 0.4961 55200.0n 0.5197 55499.9n 0.5197 55500.0n 0.5432 55799.9n 0.5432 55800.0n 0.4020 56099.9n 0.4020 56100.0n 0.4961 56399.9n 0.4961 56400.0n 0.7786 56699.9n 0.7786 56700.0n 0.4020 56999.9n 0.4020 57000.0n 0.7551 57299.9n 0.7551 57300.0n 0.4491 57599.9n 0.4491 57600.0n 0.4255 57899.9n 0.4255 57900.0n 0.4020 58199.9n 0.4020 58200.0n 0.4491 58499.9n 0.4491 58500.0n 0.4020 58799.9n 0.4020 58800.0n 0.4020 59099.9n 0.4020 59100.0n 0.4020)
Vxp4 a_xp4 0 PWL(0.0n 0.3869 299.9n 0.3869 300.0n 0.4569 599.9n 0.4569 600.0n 0.5035 899.9n 0.5035 900.0n 0.5735 1199.9n 0.5735 1200.0n 0.5269 1499.9n 0.5269 1500.0n 0.2469 1799.9n 0.2469 1800.0n 0.5269 2099.9n 0.5269 2100.0n 0.3402 2399.9n 0.3402 2400.0n 0.5035 2699.9n 0.5035 2700.0n 0.3636 2999.9n 0.3636 3000.0n 0.2936 3299.9n 0.2936 3300.0n 0.4102 3599.9n 0.4102 3600.0n 0.5735 3899.9n 0.5735 3900.0n 0.4569 4199.9n 0.4569 4200.0n 0.2702 4499.9n 0.2702 4500.0n 0.4569 4799.9n 0.4569 4800.0n 0.3869 5099.9n 0.3869 5100.0n 0.3869 5399.9n 0.3869 5400.0n 0.3869 5699.9n 0.3869 5700.0n 0.4569 5999.9n 0.4569 6000.0n 0.5035 6299.9n 0.5035 6300.0n 0.5735 6599.9n 0.5735 6600.0n 0.5269 6899.9n 0.5269 6900.0n 0.2469 7199.9n 0.2469 7200.0n 0.5269 7499.9n 0.5269 7500.0n 0.3402 7799.9n 0.3402 7800.0n 0.5035 8099.9n 0.5035 8100.0n 0.3636 8399.9n 0.3636 8400.0n 0.2936 8699.9n 0.2936 8700.0n 0.4102 8999.9n 0.4102 9000.0n 0.5735 9299.9n 0.5735 9300.0n 0.4569 9599.9n 0.4569 9600.0n 0.2702 9899.9n 0.2702 9900.0n 0.4569 10199.9n 0.4569 10200.0n 0.3869 10499.9n 0.3869 10500.0n 0.3869 10799.9n 0.3869 10800.0n 0.3869 11099.9n 0.3869 11100.0n 0.4569 11399.9n 0.4569 11400.0n 0.5035 11699.9n 0.5035 11700.0n 0.5735 11999.9n 0.5735 12000.0n 0.5269 12299.9n 0.5269 12300.0n 0.2469 12599.9n 0.2469 12600.0n 0.5269 12899.9n 0.5269 12900.0n 0.3402 13199.9n 0.3402 13200.0n 0.5035 13499.9n 0.5035 13500.0n 0.3636 13799.9n 0.3636 13800.0n 0.2936 14099.9n 0.2936 14100.0n 0.4102 14399.9n 0.4102 14400.0n 0.5735 14699.9n 0.5735 14700.0n 0.4569 14999.9n 0.4569 15000.0n 0.2702 15299.9n 0.2702 15300.0n 0.4569 15599.9n 0.4569 15600.0n 0.3869 15899.9n 0.3869 15900.0n 0.3869 16199.9n 0.3869 16200.0n 0.3869 16499.9n 0.3869 16500.0n 0.4569 16799.9n 0.4569 16800.0n 0.5035 17099.9n 0.5035 17100.0n 0.5735 17399.9n 0.5735 17400.0n 0.5269 17699.9n 0.5269 17700.0n 0.2469 17999.9n 0.2469 18000.0n 0.5269 18299.9n 0.5269 18300.0n 0.3402 18599.9n 0.3402 18600.0n 0.5035 18899.9n 0.5035 18900.0n 0.3636 19199.9n 0.3636 19200.0n 0.2936 19499.9n 0.2936 19500.0n 0.4102 19799.9n 0.4102 19800.0n 0.5735 20099.9n 0.5735 20100.0n 0.4569 20399.9n 0.4569 20400.0n 0.2702 20699.9n 0.2702 20700.0n 0.4569 20999.9n 0.4569 21000.0n 0.3869 21299.9n 0.3869 21300.0n 0.3869 21599.9n 0.3869 21600.0n 0.3869 21899.9n 0.3869 21900.0n 0.4569 22199.9n 0.4569 22200.0n 0.5035 22499.9n 0.5035 22500.0n 0.5735 22799.9n 0.5735 22800.0n 0.5269 23099.9n 0.5269 23100.0n 0.2469 23399.9n 0.2469 23400.0n 0.5269 23699.9n 0.5269 23700.0n 0.3402 23999.9n 0.3402 24000.0n 0.5035 24299.9n 0.5035 24300.0n 0.3636 24599.9n 0.3636 24600.0n 0.2936 24899.9n 0.2936 24900.0n 0.4102 25199.9n 0.4102 25200.0n 0.5735 25499.9n 0.5735 25500.0n 0.4569 25799.9n 0.4569 25800.0n 0.2702 26099.9n 0.2702 26100.0n 0.4569 26399.9n 0.4569 26400.0n 0.3869 26699.9n 0.3869 26700.0n 0.3869 26999.9n 0.3869 27000.0n 0.3869 27299.9n 0.3869 27300.0n 0.4569 27599.9n 0.4569 27600.0n 0.5035 27899.9n 0.5035 27900.0n 0.5735 28199.9n 0.5735 28200.0n 0.5269 28499.9n 0.5269 28500.0n 0.2469 28799.9n 0.2469 28800.0n 0.5269 29099.9n 0.5269 29100.0n 0.3402 29399.9n 0.3402 29400.0n 0.5035 29699.9n 0.5035 29700.0n 0.3636 29999.9n 0.3636 30000.0n 0.2936 30299.9n 0.2936 30300.0n 0.4102 30599.9n 0.4102 30600.0n 0.5735 30899.9n 0.5735 30900.0n 0.4569 31199.9n 0.4569 31200.0n 0.2702 31499.9n 0.2702 31500.0n 0.4569 31799.9n 0.4569 31800.0n 0.3869 32099.9n 0.3869 32100.0n 0.3869 32399.9n 0.3869 32400.0n 0.3869 32699.9n 0.3869 32700.0n 0.4569 32999.9n 0.4569 33000.0n 0.5035 33299.9n 0.5035 33300.0n 0.5735 33599.9n 0.5735 33600.0n 0.5269 33899.9n 0.5269 33900.0n 0.2469 34199.9n 0.2469 34200.0n 0.5269 34499.9n 0.5269 34500.0n 0.3402 34799.9n 0.3402 34800.0n 0.5035 35099.9n 0.5035 35100.0n 0.3636 35399.9n 0.3636 35400.0n 0.2936 35699.9n 0.2936 35700.0n 0.4102 35999.9n 0.4102 36000.0n 0.5735 36299.9n 0.5735 36300.0n 0.4569 36599.9n 0.4569 36600.0n 0.2702 36899.9n 0.2702 36900.0n 0.4569 37199.9n 0.4569 37200.0n 0.3869 37499.9n 0.3869 37500.0n 0.3869 37799.9n 0.3869 37800.0n 0.3869 38099.9n 0.3869 38100.0n 0.4569 38399.9n 0.4569 38400.0n 0.5035 38699.9n 0.5035 38700.0n 0.5735 38999.9n 0.5735 39000.0n 0.5269 39299.9n 0.5269 39300.0n 0.2469 39599.9n 0.2469 39600.0n 0.5269 39899.9n 0.5269 39900.0n 0.3402 40199.9n 0.3402 40200.0n 0.5035 40499.9n 0.5035 40500.0n 0.3636 40799.9n 0.3636 40800.0n 0.2936 41099.9n 0.2936 41100.0n 0.4102 41399.9n 0.4102 41400.0n 0.5735 41699.9n 0.5735 41700.0n 0.4569 41999.9n 0.4569 42000.0n 0.2702 42299.9n 0.2702 42300.0n 0.4569 42599.9n 0.4569 42600.0n 0.3869 42899.9n 0.3869 42900.0n 0.3869 43199.9n 0.3869 43200.0n 0.3869 43499.9n 0.3869 43500.0n 0.4569 43799.9n 0.4569 43800.0n 0.5035 44099.9n 0.5035 44100.0n 0.5735 44399.9n 0.5735 44400.0n 0.5269 44699.9n 0.5269 44700.0n 0.2469 44999.9n 0.2469 45000.0n 0.5269 45299.9n 0.5269 45300.0n 0.3402 45599.9n 0.3402 45600.0n 0.5035 45899.9n 0.5035 45900.0n 0.3636 46199.9n 0.3636 46200.0n 0.2936 46499.9n 0.2936 46500.0n 0.4102 46799.9n 0.4102 46800.0n 0.5735 47099.9n 0.5735 47100.0n 0.4569 47399.9n 0.4569 47400.0n 0.2702 47699.9n 0.2702 47700.0n 0.4569 47999.9n 0.4569 48000.0n 0.3869 48299.9n 0.3869 48300.0n 0.3869 48599.9n 0.3869 48600.0n 0.3869 48899.9n 0.3869 48900.0n 0.4569 49199.9n 0.4569 49200.0n 0.5035 49499.9n 0.5035 49500.0n 0.5735 49799.9n 0.5735 49800.0n 0.5269 50099.9n 0.5269 50100.0n 0.2469 50399.9n 0.2469 50400.0n 0.5269 50699.9n 0.5269 50700.0n 0.3402 50999.9n 0.3402 51000.0n 0.5035 51299.9n 0.5035 51300.0n 0.3636 51599.9n 0.3636 51600.0n 0.2936 51899.9n 0.2936 51900.0n 0.4102 52199.9n 0.4102 52200.0n 0.5735 52499.9n 0.5735 52500.0n 0.4569 52799.9n 0.4569 52800.0n 0.2702 53099.9n 0.2702 53100.0n 0.4569 53399.9n 0.4569 53400.0n 0.3869 53699.9n 0.3869 53700.0n 0.3869 53999.9n 0.3869 54000.0n 0.4336 54299.9n 0.4336 54300.0n 0.5269 54599.9n 0.5269 54600.0n 0.5502 54899.9n 0.5502 54900.0n 0.5502 55199.9n 0.5502 55200.0n 0.3869 55499.9n 0.3869 55500.0n 0.5735 55799.9n 0.5735 55800.0n 0.4802 56099.9n 0.4802 56100.0n 0.4569 56399.9n 0.4569 56400.0n 0.4802 56699.9n 0.4802 56700.0n 0.3402 56999.9n 0.3402 57000.0n 0.5502 57299.9n 0.5502 57300.0n 0.5735 57599.9n 0.5735 57600.0n 0.2702 57899.9n 0.2702 57900.0n 0.5269 58199.9n 0.5269 58200.0n 0.4102 58499.9n 0.4102 58500.0n 0.5735 58799.9n 0.5735 58800.0n 0.4102 59099.9n 0.4102 59100.0n 0.5969)
Vxn4 a_xn4 0 PWL(0.0n 0.6131 299.9n 0.6131 300.0n 0.5431 599.9n 0.5431 600.0n 0.4965 899.9n 0.4965 900.0n 0.4265 1199.9n 0.4265 1200.0n 0.4731 1499.9n 0.4731 1500.0n 0.7531 1799.9n 0.7531 1800.0n 0.4731 2099.9n 0.4731 2100.0n 0.6598 2399.9n 0.6598 2400.0n 0.4965 2699.9n 0.4965 2700.0n 0.6364 2999.9n 0.6364 3000.0n 0.7064 3299.9n 0.7064 3300.0n 0.5898 3599.9n 0.5898 3600.0n 0.4265 3899.9n 0.4265 3900.0n 0.5431 4199.9n 0.5431 4200.0n 0.7298 4499.9n 0.7298 4500.0n 0.5431 4799.9n 0.5431 4800.0n 0.6131 5099.9n 0.6131 5100.0n 0.6131 5399.9n 0.6131 5400.0n 0.6131 5699.9n 0.6131 5700.0n 0.5431 5999.9n 0.5431 6000.0n 0.4965 6299.9n 0.4965 6300.0n 0.4265 6599.9n 0.4265 6600.0n 0.4731 6899.9n 0.4731 6900.0n 0.7531 7199.9n 0.7531 7200.0n 0.4731 7499.9n 0.4731 7500.0n 0.6598 7799.9n 0.6598 7800.0n 0.4965 8099.9n 0.4965 8100.0n 0.6364 8399.9n 0.6364 8400.0n 0.7064 8699.9n 0.7064 8700.0n 0.5898 8999.9n 0.5898 9000.0n 0.4265 9299.9n 0.4265 9300.0n 0.5431 9599.9n 0.5431 9600.0n 0.7298 9899.9n 0.7298 9900.0n 0.5431 10199.9n 0.5431 10200.0n 0.6131 10499.9n 0.6131 10500.0n 0.6131 10799.9n 0.6131 10800.0n 0.6131 11099.9n 0.6131 11100.0n 0.5431 11399.9n 0.5431 11400.0n 0.4965 11699.9n 0.4965 11700.0n 0.4265 11999.9n 0.4265 12000.0n 0.4731 12299.9n 0.4731 12300.0n 0.7531 12599.9n 0.7531 12600.0n 0.4731 12899.9n 0.4731 12900.0n 0.6598 13199.9n 0.6598 13200.0n 0.4965 13499.9n 0.4965 13500.0n 0.6364 13799.9n 0.6364 13800.0n 0.7064 14099.9n 0.7064 14100.0n 0.5898 14399.9n 0.5898 14400.0n 0.4265 14699.9n 0.4265 14700.0n 0.5431 14999.9n 0.5431 15000.0n 0.7298 15299.9n 0.7298 15300.0n 0.5431 15599.9n 0.5431 15600.0n 0.6131 15899.9n 0.6131 15900.0n 0.6131 16199.9n 0.6131 16200.0n 0.6131 16499.9n 0.6131 16500.0n 0.5431 16799.9n 0.5431 16800.0n 0.4965 17099.9n 0.4965 17100.0n 0.4265 17399.9n 0.4265 17400.0n 0.4731 17699.9n 0.4731 17700.0n 0.7531 17999.9n 0.7531 18000.0n 0.4731 18299.9n 0.4731 18300.0n 0.6598 18599.9n 0.6598 18600.0n 0.4965 18899.9n 0.4965 18900.0n 0.6364 19199.9n 0.6364 19200.0n 0.7064 19499.9n 0.7064 19500.0n 0.5898 19799.9n 0.5898 19800.0n 0.4265 20099.9n 0.4265 20100.0n 0.5431 20399.9n 0.5431 20400.0n 0.7298 20699.9n 0.7298 20700.0n 0.5431 20999.9n 0.5431 21000.0n 0.6131 21299.9n 0.6131 21300.0n 0.6131 21599.9n 0.6131 21600.0n 0.6131 21899.9n 0.6131 21900.0n 0.5431 22199.9n 0.5431 22200.0n 0.4965 22499.9n 0.4965 22500.0n 0.4265 22799.9n 0.4265 22800.0n 0.4731 23099.9n 0.4731 23100.0n 0.7531 23399.9n 0.7531 23400.0n 0.4731 23699.9n 0.4731 23700.0n 0.6598 23999.9n 0.6598 24000.0n 0.4965 24299.9n 0.4965 24300.0n 0.6364 24599.9n 0.6364 24600.0n 0.7064 24899.9n 0.7064 24900.0n 0.5898 25199.9n 0.5898 25200.0n 0.4265 25499.9n 0.4265 25500.0n 0.5431 25799.9n 0.5431 25800.0n 0.7298 26099.9n 0.7298 26100.0n 0.5431 26399.9n 0.5431 26400.0n 0.6131 26699.9n 0.6131 26700.0n 0.6131 26999.9n 0.6131 27000.0n 0.6131 27299.9n 0.6131 27300.0n 0.5431 27599.9n 0.5431 27600.0n 0.4965 27899.9n 0.4965 27900.0n 0.4265 28199.9n 0.4265 28200.0n 0.4731 28499.9n 0.4731 28500.0n 0.7531 28799.9n 0.7531 28800.0n 0.4731 29099.9n 0.4731 29100.0n 0.6598 29399.9n 0.6598 29400.0n 0.4965 29699.9n 0.4965 29700.0n 0.6364 29999.9n 0.6364 30000.0n 0.7064 30299.9n 0.7064 30300.0n 0.5898 30599.9n 0.5898 30600.0n 0.4265 30899.9n 0.4265 30900.0n 0.5431 31199.9n 0.5431 31200.0n 0.7298 31499.9n 0.7298 31500.0n 0.5431 31799.9n 0.5431 31800.0n 0.6131 32099.9n 0.6131 32100.0n 0.6131 32399.9n 0.6131 32400.0n 0.6131 32699.9n 0.6131 32700.0n 0.5431 32999.9n 0.5431 33000.0n 0.4965 33299.9n 0.4965 33300.0n 0.4265 33599.9n 0.4265 33600.0n 0.4731 33899.9n 0.4731 33900.0n 0.7531 34199.9n 0.7531 34200.0n 0.4731 34499.9n 0.4731 34500.0n 0.6598 34799.9n 0.6598 34800.0n 0.4965 35099.9n 0.4965 35100.0n 0.6364 35399.9n 0.6364 35400.0n 0.7064 35699.9n 0.7064 35700.0n 0.5898 35999.9n 0.5898 36000.0n 0.4265 36299.9n 0.4265 36300.0n 0.5431 36599.9n 0.5431 36600.0n 0.7298 36899.9n 0.7298 36900.0n 0.5431 37199.9n 0.5431 37200.0n 0.6131 37499.9n 0.6131 37500.0n 0.6131 37799.9n 0.6131 37800.0n 0.6131 38099.9n 0.6131 38100.0n 0.5431 38399.9n 0.5431 38400.0n 0.4965 38699.9n 0.4965 38700.0n 0.4265 38999.9n 0.4265 39000.0n 0.4731 39299.9n 0.4731 39300.0n 0.7531 39599.9n 0.7531 39600.0n 0.4731 39899.9n 0.4731 39900.0n 0.6598 40199.9n 0.6598 40200.0n 0.4965 40499.9n 0.4965 40500.0n 0.6364 40799.9n 0.6364 40800.0n 0.7064 41099.9n 0.7064 41100.0n 0.5898 41399.9n 0.5898 41400.0n 0.4265 41699.9n 0.4265 41700.0n 0.5431 41999.9n 0.5431 42000.0n 0.7298 42299.9n 0.7298 42300.0n 0.5431 42599.9n 0.5431 42600.0n 0.6131 42899.9n 0.6131 42900.0n 0.6131 43199.9n 0.6131 43200.0n 0.6131 43499.9n 0.6131 43500.0n 0.5431 43799.9n 0.5431 43800.0n 0.4965 44099.9n 0.4965 44100.0n 0.4265 44399.9n 0.4265 44400.0n 0.4731 44699.9n 0.4731 44700.0n 0.7531 44999.9n 0.7531 45000.0n 0.4731 45299.9n 0.4731 45300.0n 0.6598 45599.9n 0.6598 45600.0n 0.4965 45899.9n 0.4965 45900.0n 0.6364 46199.9n 0.6364 46200.0n 0.7064 46499.9n 0.7064 46500.0n 0.5898 46799.9n 0.5898 46800.0n 0.4265 47099.9n 0.4265 47100.0n 0.5431 47399.9n 0.5431 47400.0n 0.7298 47699.9n 0.7298 47700.0n 0.5431 47999.9n 0.5431 48000.0n 0.6131 48299.9n 0.6131 48300.0n 0.6131 48599.9n 0.6131 48600.0n 0.6131 48899.9n 0.6131 48900.0n 0.5431 49199.9n 0.5431 49200.0n 0.4965 49499.9n 0.4965 49500.0n 0.4265 49799.9n 0.4265 49800.0n 0.4731 50099.9n 0.4731 50100.0n 0.7531 50399.9n 0.7531 50400.0n 0.4731 50699.9n 0.4731 50700.0n 0.6598 50999.9n 0.6598 51000.0n 0.4965 51299.9n 0.4965 51300.0n 0.6364 51599.9n 0.6364 51600.0n 0.7064 51899.9n 0.7064 51900.0n 0.5898 52199.9n 0.5898 52200.0n 0.4265 52499.9n 0.4265 52500.0n 0.5431 52799.9n 0.5431 52800.0n 0.7298 53099.9n 0.7298 53100.0n 0.5431 53399.9n 0.5431 53400.0n 0.6131 53699.9n 0.6131 53700.0n 0.6131 53999.9n 0.6131 54000.0n 0.5664 54299.9n 0.5664 54300.0n 0.4731 54599.9n 0.4731 54600.0n 0.4498 54899.9n 0.4498 54900.0n 0.4498 55199.9n 0.4498 55200.0n 0.6131 55499.9n 0.6131 55500.0n 0.4265 55799.9n 0.4265 55800.0n 0.5198 56099.9n 0.5198 56100.0n 0.5431 56399.9n 0.5431 56400.0n 0.5198 56699.9n 0.5198 56700.0n 0.6598 56999.9n 0.6598 57000.0n 0.4498 57299.9n 0.4498 57300.0n 0.4265 57599.9n 0.4265 57600.0n 0.7298 57899.9n 0.7298 57900.0n 0.4731 58199.9n 0.4731 58200.0n 0.5898 58499.9n 0.5898 58500.0n 0.4265 58799.9n 0.4265 58800.0n 0.5898 59099.9n 0.5898 59100.0n 0.4031)
Vxp5 a_xp5 0 PWL(0.0n 0.6451 299.9n 0.6451 300.0n 0.4156 599.9n 0.4156 600.0n 0.4156 899.9n 0.4156 900.0n 0.5215 1199.9n 0.5215 1200.0n 0.6804 1499.9n 0.6804 1500.0n 0.5039 1799.9n 0.5039 1800.0n 0.4509 2099.9n 0.4509 2100.0n 0.6627 2399.9n 0.6627 2400.0n 0.3979 2699.9n 0.3979 2700.0n 0.3979 2999.9n 0.3979 3000.0n 0.3979 3299.9n 0.3979 3300.0n 0.4156 3599.9n 0.4156 3600.0n 0.6098 3899.9n 0.6098 3900.0n 0.3979 4199.9n 0.3979 4200.0n 0.3979 4499.9n 0.3979 4500.0n 0.3979 4799.9n 0.3979 4800.0n 0.3979 5099.9n 0.3979 5100.0n 0.6627 5399.9n 0.6627 5400.0n 0.6451 5699.9n 0.6451 5700.0n 0.4156 5999.9n 0.4156 6000.0n 0.4156 6299.9n 0.4156 6300.0n 0.5215 6599.9n 0.5215 6600.0n 0.6804 6899.9n 0.6804 6900.0n 0.5039 7199.9n 0.5039 7200.0n 0.4509 7499.9n 0.4509 7500.0n 0.6627 7799.9n 0.6627 7800.0n 0.3979 8099.9n 0.3979 8100.0n 0.3979 8399.9n 0.3979 8400.0n 0.3979 8699.9n 0.3979 8700.0n 0.4156 8999.9n 0.4156 9000.0n 0.6098 9299.9n 0.6098 9300.0n 0.3979 9599.9n 0.3979 9600.0n 0.3979 9899.9n 0.3979 9900.0n 0.3979 10199.9n 0.3979 10200.0n 0.3979 10499.9n 0.3979 10500.0n 0.6627 10799.9n 0.6627 10800.0n 0.6451 11099.9n 0.6451 11100.0n 0.4156 11399.9n 0.4156 11400.0n 0.4156 11699.9n 0.4156 11700.0n 0.5215 11999.9n 0.5215 12000.0n 0.6804 12299.9n 0.6804 12300.0n 0.5039 12599.9n 0.5039 12600.0n 0.4509 12899.9n 0.4509 12900.0n 0.6627 13199.9n 0.6627 13200.0n 0.3979 13499.9n 0.3979 13500.0n 0.3979 13799.9n 0.3979 13800.0n 0.3979 14099.9n 0.3979 14100.0n 0.4156 14399.9n 0.4156 14400.0n 0.6098 14699.9n 0.6098 14700.0n 0.3979 14999.9n 0.3979 15000.0n 0.3979 15299.9n 0.3979 15300.0n 0.3979 15599.9n 0.3979 15600.0n 0.3979 15899.9n 0.3979 15900.0n 0.6627 16199.9n 0.6627 16200.0n 0.6451 16499.9n 0.6451 16500.0n 0.4156 16799.9n 0.4156 16800.0n 0.4156 17099.9n 0.4156 17100.0n 0.5215 17399.9n 0.5215 17400.0n 0.6804 17699.9n 0.6804 17700.0n 0.5039 17999.9n 0.5039 18000.0n 0.4509 18299.9n 0.4509 18300.0n 0.6627 18599.9n 0.6627 18600.0n 0.3979 18899.9n 0.3979 18900.0n 0.3979 19199.9n 0.3979 19200.0n 0.3979 19499.9n 0.3979 19500.0n 0.4156 19799.9n 0.4156 19800.0n 0.6098 20099.9n 0.6098 20100.0n 0.3979 20399.9n 0.3979 20400.0n 0.3979 20699.9n 0.3979 20700.0n 0.3979 20999.9n 0.3979 21000.0n 0.3979 21299.9n 0.3979 21300.0n 0.6627 21599.9n 0.6627 21600.0n 0.6451 21899.9n 0.6451 21900.0n 0.4156 22199.9n 0.4156 22200.0n 0.4156 22499.9n 0.4156 22500.0n 0.5215 22799.9n 0.5215 22800.0n 0.6804 23099.9n 0.6804 23100.0n 0.5039 23399.9n 0.5039 23400.0n 0.4509 23699.9n 0.4509 23700.0n 0.6627 23999.9n 0.6627 24000.0n 0.3979 24299.9n 0.3979 24300.0n 0.3979 24599.9n 0.3979 24600.0n 0.3979 24899.9n 0.3979 24900.0n 0.4156 25199.9n 0.4156 25200.0n 0.6098 25499.9n 0.6098 25500.0n 0.3979 25799.9n 0.3979 25800.0n 0.3979 26099.9n 0.3979 26100.0n 0.3979 26399.9n 0.3979 26400.0n 0.3979 26699.9n 0.3979 26700.0n 0.6627 26999.9n 0.6627 27000.0n 0.6451 27299.9n 0.6451 27300.0n 0.4156 27599.9n 0.4156 27600.0n 0.4156 27899.9n 0.4156 27900.0n 0.5215 28199.9n 0.5215 28200.0n 0.6804 28499.9n 0.6804 28500.0n 0.5039 28799.9n 0.5039 28800.0n 0.4509 29099.9n 0.4509 29100.0n 0.6627 29399.9n 0.6627 29400.0n 0.3979 29699.9n 0.3979 29700.0n 0.3979 29999.9n 0.3979 30000.0n 0.3979 30299.9n 0.3979 30300.0n 0.4156 30599.9n 0.4156 30600.0n 0.6098 30899.9n 0.6098 30900.0n 0.3979 31199.9n 0.3979 31200.0n 0.3979 31499.9n 0.3979 31500.0n 0.3979 31799.9n 0.3979 31800.0n 0.3979 32099.9n 0.3979 32100.0n 0.6627 32399.9n 0.6627 32400.0n 0.6451 32699.9n 0.6451 32700.0n 0.4156 32999.9n 0.4156 33000.0n 0.4156 33299.9n 0.4156 33300.0n 0.5215 33599.9n 0.5215 33600.0n 0.6804 33899.9n 0.6804 33900.0n 0.5039 34199.9n 0.5039 34200.0n 0.4509 34499.9n 0.4509 34500.0n 0.6627 34799.9n 0.6627 34800.0n 0.3979 35099.9n 0.3979 35100.0n 0.3979 35399.9n 0.3979 35400.0n 0.3979 35699.9n 0.3979 35700.0n 0.4156 35999.9n 0.4156 36000.0n 0.6098 36299.9n 0.6098 36300.0n 0.3979 36599.9n 0.3979 36600.0n 0.3979 36899.9n 0.3979 36900.0n 0.3979 37199.9n 0.3979 37200.0n 0.3979 37499.9n 0.3979 37500.0n 0.6627 37799.9n 0.6627 37800.0n 0.6451 38099.9n 0.6451 38100.0n 0.4156 38399.9n 0.4156 38400.0n 0.4156 38699.9n 0.4156 38700.0n 0.5215 38999.9n 0.5215 39000.0n 0.6804 39299.9n 0.6804 39300.0n 0.5039 39599.9n 0.5039 39600.0n 0.4509 39899.9n 0.4509 39900.0n 0.6627 40199.9n 0.6627 40200.0n 0.3979 40499.9n 0.3979 40500.0n 0.3979 40799.9n 0.3979 40800.0n 0.3979 41099.9n 0.3979 41100.0n 0.4156 41399.9n 0.4156 41400.0n 0.6098 41699.9n 0.6098 41700.0n 0.3979 41999.9n 0.3979 42000.0n 0.3979 42299.9n 0.3979 42300.0n 0.3979 42599.9n 0.3979 42600.0n 0.3979 42899.9n 0.3979 42900.0n 0.6627 43199.9n 0.6627 43200.0n 0.6451 43499.9n 0.6451 43500.0n 0.4156 43799.9n 0.4156 43800.0n 0.4156 44099.9n 0.4156 44100.0n 0.5215 44399.9n 0.5215 44400.0n 0.6804 44699.9n 0.6804 44700.0n 0.5039 44999.9n 0.5039 45000.0n 0.4509 45299.9n 0.4509 45300.0n 0.6627 45599.9n 0.6627 45600.0n 0.3979 45899.9n 0.3979 45900.0n 0.3979 46199.9n 0.3979 46200.0n 0.3979 46499.9n 0.3979 46500.0n 0.4156 46799.9n 0.4156 46800.0n 0.6098 47099.9n 0.6098 47100.0n 0.3979 47399.9n 0.3979 47400.0n 0.3979 47699.9n 0.3979 47700.0n 0.3979 47999.9n 0.3979 48000.0n 0.3979 48299.9n 0.3979 48300.0n 0.6627 48599.9n 0.6627 48600.0n 0.6451 48899.9n 0.6451 48900.0n 0.4156 49199.9n 0.4156 49200.0n 0.4156 49499.9n 0.4156 49500.0n 0.5215 49799.9n 0.5215 49800.0n 0.6804 50099.9n 0.6804 50100.0n 0.5039 50399.9n 0.5039 50400.0n 0.4509 50699.9n 0.4509 50700.0n 0.6627 50999.9n 0.6627 51000.0n 0.3979 51299.9n 0.3979 51300.0n 0.3979 51599.9n 0.3979 51600.0n 0.3979 51899.9n 0.3979 51900.0n 0.4156 52199.9n 0.4156 52200.0n 0.6098 52499.9n 0.6098 52500.0n 0.3979 52799.9n 0.3979 52800.0n 0.3979 53099.9n 0.3979 53100.0n 0.3979 53399.9n 0.3979 53400.0n 0.3979 53699.9n 0.3979 53700.0n 0.6627 53999.9n 0.6627 54000.0n 0.4156 54299.9n 0.4156 54300.0n 0.4509 54599.9n 0.4509 54600.0n 0.5039 54899.9n 0.5039 54900.0n 0.4862 55199.9n 0.4862 55200.0n 0.4156 55499.9n 0.4156 55500.0n 0.5215 55799.9n 0.5215 55800.0n 0.3979 56099.9n 0.3979 56100.0n 0.4509 56399.9n 0.4509 56400.0n 0.6098 56699.9n 0.6098 56700.0n 0.3979 56999.9n 0.3979 57000.0n 0.6274 57299.9n 0.6274 57300.0n 0.4685 57599.9n 0.4685 57600.0n 0.3979 57899.9n 0.3979 57900.0n 0.4332 58199.9n 0.4332 58200.0n 0.3979 58499.9n 0.3979 58500.0n 0.4332 58799.9n 0.4332 58800.0n 0.3979 59099.9n 0.3979 59100.0n 0.4862)
Vxn5 a_xn5 0 PWL(0.0n 0.3549 299.9n 0.3549 300.0n 0.5844 599.9n 0.5844 600.0n 0.5844 899.9n 0.5844 900.0n 0.4785 1199.9n 0.4785 1200.0n 0.3196 1499.9n 0.3196 1500.0n 0.4961 1799.9n 0.4961 1800.0n 0.5491 2099.9n 0.5491 2100.0n 0.3373 2399.9n 0.3373 2400.0n 0.6021 2699.9n 0.6021 2700.0n 0.6021 2999.9n 0.6021 3000.0n 0.6021 3299.9n 0.6021 3300.0n 0.5844 3599.9n 0.5844 3600.0n 0.3902 3899.9n 0.3902 3900.0n 0.6021 4199.9n 0.6021 4200.0n 0.6021 4499.9n 0.6021 4500.0n 0.6021 4799.9n 0.6021 4800.0n 0.6021 5099.9n 0.6021 5100.0n 0.3373 5399.9n 0.3373 5400.0n 0.3549 5699.9n 0.3549 5700.0n 0.5844 5999.9n 0.5844 6000.0n 0.5844 6299.9n 0.5844 6300.0n 0.4785 6599.9n 0.4785 6600.0n 0.3196 6899.9n 0.3196 6900.0n 0.4961 7199.9n 0.4961 7200.0n 0.5491 7499.9n 0.5491 7500.0n 0.3373 7799.9n 0.3373 7800.0n 0.6021 8099.9n 0.6021 8100.0n 0.6021 8399.9n 0.6021 8400.0n 0.6021 8699.9n 0.6021 8700.0n 0.5844 8999.9n 0.5844 9000.0n 0.3902 9299.9n 0.3902 9300.0n 0.6021 9599.9n 0.6021 9600.0n 0.6021 9899.9n 0.6021 9900.0n 0.6021 10199.9n 0.6021 10200.0n 0.6021 10499.9n 0.6021 10500.0n 0.3373 10799.9n 0.3373 10800.0n 0.3549 11099.9n 0.3549 11100.0n 0.5844 11399.9n 0.5844 11400.0n 0.5844 11699.9n 0.5844 11700.0n 0.4785 11999.9n 0.4785 12000.0n 0.3196 12299.9n 0.3196 12300.0n 0.4961 12599.9n 0.4961 12600.0n 0.5491 12899.9n 0.5491 12900.0n 0.3373 13199.9n 0.3373 13200.0n 0.6021 13499.9n 0.6021 13500.0n 0.6021 13799.9n 0.6021 13800.0n 0.6021 14099.9n 0.6021 14100.0n 0.5844 14399.9n 0.5844 14400.0n 0.3902 14699.9n 0.3902 14700.0n 0.6021 14999.9n 0.6021 15000.0n 0.6021 15299.9n 0.6021 15300.0n 0.6021 15599.9n 0.6021 15600.0n 0.6021 15899.9n 0.6021 15900.0n 0.3373 16199.9n 0.3373 16200.0n 0.3549 16499.9n 0.3549 16500.0n 0.5844 16799.9n 0.5844 16800.0n 0.5844 17099.9n 0.5844 17100.0n 0.4785 17399.9n 0.4785 17400.0n 0.3196 17699.9n 0.3196 17700.0n 0.4961 17999.9n 0.4961 18000.0n 0.5491 18299.9n 0.5491 18300.0n 0.3373 18599.9n 0.3373 18600.0n 0.6021 18899.9n 0.6021 18900.0n 0.6021 19199.9n 0.6021 19200.0n 0.6021 19499.9n 0.6021 19500.0n 0.5844 19799.9n 0.5844 19800.0n 0.3902 20099.9n 0.3902 20100.0n 0.6021 20399.9n 0.6021 20400.0n 0.6021 20699.9n 0.6021 20700.0n 0.6021 20999.9n 0.6021 21000.0n 0.6021 21299.9n 0.6021 21300.0n 0.3373 21599.9n 0.3373 21600.0n 0.3549 21899.9n 0.3549 21900.0n 0.5844 22199.9n 0.5844 22200.0n 0.5844 22499.9n 0.5844 22500.0n 0.4785 22799.9n 0.4785 22800.0n 0.3196 23099.9n 0.3196 23100.0n 0.4961 23399.9n 0.4961 23400.0n 0.5491 23699.9n 0.5491 23700.0n 0.3373 23999.9n 0.3373 24000.0n 0.6021 24299.9n 0.6021 24300.0n 0.6021 24599.9n 0.6021 24600.0n 0.6021 24899.9n 0.6021 24900.0n 0.5844 25199.9n 0.5844 25200.0n 0.3902 25499.9n 0.3902 25500.0n 0.6021 25799.9n 0.6021 25800.0n 0.6021 26099.9n 0.6021 26100.0n 0.6021 26399.9n 0.6021 26400.0n 0.6021 26699.9n 0.6021 26700.0n 0.3373 26999.9n 0.3373 27000.0n 0.3549 27299.9n 0.3549 27300.0n 0.5844 27599.9n 0.5844 27600.0n 0.5844 27899.9n 0.5844 27900.0n 0.4785 28199.9n 0.4785 28200.0n 0.3196 28499.9n 0.3196 28500.0n 0.4961 28799.9n 0.4961 28800.0n 0.5491 29099.9n 0.5491 29100.0n 0.3373 29399.9n 0.3373 29400.0n 0.6021 29699.9n 0.6021 29700.0n 0.6021 29999.9n 0.6021 30000.0n 0.6021 30299.9n 0.6021 30300.0n 0.5844 30599.9n 0.5844 30600.0n 0.3902 30899.9n 0.3902 30900.0n 0.6021 31199.9n 0.6021 31200.0n 0.6021 31499.9n 0.6021 31500.0n 0.6021 31799.9n 0.6021 31800.0n 0.6021 32099.9n 0.6021 32100.0n 0.3373 32399.9n 0.3373 32400.0n 0.3549 32699.9n 0.3549 32700.0n 0.5844 32999.9n 0.5844 33000.0n 0.5844 33299.9n 0.5844 33300.0n 0.4785 33599.9n 0.4785 33600.0n 0.3196 33899.9n 0.3196 33900.0n 0.4961 34199.9n 0.4961 34200.0n 0.5491 34499.9n 0.5491 34500.0n 0.3373 34799.9n 0.3373 34800.0n 0.6021 35099.9n 0.6021 35100.0n 0.6021 35399.9n 0.6021 35400.0n 0.6021 35699.9n 0.6021 35700.0n 0.5844 35999.9n 0.5844 36000.0n 0.3902 36299.9n 0.3902 36300.0n 0.6021 36599.9n 0.6021 36600.0n 0.6021 36899.9n 0.6021 36900.0n 0.6021 37199.9n 0.6021 37200.0n 0.6021 37499.9n 0.6021 37500.0n 0.3373 37799.9n 0.3373 37800.0n 0.3549 38099.9n 0.3549 38100.0n 0.5844 38399.9n 0.5844 38400.0n 0.5844 38699.9n 0.5844 38700.0n 0.4785 38999.9n 0.4785 39000.0n 0.3196 39299.9n 0.3196 39300.0n 0.4961 39599.9n 0.4961 39600.0n 0.5491 39899.9n 0.5491 39900.0n 0.3373 40199.9n 0.3373 40200.0n 0.6021 40499.9n 0.6021 40500.0n 0.6021 40799.9n 0.6021 40800.0n 0.6021 41099.9n 0.6021 41100.0n 0.5844 41399.9n 0.5844 41400.0n 0.3902 41699.9n 0.3902 41700.0n 0.6021 41999.9n 0.6021 42000.0n 0.6021 42299.9n 0.6021 42300.0n 0.6021 42599.9n 0.6021 42600.0n 0.6021 42899.9n 0.6021 42900.0n 0.3373 43199.9n 0.3373 43200.0n 0.3549 43499.9n 0.3549 43500.0n 0.5844 43799.9n 0.5844 43800.0n 0.5844 44099.9n 0.5844 44100.0n 0.4785 44399.9n 0.4785 44400.0n 0.3196 44699.9n 0.3196 44700.0n 0.4961 44999.9n 0.4961 45000.0n 0.5491 45299.9n 0.5491 45300.0n 0.3373 45599.9n 0.3373 45600.0n 0.6021 45899.9n 0.6021 45900.0n 0.6021 46199.9n 0.6021 46200.0n 0.6021 46499.9n 0.6021 46500.0n 0.5844 46799.9n 0.5844 46800.0n 0.3902 47099.9n 0.3902 47100.0n 0.6021 47399.9n 0.6021 47400.0n 0.6021 47699.9n 0.6021 47700.0n 0.6021 47999.9n 0.6021 48000.0n 0.6021 48299.9n 0.6021 48300.0n 0.3373 48599.9n 0.3373 48600.0n 0.3549 48899.9n 0.3549 48900.0n 0.5844 49199.9n 0.5844 49200.0n 0.5844 49499.9n 0.5844 49500.0n 0.4785 49799.9n 0.4785 49800.0n 0.3196 50099.9n 0.3196 50100.0n 0.4961 50399.9n 0.4961 50400.0n 0.5491 50699.9n 0.5491 50700.0n 0.3373 50999.9n 0.3373 51000.0n 0.6021 51299.9n 0.6021 51300.0n 0.6021 51599.9n 0.6021 51600.0n 0.6021 51899.9n 0.6021 51900.0n 0.5844 52199.9n 0.5844 52200.0n 0.3902 52499.9n 0.3902 52500.0n 0.6021 52799.9n 0.6021 52800.0n 0.6021 53099.9n 0.6021 53100.0n 0.6021 53399.9n 0.6021 53400.0n 0.6021 53699.9n 0.6021 53700.0n 0.3373 53999.9n 0.3373 54000.0n 0.5844 54299.9n 0.5844 54300.0n 0.5491 54599.9n 0.5491 54600.0n 0.4961 54899.9n 0.4961 54900.0n 0.5138 55199.9n 0.5138 55200.0n 0.5844 55499.9n 0.5844 55500.0n 0.4785 55799.9n 0.4785 55800.0n 0.6021 56099.9n 0.6021 56100.0n 0.5491 56399.9n 0.5491 56400.0n 0.3902 56699.9n 0.3902 56700.0n 0.6021 56999.9n 0.6021 57000.0n 0.3726 57299.9n 0.3726 57300.0n 0.5315 57599.9n 0.5315 57600.0n 0.6021 57899.9n 0.6021 57900.0n 0.5668 58199.9n 0.5668 58200.0n 0.6021 58499.9n 0.6021 58500.0n 0.5668 58799.9n 0.5668 58800.0n 0.6021 59099.9n 0.6021 59100.0n 0.5138)
Vxp6 a_xp6 0 PWL(0.0n 0.6696 299.9n 0.6696 300.0n 0.4590 599.9n 0.4590 600.0n 0.4590 899.9n 0.4590 900.0n 0.4891 1199.9n 0.4891 1200.0n 0.6395 1499.9n 0.6395 1500.0n 0.4590 1799.9n 0.4590 1800.0n 0.4590 2099.9n 0.4590 2100.0n 0.6395 2399.9n 0.6395 2400.0n 0.4590 2699.9n 0.4590 2700.0n 0.4590 2999.9n 0.4590 3000.0n 0.4590 3299.9n 0.4590 3300.0n 0.4590 3599.9n 0.4590 3600.0n 0.4590 3899.9n 0.4590 3900.0n 0.4590 4199.9n 0.4590 4200.0n 0.4590 4499.9n 0.4590 4500.0n 0.4590 4799.9n 0.4590 4800.0n 0.4590 5099.9n 0.4590 5100.0n 0.4891 5399.9n 0.4891 5400.0n 0.6696 5699.9n 0.6696 5700.0n 0.4590 5999.9n 0.4590 6000.0n 0.4590 6299.9n 0.4590 6300.0n 0.4891 6599.9n 0.4891 6600.0n 0.6395 6899.9n 0.6395 6900.0n 0.4590 7199.9n 0.4590 7200.0n 0.4590 7499.9n 0.4590 7500.0n 0.6395 7799.9n 0.6395 7800.0n 0.4590 8099.9n 0.4590 8100.0n 0.4590 8399.9n 0.4590 8400.0n 0.4590 8699.9n 0.4590 8700.0n 0.4590 8999.9n 0.4590 9000.0n 0.4590 9299.9n 0.4590 9300.0n 0.4590 9599.9n 0.4590 9600.0n 0.4590 9899.9n 0.4590 9900.0n 0.4590 10199.9n 0.4590 10200.0n 0.4590 10499.9n 0.4590 10500.0n 0.4891 10799.9n 0.4891 10800.0n 0.6696 11099.9n 0.6696 11100.0n 0.4590 11399.9n 0.4590 11400.0n 0.4590 11699.9n 0.4590 11700.0n 0.4891 11999.9n 0.4891 12000.0n 0.6395 12299.9n 0.6395 12300.0n 0.4590 12599.9n 0.4590 12600.0n 0.4590 12899.9n 0.4590 12900.0n 0.6395 13199.9n 0.6395 13200.0n 0.4590 13499.9n 0.4590 13500.0n 0.4590 13799.9n 0.4590 13800.0n 0.4590 14099.9n 0.4590 14100.0n 0.4590 14399.9n 0.4590 14400.0n 0.4590 14699.9n 0.4590 14700.0n 0.4590 14999.9n 0.4590 15000.0n 0.4590 15299.9n 0.4590 15300.0n 0.4590 15599.9n 0.4590 15600.0n 0.4590 15899.9n 0.4590 15900.0n 0.4891 16199.9n 0.4891 16200.0n 0.6696 16499.9n 0.6696 16500.0n 0.4590 16799.9n 0.4590 16800.0n 0.4590 17099.9n 0.4590 17100.0n 0.4891 17399.9n 0.4891 17400.0n 0.6395 17699.9n 0.6395 17700.0n 0.4590 17999.9n 0.4590 18000.0n 0.4590 18299.9n 0.4590 18300.0n 0.6395 18599.9n 0.6395 18600.0n 0.4590 18899.9n 0.4590 18900.0n 0.4590 19199.9n 0.4590 19200.0n 0.4590 19499.9n 0.4590 19500.0n 0.4590 19799.9n 0.4590 19800.0n 0.4590 20099.9n 0.4590 20100.0n 0.4590 20399.9n 0.4590 20400.0n 0.4590 20699.9n 0.4590 20700.0n 0.4590 20999.9n 0.4590 21000.0n 0.4590 21299.9n 0.4590 21300.0n 0.4891 21599.9n 0.4891 21600.0n 0.6696 21899.9n 0.6696 21900.0n 0.4590 22199.9n 0.4590 22200.0n 0.4590 22499.9n 0.4590 22500.0n 0.4891 22799.9n 0.4891 22800.0n 0.6395 23099.9n 0.6395 23100.0n 0.4590 23399.9n 0.4590 23400.0n 0.4590 23699.9n 0.4590 23700.0n 0.6395 23999.9n 0.6395 24000.0n 0.4590 24299.9n 0.4590 24300.0n 0.4590 24599.9n 0.4590 24600.0n 0.4590 24899.9n 0.4590 24900.0n 0.4590 25199.9n 0.4590 25200.0n 0.4590 25499.9n 0.4590 25500.0n 0.4590 25799.9n 0.4590 25800.0n 0.4590 26099.9n 0.4590 26100.0n 0.4590 26399.9n 0.4590 26400.0n 0.4590 26699.9n 0.4590 26700.0n 0.4891 26999.9n 0.4891 27000.0n 0.6696 27299.9n 0.6696 27300.0n 0.4590 27599.9n 0.4590 27600.0n 0.4590 27899.9n 0.4590 27900.0n 0.4891 28199.9n 0.4891 28200.0n 0.6395 28499.9n 0.6395 28500.0n 0.4590 28799.9n 0.4590 28800.0n 0.4590 29099.9n 0.4590 29100.0n 0.6395 29399.9n 0.6395 29400.0n 0.4590 29699.9n 0.4590 29700.0n 0.4590 29999.9n 0.4590 30000.0n 0.4590 30299.9n 0.4590 30300.0n 0.4590 30599.9n 0.4590 30600.0n 0.4590 30899.9n 0.4590 30900.0n 0.4590 31199.9n 0.4590 31200.0n 0.4590 31499.9n 0.4590 31500.0n 0.4590 31799.9n 0.4590 31800.0n 0.4590 32099.9n 0.4590 32100.0n 0.4891 32399.9n 0.4891 32400.0n 0.6696 32699.9n 0.6696 32700.0n 0.4590 32999.9n 0.4590 33000.0n 0.4590 33299.9n 0.4590 33300.0n 0.4891 33599.9n 0.4891 33600.0n 0.6395 33899.9n 0.6395 33900.0n 0.4590 34199.9n 0.4590 34200.0n 0.4590 34499.9n 0.4590 34500.0n 0.6395 34799.9n 0.6395 34800.0n 0.4590 35099.9n 0.4590 35100.0n 0.4590 35399.9n 0.4590 35400.0n 0.4590 35699.9n 0.4590 35700.0n 0.4590 35999.9n 0.4590 36000.0n 0.4590 36299.9n 0.4590 36300.0n 0.4590 36599.9n 0.4590 36600.0n 0.4590 36899.9n 0.4590 36900.0n 0.4590 37199.9n 0.4590 37200.0n 0.4590 37499.9n 0.4590 37500.0n 0.4891 37799.9n 0.4891 37800.0n 0.6696 38099.9n 0.6696 38100.0n 0.4590 38399.9n 0.4590 38400.0n 0.4590 38699.9n 0.4590 38700.0n 0.4891 38999.9n 0.4891 39000.0n 0.6395 39299.9n 0.6395 39300.0n 0.4590 39599.9n 0.4590 39600.0n 0.4590 39899.9n 0.4590 39900.0n 0.6395 40199.9n 0.6395 40200.0n 0.4590 40499.9n 0.4590 40500.0n 0.4590 40799.9n 0.4590 40800.0n 0.4590 41099.9n 0.4590 41100.0n 0.4590 41399.9n 0.4590 41400.0n 0.4590 41699.9n 0.4590 41700.0n 0.4590 41999.9n 0.4590 42000.0n 0.4590 42299.9n 0.4590 42300.0n 0.4590 42599.9n 0.4590 42600.0n 0.4590 42899.9n 0.4590 42900.0n 0.4891 43199.9n 0.4891 43200.0n 0.6696 43499.9n 0.6696 43500.0n 0.4590 43799.9n 0.4590 43800.0n 0.4590 44099.9n 0.4590 44100.0n 0.4891 44399.9n 0.4891 44400.0n 0.6395 44699.9n 0.6395 44700.0n 0.4590 44999.9n 0.4590 45000.0n 0.4590 45299.9n 0.4590 45300.0n 0.6395 45599.9n 0.6395 45600.0n 0.4590 45899.9n 0.4590 45900.0n 0.4590 46199.9n 0.4590 46200.0n 0.4590 46499.9n 0.4590 46500.0n 0.4590 46799.9n 0.4590 46800.0n 0.4590 47099.9n 0.4590 47100.0n 0.4590 47399.9n 0.4590 47400.0n 0.4590 47699.9n 0.4590 47700.0n 0.4590 47999.9n 0.4590 48000.0n 0.4590 48299.9n 0.4590 48300.0n 0.4891 48599.9n 0.4891 48600.0n 0.6696 48899.9n 0.6696 48900.0n 0.4590 49199.9n 0.4590 49200.0n 0.4590 49499.9n 0.4590 49500.0n 0.4891 49799.9n 0.4891 49800.0n 0.6395 50099.9n 0.6395 50100.0n 0.4590 50399.9n 0.4590 50400.0n 0.4590 50699.9n 0.4590 50700.0n 0.6395 50999.9n 0.6395 51000.0n 0.4590 51299.9n 0.4590 51300.0n 0.4590 51599.9n 0.4590 51600.0n 0.4590 51899.9n 0.4590 51900.0n 0.4590 52199.9n 0.4590 52200.0n 0.4590 52499.9n 0.4590 52500.0n 0.4590 52799.9n 0.4590 52800.0n 0.4590 53099.9n 0.4590 53100.0n 0.4590 53399.9n 0.4590 53400.0n 0.4590 53699.9n 0.4590 53700.0n 0.4891 53999.9n 0.4891 54000.0n 0.4590 54299.9n 0.4590 54300.0n 0.4590 54599.9n 0.4590 54600.0n 0.4590 54899.9n 0.4590 54900.0n 0.4590 55199.9n 0.4590 55200.0n 0.4590 55499.9n 0.4590 55500.0n 0.4590 55799.9n 0.4590 55800.0n 0.4590 56099.9n 0.4590 56100.0n 0.4590 56399.9n 0.4590 56400.0n 0.4590 56699.9n 0.4590 56700.0n 0.4590 56999.9n 0.4590 57000.0n 0.4891 57299.9n 0.4891 57300.0n 0.4590 57599.9n 0.4590 57600.0n 0.4590 57899.9n 0.4590 57900.0n 0.4590 58199.9n 0.4590 58200.0n 0.4590 58499.9n 0.4590 58500.0n 0.4590 58799.9n 0.4590 58800.0n 0.4590 59099.9n 0.4590 59100.0n 0.4590)
Vxn6 a_xn6 0 PWL(0.0n 0.3304 299.9n 0.3304 300.0n 0.5410 599.9n 0.5410 600.0n 0.5410 899.9n 0.5410 900.0n 0.5109 1199.9n 0.5109 1200.0n 0.3605 1499.9n 0.3605 1500.0n 0.5410 1799.9n 0.5410 1800.0n 0.5410 2099.9n 0.5410 2100.0n 0.3605 2399.9n 0.3605 2400.0n 0.5410 2699.9n 0.5410 2700.0n 0.5410 2999.9n 0.5410 3000.0n 0.5410 3299.9n 0.5410 3300.0n 0.5410 3599.9n 0.5410 3600.0n 0.5410 3899.9n 0.5410 3900.0n 0.5410 4199.9n 0.5410 4200.0n 0.5410 4499.9n 0.5410 4500.0n 0.5410 4799.9n 0.5410 4800.0n 0.5410 5099.9n 0.5410 5100.0n 0.5109 5399.9n 0.5109 5400.0n 0.3304 5699.9n 0.3304 5700.0n 0.5410 5999.9n 0.5410 6000.0n 0.5410 6299.9n 0.5410 6300.0n 0.5109 6599.9n 0.5109 6600.0n 0.3605 6899.9n 0.3605 6900.0n 0.5410 7199.9n 0.5410 7200.0n 0.5410 7499.9n 0.5410 7500.0n 0.3605 7799.9n 0.3605 7800.0n 0.5410 8099.9n 0.5410 8100.0n 0.5410 8399.9n 0.5410 8400.0n 0.5410 8699.9n 0.5410 8700.0n 0.5410 8999.9n 0.5410 9000.0n 0.5410 9299.9n 0.5410 9300.0n 0.5410 9599.9n 0.5410 9600.0n 0.5410 9899.9n 0.5410 9900.0n 0.5410 10199.9n 0.5410 10200.0n 0.5410 10499.9n 0.5410 10500.0n 0.5109 10799.9n 0.5109 10800.0n 0.3304 11099.9n 0.3304 11100.0n 0.5410 11399.9n 0.5410 11400.0n 0.5410 11699.9n 0.5410 11700.0n 0.5109 11999.9n 0.5109 12000.0n 0.3605 12299.9n 0.3605 12300.0n 0.5410 12599.9n 0.5410 12600.0n 0.5410 12899.9n 0.5410 12900.0n 0.3605 13199.9n 0.3605 13200.0n 0.5410 13499.9n 0.5410 13500.0n 0.5410 13799.9n 0.5410 13800.0n 0.5410 14099.9n 0.5410 14100.0n 0.5410 14399.9n 0.5410 14400.0n 0.5410 14699.9n 0.5410 14700.0n 0.5410 14999.9n 0.5410 15000.0n 0.5410 15299.9n 0.5410 15300.0n 0.5410 15599.9n 0.5410 15600.0n 0.5410 15899.9n 0.5410 15900.0n 0.5109 16199.9n 0.5109 16200.0n 0.3304 16499.9n 0.3304 16500.0n 0.5410 16799.9n 0.5410 16800.0n 0.5410 17099.9n 0.5410 17100.0n 0.5109 17399.9n 0.5109 17400.0n 0.3605 17699.9n 0.3605 17700.0n 0.5410 17999.9n 0.5410 18000.0n 0.5410 18299.9n 0.5410 18300.0n 0.3605 18599.9n 0.3605 18600.0n 0.5410 18899.9n 0.5410 18900.0n 0.5410 19199.9n 0.5410 19200.0n 0.5410 19499.9n 0.5410 19500.0n 0.5410 19799.9n 0.5410 19800.0n 0.5410 20099.9n 0.5410 20100.0n 0.5410 20399.9n 0.5410 20400.0n 0.5410 20699.9n 0.5410 20700.0n 0.5410 20999.9n 0.5410 21000.0n 0.5410 21299.9n 0.5410 21300.0n 0.5109 21599.9n 0.5109 21600.0n 0.3304 21899.9n 0.3304 21900.0n 0.5410 22199.9n 0.5410 22200.0n 0.5410 22499.9n 0.5410 22500.0n 0.5109 22799.9n 0.5109 22800.0n 0.3605 23099.9n 0.3605 23100.0n 0.5410 23399.9n 0.5410 23400.0n 0.5410 23699.9n 0.5410 23700.0n 0.3605 23999.9n 0.3605 24000.0n 0.5410 24299.9n 0.5410 24300.0n 0.5410 24599.9n 0.5410 24600.0n 0.5410 24899.9n 0.5410 24900.0n 0.5410 25199.9n 0.5410 25200.0n 0.5410 25499.9n 0.5410 25500.0n 0.5410 25799.9n 0.5410 25800.0n 0.5410 26099.9n 0.5410 26100.0n 0.5410 26399.9n 0.5410 26400.0n 0.5410 26699.9n 0.5410 26700.0n 0.5109 26999.9n 0.5109 27000.0n 0.3304 27299.9n 0.3304 27300.0n 0.5410 27599.9n 0.5410 27600.0n 0.5410 27899.9n 0.5410 27900.0n 0.5109 28199.9n 0.5109 28200.0n 0.3605 28499.9n 0.3605 28500.0n 0.5410 28799.9n 0.5410 28800.0n 0.5410 29099.9n 0.5410 29100.0n 0.3605 29399.9n 0.3605 29400.0n 0.5410 29699.9n 0.5410 29700.0n 0.5410 29999.9n 0.5410 30000.0n 0.5410 30299.9n 0.5410 30300.0n 0.5410 30599.9n 0.5410 30600.0n 0.5410 30899.9n 0.5410 30900.0n 0.5410 31199.9n 0.5410 31200.0n 0.5410 31499.9n 0.5410 31500.0n 0.5410 31799.9n 0.5410 31800.0n 0.5410 32099.9n 0.5410 32100.0n 0.5109 32399.9n 0.5109 32400.0n 0.3304 32699.9n 0.3304 32700.0n 0.5410 32999.9n 0.5410 33000.0n 0.5410 33299.9n 0.5410 33300.0n 0.5109 33599.9n 0.5109 33600.0n 0.3605 33899.9n 0.3605 33900.0n 0.5410 34199.9n 0.5410 34200.0n 0.5410 34499.9n 0.5410 34500.0n 0.3605 34799.9n 0.3605 34800.0n 0.5410 35099.9n 0.5410 35100.0n 0.5410 35399.9n 0.5410 35400.0n 0.5410 35699.9n 0.5410 35700.0n 0.5410 35999.9n 0.5410 36000.0n 0.5410 36299.9n 0.5410 36300.0n 0.5410 36599.9n 0.5410 36600.0n 0.5410 36899.9n 0.5410 36900.0n 0.5410 37199.9n 0.5410 37200.0n 0.5410 37499.9n 0.5410 37500.0n 0.5109 37799.9n 0.5109 37800.0n 0.3304 38099.9n 0.3304 38100.0n 0.5410 38399.9n 0.5410 38400.0n 0.5410 38699.9n 0.5410 38700.0n 0.5109 38999.9n 0.5109 39000.0n 0.3605 39299.9n 0.3605 39300.0n 0.5410 39599.9n 0.5410 39600.0n 0.5410 39899.9n 0.5410 39900.0n 0.3605 40199.9n 0.3605 40200.0n 0.5410 40499.9n 0.5410 40500.0n 0.5410 40799.9n 0.5410 40800.0n 0.5410 41099.9n 0.5410 41100.0n 0.5410 41399.9n 0.5410 41400.0n 0.5410 41699.9n 0.5410 41700.0n 0.5410 41999.9n 0.5410 42000.0n 0.5410 42299.9n 0.5410 42300.0n 0.5410 42599.9n 0.5410 42600.0n 0.5410 42899.9n 0.5410 42900.0n 0.5109 43199.9n 0.5109 43200.0n 0.3304 43499.9n 0.3304 43500.0n 0.5410 43799.9n 0.5410 43800.0n 0.5410 44099.9n 0.5410 44100.0n 0.5109 44399.9n 0.5109 44400.0n 0.3605 44699.9n 0.3605 44700.0n 0.5410 44999.9n 0.5410 45000.0n 0.5410 45299.9n 0.5410 45300.0n 0.3605 45599.9n 0.3605 45600.0n 0.5410 45899.9n 0.5410 45900.0n 0.5410 46199.9n 0.5410 46200.0n 0.5410 46499.9n 0.5410 46500.0n 0.5410 46799.9n 0.5410 46800.0n 0.5410 47099.9n 0.5410 47100.0n 0.5410 47399.9n 0.5410 47400.0n 0.5410 47699.9n 0.5410 47700.0n 0.5410 47999.9n 0.5410 48000.0n 0.5410 48299.9n 0.5410 48300.0n 0.5109 48599.9n 0.5109 48600.0n 0.3304 48899.9n 0.3304 48900.0n 0.5410 49199.9n 0.5410 49200.0n 0.5410 49499.9n 0.5410 49500.0n 0.5109 49799.9n 0.5109 49800.0n 0.3605 50099.9n 0.3605 50100.0n 0.5410 50399.9n 0.5410 50400.0n 0.5410 50699.9n 0.5410 50700.0n 0.3605 50999.9n 0.3605 51000.0n 0.5410 51299.9n 0.5410 51300.0n 0.5410 51599.9n 0.5410 51600.0n 0.5410 51899.9n 0.5410 51900.0n 0.5410 52199.9n 0.5410 52200.0n 0.5410 52499.9n 0.5410 52500.0n 0.5410 52799.9n 0.5410 52800.0n 0.5410 53099.9n 0.5410 53100.0n 0.5410 53399.9n 0.5410 53400.0n 0.5410 53699.9n 0.5410 53700.0n 0.5109 53999.9n 0.5109 54000.0n 0.5410 54299.9n 0.5410 54300.0n 0.5410 54599.9n 0.5410 54600.0n 0.5410 54899.9n 0.5410 54900.0n 0.5410 55199.9n 0.5410 55200.0n 0.5410 55499.9n 0.5410 55500.0n 0.5410 55799.9n 0.5410 55800.0n 0.5410 56099.9n 0.5410 56100.0n 0.5410 56399.9n 0.5410 56400.0n 0.5410 56699.9n 0.5410 56700.0n 0.5410 56999.9n 0.5410 57000.0n 0.5109 57299.9n 0.5109 57300.0n 0.5410 57599.9n 0.5410 57600.0n 0.5410 57899.9n 0.5410 57900.0n 0.5410 58199.9n 0.5410 58200.0n 0.5410 58499.9n 0.5410 58500.0n 0.5410 58799.9n 0.5410 58800.0n 0.5410 59099.9n 0.5410 59100.0n 0.5410)
Vxp7 a_xp7 0 PWL(0.0n 0.4875 299.9n 0.4875 300.0n 0.4875 599.9n 0.4875 600.0n 0.4875 899.9n 0.4875 900.0n 0.4875 1199.9n 0.4875 1200.0n 0.4875 1499.9n 0.4875 1500.0n 0.4875 1799.9n 0.4875 1800.0n 0.4875 2099.9n 0.4875 2100.0n 0.4875 2399.9n 0.4875 2400.0n 0.4875 2699.9n 0.4875 2700.0n 0.4875 2999.9n 0.4875 3000.0n 0.4875 3299.9n 0.4875 3300.0n 0.4875 3599.9n 0.4875 3600.0n 0.4875 3899.9n 0.4875 3900.0n 0.4875 4199.9n 0.4875 4200.0n 0.4875 4499.9n 0.4875 4500.0n 0.4875 4799.9n 0.4875 4800.0n 0.4875 5099.9n 0.4875 5100.0n 0.4875 5399.9n 0.4875 5400.0n 0.4875 5699.9n 0.4875 5700.0n 0.4875 5999.9n 0.4875 6000.0n 0.4875 6299.9n 0.4875 6300.0n 0.4875 6599.9n 0.4875 6600.0n 0.4875 6899.9n 0.4875 6900.0n 0.4875 7199.9n 0.4875 7200.0n 0.4875 7499.9n 0.4875 7500.0n 0.4875 7799.9n 0.4875 7800.0n 0.4875 8099.9n 0.4875 8100.0n 0.4875 8399.9n 0.4875 8400.0n 0.4875 8699.9n 0.4875 8700.0n 0.4875 8999.9n 0.4875 9000.0n 0.4875 9299.9n 0.4875 9300.0n 0.4875 9599.9n 0.4875 9600.0n 0.4875 9899.9n 0.4875 9900.0n 0.4875 10199.9n 0.4875 10200.0n 0.4875 10499.9n 0.4875 10500.0n 0.4875 10799.9n 0.4875 10800.0n 0.4875 11099.9n 0.4875 11100.0n 0.4875 11399.9n 0.4875 11400.0n 0.4875 11699.9n 0.4875 11700.0n 0.4875 11999.9n 0.4875 12000.0n 0.4875 12299.9n 0.4875 12300.0n 0.4875 12599.9n 0.4875 12600.0n 0.4875 12899.9n 0.4875 12900.0n 0.4875 13199.9n 0.4875 13200.0n 0.4875 13499.9n 0.4875 13500.0n 0.4875 13799.9n 0.4875 13800.0n 0.4875 14099.9n 0.4875 14100.0n 0.4875 14399.9n 0.4875 14400.0n 0.4875 14699.9n 0.4875 14700.0n 0.4875 14999.9n 0.4875 15000.0n 0.4875 15299.9n 0.4875 15300.0n 0.4875 15599.9n 0.4875 15600.0n 0.4875 15899.9n 0.4875 15900.0n 0.4875 16199.9n 0.4875 16200.0n 0.4875 16499.9n 0.4875 16500.0n 0.4875 16799.9n 0.4875 16800.0n 0.4875 17099.9n 0.4875 17100.0n 0.4875 17399.9n 0.4875 17400.0n 0.4875 17699.9n 0.4875 17700.0n 0.4875 17999.9n 0.4875 18000.0n 0.4875 18299.9n 0.4875 18300.0n 0.4875 18599.9n 0.4875 18600.0n 0.4875 18899.9n 0.4875 18900.0n 0.4875 19199.9n 0.4875 19200.0n 0.4875 19499.9n 0.4875 19500.0n 0.4875 19799.9n 0.4875 19800.0n 0.4875 20099.9n 0.4875 20100.0n 0.4875 20399.9n 0.4875 20400.0n 0.4875 20699.9n 0.4875 20700.0n 0.4875 20999.9n 0.4875 21000.0n 0.4875 21299.9n 0.4875 21300.0n 0.4875 21599.9n 0.4875 21600.0n 0.4875 21899.9n 0.4875 21900.0n 0.4875 22199.9n 0.4875 22200.0n 0.4875 22499.9n 0.4875 22500.0n 0.4875 22799.9n 0.4875 22800.0n 0.4875 23099.9n 0.4875 23100.0n 0.4875 23399.9n 0.4875 23400.0n 0.4875 23699.9n 0.4875 23700.0n 0.4875 23999.9n 0.4875 24000.0n 0.4875 24299.9n 0.4875 24300.0n 0.4875 24599.9n 0.4875 24600.0n 0.4875 24899.9n 0.4875 24900.0n 0.4875 25199.9n 0.4875 25200.0n 0.4875 25499.9n 0.4875 25500.0n 0.4875 25799.9n 0.4875 25800.0n 0.4875 26099.9n 0.4875 26100.0n 0.4875 26399.9n 0.4875 26400.0n 0.4875 26699.9n 0.4875 26700.0n 0.4875 26999.9n 0.4875 27000.0n 0.4875 27299.9n 0.4875 27300.0n 0.4875 27599.9n 0.4875 27600.0n 0.4875 27899.9n 0.4875 27900.0n 0.4875 28199.9n 0.4875 28200.0n 0.4875 28499.9n 0.4875 28500.0n 0.4875 28799.9n 0.4875 28800.0n 0.4875 29099.9n 0.4875 29100.0n 0.4875 29399.9n 0.4875 29400.0n 0.4875 29699.9n 0.4875 29700.0n 0.4875 29999.9n 0.4875 30000.0n 0.4875 30299.9n 0.4875 30300.0n 0.4875 30599.9n 0.4875 30600.0n 0.4875 30899.9n 0.4875 30900.0n 0.4875 31199.9n 0.4875 31200.0n 0.4875 31499.9n 0.4875 31500.0n 0.4875 31799.9n 0.4875 31800.0n 0.4875 32099.9n 0.4875 32100.0n 0.4875 32399.9n 0.4875 32400.0n 0.4875 32699.9n 0.4875 32700.0n 0.4875 32999.9n 0.4875 33000.0n 0.4875 33299.9n 0.4875 33300.0n 0.4875 33599.9n 0.4875 33600.0n 0.4875 33899.9n 0.4875 33900.0n 0.4875 34199.9n 0.4875 34200.0n 0.4875 34499.9n 0.4875 34500.0n 0.4875 34799.9n 0.4875 34800.0n 0.4875 35099.9n 0.4875 35100.0n 0.4875 35399.9n 0.4875 35400.0n 0.4875 35699.9n 0.4875 35700.0n 0.4875 35999.9n 0.4875 36000.0n 0.4875 36299.9n 0.4875 36300.0n 0.4875 36599.9n 0.4875 36600.0n 0.4875 36899.9n 0.4875 36900.0n 0.4875 37199.9n 0.4875 37200.0n 0.4875 37499.9n 0.4875 37500.0n 0.4875 37799.9n 0.4875 37800.0n 0.4875 38099.9n 0.4875 38100.0n 0.4875 38399.9n 0.4875 38400.0n 0.4875 38699.9n 0.4875 38700.0n 0.4875 38999.9n 0.4875 39000.0n 0.4875 39299.9n 0.4875 39300.0n 0.4875 39599.9n 0.4875 39600.0n 0.4875 39899.9n 0.4875 39900.0n 0.4875 40199.9n 0.4875 40200.0n 0.4875 40499.9n 0.4875 40500.0n 0.4875 40799.9n 0.4875 40800.0n 0.4875 41099.9n 0.4875 41100.0n 0.4875 41399.9n 0.4875 41400.0n 0.4875 41699.9n 0.4875 41700.0n 0.4875 41999.9n 0.4875 42000.0n 0.4875 42299.9n 0.4875 42300.0n 0.4875 42599.9n 0.4875 42600.0n 0.4875 42899.9n 0.4875 42900.0n 0.4875 43199.9n 0.4875 43200.0n 0.4875 43499.9n 0.4875 43500.0n 0.4875 43799.9n 0.4875 43800.0n 0.4875 44099.9n 0.4875 44100.0n 0.4875 44399.9n 0.4875 44400.0n 0.4875 44699.9n 0.4875 44700.0n 0.4875 44999.9n 0.4875 45000.0n 0.4875 45299.9n 0.4875 45300.0n 0.4875 45599.9n 0.4875 45600.0n 0.4875 45899.9n 0.4875 45900.0n 0.4875 46199.9n 0.4875 46200.0n 0.4875 46499.9n 0.4875 46500.0n 0.4875 46799.9n 0.4875 46800.0n 0.4875 47099.9n 0.4875 47100.0n 0.4875 47399.9n 0.4875 47400.0n 0.4875 47699.9n 0.4875 47700.0n 0.4875 47999.9n 0.4875 48000.0n 0.4875 48299.9n 0.4875 48300.0n 0.4875 48599.9n 0.4875 48600.0n 0.4875 48899.9n 0.4875 48900.0n 0.4875 49199.9n 0.4875 49200.0n 0.4875 49499.9n 0.4875 49500.0n 0.4875 49799.9n 0.4875 49800.0n 0.4875 50099.9n 0.4875 50100.0n 0.4875 50399.9n 0.4875 50400.0n 0.4875 50699.9n 0.4875 50700.0n 0.4875 50999.9n 0.4875 51000.0n 0.4875 51299.9n 0.4875 51300.0n 0.4875 51599.9n 0.4875 51600.0n 0.4875 51899.9n 0.4875 51900.0n 0.4875 52199.9n 0.4875 52200.0n 0.4875 52499.9n 0.4875 52500.0n 0.4875 52799.9n 0.4875 52800.0n 0.4875 53099.9n 0.4875 53100.0n 0.4875 53399.9n 0.4875 53400.0n 0.4875 53699.9n 0.4875 53700.0n 0.4875 53999.9n 0.4875 54000.0n 0.4875 54299.9n 0.4875 54300.0n 0.4875 54599.9n 0.4875 54600.0n 0.4875 54899.9n 0.4875 54900.0n 0.4875 55199.9n 0.4875 55200.0n 0.4875 55499.9n 0.4875 55500.0n 0.4875 55799.9n 0.4875 55800.0n 0.4875 56099.9n 0.4875 56100.0n 0.4875 56399.9n 0.4875 56400.0n 0.4875 56699.9n 0.4875 56700.0n 0.4875 56999.9n 0.4875 57000.0n 0.4875 57299.9n 0.4875 57300.0n 0.4875 57599.9n 0.4875 57600.0n 0.4875 57899.9n 0.4875 57900.0n 0.4875 58199.9n 0.4875 58200.0n 0.4875 58499.9n 0.4875 58500.0n 0.4875 58799.9n 0.4875 58800.0n 0.4875 59099.9n 0.4875 59100.0n 0.4875)
Vxn7 a_xn7 0 PWL(0.0n 0.5125 299.9n 0.5125 300.0n 0.5125 599.9n 0.5125 600.0n 0.5125 899.9n 0.5125 900.0n 0.5125 1199.9n 0.5125 1200.0n 0.5125 1499.9n 0.5125 1500.0n 0.5125 1799.9n 0.5125 1800.0n 0.5125 2099.9n 0.5125 2100.0n 0.5125 2399.9n 0.5125 2400.0n 0.5125 2699.9n 0.5125 2700.0n 0.5125 2999.9n 0.5125 3000.0n 0.5125 3299.9n 0.5125 3300.0n 0.5125 3599.9n 0.5125 3600.0n 0.5125 3899.9n 0.5125 3900.0n 0.5125 4199.9n 0.5125 4200.0n 0.5125 4499.9n 0.5125 4500.0n 0.5125 4799.9n 0.5125 4800.0n 0.5125 5099.9n 0.5125 5100.0n 0.5125 5399.9n 0.5125 5400.0n 0.5125 5699.9n 0.5125 5700.0n 0.5125 5999.9n 0.5125 6000.0n 0.5125 6299.9n 0.5125 6300.0n 0.5125 6599.9n 0.5125 6600.0n 0.5125 6899.9n 0.5125 6900.0n 0.5125 7199.9n 0.5125 7200.0n 0.5125 7499.9n 0.5125 7500.0n 0.5125 7799.9n 0.5125 7800.0n 0.5125 8099.9n 0.5125 8100.0n 0.5125 8399.9n 0.5125 8400.0n 0.5125 8699.9n 0.5125 8700.0n 0.5125 8999.9n 0.5125 9000.0n 0.5125 9299.9n 0.5125 9300.0n 0.5125 9599.9n 0.5125 9600.0n 0.5125 9899.9n 0.5125 9900.0n 0.5125 10199.9n 0.5125 10200.0n 0.5125 10499.9n 0.5125 10500.0n 0.5125 10799.9n 0.5125 10800.0n 0.5125 11099.9n 0.5125 11100.0n 0.5125 11399.9n 0.5125 11400.0n 0.5125 11699.9n 0.5125 11700.0n 0.5125 11999.9n 0.5125 12000.0n 0.5125 12299.9n 0.5125 12300.0n 0.5125 12599.9n 0.5125 12600.0n 0.5125 12899.9n 0.5125 12900.0n 0.5125 13199.9n 0.5125 13200.0n 0.5125 13499.9n 0.5125 13500.0n 0.5125 13799.9n 0.5125 13800.0n 0.5125 14099.9n 0.5125 14100.0n 0.5125 14399.9n 0.5125 14400.0n 0.5125 14699.9n 0.5125 14700.0n 0.5125 14999.9n 0.5125 15000.0n 0.5125 15299.9n 0.5125 15300.0n 0.5125 15599.9n 0.5125 15600.0n 0.5125 15899.9n 0.5125 15900.0n 0.5125 16199.9n 0.5125 16200.0n 0.5125 16499.9n 0.5125 16500.0n 0.5125 16799.9n 0.5125 16800.0n 0.5125 17099.9n 0.5125 17100.0n 0.5125 17399.9n 0.5125 17400.0n 0.5125 17699.9n 0.5125 17700.0n 0.5125 17999.9n 0.5125 18000.0n 0.5125 18299.9n 0.5125 18300.0n 0.5125 18599.9n 0.5125 18600.0n 0.5125 18899.9n 0.5125 18900.0n 0.5125 19199.9n 0.5125 19200.0n 0.5125 19499.9n 0.5125 19500.0n 0.5125 19799.9n 0.5125 19800.0n 0.5125 20099.9n 0.5125 20100.0n 0.5125 20399.9n 0.5125 20400.0n 0.5125 20699.9n 0.5125 20700.0n 0.5125 20999.9n 0.5125 21000.0n 0.5125 21299.9n 0.5125 21300.0n 0.5125 21599.9n 0.5125 21600.0n 0.5125 21899.9n 0.5125 21900.0n 0.5125 22199.9n 0.5125 22200.0n 0.5125 22499.9n 0.5125 22500.0n 0.5125 22799.9n 0.5125 22800.0n 0.5125 23099.9n 0.5125 23100.0n 0.5125 23399.9n 0.5125 23400.0n 0.5125 23699.9n 0.5125 23700.0n 0.5125 23999.9n 0.5125 24000.0n 0.5125 24299.9n 0.5125 24300.0n 0.5125 24599.9n 0.5125 24600.0n 0.5125 24899.9n 0.5125 24900.0n 0.5125 25199.9n 0.5125 25200.0n 0.5125 25499.9n 0.5125 25500.0n 0.5125 25799.9n 0.5125 25800.0n 0.5125 26099.9n 0.5125 26100.0n 0.5125 26399.9n 0.5125 26400.0n 0.5125 26699.9n 0.5125 26700.0n 0.5125 26999.9n 0.5125 27000.0n 0.5125 27299.9n 0.5125 27300.0n 0.5125 27599.9n 0.5125 27600.0n 0.5125 27899.9n 0.5125 27900.0n 0.5125 28199.9n 0.5125 28200.0n 0.5125 28499.9n 0.5125 28500.0n 0.5125 28799.9n 0.5125 28800.0n 0.5125 29099.9n 0.5125 29100.0n 0.5125 29399.9n 0.5125 29400.0n 0.5125 29699.9n 0.5125 29700.0n 0.5125 29999.9n 0.5125 30000.0n 0.5125 30299.9n 0.5125 30300.0n 0.5125 30599.9n 0.5125 30600.0n 0.5125 30899.9n 0.5125 30900.0n 0.5125 31199.9n 0.5125 31200.0n 0.5125 31499.9n 0.5125 31500.0n 0.5125 31799.9n 0.5125 31800.0n 0.5125 32099.9n 0.5125 32100.0n 0.5125 32399.9n 0.5125 32400.0n 0.5125 32699.9n 0.5125 32700.0n 0.5125 32999.9n 0.5125 33000.0n 0.5125 33299.9n 0.5125 33300.0n 0.5125 33599.9n 0.5125 33600.0n 0.5125 33899.9n 0.5125 33900.0n 0.5125 34199.9n 0.5125 34200.0n 0.5125 34499.9n 0.5125 34500.0n 0.5125 34799.9n 0.5125 34800.0n 0.5125 35099.9n 0.5125 35100.0n 0.5125 35399.9n 0.5125 35400.0n 0.5125 35699.9n 0.5125 35700.0n 0.5125 35999.9n 0.5125 36000.0n 0.5125 36299.9n 0.5125 36300.0n 0.5125 36599.9n 0.5125 36600.0n 0.5125 36899.9n 0.5125 36900.0n 0.5125 37199.9n 0.5125 37200.0n 0.5125 37499.9n 0.5125 37500.0n 0.5125 37799.9n 0.5125 37800.0n 0.5125 38099.9n 0.5125 38100.0n 0.5125 38399.9n 0.5125 38400.0n 0.5125 38699.9n 0.5125 38700.0n 0.5125 38999.9n 0.5125 39000.0n 0.5125 39299.9n 0.5125 39300.0n 0.5125 39599.9n 0.5125 39600.0n 0.5125 39899.9n 0.5125 39900.0n 0.5125 40199.9n 0.5125 40200.0n 0.5125 40499.9n 0.5125 40500.0n 0.5125 40799.9n 0.5125 40800.0n 0.5125 41099.9n 0.5125 41100.0n 0.5125 41399.9n 0.5125 41400.0n 0.5125 41699.9n 0.5125 41700.0n 0.5125 41999.9n 0.5125 42000.0n 0.5125 42299.9n 0.5125 42300.0n 0.5125 42599.9n 0.5125 42600.0n 0.5125 42899.9n 0.5125 42900.0n 0.5125 43199.9n 0.5125 43200.0n 0.5125 43499.9n 0.5125 43500.0n 0.5125 43799.9n 0.5125 43800.0n 0.5125 44099.9n 0.5125 44100.0n 0.5125 44399.9n 0.5125 44400.0n 0.5125 44699.9n 0.5125 44700.0n 0.5125 44999.9n 0.5125 45000.0n 0.5125 45299.9n 0.5125 45300.0n 0.5125 45599.9n 0.5125 45600.0n 0.5125 45899.9n 0.5125 45900.0n 0.5125 46199.9n 0.5125 46200.0n 0.5125 46499.9n 0.5125 46500.0n 0.5125 46799.9n 0.5125 46800.0n 0.5125 47099.9n 0.5125 47100.0n 0.5125 47399.9n 0.5125 47400.0n 0.5125 47699.9n 0.5125 47700.0n 0.5125 47999.9n 0.5125 48000.0n 0.5125 48299.9n 0.5125 48300.0n 0.5125 48599.9n 0.5125 48600.0n 0.5125 48899.9n 0.5125 48900.0n 0.5125 49199.9n 0.5125 49200.0n 0.5125 49499.9n 0.5125 49500.0n 0.5125 49799.9n 0.5125 49800.0n 0.5125 50099.9n 0.5125 50100.0n 0.5125 50399.9n 0.5125 50400.0n 0.5125 50699.9n 0.5125 50700.0n 0.5125 50999.9n 0.5125 51000.0n 0.5125 51299.9n 0.5125 51300.0n 0.5125 51599.9n 0.5125 51600.0n 0.5125 51899.9n 0.5125 51900.0n 0.5125 52199.9n 0.5125 52200.0n 0.5125 52499.9n 0.5125 52500.0n 0.5125 52799.9n 0.5125 52800.0n 0.5125 53099.9n 0.5125 53100.0n 0.5125 53399.9n 0.5125 53400.0n 0.5125 53699.9n 0.5125 53700.0n 0.5125 53999.9n 0.5125 54000.0n 0.5125 54299.9n 0.5125 54300.0n 0.5125 54599.9n 0.5125 54600.0n 0.5125 54899.9n 0.5125 54900.0n 0.5125 55199.9n 0.5125 55200.0n 0.5125 55499.9n 0.5125 55500.0n 0.5125 55799.9n 0.5125 55800.0n 0.5125 56099.9n 0.5125 56100.0n 0.5125 56399.9n 0.5125 56400.0n 0.5125 56699.9n 0.5125 56700.0n 0.5125 56999.9n 0.5125 57000.0n 0.5125 57299.9n 0.5125 57300.0n 0.5125 57599.9n 0.5125 57600.0n 0.5125 57899.9n 0.5125 57900.0n 0.5125 58199.9n 0.5125 58200.0n 0.5125 58499.9n 0.5125 58500.0n 0.5125 58799.9n 0.5125 58800.0n 0.5125 59099.9n 0.5125 59100.0n 0.5125)
Vxp8 a_xp8 0 PWL(0.0n 0.4941 299.9n 0.4941 300.0n 0.4941 599.9n 0.4941 600.0n 0.4941 899.9n 0.4941 900.0n 0.4941 1199.9n 0.4941 1200.0n 0.4941 1499.9n 0.4941 1500.0n 0.4941 1799.9n 0.4941 1800.0n 0.4941 2099.9n 0.4941 2100.0n 0.4941 2399.9n 0.4941 2400.0n 0.4941 2699.9n 0.4941 2700.0n 0.4941 2999.9n 0.4941 3000.0n 0.4941 3299.9n 0.4941 3300.0n 0.4941 3599.9n 0.4941 3600.0n 0.4941 3899.9n 0.4941 3900.0n 0.4941 4199.9n 0.4941 4200.0n 0.4941 4499.9n 0.4941 4500.0n 0.4941 4799.9n 0.4941 4800.0n 0.4941 5099.9n 0.4941 5100.0n 0.4941 5399.9n 0.4941 5400.0n 0.4941 5699.9n 0.4941 5700.0n 0.4941 5999.9n 0.4941 6000.0n 0.4941 6299.9n 0.4941 6300.0n 0.4941 6599.9n 0.4941 6600.0n 0.4941 6899.9n 0.4941 6900.0n 0.4941 7199.9n 0.4941 7200.0n 0.4941 7499.9n 0.4941 7500.0n 0.4941 7799.9n 0.4941 7800.0n 0.4941 8099.9n 0.4941 8100.0n 0.4941 8399.9n 0.4941 8400.0n 0.4941 8699.9n 0.4941 8700.0n 0.4941 8999.9n 0.4941 9000.0n 0.4941 9299.9n 0.4941 9300.0n 0.4941 9599.9n 0.4941 9600.0n 0.4941 9899.9n 0.4941 9900.0n 0.4941 10199.9n 0.4941 10200.0n 0.4941 10499.9n 0.4941 10500.0n 0.4941 10799.9n 0.4941 10800.0n 0.4941 11099.9n 0.4941 11100.0n 0.4941 11399.9n 0.4941 11400.0n 0.4941 11699.9n 0.4941 11700.0n 0.4941 11999.9n 0.4941 12000.0n 0.4941 12299.9n 0.4941 12300.0n 0.4941 12599.9n 0.4941 12600.0n 0.4941 12899.9n 0.4941 12900.0n 0.4941 13199.9n 0.4941 13200.0n 0.4941 13499.9n 0.4941 13500.0n 0.4941 13799.9n 0.4941 13800.0n 0.4941 14099.9n 0.4941 14100.0n 0.4941 14399.9n 0.4941 14400.0n 0.4941 14699.9n 0.4941 14700.0n 0.4941 14999.9n 0.4941 15000.0n 0.4941 15299.9n 0.4941 15300.0n 0.4941 15599.9n 0.4941 15600.0n 0.4941 15899.9n 0.4941 15900.0n 0.4941 16199.9n 0.4941 16200.0n 0.4941 16499.9n 0.4941 16500.0n 0.4941 16799.9n 0.4941 16800.0n 0.4941 17099.9n 0.4941 17100.0n 0.4941 17399.9n 0.4941 17400.0n 0.4941 17699.9n 0.4941 17700.0n 0.4941 17999.9n 0.4941 18000.0n 0.4941 18299.9n 0.4941 18300.0n 0.4941 18599.9n 0.4941 18600.0n 0.4941 18899.9n 0.4941 18900.0n 0.4941 19199.9n 0.4941 19200.0n 0.4941 19499.9n 0.4941 19500.0n 0.4941 19799.9n 0.4941 19800.0n 0.4941 20099.9n 0.4941 20100.0n 0.4941 20399.9n 0.4941 20400.0n 0.4941 20699.9n 0.4941 20700.0n 0.4941 20999.9n 0.4941 21000.0n 0.4941 21299.9n 0.4941 21300.0n 0.4941 21599.9n 0.4941 21600.0n 0.4941 21899.9n 0.4941 21900.0n 0.4941 22199.9n 0.4941 22200.0n 0.4941 22499.9n 0.4941 22500.0n 0.4941 22799.9n 0.4941 22800.0n 0.4941 23099.9n 0.4941 23100.0n 0.4941 23399.9n 0.4941 23400.0n 0.4941 23699.9n 0.4941 23700.0n 0.4941 23999.9n 0.4941 24000.0n 0.4941 24299.9n 0.4941 24300.0n 0.4941 24599.9n 0.4941 24600.0n 0.4941 24899.9n 0.4941 24900.0n 0.4941 25199.9n 0.4941 25200.0n 0.4941 25499.9n 0.4941 25500.0n 0.4941 25799.9n 0.4941 25800.0n 0.4941 26099.9n 0.4941 26100.0n 0.4941 26399.9n 0.4941 26400.0n 0.4941 26699.9n 0.4941 26700.0n 0.4941 26999.9n 0.4941 27000.0n 0.4941 27299.9n 0.4941 27300.0n 0.4941 27599.9n 0.4941 27600.0n 0.4941 27899.9n 0.4941 27900.0n 0.4941 28199.9n 0.4941 28200.0n 0.4941 28499.9n 0.4941 28500.0n 0.4941 28799.9n 0.4941 28800.0n 0.4941 29099.9n 0.4941 29100.0n 0.4941 29399.9n 0.4941 29400.0n 0.4941 29699.9n 0.4941 29700.0n 0.4941 29999.9n 0.4941 30000.0n 0.4941 30299.9n 0.4941 30300.0n 0.4941 30599.9n 0.4941 30600.0n 0.4941 30899.9n 0.4941 30900.0n 0.4941 31199.9n 0.4941 31200.0n 0.4941 31499.9n 0.4941 31500.0n 0.4941 31799.9n 0.4941 31800.0n 0.4941 32099.9n 0.4941 32100.0n 0.4941 32399.9n 0.4941 32400.0n 0.4941 32699.9n 0.4941 32700.0n 0.4941 32999.9n 0.4941 33000.0n 0.4941 33299.9n 0.4941 33300.0n 0.4941 33599.9n 0.4941 33600.0n 0.4941 33899.9n 0.4941 33900.0n 0.4941 34199.9n 0.4941 34200.0n 0.4941 34499.9n 0.4941 34500.0n 0.4941 34799.9n 0.4941 34800.0n 0.4941 35099.9n 0.4941 35100.0n 0.4941 35399.9n 0.4941 35400.0n 0.4941 35699.9n 0.4941 35700.0n 0.4941 35999.9n 0.4941 36000.0n 0.4941 36299.9n 0.4941 36300.0n 0.4941 36599.9n 0.4941 36600.0n 0.4941 36899.9n 0.4941 36900.0n 0.4941 37199.9n 0.4941 37200.0n 0.4941 37499.9n 0.4941 37500.0n 0.4941 37799.9n 0.4941 37800.0n 0.4941 38099.9n 0.4941 38100.0n 0.4941 38399.9n 0.4941 38400.0n 0.4941 38699.9n 0.4941 38700.0n 0.4941 38999.9n 0.4941 39000.0n 0.4941 39299.9n 0.4941 39300.0n 0.4941 39599.9n 0.4941 39600.0n 0.4941 39899.9n 0.4941 39900.0n 0.4941 40199.9n 0.4941 40200.0n 0.4941 40499.9n 0.4941 40500.0n 0.4941 40799.9n 0.4941 40800.0n 0.4941 41099.9n 0.4941 41100.0n 0.4941 41399.9n 0.4941 41400.0n 0.4941 41699.9n 0.4941 41700.0n 0.4941 41999.9n 0.4941 42000.0n 0.4941 42299.9n 0.4941 42300.0n 0.4941 42599.9n 0.4941 42600.0n 0.4941 42899.9n 0.4941 42900.0n 0.4941 43199.9n 0.4941 43200.0n 0.4941 43499.9n 0.4941 43500.0n 0.4941 43799.9n 0.4941 43800.0n 0.4941 44099.9n 0.4941 44100.0n 0.4941 44399.9n 0.4941 44400.0n 0.4941 44699.9n 0.4941 44700.0n 0.4941 44999.9n 0.4941 45000.0n 0.4941 45299.9n 0.4941 45300.0n 0.4941 45599.9n 0.4941 45600.0n 0.4941 45899.9n 0.4941 45900.0n 0.4941 46199.9n 0.4941 46200.0n 0.4941 46499.9n 0.4941 46500.0n 0.4941 46799.9n 0.4941 46800.0n 0.4941 47099.9n 0.4941 47100.0n 0.4941 47399.9n 0.4941 47400.0n 0.4941 47699.9n 0.4941 47700.0n 0.4941 47999.9n 0.4941 48000.0n 0.4941 48299.9n 0.4941 48300.0n 0.4941 48599.9n 0.4941 48600.0n 0.4941 48899.9n 0.4941 48900.0n 0.4941 49199.9n 0.4941 49200.0n 0.4941 49499.9n 0.4941 49500.0n 0.4941 49799.9n 0.4941 49800.0n 0.4941 50099.9n 0.4941 50100.0n 0.4941 50399.9n 0.4941 50400.0n 0.4941 50699.9n 0.4941 50700.0n 0.4941 50999.9n 0.4941 51000.0n 0.4941 51299.9n 0.4941 51300.0n 0.4941 51599.9n 0.4941 51600.0n 0.4941 51899.9n 0.4941 51900.0n 0.4941 52199.9n 0.4941 52200.0n 0.4941 52499.9n 0.4941 52500.0n 0.4941 52799.9n 0.4941 52800.0n 0.4941 53099.9n 0.4941 53100.0n 0.4941 53399.9n 0.4941 53400.0n 0.4941 53699.9n 0.4941 53700.0n 0.4941 53999.9n 0.4941 54000.0n 0.4941 54299.9n 0.4941 54300.0n 0.4941 54599.9n 0.4941 54600.0n 0.4941 54899.9n 0.4941 54900.0n 0.4941 55199.9n 0.4941 55200.0n 0.4941 55499.9n 0.4941 55500.0n 0.4941 55799.9n 0.4941 55800.0n 0.4941 56099.9n 0.4941 56100.0n 0.4941 56399.9n 0.4941 56400.0n 0.4941 56699.9n 0.4941 56700.0n 0.4941 56999.9n 0.4941 57000.0n 0.4941 57299.9n 0.4941 57300.0n 0.4941 57599.9n 0.4941 57600.0n 0.4941 57899.9n 0.4941 57900.0n 0.4941 58199.9n 0.4941 58200.0n 0.4941 58499.9n 0.4941 58500.0n 0.4941 58799.9n 0.4941 58800.0n 0.4941 59099.9n 0.4941 59100.0n 0.4941)
Vxn8 a_xn8 0 PWL(0.0n 0.5059 299.9n 0.5059 300.0n 0.5059 599.9n 0.5059 600.0n 0.5059 899.9n 0.5059 900.0n 0.5059 1199.9n 0.5059 1200.0n 0.5059 1499.9n 0.5059 1500.0n 0.5059 1799.9n 0.5059 1800.0n 0.5059 2099.9n 0.5059 2100.0n 0.5059 2399.9n 0.5059 2400.0n 0.5059 2699.9n 0.5059 2700.0n 0.5059 2999.9n 0.5059 3000.0n 0.5059 3299.9n 0.5059 3300.0n 0.5059 3599.9n 0.5059 3600.0n 0.5059 3899.9n 0.5059 3900.0n 0.5059 4199.9n 0.5059 4200.0n 0.5059 4499.9n 0.5059 4500.0n 0.5059 4799.9n 0.5059 4800.0n 0.5059 5099.9n 0.5059 5100.0n 0.5059 5399.9n 0.5059 5400.0n 0.5059 5699.9n 0.5059 5700.0n 0.5059 5999.9n 0.5059 6000.0n 0.5059 6299.9n 0.5059 6300.0n 0.5059 6599.9n 0.5059 6600.0n 0.5059 6899.9n 0.5059 6900.0n 0.5059 7199.9n 0.5059 7200.0n 0.5059 7499.9n 0.5059 7500.0n 0.5059 7799.9n 0.5059 7800.0n 0.5059 8099.9n 0.5059 8100.0n 0.5059 8399.9n 0.5059 8400.0n 0.5059 8699.9n 0.5059 8700.0n 0.5059 8999.9n 0.5059 9000.0n 0.5059 9299.9n 0.5059 9300.0n 0.5059 9599.9n 0.5059 9600.0n 0.5059 9899.9n 0.5059 9900.0n 0.5059 10199.9n 0.5059 10200.0n 0.5059 10499.9n 0.5059 10500.0n 0.5059 10799.9n 0.5059 10800.0n 0.5059 11099.9n 0.5059 11100.0n 0.5059 11399.9n 0.5059 11400.0n 0.5059 11699.9n 0.5059 11700.0n 0.5059 11999.9n 0.5059 12000.0n 0.5059 12299.9n 0.5059 12300.0n 0.5059 12599.9n 0.5059 12600.0n 0.5059 12899.9n 0.5059 12900.0n 0.5059 13199.9n 0.5059 13200.0n 0.5059 13499.9n 0.5059 13500.0n 0.5059 13799.9n 0.5059 13800.0n 0.5059 14099.9n 0.5059 14100.0n 0.5059 14399.9n 0.5059 14400.0n 0.5059 14699.9n 0.5059 14700.0n 0.5059 14999.9n 0.5059 15000.0n 0.5059 15299.9n 0.5059 15300.0n 0.5059 15599.9n 0.5059 15600.0n 0.5059 15899.9n 0.5059 15900.0n 0.5059 16199.9n 0.5059 16200.0n 0.5059 16499.9n 0.5059 16500.0n 0.5059 16799.9n 0.5059 16800.0n 0.5059 17099.9n 0.5059 17100.0n 0.5059 17399.9n 0.5059 17400.0n 0.5059 17699.9n 0.5059 17700.0n 0.5059 17999.9n 0.5059 18000.0n 0.5059 18299.9n 0.5059 18300.0n 0.5059 18599.9n 0.5059 18600.0n 0.5059 18899.9n 0.5059 18900.0n 0.5059 19199.9n 0.5059 19200.0n 0.5059 19499.9n 0.5059 19500.0n 0.5059 19799.9n 0.5059 19800.0n 0.5059 20099.9n 0.5059 20100.0n 0.5059 20399.9n 0.5059 20400.0n 0.5059 20699.9n 0.5059 20700.0n 0.5059 20999.9n 0.5059 21000.0n 0.5059 21299.9n 0.5059 21300.0n 0.5059 21599.9n 0.5059 21600.0n 0.5059 21899.9n 0.5059 21900.0n 0.5059 22199.9n 0.5059 22200.0n 0.5059 22499.9n 0.5059 22500.0n 0.5059 22799.9n 0.5059 22800.0n 0.5059 23099.9n 0.5059 23100.0n 0.5059 23399.9n 0.5059 23400.0n 0.5059 23699.9n 0.5059 23700.0n 0.5059 23999.9n 0.5059 24000.0n 0.5059 24299.9n 0.5059 24300.0n 0.5059 24599.9n 0.5059 24600.0n 0.5059 24899.9n 0.5059 24900.0n 0.5059 25199.9n 0.5059 25200.0n 0.5059 25499.9n 0.5059 25500.0n 0.5059 25799.9n 0.5059 25800.0n 0.5059 26099.9n 0.5059 26100.0n 0.5059 26399.9n 0.5059 26400.0n 0.5059 26699.9n 0.5059 26700.0n 0.5059 26999.9n 0.5059 27000.0n 0.5059 27299.9n 0.5059 27300.0n 0.5059 27599.9n 0.5059 27600.0n 0.5059 27899.9n 0.5059 27900.0n 0.5059 28199.9n 0.5059 28200.0n 0.5059 28499.9n 0.5059 28500.0n 0.5059 28799.9n 0.5059 28800.0n 0.5059 29099.9n 0.5059 29100.0n 0.5059 29399.9n 0.5059 29400.0n 0.5059 29699.9n 0.5059 29700.0n 0.5059 29999.9n 0.5059 30000.0n 0.5059 30299.9n 0.5059 30300.0n 0.5059 30599.9n 0.5059 30600.0n 0.5059 30899.9n 0.5059 30900.0n 0.5059 31199.9n 0.5059 31200.0n 0.5059 31499.9n 0.5059 31500.0n 0.5059 31799.9n 0.5059 31800.0n 0.5059 32099.9n 0.5059 32100.0n 0.5059 32399.9n 0.5059 32400.0n 0.5059 32699.9n 0.5059 32700.0n 0.5059 32999.9n 0.5059 33000.0n 0.5059 33299.9n 0.5059 33300.0n 0.5059 33599.9n 0.5059 33600.0n 0.5059 33899.9n 0.5059 33900.0n 0.5059 34199.9n 0.5059 34200.0n 0.5059 34499.9n 0.5059 34500.0n 0.5059 34799.9n 0.5059 34800.0n 0.5059 35099.9n 0.5059 35100.0n 0.5059 35399.9n 0.5059 35400.0n 0.5059 35699.9n 0.5059 35700.0n 0.5059 35999.9n 0.5059 36000.0n 0.5059 36299.9n 0.5059 36300.0n 0.5059 36599.9n 0.5059 36600.0n 0.5059 36899.9n 0.5059 36900.0n 0.5059 37199.9n 0.5059 37200.0n 0.5059 37499.9n 0.5059 37500.0n 0.5059 37799.9n 0.5059 37800.0n 0.5059 38099.9n 0.5059 38100.0n 0.5059 38399.9n 0.5059 38400.0n 0.5059 38699.9n 0.5059 38700.0n 0.5059 38999.9n 0.5059 39000.0n 0.5059 39299.9n 0.5059 39300.0n 0.5059 39599.9n 0.5059 39600.0n 0.5059 39899.9n 0.5059 39900.0n 0.5059 40199.9n 0.5059 40200.0n 0.5059 40499.9n 0.5059 40500.0n 0.5059 40799.9n 0.5059 40800.0n 0.5059 41099.9n 0.5059 41100.0n 0.5059 41399.9n 0.5059 41400.0n 0.5059 41699.9n 0.5059 41700.0n 0.5059 41999.9n 0.5059 42000.0n 0.5059 42299.9n 0.5059 42300.0n 0.5059 42599.9n 0.5059 42600.0n 0.5059 42899.9n 0.5059 42900.0n 0.5059 43199.9n 0.5059 43200.0n 0.5059 43499.9n 0.5059 43500.0n 0.5059 43799.9n 0.5059 43800.0n 0.5059 44099.9n 0.5059 44100.0n 0.5059 44399.9n 0.5059 44400.0n 0.5059 44699.9n 0.5059 44700.0n 0.5059 44999.9n 0.5059 45000.0n 0.5059 45299.9n 0.5059 45300.0n 0.5059 45599.9n 0.5059 45600.0n 0.5059 45899.9n 0.5059 45900.0n 0.5059 46199.9n 0.5059 46200.0n 0.5059 46499.9n 0.5059 46500.0n 0.5059 46799.9n 0.5059 46800.0n 0.5059 47099.9n 0.5059 47100.0n 0.5059 47399.9n 0.5059 47400.0n 0.5059 47699.9n 0.5059 47700.0n 0.5059 47999.9n 0.5059 48000.0n 0.5059 48299.9n 0.5059 48300.0n 0.5059 48599.9n 0.5059 48600.0n 0.5059 48899.9n 0.5059 48900.0n 0.5059 49199.9n 0.5059 49200.0n 0.5059 49499.9n 0.5059 49500.0n 0.5059 49799.9n 0.5059 49800.0n 0.5059 50099.9n 0.5059 50100.0n 0.5059 50399.9n 0.5059 50400.0n 0.5059 50699.9n 0.5059 50700.0n 0.5059 50999.9n 0.5059 51000.0n 0.5059 51299.9n 0.5059 51300.0n 0.5059 51599.9n 0.5059 51600.0n 0.5059 51899.9n 0.5059 51900.0n 0.5059 52199.9n 0.5059 52200.0n 0.5059 52499.9n 0.5059 52500.0n 0.5059 52799.9n 0.5059 52800.0n 0.5059 53099.9n 0.5059 53100.0n 0.5059 53399.9n 0.5059 53400.0n 0.5059 53699.9n 0.5059 53700.0n 0.5059 53999.9n 0.5059 54000.0n 0.5059 54299.9n 0.5059 54300.0n 0.5059 54599.9n 0.5059 54600.0n 0.5059 54899.9n 0.5059 54900.0n 0.5059 55199.9n 0.5059 55200.0n 0.5059 55499.9n 0.5059 55500.0n 0.5059 55799.9n 0.5059 55800.0n 0.5059 56099.9n 0.5059 56100.0n 0.5059 56399.9n 0.5059 56400.0n 0.5059 56699.9n 0.5059 56700.0n 0.5059 56999.9n 0.5059 57000.0n 0.5059 57299.9n 0.5059 57300.0n 0.5059 57599.9n 0.5059 57600.0n 0.5059 57899.9n 0.5059 57900.0n 0.5059 58199.9n 0.5059 58200.0n 0.5059 58499.9n 0.5059 58500.0n 0.5059 58799.9n 0.5059 58800.0n 0.5059 59099.9n 0.5059 59100.0n 0.5059)
Vxp9 a_xp9 0 PWL(0.0n 0.4376 299.9n 0.4376 300.0n 0.4376 599.9n 0.4376 600.0n 0.5315 899.9n 0.5315 900.0n 0.4376 1199.9n 0.4376 1200.0n 0.4376 1499.9n 0.4376 1500.0n 0.4376 1799.9n 0.4376 1800.0n 0.4376 2099.9n 0.4376 2100.0n 0.4376 2399.9n 0.4376 2400.0n 0.6880 2699.9n 0.6880 2700.0n 0.5628 2999.9n 0.5628 3000.0n 0.7819 3299.9n 0.7819 3300.0n 0.4689 3599.9n 0.4689 3600.0n 0.4376 3899.9n 0.4376 3900.0n 0.4376 4199.9n 0.4376 4200.0n 0.7819 4499.9n 0.7819 4500.0n 0.6567 4799.9n 0.6567 4800.0n 0.4376 5099.9n 0.4376 5100.0n 0.4376 5399.9n 0.4376 5400.0n 0.4376 5699.9n 0.4376 5700.0n 0.4376 5999.9n 0.4376 6000.0n 0.5315 6299.9n 0.5315 6300.0n 0.4376 6599.9n 0.4376 6600.0n 0.4376 6899.9n 0.4376 6900.0n 0.4376 7199.9n 0.4376 7200.0n 0.4376 7499.9n 0.4376 7500.0n 0.4376 7799.9n 0.4376 7800.0n 0.6880 8099.9n 0.6880 8100.0n 0.5628 8399.9n 0.5628 8400.0n 0.7819 8699.9n 0.7819 8700.0n 0.4689 8999.9n 0.4689 9000.0n 0.4376 9299.9n 0.4376 9300.0n 0.4376 9599.9n 0.4376 9600.0n 0.7819 9899.9n 0.7819 9900.0n 0.6567 10199.9n 0.6567 10200.0n 0.4376 10499.9n 0.4376 10500.0n 0.4376 10799.9n 0.4376 10800.0n 0.4376 11099.9n 0.4376 11100.0n 0.4376 11399.9n 0.4376 11400.0n 0.5315 11699.9n 0.5315 11700.0n 0.4376 11999.9n 0.4376 12000.0n 0.4376 12299.9n 0.4376 12300.0n 0.4376 12599.9n 0.4376 12600.0n 0.4376 12899.9n 0.4376 12900.0n 0.4376 13199.9n 0.4376 13200.0n 0.6880 13499.9n 0.6880 13500.0n 0.5628 13799.9n 0.5628 13800.0n 0.7819 14099.9n 0.7819 14100.0n 0.4689 14399.9n 0.4689 14400.0n 0.4376 14699.9n 0.4376 14700.0n 0.4376 14999.9n 0.4376 15000.0n 0.7819 15299.9n 0.7819 15300.0n 0.6567 15599.9n 0.6567 15600.0n 0.4376 15899.9n 0.4376 15900.0n 0.4376 16199.9n 0.4376 16200.0n 0.4376 16499.9n 0.4376 16500.0n 0.4376 16799.9n 0.4376 16800.0n 0.5315 17099.9n 0.5315 17100.0n 0.4376 17399.9n 0.4376 17400.0n 0.4376 17699.9n 0.4376 17700.0n 0.4376 17999.9n 0.4376 18000.0n 0.4376 18299.9n 0.4376 18300.0n 0.4376 18599.9n 0.4376 18600.0n 0.6880 18899.9n 0.6880 18900.0n 0.5628 19199.9n 0.5628 19200.0n 0.7819 19499.9n 0.7819 19500.0n 0.4689 19799.9n 0.4689 19800.0n 0.4376 20099.9n 0.4376 20100.0n 0.4376 20399.9n 0.4376 20400.0n 0.7819 20699.9n 0.7819 20700.0n 0.6567 20999.9n 0.6567 21000.0n 0.4376 21299.9n 0.4376 21300.0n 0.4376 21599.9n 0.4376 21600.0n 0.4376 21899.9n 0.4376 21900.0n 0.4376 22199.9n 0.4376 22200.0n 0.5315 22499.9n 0.5315 22500.0n 0.4376 22799.9n 0.4376 22800.0n 0.4376 23099.9n 0.4376 23100.0n 0.4376 23399.9n 0.4376 23400.0n 0.4376 23699.9n 0.4376 23700.0n 0.4376 23999.9n 0.4376 24000.0n 0.6880 24299.9n 0.6880 24300.0n 0.5628 24599.9n 0.5628 24600.0n 0.7819 24899.9n 0.7819 24900.0n 0.4689 25199.9n 0.4689 25200.0n 0.4376 25499.9n 0.4376 25500.0n 0.4376 25799.9n 0.4376 25800.0n 0.7819 26099.9n 0.7819 26100.0n 0.6567 26399.9n 0.6567 26400.0n 0.4376 26699.9n 0.4376 26700.0n 0.4376 26999.9n 0.4376 27000.0n 0.4376 27299.9n 0.4376 27300.0n 0.4376 27599.9n 0.4376 27600.0n 0.5315 27899.9n 0.5315 27900.0n 0.4376 28199.9n 0.4376 28200.0n 0.4376 28499.9n 0.4376 28500.0n 0.4376 28799.9n 0.4376 28800.0n 0.4376 29099.9n 0.4376 29100.0n 0.4376 29399.9n 0.4376 29400.0n 0.6880 29699.9n 0.6880 29700.0n 0.5628 29999.9n 0.5628 30000.0n 0.7819 30299.9n 0.7819 30300.0n 0.4689 30599.9n 0.4689 30600.0n 0.4376 30899.9n 0.4376 30900.0n 0.4376 31199.9n 0.4376 31200.0n 0.7819 31499.9n 0.7819 31500.0n 0.6567 31799.9n 0.6567 31800.0n 0.4376 32099.9n 0.4376 32100.0n 0.4376 32399.9n 0.4376 32400.0n 0.4376 32699.9n 0.4376 32700.0n 0.4376 32999.9n 0.4376 33000.0n 0.5315 33299.9n 0.5315 33300.0n 0.4376 33599.9n 0.4376 33600.0n 0.4376 33899.9n 0.4376 33900.0n 0.4376 34199.9n 0.4376 34200.0n 0.4376 34499.9n 0.4376 34500.0n 0.4376 34799.9n 0.4376 34800.0n 0.6880 35099.9n 0.6880 35100.0n 0.5628 35399.9n 0.5628 35400.0n 0.7819 35699.9n 0.7819 35700.0n 0.4689 35999.9n 0.4689 36000.0n 0.4376 36299.9n 0.4376 36300.0n 0.4376 36599.9n 0.4376 36600.0n 0.7819 36899.9n 0.7819 36900.0n 0.6567 37199.9n 0.6567 37200.0n 0.4376 37499.9n 0.4376 37500.0n 0.4376 37799.9n 0.4376 37800.0n 0.4376 38099.9n 0.4376 38100.0n 0.4376 38399.9n 0.4376 38400.0n 0.5315 38699.9n 0.5315 38700.0n 0.4376 38999.9n 0.4376 39000.0n 0.4376 39299.9n 0.4376 39300.0n 0.4376 39599.9n 0.4376 39600.0n 0.4376 39899.9n 0.4376 39900.0n 0.4376 40199.9n 0.4376 40200.0n 0.6880 40499.9n 0.6880 40500.0n 0.5628 40799.9n 0.5628 40800.0n 0.7819 41099.9n 0.7819 41100.0n 0.4689 41399.9n 0.4689 41400.0n 0.4376 41699.9n 0.4376 41700.0n 0.4376 41999.9n 0.4376 42000.0n 0.7819 42299.9n 0.7819 42300.0n 0.6567 42599.9n 0.6567 42600.0n 0.4376 42899.9n 0.4376 42900.0n 0.4376 43199.9n 0.4376 43200.0n 0.4376 43499.9n 0.4376 43500.0n 0.4376 43799.9n 0.4376 43800.0n 0.5315 44099.9n 0.5315 44100.0n 0.4376 44399.9n 0.4376 44400.0n 0.4376 44699.9n 0.4376 44700.0n 0.4376 44999.9n 0.4376 45000.0n 0.4376 45299.9n 0.4376 45300.0n 0.4376 45599.9n 0.4376 45600.0n 0.6880 45899.9n 0.6880 45900.0n 0.5628 46199.9n 0.5628 46200.0n 0.7819 46499.9n 0.7819 46500.0n 0.4689 46799.9n 0.4689 46800.0n 0.4376 47099.9n 0.4376 47100.0n 0.4376 47399.9n 0.4376 47400.0n 0.7819 47699.9n 0.7819 47700.0n 0.6567 47999.9n 0.6567 48000.0n 0.4376 48299.9n 0.4376 48300.0n 0.4376 48599.9n 0.4376 48600.0n 0.4376 48899.9n 0.4376 48900.0n 0.4376 49199.9n 0.4376 49200.0n 0.5315 49499.9n 0.5315 49500.0n 0.4376 49799.9n 0.4376 49800.0n 0.4376 50099.9n 0.4376 50100.0n 0.4376 50399.9n 0.4376 50400.0n 0.4376 50699.9n 0.4376 50700.0n 0.4376 50999.9n 0.4376 51000.0n 0.6880 51299.9n 0.6880 51300.0n 0.5628 51599.9n 0.5628 51600.0n 0.7819 51899.9n 0.7819 51900.0n 0.4689 52199.9n 0.4689 52200.0n 0.4376 52499.9n 0.4376 52500.0n 0.4376 52799.9n 0.4376 52800.0n 0.7819 53099.9n 0.7819 53100.0n 0.6567 53399.9n 0.6567 53400.0n 0.4376 53699.9n 0.4376 53700.0n 0.4376 53999.9n 0.4376 54000.0n 0.4689 54299.9n 0.4689 54300.0n 0.4376 54599.9n 0.4376 54600.0n 0.4376 54899.9n 0.4376 54900.0n 0.4376 55199.9n 0.4376 55200.0n 0.4376 55499.9n 0.4376 55500.0n 0.4376 55799.9n 0.4376 55800.0n 0.4376 56099.9n 0.4376 56100.0n 0.4376 56399.9n 0.4376 56400.0n 0.4376 56699.9n 0.4376 56700.0n 0.4376 56999.9n 0.4376 57000.0n 0.4376 57299.9n 0.4376 57300.0n 0.4376 57599.9n 0.4376 57600.0n 0.6567 57899.9n 0.6567 57900.0n 0.7819 58199.9n 0.7819 58200.0n 0.6254 58499.9n 0.6254 58500.0n 0.6880 58799.9n 0.6880 58800.0n 0.8000 59099.9n 0.8000 59100.0n 0.6567)
Vxn9 a_xn9 0 PWL(0.0n 0.5624 299.9n 0.5624 300.0n 0.5624 599.9n 0.5624 600.0n 0.4685 899.9n 0.4685 900.0n 0.5624 1199.9n 0.5624 1200.0n 0.5624 1499.9n 0.5624 1500.0n 0.5624 1799.9n 0.5624 1800.0n 0.5624 2099.9n 0.5624 2100.0n 0.5624 2399.9n 0.5624 2400.0n 0.3120 2699.9n 0.3120 2700.0n 0.4372 2999.9n 0.4372 3000.0n 0.2181 3299.9n 0.2181 3300.0n 0.5311 3599.9n 0.5311 3600.0n 0.5624 3899.9n 0.5624 3900.0n 0.5624 4199.9n 0.5624 4200.0n 0.2181 4499.9n 0.2181 4500.0n 0.3433 4799.9n 0.3433 4800.0n 0.5624 5099.9n 0.5624 5100.0n 0.5624 5399.9n 0.5624 5400.0n 0.5624 5699.9n 0.5624 5700.0n 0.5624 5999.9n 0.5624 6000.0n 0.4685 6299.9n 0.4685 6300.0n 0.5624 6599.9n 0.5624 6600.0n 0.5624 6899.9n 0.5624 6900.0n 0.5624 7199.9n 0.5624 7200.0n 0.5624 7499.9n 0.5624 7500.0n 0.5624 7799.9n 0.5624 7800.0n 0.3120 8099.9n 0.3120 8100.0n 0.4372 8399.9n 0.4372 8400.0n 0.2181 8699.9n 0.2181 8700.0n 0.5311 8999.9n 0.5311 9000.0n 0.5624 9299.9n 0.5624 9300.0n 0.5624 9599.9n 0.5624 9600.0n 0.2181 9899.9n 0.2181 9900.0n 0.3433 10199.9n 0.3433 10200.0n 0.5624 10499.9n 0.5624 10500.0n 0.5624 10799.9n 0.5624 10800.0n 0.5624 11099.9n 0.5624 11100.0n 0.5624 11399.9n 0.5624 11400.0n 0.4685 11699.9n 0.4685 11700.0n 0.5624 11999.9n 0.5624 12000.0n 0.5624 12299.9n 0.5624 12300.0n 0.5624 12599.9n 0.5624 12600.0n 0.5624 12899.9n 0.5624 12900.0n 0.5624 13199.9n 0.5624 13200.0n 0.3120 13499.9n 0.3120 13500.0n 0.4372 13799.9n 0.4372 13800.0n 0.2181 14099.9n 0.2181 14100.0n 0.5311 14399.9n 0.5311 14400.0n 0.5624 14699.9n 0.5624 14700.0n 0.5624 14999.9n 0.5624 15000.0n 0.2181 15299.9n 0.2181 15300.0n 0.3433 15599.9n 0.3433 15600.0n 0.5624 15899.9n 0.5624 15900.0n 0.5624 16199.9n 0.5624 16200.0n 0.5624 16499.9n 0.5624 16500.0n 0.5624 16799.9n 0.5624 16800.0n 0.4685 17099.9n 0.4685 17100.0n 0.5624 17399.9n 0.5624 17400.0n 0.5624 17699.9n 0.5624 17700.0n 0.5624 17999.9n 0.5624 18000.0n 0.5624 18299.9n 0.5624 18300.0n 0.5624 18599.9n 0.5624 18600.0n 0.3120 18899.9n 0.3120 18900.0n 0.4372 19199.9n 0.4372 19200.0n 0.2181 19499.9n 0.2181 19500.0n 0.5311 19799.9n 0.5311 19800.0n 0.5624 20099.9n 0.5624 20100.0n 0.5624 20399.9n 0.5624 20400.0n 0.2181 20699.9n 0.2181 20700.0n 0.3433 20999.9n 0.3433 21000.0n 0.5624 21299.9n 0.5624 21300.0n 0.5624 21599.9n 0.5624 21600.0n 0.5624 21899.9n 0.5624 21900.0n 0.5624 22199.9n 0.5624 22200.0n 0.4685 22499.9n 0.4685 22500.0n 0.5624 22799.9n 0.5624 22800.0n 0.5624 23099.9n 0.5624 23100.0n 0.5624 23399.9n 0.5624 23400.0n 0.5624 23699.9n 0.5624 23700.0n 0.5624 23999.9n 0.5624 24000.0n 0.3120 24299.9n 0.3120 24300.0n 0.4372 24599.9n 0.4372 24600.0n 0.2181 24899.9n 0.2181 24900.0n 0.5311 25199.9n 0.5311 25200.0n 0.5624 25499.9n 0.5624 25500.0n 0.5624 25799.9n 0.5624 25800.0n 0.2181 26099.9n 0.2181 26100.0n 0.3433 26399.9n 0.3433 26400.0n 0.5624 26699.9n 0.5624 26700.0n 0.5624 26999.9n 0.5624 27000.0n 0.5624 27299.9n 0.5624 27300.0n 0.5624 27599.9n 0.5624 27600.0n 0.4685 27899.9n 0.4685 27900.0n 0.5624 28199.9n 0.5624 28200.0n 0.5624 28499.9n 0.5624 28500.0n 0.5624 28799.9n 0.5624 28800.0n 0.5624 29099.9n 0.5624 29100.0n 0.5624 29399.9n 0.5624 29400.0n 0.3120 29699.9n 0.3120 29700.0n 0.4372 29999.9n 0.4372 30000.0n 0.2181 30299.9n 0.2181 30300.0n 0.5311 30599.9n 0.5311 30600.0n 0.5624 30899.9n 0.5624 30900.0n 0.5624 31199.9n 0.5624 31200.0n 0.2181 31499.9n 0.2181 31500.0n 0.3433 31799.9n 0.3433 31800.0n 0.5624 32099.9n 0.5624 32100.0n 0.5624 32399.9n 0.5624 32400.0n 0.5624 32699.9n 0.5624 32700.0n 0.5624 32999.9n 0.5624 33000.0n 0.4685 33299.9n 0.4685 33300.0n 0.5624 33599.9n 0.5624 33600.0n 0.5624 33899.9n 0.5624 33900.0n 0.5624 34199.9n 0.5624 34200.0n 0.5624 34499.9n 0.5624 34500.0n 0.5624 34799.9n 0.5624 34800.0n 0.3120 35099.9n 0.3120 35100.0n 0.4372 35399.9n 0.4372 35400.0n 0.2181 35699.9n 0.2181 35700.0n 0.5311 35999.9n 0.5311 36000.0n 0.5624 36299.9n 0.5624 36300.0n 0.5624 36599.9n 0.5624 36600.0n 0.2181 36899.9n 0.2181 36900.0n 0.3433 37199.9n 0.3433 37200.0n 0.5624 37499.9n 0.5624 37500.0n 0.5624 37799.9n 0.5624 37800.0n 0.5624 38099.9n 0.5624 38100.0n 0.5624 38399.9n 0.5624 38400.0n 0.4685 38699.9n 0.4685 38700.0n 0.5624 38999.9n 0.5624 39000.0n 0.5624 39299.9n 0.5624 39300.0n 0.5624 39599.9n 0.5624 39600.0n 0.5624 39899.9n 0.5624 39900.0n 0.5624 40199.9n 0.5624 40200.0n 0.3120 40499.9n 0.3120 40500.0n 0.4372 40799.9n 0.4372 40800.0n 0.2181 41099.9n 0.2181 41100.0n 0.5311 41399.9n 0.5311 41400.0n 0.5624 41699.9n 0.5624 41700.0n 0.5624 41999.9n 0.5624 42000.0n 0.2181 42299.9n 0.2181 42300.0n 0.3433 42599.9n 0.3433 42600.0n 0.5624 42899.9n 0.5624 42900.0n 0.5624 43199.9n 0.5624 43200.0n 0.5624 43499.9n 0.5624 43500.0n 0.5624 43799.9n 0.5624 43800.0n 0.4685 44099.9n 0.4685 44100.0n 0.5624 44399.9n 0.5624 44400.0n 0.5624 44699.9n 0.5624 44700.0n 0.5624 44999.9n 0.5624 45000.0n 0.5624 45299.9n 0.5624 45300.0n 0.5624 45599.9n 0.5624 45600.0n 0.3120 45899.9n 0.3120 45900.0n 0.4372 46199.9n 0.4372 46200.0n 0.2181 46499.9n 0.2181 46500.0n 0.5311 46799.9n 0.5311 46800.0n 0.5624 47099.9n 0.5624 47100.0n 0.5624 47399.9n 0.5624 47400.0n 0.2181 47699.9n 0.2181 47700.0n 0.3433 47999.9n 0.3433 48000.0n 0.5624 48299.9n 0.5624 48300.0n 0.5624 48599.9n 0.5624 48600.0n 0.5624 48899.9n 0.5624 48900.0n 0.5624 49199.9n 0.5624 49200.0n 0.4685 49499.9n 0.4685 49500.0n 0.5624 49799.9n 0.5624 49800.0n 0.5624 50099.9n 0.5624 50100.0n 0.5624 50399.9n 0.5624 50400.0n 0.5624 50699.9n 0.5624 50700.0n 0.5624 50999.9n 0.5624 51000.0n 0.3120 51299.9n 0.3120 51300.0n 0.4372 51599.9n 0.4372 51600.0n 0.2181 51899.9n 0.2181 51900.0n 0.5311 52199.9n 0.5311 52200.0n 0.5624 52499.9n 0.5624 52500.0n 0.5624 52799.9n 0.5624 52800.0n 0.2181 53099.9n 0.2181 53100.0n 0.3433 53399.9n 0.3433 53400.0n 0.5624 53699.9n 0.5624 53700.0n 0.5624 53999.9n 0.5624 54000.0n 0.5311 54299.9n 0.5311 54300.0n 0.5624 54599.9n 0.5624 54600.0n 0.5624 54899.9n 0.5624 54900.0n 0.5624 55199.9n 0.5624 55200.0n 0.5624 55499.9n 0.5624 55500.0n 0.5624 55799.9n 0.5624 55800.0n 0.5624 56099.9n 0.5624 56100.0n 0.5624 56399.9n 0.5624 56400.0n 0.5624 56699.9n 0.5624 56700.0n 0.5624 56999.9n 0.5624 57000.0n 0.5624 57299.9n 0.5624 57300.0n 0.5624 57599.9n 0.5624 57600.0n 0.3433 57899.9n 0.3433 57900.0n 0.2181 58199.9n 0.2181 58200.0n 0.3746 58499.9n 0.3746 58500.0n 0.3120 58799.9n 0.3120 58800.0n 0.2000 59099.9n 0.2000 59100.0n 0.3433)
Vxp10 a_xp10 0 PWL(0.0n 0.3084 299.9n 0.3084 300.0n 0.4929 599.9n 0.4929 600.0n 0.6036 899.9n 0.6036 900.0n 0.4376 1199.9n 0.4376 1200.0n 0.3638 1499.9n 0.3638 1500.0n 0.5114 1799.9n 0.5114 1800.0n 0.5667 2099.9n 0.5667 2100.0n 0.3084 2399.9n 0.3084 2400.0n 0.5114 2699.9n 0.5114 2700.0n 0.6036 2999.9n 0.6036 3000.0n 0.5852 3299.9n 0.5852 3300.0n 0.6036 3599.9n 0.6036 3600.0n 0.4007 3899.9n 0.4007 3900.0n 0.3638 4199.9n 0.3638 4200.0n 0.5852 4499.9n 0.5852 4500.0n 0.5852 4799.9n 0.5852 4800.0n 0.5667 5099.9n 0.5667 5100.0n 0.3084 5399.9n 0.3084 5400.0n 0.3084 5699.9n 0.3084 5700.0n 0.4929 5999.9n 0.4929 6000.0n 0.6036 6299.9n 0.6036 6300.0n 0.4376 6599.9n 0.4376 6600.0n 0.3638 6899.9n 0.3638 6900.0n 0.5114 7199.9n 0.5114 7200.0n 0.5667 7499.9n 0.5667 7500.0n 0.3084 7799.9n 0.3084 7800.0n 0.5114 8099.9n 0.5114 8100.0n 0.6036 8399.9n 0.6036 8400.0n 0.5852 8699.9n 0.5852 8700.0n 0.6036 8999.9n 0.6036 9000.0n 0.4007 9299.9n 0.4007 9300.0n 0.3638 9599.9n 0.3638 9600.0n 0.5852 9899.9n 0.5852 9900.0n 0.5852 10199.9n 0.5852 10200.0n 0.5667 10499.9n 0.5667 10500.0n 0.3084 10799.9n 0.3084 10800.0n 0.3084 11099.9n 0.3084 11100.0n 0.4929 11399.9n 0.4929 11400.0n 0.6036 11699.9n 0.6036 11700.0n 0.4376 11999.9n 0.4376 12000.0n 0.3638 12299.9n 0.3638 12300.0n 0.5114 12599.9n 0.5114 12600.0n 0.5667 12899.9n 0.5667 12900.0n 0.3084 13199.9n 0.3084 13200.0n 0.5114 13499.9n 0.5114 13500.0n 0.6036 13799.9n 0.6036 13800.0n 0.5852 14099.9n 0.5852 14100.0n 0.6036 14399.9n 0.6036 14400.0n 0.4007 14699.9n 0.4007 14700.0n 0.3638 14999.9n 0.3638 15000.0n 0.5852 15299.9n 0.5852 15300.0n 0.5852 15599.9n 0.5852 15600.0n 0.5667 15899.9n 0.5667 15900.0n 0.3084 16199.9n 0.3084 16200.0n 0.3084 16499.9n 0.3084 16500.0n 0.4929 16799.9n 0.4929 16800.0n 0.6036 17099.9n 0.6036 17100.0n 0.4376 17399.9n 0.4376 17400.0n 0.3638 17699.9n 0.3638 17700.0n 0.5114 17999.9n 0.5114 18000.0n 0.5667 18299.9n 0.5667 18300.0n 0.3084 18599.9n 0.3084 18600.0n 0.5114 18899.9n 0.5114 18900.0n 0.6036 19199.9n 0.6036 19200.0n 0.5852 19499.9n 0.5852 19500.0n 0.6036 19799.9n 0.6036 19800.0n 0.4007 20099.9n 0.4007 20100.0n 0.3638 20399.9n 0.3638 20400.0n 0.5852 20699.9n 0.5852 20700.0n 0.5852 20999.9n 0.5852 21000.0n 0.5667 21299.9n 0.5667 21300.0n 0.3084 21599.9n 0.3084 21600.0n 0.3084 21899.9n 0.3084 21900.0n 0.4929 22199.9n 0.4929 22200.0n 0.6036 22499.9n 0.6036 22500.0n 0.4376 22799.9n 0.4376 22800.0n 0.3638 23099.9n 0.3638 23100.0n 0.5114 23399.9n 0.5114 23400.0n 0.5667 23699.9n 0.5667 23700.0n 0.3084 23999.9n 0.3084 24000.0n 0.5114 24299.9n 0.5114 24300.0n 0.6036 24599.9n 0.6036 24600.0n 0.5852 24899.9n 0.5852 24900.0n 0.6036 25199.9n 0.6036 25200.0n 0.4007 25499.9n 0.4007 25500.0n 0.3638 25799.9n 0.3638 25800.0n 0.5852 26099.9n 0.5852 26100.0n 0.5852 26399.9n 0.5852 26400.0n 0.5667 26699.9n 0.5667 26700.0n 0.3084 26999.9n 0.3084 27000.0n 0.3084 27299.9n 0.3084 27300.0n 0.4929 27599.9n 0.4929 27600.0n 0.6036 27899.9n 0.6036 27900.0n 0.4376 28199.9n 0.4376 28200.0n 0.3638 28499.9n 0.3638 28500.0n 0.5114 28799.9n 0.5114 28800.0n 0.5667 29099.9n 0.5667 29100.0n 0.3084 29399.9n 0.3084 29400.0n 0.5114 29699.9n 0.5114 29700.0n 0.6036 29999.9n 0.6036 30000.0n 0.5852 30299.9n 0.5852 30300.0n 0.6036 30599.9n 0.6036 30600.0n 0.4007 30899.9n 0.4007 30900.0n 0.3638 31199.9n 0.3638 31200.0n 0.5852 31499.9n 0.5852 31500.0n 0.5852 31799.9n 0.5852 31800.0n 0.5667 32099.9n 0.5667 32100.0n 0.3084 32399.9n 0.3084 32400.0n 0.3084 32699.9n 0.3084 32700.0n 0.4929 32999.9n 0.4929 33000.0n 0.6036 33299.9n 0.6036 33300.0n 0.4376 33599.9n 0.4376 33600.0n 0.3638 33899.9n 0.3638 33900.0n 0.5114 34199.9n 0.5114 34200.0n 0.5667 34499.9n 0.5667 34500.0n 0.3084 34799.9n 0.3084 34800.0n 0.5114 35099.9n 0.5114 35100.0n 0.6036 35399.9n 0.6036 35400.0n 0.5852 35699.9n 0.5852 35700.0n 0.6036 35999.9n 0.6036 36000.0n 0.4007 36299.9n 0.4007 36300.0n 0.3638 36599.9n 0.3638 36600.0n 0.5852 36899.9n 0.5852 36900.0n 0.5852 37199.9n 0.5852 37200.0n 0.5667 37499.9n 0.5667 37500.0n 0.3084 37799.9n 0.3084 37800.0n 0.3084 38099.9n 0.3084 38100.0n 0.4929 38399.9n 0.4929 38400.0n 0.6036 38699.9n 0.6036 38700.0n 0.4376 38999.9n 0.4376 39000.0n 0.3638 39299.9n 0.3638 39300.0n 0.5114 39599.9n 0.5114 39600.0n 0.5667 39899.9n 0.5667 39900.0n 0.3084 40199.9n 0.3084 40200.0n 0.5114 40499.9n 0.5114 40500.0n 0.6036 40799.9n 0.6036 40800.0n 0.5852 41099.9n 0.5852 41100.0n 0.6036 41399.9n 0.6036 41400.0n 0.4007 41699.9n 0.4007 41700.0n 0.3638 41999.9n 0.3638 42000.0n 0.5852 42299.9n 0.5852 42300.0n 0.5852 42599.9n 0.5852 42600.0n 0.5667 42899.9n 0.5667 42900.0n 0.3084 43199.9n 0.3084 43200.0n 0.3084 43499.9n 0.3084 43500.0n 0.4929 43799.9n 0.4929 43800.0n 0.6036 44099.9n 0.6036 44100.0n 0.4376 44399.9n 0.4376 44400.0n 0.3638 44699.9n 0.3638 44700.0n 0.5114 44999.9n 0.5114 45000.0n 0.5667 45299.9n 0.5667 45300.0n 0.3084 45599.9n 0.3084 45600.0n 0.5114 45899.9n 0.5114 45900.0n 0.6036 46199.9n 0.6036 46200.0n 0.5852 46499.9n 0.5852 46500.0n 0.6036 46799.9n 0.6036 46800.0n 0.4007 47099.9n 0.4007 47100.0n 0.3638 47399.9n 0.3638 47400.0n 0.5852 47699.9n 0.5852 47700.0n 0.5852 47999.9n 0.5852 48000.0n 0.5667 48299.9n 0.5667 48300.0n 0.3084 48599.9n 0.3084 48600.0n 0.3084 48899.9n 0.3084 48900.0n 0.4929 49199.9n 0.4929 49200.0n 0.6036 49499.9n 0.6036 49500.0n 0.4376 49799.9n 0.4376 49800.0n 0.3638 50099.9n 0.3638 50100.0n 0.5114 50399.9n 0.5114 50400.0n 0.5667 50699.9n 0.5667 50700.0n 0.3084 50999.9n 0.3084 51000.0n 0.5114 51299.9n 0.5114 51300.0n 0.6036 51599.9n 0.6036 51600.0n 0.5852 51899.9n 0.5852 51900.0n 0.6036 52199.9n 0.6036 52200.0n 0.4007 52499.9n 0.4007 52500.0n 0.3638 52799.9n 0.3638 52800.0n 0.5852 53099.9n 0.5852 53100.0n 0.5852 53399.9n 0.5852 53400.0n 0.5667 53699.9n 0.5667 53700.0n 0.3084 53999.9n 0.3084 54000.0n 0.5298 54299.9n 0.5298 54300.0n 0.4929 54599.9n 0.4929 54600.0n 0.4929 54899.9n 0.4929 54900.0n 0.5114 55199.9n 0.5114 55200.0n 0.4929 55499.9n 0.4929 55500.0n 0.5667 55799.9n 0.5667 55800.0n 0.3453 56099.9n 0.3453 56100.0n 0.4376 56399.9n 0.4376 56400.0n 0.3084 56699.9n 0.3084 56700.0n 0.3822 56999.9n 0.3822 57000.0n 0.3084 57299.9n 0.3084 57300.0n 0.3453 57599.9n 0.3453 57600.0n 0.5667 57899.9n 0.5667 57900.0n 0.5852 58199.9n 0.5852 58200.0n 0.6036 58499.9n 0.6036 58500.0n 0.5667 58799.9n 0.5667 58800.0n 0.5483 59099.9n 0.5483 59100.0n 0.4929)
Vxn10 a_xn10 0 PWL(0.0n 0.6916 299.9n 0.6916 300.0n 0.5071 599.9n 0.5071 600.0n 0.3964 899.9n 0.3964 900.0n 0.5624 1199.9n 0.5624 1200.0n 0.6362 1499.9n 0.6362 1500.0n 0.4886 1799.9n 0.4886 1800.0n 0.4333 2099.9n 0.4333 2100.0n 0.6916 2399.9n 0.6916 2400.0n 0.4886 2699.9n 0.4886 2700.0n 0.3964 2999.9n 0.3964 3000.0n 0.4148 3299.9n 0.4148 3300.0n 0.3964 3599.9n 0.3964 3600.0n 0.5993 3899.9n 0.5993 3900.0n 0.6362 4199.9n 0.6362 4200.0n 0.4148 4499.9n 0.4148 4500.0n 0.4148 4799.9n 0.4148 4800.0n 0.4333 5099.9n 0.4333 5100.0n 0.6916 5399.9n 0.6916 5400.0n 0.6916 5699.9n 0.6916 5700.0n 0.5071 5999.9n 0.5071 6000.0n 0.3964 6299.9n 0.3964 6300.0n 0.5624 6599.9n 0.5624 6600.0n 0.6362 6899.9n 0.6362 6900.0n 0.4886 7199.9n 0.4886 7200.0n 0.4333 7499.9n 0.4333 7500.0n 0.6916 7799.9n 0.6916 7800.0n 0.4886 8099.9n 0.4886 8100.0n 0.3964 8399.9n 0.3964 8400.0n 0.4148 8699.9n 0.4148 8700.0n 0.3964 8999.9n 0.3964 9000.0n 0.5993 9299.9n 0.5993 9300.0n 0.6362 9599.9n 0.6362 9600.0n 0.4148 9899.9n 0.4148 9900.0n 0.4148 10199.9n 0.4148 10200.0n 0.4333 10499.9n 0.4333 10500.0n 0.6916 10799.9n 0.6916 10800.0n 0.6916 11099.9n 0.6916 11100.0n 0.5071 11399.9n 0.5071 11400.0n 0.3964 11699.9n 0.3964 11700.0n 0.5624 11999.9n 0.5624 12000.0n 0.6362 12299.9n 0.6362 12300.0n 0.4886 12599.9n 0.4886 12600.0n 0.4333 12899.9n 0.4333 12900.0n 0.6916 13199.9n 0.6916 13200.0n 0.4886 13499.9n 0.4886 13500.0n 0.3964 13799.9n 0.3964 13800.0n 0.4148 14099.9n 0.4148 14100.0n 0.3964 14399.9n 0.3964 14400.0n 0.5993 14699.9n 0.5993 14700.0n 0.6362 14999.9n 0.6362 15000.0n 0.4148 15299.9n 0.4148 15300.0n 0.4148 15599.9n 0.4148 15600.0n 0.4333 15899.9n 0.4333 15900.0n 0.6916 16199.9n 0.6916 16200.0n 0.6916 16499.9n 0.6916 16500.0n 0.5071 16799.9n 0.5071 16800.0n 0.3964 17099.9n 0.3964 17100.0n 0.5624 17399.9n 0.5624 17400.0n 0.6362 17699.9n 0.6362 17700.0n 0.4886 17999.9n 0.4886 18000.0n 0.4333 18299.9n 0.4333 18300.0n 0.6916 18599.9n 0.6916 18600.0n 0.4886 18899.9n 0.4886 18900.0n 0.3964 19199.9n 0.3964 19200.0n 0.4148 19499.9n 0.4148 19500.0n 0.3964 19799.9n 0.3964 19800.0n 0.5993 20099.9n 0.5993 20100.0n 0.6362 20399.9n 0.6362 20400.0n 0.4148 20699.9n 0.4148 20700.0n 0.4148 20999.9n 0.4148 21000.0n 0.4333 21299.9n 0.4333 21300.0n 0.6916 21599.9n 0.6916 21600.0n 0.6916 21899.9n 0.6916 21900.0n 0.5071 22199.9n 0.5071 22200.0n 0.3964 22499.9n 0.3964 22500.0n 0.5624 22799.9n 0.5624 22800.0n 0.6362 23099.9n 0.6362 23100.0n 0.4886 23399.9n 0.4886 23400.0n 0.4333 23699.9n 0.4333 23700.0n 0.6916 23999.9n 0.6916 24000.0n 0.4886 24299.9n 0.4886 24300.0n 0.3964 24599.9n 0.3964 24600.0n 0.4148 24899.9n 0.4148 24900.0n 0.3964 25199.9n 0.3964 25200.0n 0.5993 25499.9n 0.5993 25500.0n 0.6362 25799.9n 0.6362 25800.0n 0.4148 26099.9n 0.4148 26100.0n 0.4148 26399.9n 0.4148 26400.0n 0.4333 26699.9n 0.4333 26700.0n 0.6916 26999.9n 0.6916 27000.0n 0.6916 27299.9n 0.6916 27300.0n 0.5071 27599.9n 0.5071 27600.0n 0.3964 27899.9n 0.3964 27900.0n 0.5624 28199.9n 0.5624 28200.0n 0.6362 28499.9n 0.6362 28500.0n 0.4886 28799.9n 0.4886 28800.0n 0.4333 29099.9n 0.4333 29100.0n 0.6916 29399.9n 0.6916 29400.0n 0.4886 29699.9n 0.4886 29700.0n 0.3964 29999.9n 0.3964 30000.0n 0.4148 30299.9n 0.4148 30300.0n 0.3964 30599.9n 0.3964 30600.0n 0.5993 30899.9n 0.5993 30900.0n 0.6362 31199.9n 0.6362 31200.0n 0.4148 31499.9n 0.4148 31500.0n 0.4148 31799.9n 0.4148 31800.0n 0.4333 32099.9n 0.4333 32100.0n 0.6916 32399.9n 0.6916 32400.0n 0.6916 32699.9n 0.6916 32700.0n 0.5071 32999.9n 0.5071 33000.0n 0.3964 33299.9n 0.3964 33300.0n 0.5624 33599.9n 0.5624 33600.0n 0.6362 33899.9n 0.6362 33900.0n 0.4886 34199.9n 0.4886 34200.0n 0.4333 34499.9n 0.4333 34500.0n 0.6916 34799.9n 0.6916 34800.0n 0.4886 35099.9n 0.4886 35100.0n 0.3964 35399.9n 0.3964 35400.0n 0.4148 35699.9n 0.4148 35700.0n 0.3964 35999.9n 0.3964 36000.0n 0.5993 36299.9n 0.5993 36300.0n 0.6362 36599.9n 0.6362 36600.0n 0.4148 36899.9n 0.4148 36900.0n 0.4148 37199.9n 0.4148 37200.0n 0.4333 37499.9n 0.4333 37500.0n 0.6916 37799.9n 0.6916 37800.0n 0.6916 38099.9n 0.6916 38100.0n 0.5071 38399.9n 0.5071 38400.0n 0.3964 38699.9n 0.3964 38700.0n 0.5624 38999.9n 0.5624 39000.0n 0.6362 39299.9n 0.6362 39300.0n 0.4886 39599.9n 0.4886 39600.0n 0.4333 39899.9n 0.4333 39900.0n 0.6916 40199.9n 0.6916 40200.0n 0.4886 40499.9n 0.4886 40500.0n 0.3964 40799.9n 0.3964 40800.0n 0.4148 41099.9n 0.4148 41100.0n 0.3964 41399.9n 0.3964 41400.0n 0.5993 41699.9n 0.5993 41700.0n 0.6362 41999.9n 0.6362 42000.0n 0.4148 42299.9n 0.4148 42300.0n 0.4148 42599.9n 0.4148 42600.0n 0.4333 42899.9n 0.4333 42900.0n 0.6916 43199.9n 0.6916 43200.0n 0.6916 43499.9n 0.6916 43500.0n 0.5071 43799.9n 0.5071 43800.0n 0.3964 44099.9n 0.3964 44100.0n 0.5624 44399.9n 0.5624 44400.0n 0.6362 44699.9n 0.6362 44700.0n 0.4886 44999.9n 0.4886 45000.0n 0.4333 45299.9n 0.4333 45300.0n 0.6916 45599.9n 0.6916 45600.0n 0.4886 45899.9n 0.4886 45900.0n 0.3964 46199.9n 0.3964 46200.0n 0.4148 46499.9n 0.4148 46500.0n 0.3964 46799.9n 0.3964 46800.0n 0.5993 47099.9n 0.5993 47100.0n 0.6362 47399.9n 0.6362 47400.0n 0.4148 47699.9n 0.4148 47700.0n 0.4148 47999.9n 0.4148 48000.0n 0.4333 48299.9n 0.4333 48300.0n 0.6916 48599.9n 0.6916 48600.0n 0.6916 48899.9n 0.6916 48900.0n 0.5071 49199.9n 0.5071 49200.0n 0.3964 49499.9n 0.3964 49500.0n 0.5624 49799.9n 0.5624 49800.0n 0.6362 50099.9n 0.6362 50100.0n 0.4886 50399.9n 0.4886 50400.0n 0.4333 50699.9n 0.4333 50700.0n 0.6916 50999.9n 0.6916 51000.0n 0.4886 51299.9n 0.4886 51300.0n 0.3964 51599.9n 0.3964 51600.0n 0.4148 51899.9n 0.4148 51900.0n 0.3964 52199.9n 0.3964 52200.0n 0.5993 52499.9n 0.5993 52500.0n 0.6362 52799.9n 0.6362 52800.0n 0.4148 53099.9n 0.4148 53100.0n 0.4148 53399.9n 0.4148 53400.0n 0.4333 53699.9n 0.4333 53700.0n 0.6916 53999.9n 0.6916 54000.0n 0.4702 54299.9n 0.4702 54300.0n 0.5071 54599.9n 0.5071 54600.0n 0.5071 54899.9n 0.5071 54900.0n 0.4886 55199.9n 0.4886 55200.0n 0.5071 55499.9n 0.5071 55500.0n 0.4333 55799.9n 0.4333 55800.0n 0.6547 56099.9n 0.6547 56100.0n 0.5624 56399.9n 0.5624 56400.0n 0.6916 56699.9n 0.6916 56700.0n 0.6178 56999.9n 0.6178 57000.0n 0.6916 57299.9n 0.6916 57300.0n 0.6547 57599.9n 0.6547 57600.0n 0.4333 57899.9n 0.4333 57900.0n 0.4148 58199.9n 0.4148 58200.0n 0.3964 58499.9n 0.3964 58500.0n 0.4333 58799.9n 0.4333 58800.0n 0.4517 59099.9n 0.4517 59100.0n 0.5071)
Vxp11 a_xp11 0 PWL(0.0n 0.2742 299.9n 0.2742 300.0n 0.5257 599.9n 0.5257 600.0n 0.3245 899.9n 0.3245 900.0n 0.6011 1199.9n 0.6011 1200.0n 0.4754 1499.9n 0.4754 1500.0n 0.5005 1799.9n 0.5005 1800.0n 0.4502 2099.9n 0.4502 2100.0n 0.2993 2399.9n 0.2993 2400.0n 0.3999 2699.9n 0.3999 2700.0n 0.4251 2999.9n 0.4251 3000.0n 0.4754 3299.9n 0.4754 3300.0n 0.6011 3599.9n 0.6011 3600.0n 0.5760 3899.9n 0.5760 3900.0n 0.6011 4199.9n 0.6011 4200.0n 0.5760 4499.9n 0.5760 4500.0n 0.4502 4799.9n 0.4502 4800.0n 0.5005 5099.9n 0.5005 5100.0n 0.2000 5399.9n 0.2000 5400.0n 0.2742 5699.9n 0.2742 5700.0n 0.5257 5999.9n 0.5257 6000.0n 0.3245 6299.9n 0.3245 6300.0n 0.6011 6599.9n 0.6011 6600.0n 0.4754 6899.9n 0.4754 6900.0n 0.5005 7199.9n 0.5005 7200.0n 0.4502 7499.9n 0.4502 7500.0n 0.2993 7799.9n 0.2993 7800.0n 0.3999 8099.9n 0.3999 8100.0n 0.4251 8399.9n 0.4251 8400.0n 0.4754 8699.9n 0.4754 8700.0n 0.6011 8999.9n 0.6011 9000.0n 0.5760 9299.9n 0.5760 9300.0n 0.6011 9599.9n 0.6011 9600.0n 0.5760 9899.9n 0.5760 9900.0n 0.4502 10199.9n 0.4502 10200.0n 0.5005 10499.9n 0.5005 10500.0n 0.2000 10799.9n 0.2000 10800.0n 0.2742 11099.9n 0.2742 11100.0n 0.5257 11399.9n 0.5257 11400.0n 0.3245 11699.9n 0.3245 11700.0n 0.6011 11999.9n 0.6011 12000.0n 0.4754 12299.9n 0.4754 12300.0n 0.5005 12599.9n 0.5005 12600.0n 0.4502 12899.9n 0.4502 12900.0n 0.2993 13199.9n 0.2993 13200.0n 0.3999 13499.9n 0.3999 13500.0n 0.4251 13799.9n 0.4251 13800.0n 0.4754 14099.9n 0.4754 14100.0n 0.6011 14399.9n 0.6011 14400.0n 0.5760 14699.9n 0.5760 14700.0n 0.6011 14999.9n 0.6011 15000.0n 0.5760 15299.9n 0.5760 15300.0n 0.4502 15599.9n 0.4502 15600.0n 0.5005 15899.9n 0.5005 15900.0n 0.2000 16199.9n 0.2000 16200.0n 0.2742 16499.9n 0.2742 16500.0n 0.5257 16799.9n 0.5257 16800.0n 0.3245 17099.9n 0.3245 17100.0n 0.6011 17399.9n 0.6011 17400.0n 0.4754 17699.9n 0.4754 17700.0n 0.5005 17999.9n 0.5005 18000.0n 0.4502 18299.9n 0.4502 18300.0n 0.2993 18599.9n 0.2993 18600.0n 0.3999 18899.9n 0.3999 18900.0n 0.4251 19199.9n 0.4251 19200.0n 0.4754 19499.9n 0.4754 19500.0n 0.6011 19799.9n 0.6011 19800.0n 0.5760 20099.9n 0.5760 20100.0n 0.6011 20399.9n 0.6011 20400.0n 0.5760 20699.9n 0.5760 20700.0n 0.4502 20999.9n 0.4502 21000.0n 0.5005 21299.9n 0.5005 21300.0n 0.2000 21599.9n 0.2000 21600.0n 0.2742 21899.9n 0.2742 21900.0n 0.5257 22199.9n 0.5257 22200.0n 0.3245 22499.9n 0.3245 22500.0n 0.6011 22799.9n 0.6011 22800.0n 0.4754 23099.9n 0.4754 23100.0n 0.5005 23399.9n 0.5005 23400.0n 0.4502 23699.9n 0.4502 23700.0n 0.2993 23999.9n 0.2993 24000.0n 0.3999 24299.9n 0.3999 24300.0n 0.4251 24599.9n 0.4251 24600.0n 0.4754 24899.9n 0.4754 24900.0n 0.6011 25199.9n 0.6011 25200.0n 0.5760 25499.9n 0.5760 25500.0n 0.6011 25799.9n 0.6011 25800.0n 0.5760 26099.9n 0.5760 26100.0n 0.4502 26399.9n 0.4502 26400.0n 0.5005 26699.9n 0.5005 26700.0n 0.2000 26999.9n 0.2000 27000.0n 0.2742 27299.9n 0.2742 27300.0n 0.5257 27599.9n 0.5257 27600.0n 0.3245 27899.9n 0.3245 27900.0n 0.6011 28199.9n 0.6011 28200.0n 0.4754 28499.9n 0.4754 28500.0n 0.5005 28799.9n 0.5005 28800.0n 0.4502 29099.9n 0.4502 29100.0n 0.2993 29399.9n 0.2993 29400.0n 0.3999 29699.9n 0.3999 29700.0n 0.4251 29999.9n 0.4251 30000.0n 0.4754 30299.9n 0.4754 30300.0n 0.6011 30599.9n 0.6011 30600.0n 0.5760 30899.9n 0.5760 30900.0n 0.6011 31199.9n 0.6011 31200.0n 0.5760 31499.9n 0.5760 31500.0n 0.4502 31799.9n 0.4502 31800.0n 0.5005 32099.9n 0.5005 32100.0n 0.2000 32399.9n 0.2000 32400.0n 0.2742 32699.9n 0.2742 32700.0n 0.5257 32999.9n 0.5257 33000.0n 0.3245 33299.9n 0.3245 33300.0n 0.6011 33599.9n 0.6011 33600.0n 0.4754 33899.9n 0.4754 33900.0n 0.5005 34199.9n 0.5005 34200.0n 0.4502 34499.9n 0.4502 34500.0n 0.2993 34799.9n 0.2993 34800.0n 0.3999 35099.9n 0.3999 35100.0n 0.4251 35399.9n 0.4251 35400.0n 0.4754 35699.9n 0.4754 35700.0n 0.6011 35999.9n 0.6011 36000.0n 0.5760 36299.9n 0.5760 36300.0n 0.6011 36599.9n 0.6011 36600.0n 0.5760 36899.9n 0.5760 36900.0n 0.4502 37199.9n 0.4502 37200.0n 0.5005 37499.9n 0.5005 37500.0n 0.2000 37799.9n 0.2000 37800.0n 0.2742 38099.9n 0.2742 38100.0n 0.5257 38399.9n 0.5257 38400.0n 0.3245 38699.9n 0.3245 38700.0n 0.6011 38999.9n 0.6011 39000.0n 0.4754 39299.9n 0.4754 39300.0n 0.5005 39599.9n 0.5005 39600.0n 0.4502 39899.9n 0.4502 39900.0n 0.2993 40199.9n 0.2993 40200.0n 0.3999 40499.9n 0.3999 40500.0n 0.4251 40799.9n 0.4251 40800.0n 0.4754 41099.9n 0.4754 41100.0n 0.6011 41399.9n 0.6011 41400.0n 0.5760 41699.9n 0.5760 41700.0n 0.6011 41999.9n 0.6011 42000.0n 0.5760 42299.9n 0.5760 42300.0n 0.4502 42599.9n 0.4502 42600.0n 0.5005 42899.9n 0.5005 42900.0n 0.2000 43199.9n 0.2000 43200.0n 0.2742 43499.9n 0.2742 43500.0n 0.5257 43799.9n 0.5257 43800.0n 0.3245 44099.9n 0.3245 44100.0n 0.6011 44399.9n 0.6011 44400.0n 0.4754 44699.9n 0.4754 44700.0n 0.5005 44999.9n 0.5005 45000.0n 0.4502 45299.9n 0.4502 45300.0n 0.2993 45599.9n 0.2993 45600.0n 0.3999 45899.9n 0.3999 45900.0n 0.4251 46199.9n 0.4251 46200.0n 0.4754 46499.9n 0.4754 46500.0n 0.6011 46799.9n 0.6011 46800.0n 0.5760 47099.9n 0.5760 47100.0n 0.6011 47399.9n 0.6011 47400.0n 0.5760 47699.9n 0.5760 47700.0n 0.4502 47999.9n 0.4502 48000.0n 0.5005 48299.9n 0.5005 48300.0n 0.2000 48599.9n 0.2000 48600.0n 0.2742 48899.9n 0.2742 48900.0n 0.5257 49199.9n 0.5257 49200.0n 0.3245 49499.9n 0.3245 49500.0n 0.6011 49799.9n 0.6011 49800.0n 0.4754 50099.9n 0.4754 50100.0n 0.5005 50399.9n 0.5005 50400.0n 0.4502 50699.9n 0.4502 50700.0n 0.2993 50999.9n 0.2993 51000.0n 0.3999 51299.9n 0.3999 51300.0n 0.4251 51599.9n 0.4251 51600.0n 0.4754 51899.9n 0.4754 51900.0n 0.6011 52199.9n 0.6011 52200.0n 0.5760 52499.9n 0.5760 52500.0n 0.6011 52799.9n 0.6011 52800.0n 0.5760 53099.9n 0.5760 53100.0n 0.4502 53399.9n 0.4502 53400.0n 0.5005 53699.9n 0.5005 53700.0n 0.2000 53999.9n 0.2000 54000.0n 0.5005 54299.9n 0.5005 54300.0n 0.5760 54599.9n 0.5760 54600.0n 0.5760 54899.9n 0.5760 54900.0n 0.6011 55199.9n 0.6011 55200.0n 0.5760 55499.9n 0.5760 55500.0n 0.5760 55799.9n 0.5760 55800.0n 0.6011 56099.9n 0.6011 56100.0n 0.6011 56399.9n 0.6011 56400.0n 0.2742 56699.9n 0.2742 56700.0n 0.6011 56999.9n 0.6011 57000.0n 0.2239 57299.9n 0.2239 57300.0n 0.6011 57599.9n 0.6011 57600.0n 0.5257 57899.9n 0.5257 57900.0n 0.5005 58199.9n 0.5005 58200.0n 0.4502 58499.9n 0.4502 58500.0n 0.3999 58799.9n 0.3999 58800.0n 0.4502 59099.9n 0.4502 59100.0n 0.2993)
Vxn11 a_xn11 0 PWL(0.0n 0.7258 299.9n 0.7258 300.0n 0.4743 599.9n 0.4743 600.0n 0.6755 899.9n 0.6755 900.0n 0.3989 1199.9n 0.3989 1200.0n 0.5246 1499.9n 0.5246 1500.0n 0.4995 1799.9n 0.4995 1800.0n 0.5498 2099.9n 0.5498 2100.0n 0.7007 2399.9n 0.7007 2400.0n 0.6001 2699.9n 0.6001 2700.0n 0.5749 2999.9n 0.5749 3000.0n 0.5246 3299.9n 0.5246 3300.0n 0.3989 3599.9n 0.3989 3600.0n 0.4240 3899.9n 0.4240 3900.0n 0.3989 4199.9n 0.3989 4200.0n 0.4240 4499.9n 0.4240 4500.0n 0.5498 4799.9n 0.5498 4800.0n 0.4995 5099.9n 0.4995 5100.0n 0.8000 5399.9n 0.8000 5400.0n 0.7258 5699.9n 0.7258 5700.0n 0.4743 5999.9n 0.4743 6000.0n 0.6755 6299.9n 0.6755 6300.0n 0.3989 6599.9n 0.3989 6600.0n 0.5246 6899.9n 0.5246 6900.0n 0.4995 7199.9n 0.4995 7200.0n 0.5498 7499.9n 0.5498 7500.0n 0.7007 7799.9n 0.7007 7800.0n 0.6001 8099.9n 0.6001 8100.0n 0.5749 8399.9n 0.5749 8400.0n 0.5246 8699.9n 0.5246 8700.0n 0.3989 8999.9n 0.3989 9000.0n 0.4240 9299.9n 0.4240 9300.0n 0.3989 9599.9n 0.3989 9600.0n 0.4240 9899.9n 0.4240 9900.0n 0.5498 10199.9n 0.5498 10200.0n 0.4995 10499.9n 0.4995 10500.0n 0.8000 10799.9n 0.8000 10800.0n 0.7258 11099.9n 0.7258 11100.0n 0.4743 11399.9n 0.4743 11400.0n 0.6755 11699.9n 0.6755 11700.0n 0.3989 11999.9n 0.3989 12000.0n 0.5246 12299.9n 0.5246 12300.0n 0.4995 12599.9n 0.4995 12600.0n 0.5498 12899.9n 0.5498 12900.0n 0.7007 13199.9n 0.7007 13200.0n 0.6001 13499.9n 0.6001 13500.0n 0.5749 13799.9n 0.5749 13800.0n 0.5246 14099.9n 0.5246 14100.0n 0.3989 14399.9n 0.3989 14400.0n 0.4240 14699.9n 0.4240 14700.0n 0.3989 14999.9n 0.3989 15000.0n 0.4240 15299.9n 0.4240 15300.0n 0.5498 15599.9n 0.5498 15600.0n 0.4995 15899.9n 0.4995 15900.0n 0.8000 16199.9n 0.8000 16200.0n 0.7258 16499.9n 0.7258 16500.0n 0.4743 16799.9n 0.4743 16800.0n 0.6755 17099.9n 0.6755 17100.0n 0.3989 17399.9n 0.3989 17400.0n 0.5246 17699.9n 0.5246 17700.0n 0.4995 17999.9n 0.4995 18000.0n 0.5498 18299.9n 0.5498 18300.0n 0.7007 18599.9n 0.7007 18600.0n 0.6001 18899.9n 0.6001 18900.0n 0.5749 19199.9n 0.5749 19200.0n 0.5246 19499.9n 0.5246 19500.0n 0.3989 19799.9n 0.3989 19800.0n 0.4240 20099.9n 0.4240 20100.0n 0.3989 20399.9n 0.3989 20400.0n 0.4240 20699.9n 0.4240 20700.0n 0.5498 20999.9n 0.5498 21000.0n 0.4995 21299.9n 0.4995 21300.0n 0.8000 21599.9n 0.8000 21600.0n 0.7258 21899.9n 0.7258 21900.0n 0.4743 22199.9n 0.4743 22200.0n 0.6755 22499.9n 0.6755 22500.0n 0.3989 22799.9n 0.3989 22800.0n 0.5246 23099.9n 0.5246 23100.0n 0.4995 23399.9n 0.4995 23400.0n 0.5498 23699.9n 0.5498 23700.0n 0.7007 23999.9n 0.7007 24000.0n 0.6001 24299.9n 0.6001 24300.0n 0.5749 24599.9n 0.5749 24600.0n 0.5246 24899.9n 0.5246 24900.0n 0.3989 25199.9n 0.3989 25200.0n 0.4240 25499.9n 0.4240 25500.0n 0.3989 25799.9n 0.3989 25800.0n 0.4240 26099.9n 0.4240 26100.0n 0.5498 26399.9n 0.5498 26400.0n 0.4995 26699.9n 0.4995 26700.0n 0.8000 26999.9n 0.8000 27000.0n 0.7258 27299.9n 0.7258 27300.0n 0.4743 27599.9n 0.4743 27600.0n 0.6755 27899.9n 0.6755 27900.0n 0.3989 28199.9n 0.3989 28200.0n 0.5246 28499.9n 0.5246 28500.0n 0.4995 28799.9n 0.4995 28800.0n 0.5498 29099.9n 0.5498 29100.0n 0.7007 29399.9n 0.7007 29400.0n 0.6001 29699.9n 0.6001 29700.0n 0.5749 29999.9n 0.5749 30000.0n 0.5246 30299.9n 0.5246 30300.0n 0.3989 30599.9n 0.3989 30600.0n 0.4240 30899.9n 0.4240 30900.0n 0.3989 31199.9n 0.3989 31200.0n 0.4240 31499.9n 0.4240 31500.0n 0.5498 31799.9n 0.5498 31800.0n 0.4995 32099.9n 0.4995 32100.0n 0.8000 32399.9n 0.8000 32400.0n 0.7258 32699.9n 0.7258 32700.0n 0.4743 32999.9n 0.4743 33000.0n 0.6755 33299.9n 0.6755 33300.0n 0.3989 33599.9n 0.3989 33600.0n 0.5246 33899.9n 0.5246 33900.0n 0.4995 34199.9n 0.4995 34200.0n 0.5498 34499.9n 0.5498 34500.0n 0.7007 34799.9n 0.7007 34800.0n 0.6001 35099.9n 0.6001 35100.0n 0.5749 35399.9n 0.5749 35400.0n 0.5246 35699.9n 0.5246 35700.0n 0.3989 35999.9n 0.3989 36000.0n 0.4240 36299.9n 0.4240 36300.0n 0.3989 36599.9n 0.3989 36600.0n 0.4240 36899.9n 0.4240 36900.0n 0.5498 37199.9n 0.5498 37200.0n 0.4995 37499.9n 0.4995 37500.0n 0.8000 37799.9n 0.8000 37800.0n 0.7258 38099.9n 0.7258 38100.0n 0.4743 38399.9n 0.4743 38400.0n 0.6755 38699.9n 0.6755 38700.0n 0.3989 38999.9n 0.3989 39000.0n 0.5246 39299.9n 0.5246 39300.0n 0.4995 39599.9n 0.4995 39600.0n 0.5498 39899.9n 0.5498 39900.0n 0.7007 40199.9n 0.7007 40200.0n 0.6001 40499.9n 0.6001 40500.0n 0.5749 40799.9n 0.5749 40800.0n 0.5246 41099.9n 0.5246 41100.0n 0.3989 41399.9n 0.3989 41400.0n 0.4240 41699.9n 0.4240 41700.0n 0.3989 41999.9n 0.3989 42000.0n 0.4240 42299.9n 0.4240 42300.0n 0.5498 42599.9n 0.5498 42600.0n 0.4995 42899.9n 0.4995 42900.0n 0.8000 43199.9n 0.8000 43200.0n 0.7258 43499.9n 0.7258 43500.0n 0.4743 43799.9n 0.4743 43800.0n 0.6755 44099.9n 0.6755 44100.0n 0.3989 44399.9n 0.3989 44400.0n 0.5246 44699.9n 0.5246 44700.0n 0.4995 44999.9n 0.4995 45000.0n 0.5498 45299.9n 0.5498 45300.0n 0.7007 45599.9n 0.7007 45600.0n 0.6001 45899.9n 0.6001 45900.0n 0.5749 46199.9n 0.5749 46200.0n 0.5246 46499.9n 0.5246 46500.0n 0.3989 46799.9n 0.3989 46800.0n 0.4240 47099.9n 0.4240 47100.0n 0.3989 47399.9n 0.3989 47400.0n 0.4240 47699.9n 0.4240 47700.0n 0.5498 47999.9n 0.5498 48000.0n 0.4995 48299.9n 0.4995 48300.0n 0.8000 48599.9n 0.8000 48600.0n 0.7258 48899.9n 0.7258 48900.0n 0.4743 49199.9n 0.4743 49200.0n 0.6755 49499.9n 0.6755 49500.0n 0.3989 49799.9n 0.3989 49800.0n 0.5246 50099.9n 0.5246 50100.0n 0.4995 50399.9n 0.4995 50400.0n 0.5498 50699.9n 0.5498 50700.0n 0.7007 50999.9n 0.7007 51000.0n 0.6001 51299.9n 0.6001 51300.0n 0.5749 51599.9n 0.5749 51600.0n 0.5246 51899.9n 0.5246 51900.0n 0.3989 52199.9n 0.3989 52200.0n 0.4240 52499.9n 0.4240 52500.0n 0.3989 52799.9n 0.3989 52800.0n 0.4240 53099.9n 0.4240 53100.0n 0.5498 53399.9n 0.5498 53400.0n 0.4995 53699.9n 0.4995 53700.0n 0.8000 53999.9n 0.8000 54000.0n 0.4995 54299.9n 0.4995 54300.0n 0.4240 54599.9n 0.4240 54600.0n 0.4240 54899.9n 0.4240 54900.0n 0.3989 55199.9n 0.3989 55200.0n 0.4240 55499.9n 0.4240 55500.0n 0.4240 55799.9n 0.4240 55800.0n 0.3989 56099.9n 0.3989 56100.0n 0.3989 56399.9n 0.3989 56400.0n 0.7258 56699.9n 0.7258 56700.0n 0.3989 56999.9n 0.3989 57000.0n 0.7761 57299.9n 0.7761 57300.0n 0.3989 57599.9n 0.3989 57600.0n 0.4743 57899.9n 0.4743 57900.0n 0.4995 58199.9n 0.4995 58200.0n 0.5498 58499.9n 0.5498 58500.0n 0.6001 58799.9n 0.6001 58800.0n 0.5498 59099.9n 0.5498 59100.0n 0.7007)
Vxp12 a_xp12 0 PWL(0.0n 0.6196 299.9n 0.6196 300.0n 0.5778 599.9n 0.5778 600.0n 0.4732 899.9n 0.4732 900.0n 0.5987 1199.9n 0.5987 1200.0n 0.6196 1499.9n 0.6196 1500.0n 0.2850 1799.9n 0.2850 1800.0n 0.4314 2099.9n 0.4314 2100.0n 0.5987 2399.9n 0.5987 2400.0n 0.6196 2699.9n 0.6196 2700.0n 0.5778 2999.9n 0.5778 3000.0n 0.5360 3299.9n 0.5360 3300.0n 0.6196 3599.9n 0.6196 3600.0n 0.6196 3899.9n 0.6196 3900.0n 0.6196 4199.9n 0.6196 4200.0n 0.4314 4499.9n 0.4314 4500.0n 0.6196 4799.9n 0.6196 4800.0n 0.5360 5099.9n 0.5360 5100.0n 0.5151 5399.9n 0.5151 5400.0n 0.6196 5699.9n 0.6196 5700.0n 0.5778 5999.9n 0.5778 6000.0n 0.4732 6299.9n 0.4732 6300.0n 0.5987 6599.9n 0.5987 6600.0n 0.6196 6899.9n 0.6196 6900.0n 0.2850 7199.9n 0.2850 7200.0n 0.4314 7499.9n 0.4314 7500.0n 0.5987 7799.9n 0.5987 7800.0n 0.6196 8099.9n 0.6196 8100.0n 0.5778 8399.9n 0.5778 8400.0n 0.5360 8699.9n 0.5360 8700.0n 0.6196 8999.9n 0.6196 9000.0n 0.6196 9299.9n 0.6196 9300.0n 0.6196 9599.9n 0.6196 9600.0n 0.4314 9899.9n 0.4314 9900.0n 0.6196 10199.9n 0.6196 10200.0n 0.5360 10499.9n 0.5360 10500.0n 0.5151 10799.9n 0.5151 10800.0n 0.6196 11099.9n 0.6196 11100.0n 0.5778 11399.9n 0.5778 11400.0n 0.4732 11699.9n 0.4732 11700.0n 0.5987 11999.9n 0.5987 12000.0n 0.6196 12299.9n 0.6196 12300.0n 0.2850 12599.9n 0.2850 12600.0n 0.4314 12899.9n 0.4314 12900.0n 0.5987 13199.9n 0.5987 13200.0n 0.6196 13499.9n 0.6196 13500.0n 0.5778 13799.9n 0.5778 13800.0n 0.5360 14099.9n 0.5360 14100.0n 0.6196 14399.9n 0.6196 14400.0n 0.6196 14699.9n 0.6196 14700.0n 0.6196 14999.9n 0.6196 15000.0n 0.4314 15299.9n 0.4314 15300.0n 0.6196 15599.9n 0.6196 15600.0n 0.5360 15899.9n 0.5360 15900.0n 0.5151 16199.9n 0.5151 16200.0n 0.6196 16499.9n 0.6196 16500.0n 0.5778 16799.9n 0.5778 16800.0n 0.4732 17099.9n 0.4732 17100.0n 0.5987 17399.9n 0.5987 17400.0n 0.6196 17699.9n 0.6196 17700.0n 0.2850 17999.9n 0.2850 18000.0n 0.4314 18299.9n 0.4314 18300.0n 0.5987 18599.9n 0.5987 18600.0n 0.6196 18899.9n 0.6196 18900.0n 0.5778 19199.9n 0.5778 19200.0n 0.5360 19499.9n 0.5360 19500.0n 0.6196 19799.9n 0.6196 19800.0n 0.6196 20099.9n 0.6196 20100.0n 0.6196 20399.9n 0.6196 20400.0n 0.4314 20699.9n 0.4314 20700.0n 0.6196 20999.9n 0.6196 21000.0n 0.5360 21299.9n 0.5360 21300.0n 0.5151 21599.9n 0.5151 21600.0n 0.6196 21899.9n 0.6196 21900.0n 0.5778 22199.9n 0.5778 22200.0n 0.4732 22499.9n 0.4732 22500.0n 0.5987 22799.9n 0.5987 22800.0n 0.6196 23099.9n 0.6196 23100.0n 0.2850 23399.9n 0.2850 23400.0n 0.4314 23699.9n 0.4314 23700.0n 0.5987 23999.9n 0.5987 24000.0n 0.6196 24299.9n 0.6196 24300.0n 0.5778 24599.9n 0.5778 24600.0n 0.5360 24899.9n 0.5360 24900.0n 0.6196 25199.9n 0.6196 25200.0n 0.6196 25499.9n 0.6196 25500.0n 0.6196 25799.9n 0.6196 25800.0n 0.4314 26099.9n 0.4314 26100.0n 0.6196 26399.9n 0.6196 26400.0n 0.5360 26699.9n 0.5360 26700.0n 0.5151 26999.9n 0.5151 27000.0n 0.6196 27299.9n 0.6196 27300.0n 0.5778 27599.9n 0.5778 27600.0n 0.4732 27899.9n 0.4732 27900.0n 0.5987 28199.9n 0.5987 28200.0n 0.6196 28499.9n 0.6196 28500.0n 0.2850 28799.9n 0.2850 28800.0n 0.4314 29099.9n 0.4314 29100.0n 0.5987 29399.9n 0.5987 29400.0n 0.6196 29699.9n 0.6196 29700.0n 0.5778 29999.9n 0.5778 30000.0n 0.5360 30299.9n 0.5360 30300.0n 0.6196 30599.9n 0.6196 30600.0n 0.6196 30899.9n 0.6196 30900.0n 0.6196 31199.9n 0.6196 31200.0n 0.4314 31499.9n 0.4314 31500.0n 0.6196 31799.9n 0.6196 31800.0n 0.5360 32099.9n 0.5360 32100.0n 0.5151 32399.9n 0.5151 32400.0n 0.6196 32699.9n 0.6196 32700.0n 0.5778 32999.9n 0.5778 33000.0n 0.4732 33299.9n 0.4732 33300.0n 0.5987 33599.9n 0.5987 33600.0n 0.6196 33899.9n 0.6196 33900.0n 0.2850 34199.9n 0.2850 34200.0n 0.4314 34499.9n 0.4314 34500.0n 0.5987 34799.9n 0.5987 34800.0n 0.6196 35099.9n 0.6196 35100.0n 0.5778 35399.9n 0.5778 35400.0n 0.5360 35699.9n 0.5360 35700.0n 0.6196 35999.9n 0.6196 36000.0n 0.6196 36299.9n 0.6196 36300.0n 0.6196 36599.9n 0.6196 36600.0n 0.4314 36899.9n 0.4314 36900.0n 0.6196 37199.9n 0.6196 37200.0n 0.5360 37499.9n 0.5360 37500.0n 0.5151 37799.9n 0.5151 37800.0n 0.6196 38099.9n 0.6196 38100.0n 0.5778 38399.9n 0.5778 38400.0n 0.4732 38699.9n 0.4732 38700.0n 0.5987 38999.9n 0.5987 39000.0n 0.6196 39299.9n 0.6196 39300.0n 0.2850 39599.9n 0.2850 39600.0n 0.4314 39899.9n 0.4314 39900.0n 0.5987 40199.9n 0.5987 40200.0n 0.6196 40499.9n 0.6196 40500.0n 0.5778 40799.9n 0.5778 40800.0n 0.5360 41099.9n 0.5360 41100.0n 0.6196 41399.9n 0.6196 41400.0n 0.6196 41699.9n 0.6196 41700.0n 0.6196 41999.9n 0.6196 42000.0n 0.4314 42299.9n 0.4314 42300.0n 0.6196 42599.9n 0.6196 42600.0n 0.5360 42899.9n 0.5360 42900.0n 0.5151 43199.9n 0.5151 43200.0n 0.6196 43499.9n 0.6196 43500.0n 0.5778 43799.9n 0.5778 43800.0n 0.4732 44099.9n 0.4732 44100.0n 0.5987 44399.9n 0.5987 44400.0n 0.6196 44699.9n 0.6196 44700.0n 0.2850 44999.9n 0.2850 45000.0n 0.4314 45299.9n 0.4314 45300.0n 0.5987 45599.9n 0.5987 45600.0n 0.6196 45899.9n 0.6196 45900.0n 0.5778 46199.9n 0.5778 46200.0n 0.5360 46499.9n 0.5360 46500.0n 0.6196 46799.9n 0.6196 46800.0n 0.6196 47099.9n 0.6196 47100.0n 0.6196 47399.9n 0.6196 47400.0n 0.4314 47699.9n 0.4314 47700.0n 0.6196 47999.9n 0.6196 48000.0n 0.5360 48299.9n 0.5360 48300.0n 0.5151 48599.9n 0.5151 48600.0n 0.6196 48899.9n 0.6196 48900.0n 0.5778 49199.9n 0.5778 49200.0n 0.4732 49499.9n 0.4732 49500.0n 0.5987 49799.9n 0.5987 49800.0n 0.6196 50099.9n 0.6196 50100.0n 0.2850 50399.9n 0.2850 50400.0n 0.4314 50699.9n 0.4314 50700.0n 0.5987 50999.9n 0.5987 51000.0n 0.6196 51299.9n 0.6196 51300.0n 0.5778 51599.9n 0.5778 51600.0n 0.5360 51899.9n 0.5360 51900.0n 0.6196 52199.9n 0.6196 52200.0n 0.6196 52499.9n 0.6196 52500.0n 0.6196 52799.9n 0.6196 52800.0n 0.4314 53099.9n 0.4314 53100.0n 0.6196 53399.9n 0.6196 53400.0n 0.5360 53699.9n 0.5360 53700.0n 0.5151 53999.9n 0.5151 54000.0n 0.5151 54299.9n 0.5151 54300.0n 0.5151 54599.9n 0.5151 54600.0n 0.5151 54899.9n 0.5151 54900.0n 0.6196 55199.9n 0.6196 55200.0n 0.5778 55499.9n 0.5778 55500.0n 0.4314 55799.9n 0.4314 55800.0n 0.6196 56099.9n 0.6196 56100.0n 0.6196 56399.9n 0.6196 56400.0n 0.5987 56699.9n 0.5987 56700.0n 0.4942 56999.9n 0.4942 57000.0n 0.6196 57299.9n 0.6196 57300.0n 0.6196 57599.9n 0.6196 57600.0n 0.4732 57899.9n 0.4732 57900.0n 0.6196 58199.9n 0.6196 58200.0n 0.5778 58499.9n 0.5778 58500.0n 0.5778 58799.9n 0.5778 58800.0n 0.6196 59099.9n 0.6196 59100.0n 0.4942)
Vxn12 a_xn12 0 PWL(0.0n 0.3804 299.9n 0.3804 300.0n 0.4222 599.9n 0.4222 600.0n 0.5268 899.9n 0.5268 900.0n 0.4013 1199.9n 0.4013 1200.0n 0.3804 1499.9n 0.3804 1500.0n 0.7150 1799.9n 0.7150 1800.0n 0.5686 2099.9n 0.5686 2100.0n 0.4013 2399.9n 0.4013 2400.0n 0.3804 2699.9n 0.3804 2700.0n 0.4222 2999.9n 0.4222 3000.0n 0.4640 3299.9n 0.4640 3300.0n 0.3804 3599.9n 0.3804 3600.0n 0.3804 3899.9n 0.3804 3900.0n 0.3804 4199.9n 0.3804 4200.0n 0.5686 4499.9n 0.5686 4500.0n 0.3804 4799.9n 0.3804 4800.0n 0.4640 5099.9n 0.4640 5100.0n 0.4849 5399.9n 0.4849 5400.0n 0.3804 5699.9n 0.3804 5700.0n 0.4222 5999.9n 0.4222 6000.0n 0.5268 6299.9n 0.5268 6300.0n 0.4013 6599.9n 0.4013 6600.0n 0.3804 6899.9n 0.3804 6900.0n 0.7150 7199.9n 0.7150 7200.0n 0.5686 7499.9n 0.5686 7500.0n 0.4013 7799.9n 0.4013 7800.0n 0.3804 8099.9n 0.3804 8100.0n 0.4222 8399.9n 0.4222 8400.0n 0.4640 8699.9n 0.4640 8700.0n 0.3804 8999.9n 0.3804 9000.0n 0.3804 9299.9n 0.3804 9300.0n 0.3804 9599.9n 0.3804 9600.0n 0.5686 9899.9n 0.5686 9900.0n 0.3804 10199.9n 0.3804 10200.0n 0.4640 10499.9n 0.4640 10500.0n 0.4849 10799.9n 0.4849 10800.0n 0.3804 11099.9n 0.3804 11100.0n 0.4222 11399.9n 0.4222 11400.0n 0.5268 11699.9n 0.5268 11700.0n 0.4013 11999.9n 0.4013 12000.0n 0.3804 12299.9n 0.3804 12300.0n 0.7150 12599.9n 0.7150 12600.0n 0.5686 12899.9n 0.5686 12900.0n 0.4013 13199.9n 0.4013 13200.0n 0.3804 13499.9n 0.3804 13500.0n 0.4222 13799.9n 0.4222 13800.0n 0.4640 14099.9n 0.4640 14100.0n 0.3804 14399.9n 0.3804 14400.0n 0.3804 14699.9n 0.3804 14700.0n 0.3804 14999.9n 0.3804 15000.0n 0.5686 15299.9n 0.5686 15300.0n 0.3804 15599.9n 0.3804 15600.0n 0.4640 15899.9n 0.4640 15900.0n 0.4849 16199.9n 0.4849 16200.0n 0.3804 16499.9n 0.3804 16500.0n 0.4222 16799.9n 0.4222 16800.0n 0.5268 17099.9n 0.5268 17100.0n 0.4013 17399.9n 0.4013 17400.0n 0.3804 17699.9n 0.3804 17700.0n 0.7150 17999.9n 0.7150 18000.0n 0.5686 18299.9n 0.5686 18300.0n 0.4013 18599.9n 0.4013 18600.0n 0.3804 18899.9n 0.3804 18900.0n 0.4222 19199.9n 0.4222 19200.0n 0.4640 19499.9n 0.4640 19500.0n 0.3804 19799.9n 0.3804 19800.0n 0.3804 20099.9n 0.3804 20100.0n 0.3804 20399.9n 0.3804 20400.0n 0.5686 20699.9n 0.5686 20700.0n 0.3804 20999.9n 0.3804 21000.0n 0.4640 21299.9n 0.4640 21300.0n 0.4849 21599.9n 0.4849 21600.0n 0.3804 21899.9n 0.3804 21900.0n 0.4222 22199.9n 0.4222 22200.0n 0.5268 22499.9n 0.5268 22500.0n 0.4013 22799.9n 0.4013 22800.0n 0.3804 23099.9n 0.3804 23100.0n 0.7150 23399.9n 0.7150 23400.0n 0.5686 23699.9n 0.5686 23700.0n 0.4013 23999.9n 0.4013 24000.0n 0.3804 24299.9n 0.3804 24300.0n 0.4222 24599.9n 0.4222 24600.0n 0.4640 24899.9n 0.4640 24900.0n 0.3804 25199.9n 0.3804 25200.0n 0.3804 25499.9n 0.3804 25500.0n 0.3804 25799.9n 0.3804 25800.0n 0.5686 26099.9n 0.5686 26100.0n 0.3804 26399.9n 0.3804 26400.0n 0.4640 26699.9n 0.4640 26700.0n 0.4849 26999.9n 0.4849 27000.0n 0.3804 27299.9n 0.3804 27300.0n 0.4222 27599.9n 0.4222 27600.0n 0.5268 27899.9n 0.5268 27900.0n 0.4013 28199.9n 0.4013 28200.0n 0.3804 28499.9n 0.3804 28500.0n 0.7150 28799.9n 0.7150 28800.0n 0.5686 29099.9n 0.5686 29100.0n 0.4013 29399.9n 0.4013 29400.0n 0.3804 29699.9n 0.3804 29700.0n 0.4222 29999.9n 0.4222 30000.0n 0.4640 30299.9n 0.4640 30300.0n 0.3804 30599.9n 0.3804 30600.0n 0.3804 30899.9n 0.3804 30900.0n 0.3804 31199.9n 0.3804 31200.0n 0.5686 31499.9n 0.5686 31500.0n 0.3804 31799.9n 0.3804 31800.0n 0.4640 32099.9n 0.4640 32100.0n 0.4849 32399.9n 0.4849 32400.0n 0.3804 32699.9n 0.3804 32700.0n 0.4222 32999.9n 0.4222 33000.0n 0.5268 33299.9n 0.5268 33300.0n 0.4013 33599.9n 0.4013 33600.0n 0.3804 33899.9n 0.3804 33900.0n 0.7150 34199.9n 0.7150 34200.0n 0.5686 34499.9n 0.5686 34500.0n 0.4013 34799.9n 0.4013 34800.0n 0.3804 35099.9n 0.3804 35100.0n 0.4222 35399.9n 0.4222 35400.0n 0.4640 35699.9n 0.4640 35700.0n 0.3804 35999.9n 0.3804 36000.0n 0.3804 36299.9n 0.3804 36300.0n 0.3804 36599.9n 0.3804 36600.0n 0.5686 36899.9n 0.5686 36900.0n 0.3804 37199.9n 0.3804 37200.0n 0.4640 37499.9n 0.4640 37500.0n 0.4849 37799.9n 0.4849 37800.0n 0.3804 38099.9n 0.3804 38100.0n 0.4222 38399.9n 0.4222 38400.0n 0.5268 38699.9n 0.5268 38700.0n 0.4013 38999.9n 0.4013 39000.0n 0.3804 39299.9n 0.3804 39300.0n 0.7150 39599.9n 0.7150 39600.0n 0.5686 39899.9n 0.5686 39900.0n 0.4013 40199.9n 0.4013 40200.0n 0.3804 40499.9n 0.3804 40500.0n 0.4222 40799.9n 0.4222 40800.0n 0.4640 41099.9n 0.4640 41100.0n 0.3804 41399.9n 0.3804 41400.0n 0.3804 41699.9n 0.3804 41700.0n 0.3804 41999.9n 0.3804 42000.0n 0.5686 42299.9n 0.5686 42300.0n 0.3804 42599.9n 0.3804 42600.0n 0.4640 42899.9n 0.4640 42900.0n 0.4849 43199.9n 0.4849 43200.0n 0.3804 43499.9n 0.3804 43500.0n 0.4222 43799.9n 0.4222 43800.0n 0.5268 44099.9n 0.5268 44100.0n 0.4013 44399.9n 0.4013 44400.0n 0.3804 44699.9n 0.3804 44700.0n 0.7150 44999.9n 0.7150 45000.0n 0.5686 45299.9n 0.5686 45300.0n 0.4013 45599.9n 0.4013 45600.0n 0.3804 45899.9n 0.3804 45900.0n 0.4222 46199.9n 0.4222 46200.0n 0.4640 46499.9n 0.4640 46500.0n 0.3804 46799.9n 0.3804 46800.0n 0.3804 47099.9n 0.3804 47100.0n 0.3804 47399.9n 0.3804 47400.0n 0.5686 47699.9n 0.5686 47700.0n 0.3804 47999.9n 0.3804 48000.0n 0.4640 48299.9n 0.4640 48300.0n 0.4849 48599.9n 0.4849 48600.0n 0.3804 48899.9n 0.3804 48900.0n 0.4222 49199.9n 0.4222 49200.0n 0.5268 49499.9n 0.5268 49500.0n 0.4013 49799.9n 0.4013 49800.0n 0.3804 50099.9n 0.3804 50100.0n 0.7150 50399.9n 0.7150 50400.0n 0.5686 50699.9n 0.5686 50700.0n 0.4013 50999.9n 0.4013 51000.0n 0.3804 51299.9n 0.3804 51300.0n 0.4222 51599.9n 0.4222 51600.0n 0.4640 51899.9n 0.4640 51900.0n 0.3804 52199.9n 0.3804 52200.0n 0.3804 52499.9n 0.3804 52500.0n 0.3804 52799.9n 0.3804 52800.0n 0.5686 53099.9n 0.5686 53100.0n 0.3804 53399.9n 0.3804 53400.0n 0.4640 53699.9n 0.4640 53700.0n 0.4849 53999.9n 0.4849 54000.0n 0.4849 54299.9n 0.4849 54300.0n 0.4849 54599.9n 0.4849 54600.0n 0.4849 54899.9n 0.4849 54900.0n 0.3804 55199.9n 0.3804 55200.0n 0.4222 55499.9n 0.4222 55500.0n 0.5686 55799.9n 0.5686 55800.0n 0.3804 56099.9n 0.3804 56100.0n 0.3804 56399.9n 0.3804 56400.0n 0.4013 56699.9n 0.4013 56700.0n 0.5058 56999.9n 0.5058 57000.0n 0.3804 57299.9n 0.3804 57300.0n 0.3804 57599.9n 0.3804 57600.0n 0.5268 57899.9n 0.5268 57900.0n 0.3804 58199.9n 0.3804 58200.0n 0.4222 58499.9n 0.4222 58500.0n 0.4222 58799.9n 0.4222 58800.0n 0.3804 59099.9n 0.3804 59100.0n 0.5058)
Vxp13 a_xp13 0 PWL(0.0n 0.6293 299.9n 0.6293 300.0n 0.5797 599.9n 0.5797 600.0n 0.5797 899.9n 0.5797 900.0n 0.6293 1199.9n 0.6293 1200.0n 0.6293 1499.9n 0.6293 1500.0n 0.6293 1799.9n 0.6293 1800.0n 0.5797 2099.9n 0.5797 2100.0n 0.6293 2399.9n 0.6293 2400.0n 0.3649 2699.9n 0.3649 2700.0n 0.4145 2999.9n 0.4145 3000.0n 0.3649 3299.9n 0.3649 3300.0n 0.4640 3599.9n 0.4640 3600.0n 0.5467 3899.9n 0.5467 3900.0n 0.4145 4199.9n 0.4145 4200.0n 0.3649 4499.9n 0.3649 4500.0n 0.3649 4799.9n 0.3649 4800.0n 0.4310 5099.9n 0.4310 5100.0n 0.6293 5399.9n 0.6293 5400.0n 0.6293 5699.9n 0.6293 5700.0n 0.5797 5999.9n 0.5797 6000.0n 0.5797 6299.9n 0.5797 6300.0n 0.6293 6599.9n 0.6293 6600.0n 0.6293 6899.9n 0.6293 6900.0n 0.6293 7199.9n 0.6293 7200.0n 0.5797 7499.9n 0.5797 7500.0n 0.6293 7799.9n 0.6293 7800.0n 0.3649 8099.9n 0.3649 8100.0n 0.4145 8399.9n 0.4145 8400.0n 0.3649 8699.9n 0.3649 8700.0n 0.4640 8999.9n 0.4640 9000.0n 0.5467 9299.9n 0.5467 9300.0n 0.4145 9599.9n 0.4145 9600.0n 0.3649 9899.9n 0.3649 9900.0n 0.3649 10199.9n 0.3649 10200.0n 0.4310 10499.9n 0.4310 10500.0n 0.6293 10799.9n 0.6293 10800.0n 0.6293 11099.9n 0.6293 11100.0n 0.5797 11399.9n 0.5797 11400.0n 0.5797 11699.9n 0.5797 11700.0n 0.6293 11999.9n 0.6293 12000.0n 0.6293 12299.9n 0.6293 12300.0n 0.6293 12599.9n 0.6293 12600.0n 0.5797 12899.9n 0.5797 12900.0n 0.6293 13199.9n 0.6293 13200.0n 0.3649 13499.9n 0.3649 13500.0n 0.4145 13799.9n 0.4145 13800.0n 0.3649 14099.9n 0.3649 14100.0n 0.4640 14399.9n 0.4640 14400.0n 0.5467 14699.9n 0.5467 14700.0n 0.4145 14999.9n 0.4145 15000.0n 0.3649 15299.9n 0.3649 15300.0n 0.3649 15599.9n 0.3649 15600.0n 0.4310 15899.9n 0.4310 15900.0n 0.6293 16199.9n 0.6293 16200.0n 0.6293 16499.9n 0.6293 16500.0n 0.5797 16799.9n 0.5797 16800.0n 0.5797 17099.9n 0.5797 17100.0n 0.6293 17399.9n 0.6293 17400.0n 0.6293 17699.9n 0.6293 17700.0n 0.6293 17999.9n 0.6293 18000.0n 0.5797 18299.9n 0.5797 18300.0n 0.6293 18599.9n 0.6293 18600.0n 0.3649 18899.9n 0.3649 18900.0n 0.4145 19199.9n 0.4145 19200.0n 0.3649 19499.9n 0.3649 19500.0n 0.4640 19799.9n 0.4640 19800.0n 0.5467 20099.9n 0.5467 20100.0n 0.4145 20399.9n 0.4145 20400.0n 0.3649 20699.9n 0.3649 20700.0n 0.3649 20999.9n 0.3649 21000.0n 0.4310 21299.9n 0.4310 21300.0n 0.6293 21599.9n 0.6293 21600.0n 0.6293 21899.9n 0.6293 21900.0n 0.5797 22199.9n 0.5797 22200.0n 0.5797 22499.9n 0.5797 22500.0n 0.6293 22799.9n 0.6293 22800.0n 0.6293 23099.9n 0.6293 23100.0n 0.6293 23399.9n 0.6293 23400.0n 0.5797 23699.9n 0.5797 23700.0n 0.6293 23999.9n 0.6293 24000.0n 0.3649 24299.9n 0.3649 24300.0n 0.4145 24599.9n 0.4145 24600.0n 0.3649 24899.9n 0.3649 24900.0n 0.4640 25199.9n 0.4640 25200.0n 0.5467 25499.9n 0.5467 25500.0n 0.4145 25799.9n 0.4145 25800.0n 0.3649 26099.9n 0.3649 26100.0n 0.3649 26399.9n 0.3649 26400.0n 0.4310 26699.9n 0.4310 26700.0n 0.6293 26999.9n 0.6293 27000.0n 0.6293 27299.9n 0.6293 27300.0n 0.5797 27599.9n 0.5797 27600.0n 0.5797 27899.9n 0.5797 27900.0n 0.6293 28199.9n 0.6293 28200.0n 0.6293 28499.9n 0.6293 28500.0n 0.6293 28799.9n 0.6293 28800.0n 0.5797 29099.9n 0.5797 29100.0n 0.6293 29399.9n 0.6293 29400.0n 0.3649 29699.9n 0.3649 29700.0n 0.4145 29999.9n 0.4145 30000.0n 0.3649 30299.9n 0.3649 30300.0n 0.4640 30599.9n 0.4640 30600.0n 0.5467 30899.9n 0.5467 30900.0n 0.4145 31199.9n 0.4145 31200.0n 0.3649 31499.9n 0.3649 31500.0n 0.3649 31799.9n 0.3649 31800.0n 0.4310 32099.9n 0.4310 32100.0n 0.6293 32399.9n 0.6293 32400.0n 0.6293 32699.9n 0.6293 32700.0n 0.5797 32999.9n 0.5797 33000.0n 0.5797 33299.9n 0.5797 33300.0n 0.6293 33599.9n 0.6293 33600.0n 0.6293 33899.9n 0.6293 33900.0n 0.6293 34199.9n 0.6293 34200.0n 0.5797 34499.9n 0.5797 34500.0n 0.6293 34799.9n 0.6293 34800.0n 0.3649 35099.9n 0.3649 35100.0n 0.4145 35399.9n 0.4145 35400.0n 0.3649 35699.9n 0.3649 35700.0n 0.4640 35999.9n 0.4640 36000.0n 0.5467 36299.9n 0.5467 36300.0n 0.4145 36599.9n 0.4145 36600.0n 0.3649 36899.9n 0.3649 36900.0n 0.3649 37199.9n 0.3649 37200.0n 0.4310 37499.9n 0.4310 37500.0n 0.6293 37799.9n 0.6293 37800.0n 0.6293 38099.9n 0.6293 38100.0n 0.5797 38399.9n 0.5797 38400.0n 0.5797 38699.9n 0.5797 38700.0n 0.6293 38999.9n 0.6293 39000.0n 0.6293 39299.9n 0.6293 39300.0n 0.6293 39599.9n 0.6293 39600.0n 0.5797 39899.9n 0.5797 39900.0n 0.6293 40199.9n 0.6293 40200.0n 0.3649 40499.9n 0.3649 40500.0n 0.4145 40799.9n 0.4145 40800.0n 0.3649 41099.9n 0.3649 41100.0n 0.4640 41399.9n 0.4640 41400.0n 0.5467 41699.9n 0.5467 41700.0n 0.4145 41999.9n 0.4145 42000.0n 0.3649 42299.9n 0.3649 42300.0n 0.3649 42599.9n 0.3649 42600.0n 0.4310 42899.9n 0.4310 42900.0n 0.6293 43199.9n 0.6293 43200.0n 0.6293 43499.9n 0.6293 43500.0n 0.5797 43799.9n 0.5797 43800.0n 0.5797 44099.9n 0.5797 44100.0n 0.6293 44399.9n 0.6293 44400.0n 0.6293 44699.9n 0.6293 44700.0n 0.6293 44999.9n 0.6293 45000.0n 0.5797 45299.9n 0.5797 45300.0n 0.6293 45599.9n 0.6293 45600.0n 0.3649 45899.9n 0.3649 45900.0n 0.4145 46199.9n 0.4145 46200.0n 0.3649 46499.9n 0.3649 46500.0n 0.4640 46799.9n 0.4640 46800.0n 0.5467 47099.9n 0.5467 47100.0n 0.4145 47399.9n 0.4145 47400.0n 0.3649 47699.9n 0.3649 47700.0n 0.3649 47999.9n 0.3649 48000.0n 0.4310 48299.9n 0.4310 48300.0n 0.6293 48599.9n 0.6293 48600.0n 0.6293 48899.9n 0.6293 48900.0n 0.5797 49199.9n 0.5797 49200.0n 0.5797 49499.9n 0.5797 49500.0n 0.6293 49799.9n 0.6293 49800.0n 0.6293 50099.9n 0.6293 50100.0n 0.6293 50399.9n 0.6293 50400.0n 0.5797 50699.9n 0.5797 50700.0n 0.6293 50999.9n 0.6293 51000.0n 0.3649 51299.9n 0.3649 51300.0n 0.4145 51599.9n 0.4145 51600.0n 0.3649 51899.9n 0.3649 51900.0n 0.4640 52199.9n 0.4640 52200.0n 0.5467 52499.9n 0.5467 52500.0n 0.4145 52799.9n 0.4145 52800.0n 0.3649 53099.9n 0.3649 53100.0n 0.3649 53399.9n 0.3649 53400.0n 0.4310 53699.9n 0.4310 53700.0n 0.6293 53999.9n 0.6293 54000.0n 0.4971 54299.9n 0.4971 54300.0n 0.6128 54599.9n 0.6128 54600.0n 0.6128 54899.9n 0.6128 54900.0n 0.6293 55199.9n 0.6293 55200.0n 0.5962 55499.9n 0.5962 55500.0n 0.6128 55799.9n 0.6128 55800.0n 0.3979 56099.9n 0.3979 56100.0n 0.4806 56399.9n 0.4806 56400.0n 0.5962 56699.9n 0.5962 56700.0n 0.3649 56999.9n 0.3649 57000.0n 0.6293 57299.9n 0.6293 57300.0n 0.5467 57599.9n 0.5467 57600.0n 0.3649 57899.9n 0.3649 57900.0n 0.4806 58199.9n 0.4806 58200.0n 0.4310 58499.9n 0.4310 58500.0n 0.4971 58799.9n 0.4971 58800.0n 0.3979 59099.9n 0.3979 59100.0n 0.5632)
Vxn13 a_xn13 0 PWL(0.0n 0.3707 299.9n 0.3707 300.0n 0.4203 599.9n 0.4203 600.0n 0.4203 899.9n 0.4203 900.0n 0.3707 1199.9n 0.3707 1200.0n 0.3707 1499.9n 0.3707 1500.0n 0.3707 1799.9n 0.3707 1800.0n 0.4203 2099.9n 0.4203 2100.0n 0.3707 2399.9n 0.3707 2400.0n 0.6351 2699.9n 0.6351 2700.0n 0.5855 2999.9n 0.5855 3000.0n 0.6351 3299.9n 0.6351 3300.0n 0.5360 3599.9n 0.5360 3600.0n 0.4533 3899.9n 0.4533 3900.0n 0.5855 4199.9n 0.5855 4200.0n 0.6351 4499.9n 0.6351 4500.0n 0.6351 4799.9n 0.6351 4800.0n 0.5690 5099.9n 0.5690 5100.0n 0.3707 5399.9n 0.3707 5400.0n 0.3707 5699.9n 0.3707 5700.0n 0.4203 5999.9n 0.4203 6000.0n 0.4203 6299.9n 0.4203 6300.0n 0.3707 6599.9n 0.3707 6600.0n 0.3707 6899.9n 0.3707 6900.0n 0.3707 7199.9n 0.3707 7200.0n 0.4203 7499.9n 0.4203 7500.0n 0.3707 7799.9n 0.3707 7800.0n 0.6351 8099.9n 0.6351 8100.0n 0.5855 8399.9n 0.5855 8400.0n 0.6351 8699.9n 0.6351 8700.0n 0.5360 8999.9n 0.5360 9000.0n 0.4533 9299.9n 0.4533 9300.0n 0.5855 9599.9n 0.5855 9600.0n 0.6351 9899.9n 0.6351 9900.0n 0.6351 10199.9n 0.6351 10200.0n 0.5690 10499.9n 0.5690 10500.0n 0.3707 10799.9n 0.3707 10800.0n 0.3707 11099.9n 0.3707 11100.0n 0.4203 11399.9n 0.4203 11400.0n 0.4203 11699.9n 0.4203 11700.0n 0.3707 11999.9n 0.3707 12000.0n 0.3707 12299.9n 0.3707 12300.0n 0.3707 12599.9n 0.3707 12600.0n 0.4203 12899.9n 0.4203 12900.0n 0.3707 13199.9n 0.3707 13200.0n 0.6351 13499.9n 0.6351 13500.0n 0.5855 13799.9n 0.5855 13800.0n 0.6351 14099.9n 0.6351 14100.0n 0.5360 14399.9n 0.5360 14400.0n 0.4533 14699.9n 0.4533 14700.0n 0.5855 14999.9n 0.5855 15000.0n 0.6351 15299.9n 0.6351 15300.0n 0.6351 15599.9n 0.6351 15600.0n 0.5690 15899.9n 0.5690 15900.0n 0.3707 16199.9n 0.3707 16200.0n 0.3707 16499.9n 0.3707 16500.0n 0.4203 16799.9n 0.4203 16800.0n 0.4203 17099.9n 0.4203 17100.0n 0.3707 17399.9n 0.3707 17400.0n 0.3707 17699.9n 0.3707 17700.0n 0.3707 17999.9n 0.3707 18000.0n 0.4203 18299.9n 0.4203 18300.0n 0.3707 18599.9n 0.3707 18600.0n 0.6351 18899.9n 0.6351 18900.0n 0.5855 19199.9n 0.5855 19200.0n 0.6351 19499.9n 0.6351 19500.0n 0.5360 19799.9n 0.5360 19800.0n 0.4533 20099.9n 0.4533 20100.0n 0.5855 20399.9n 0.5855 20400.0n 0.6351 20699.9n 0.6351 20700.0n 0.6351 20999.9n 0.6351 21000.0n 0.5690 21299.9n 0.5690 21300.0n 0.3707 21599.9n 0.3707 21600.0n 0.3707 21899.9n 0.3707 21900.0n 0.4203 22199.9n 0.4203 22200.0n 0.4203 22499.9n 0.4203 22500.0n 0.3707 22799.9n 0.3707 22800.0n 0.3707 23099.9n 0.3707 23100.0n 0.3707 23399.9n 0.3707 23400.0n 0.4203 23699.9n 0.4203 23700.0n 0.3707 23999.9n 0.3707 24000.0n 0.6351 24299.9n 0.6351 24300.0n 0.5855 24599.9n 0.5855 24600.0n 0.6351 24899.9n 0.6351 24900.0n 0.5360 25199.9n 0.5360 25200.0n 0.4533 25499.9n 0.4533 25500.0n 0.5855 25799.9n 0.5855 25800.0n 0.6351 26099.9n 0.6351 26100.0n 0.6351 26399.9n 0.6351 26400.0n 0.5690 26699.9n 0.5690 26700.0n 0.3707 26999.9n 0.3707 27000.0n 0.3707 27299.9n 0.3707 27300.0n 0.4203 27599.9n 0.4203 27600.0n 0.4203 27899.9n 0.4203 27900.0n 0.3707 28199.9n 0.3707 28200.0n 0.3707 28499.9n 0.3707 28500.0n 0.3707 28799.9n 0.3707 28800.0n 0.4203 29099.9n 0.4203 29100.0n 0.3707 29399.9n 0.3707 29400.0n 0.6351 29699.9n 0.6351 29700.0n 0.5855 29999.9n 0.5855 30000.0n 0.6351 30299.9n 0.6351 30300.0n 0.5360 30599.9n 0.5360 30600.0n 0.4533 30899.9n 0.4533 30900.0n 0.5855 31199.9n 0.5855 31200.0n 0.6351 31499.9n 0.6351 31500.0n 0.6351 31799.9n 0.6351 31800.0n 0.5690 32099.9n 0.5690 32100.0n 0.3707 32399.9n 0.3707 32400.0n 0.3707 32699.9n 0.3707 32700.0n 0.4203 32999.9n 0.4203 33000.0n 0.4203 33299.9n 0.4203 33300.0n 0.3707 33599.9n 0.3707 33600.0n 0.3707 33899.9n 0.3707 33900.0n 0.3707 34199.9n 0.3707 34200.0n 0.4203 34499.9n 0.4203 34500.0n 0.3707 34799.9n 0.3707 34800.0n 0.6351 35099.9n 0.6351 35100.0n 0.5855 35399.9n 0.5855 35400.0n 0.6351 35699.9n 0.6351 35700.0n 0.5360 35999.9n 0.5360 36000.0n 0.4533 36299.9n 0.4533 36300.0n 0.5855 36599.9n 0.5855 36600.0n 0.6351 36899.9n 0.6351 36900.0n 0.6351 37199.9n 0.6351 37200.0n 0.5690 37499.9n 0.5690 37500.0n 0.3707 37799.9n 0.3707 37800.0n 0.3707 38099.9n 0.3707 38100.0n 0.4203 38399.9n 0.4203 38400.0n 0.4203 38699.9n 0.4203 38700.0n 0.3707 38999.9n 0.3707 39000.0n 0.3707 39299.9n 0.3707 39300.0n 0.3707 39599.9n 0.3707 39600.0n 0.4203 39899.9n 0.4203 39900.0n 0.3707 40199.9n 0.3707 40200.0n 0.6351 40499.9n 0.6351 40500.0n 0.5855 40799.9n 0.5855 40800.0n 0.6351 41099.9n 0.6351 41100.0n 0.5360 41399.9n 0.5360 41400.0n 0.4533 41699.9n 0.4533 41700.0n 0.5855 41999.9n 0.5855 42000.0n 0.6351 42299.9n 0.6351 42300.0n 0.6351 42599.9n 0.6351 42600.0n 0.5690 42899.9n 0.5690 42900.0n 0.3707 43199.9n 0.3707 43200.0n 0.3707 43499.9n 0.3707 43500.0n 0.4203 43799.9n 0.4203 43800.0n 0.4203 44099.9n 0.4203 44100.0n 0.3707 44399.9n 0.3707 44400.0n 0.3707 44699.9n 0.3707 44700.0n 0.3707 44999.9n 0.3707 45000.0n 0.4203 45299.9n 0.4203 45300.0n 0.3707 45599.9n 0.3707 45600.0n 0.6351 45899.9n 0.6351 45900.0n 0.5855 46199.9n 0.5855 46200.0n 0.6351 46499.9n 0.6351 46500.0n 0.5360 46799.9n 0.5360 46800.0n 0.4533 47099.9n 0.4533 47100.0n 0.5855 47399.9n 0.5855 47400.0n 0.6351 47699.9n 0.6351 47700.0n 0.6351 47999.9n 0.6351 48000.0n 0.5690 48299.9n 0.5690 48300.0n 0.3707 48599.9n 0.3707 48600.0n 0.3707 48899.9n 0.3707 48900.0n 0.4203 49199.9n 0.4203 49200.0n 0.4203 49499.9n 0.4203 49500.0n 0.3707 49799.9n 0.3707 49800.0n 0.3707 50099.9n 0.3707 50100.0n 0.3707 50399.9n 0.3707 50400.0n 0.4203 50699.9n 0.4203 50700.0n 0.3707 50999.9n 0.3707 51000.0n 0.6351 51299.9n 0.6351 51300.0n 0.5855 51599.9n 0.5855 51600.0n 0.6351 51899.9n 0.6351 51900.0n 0.5360 52199.9n 0.5360 52200.0n 0.4533 52499.9n 0.4533 52500.0n 0.5855 52799.9n 0.5855 52800.0n 0.6351 53099.9n 0.6351 53100.0n 0.6351 53399.9n 0.6351 53400.0n 0.5690 53699.9n 0.5690 53700.0n 0.3707 53999.9n 0.3707 54000.0n 0.5029 54299.9n 0.5029 54300.0n 0.3872 54599.9n 0.3872 54600.0n 0.3872 54899.9n 0.3872 54900.0n 0.3707 55199.9n 0.3707 55200.0n 0.4038 55499.9n 0.4038 55500.0n 0.3872 55799.9n 0.3872 55800.0n 0.6021 56099.9n 0.6021 56100.0n 0.5194 56399.9n 0.5194 56400.0n 0.4038 56699.9n 0.4038 56700.0n 0.6351 56999.9n 0.6351 57000.0n 0.3707 57299.9n 0.3707 57300.0n 0.4533 57599.9n 0.4533 57600.0n 0.6351 57899.9n 0.6351 57900.0n 0.5194 58199.9n 0.5194 58200.0n 0.5690 58499.9n 0.5690 58500.0n 0.5029 58799.9n 0.5029 58800.0n 0.6021 59099.9n 0.6021 59100.0n 0.4368)
Vxp14 a_xp14 0 PWL(0.0n 0.6995 299.9n 0.6995 300.0n 0.4485 599.9n 0.4485 600.0n 0.4485 899.9n 0.4485 900.0n 0.7274 1199.9n 0.7274 1200.0n 0.5880 1499.9n 0.5880 1500.0n 0.5043 1799.9n 0.5043 1800.0n 0.4485 2099.9n 0.4485 2100.0n 0.5601 2399.9n 0.5601 2400.0n 0.4485 2699.9n 0.4485 2700.0n 0.4485 2999.9n 0.4485 3000.0n 0.4485 3299.9n 0.4485 3300.0n 0.4485 3599.9n 0.4485 3600.0n 0.4485 3899.9n 0.4485 3900.0n 0.4485 4199.9n 0.4485 4200.0n 0.4485 4499.9n 0.4485 4500.0n 0.4485 4799.9n 0.4485 4800.0n 0.4485 5099.9n 0.4485 5100.0n 0.4485 5399.9n 0.4485 5400.0n 0.6995 5699.9n 0.6995 5700.0n 0.4485 5999.9n 0.4485 6000.0n 0.4485 6299.9n 0.4485 6300.0n 0.7274 6599.9n 0.7274 6600.0n 0.5880 6899.9n 0.5880 6900.0n 0.5043 7199.9n 0.5043 7200.0n 0.4485 7499.9n 0.4485 7500.0n 0.5601 7799.9n 0.5601 7800.0n 0.4485 8099.9n 0.4485 8100.0n 0.4485 8399.9n 0.4485 8400.0n 0.4485 8699.9n 0.4485 8700.0n 0.4485 8999.9n 0.4485 9000.0n 0.4485 9299.9n 0.4485 9300.0n 0.4485 9599.9n 0.4485 9600.0n 0.4485 9899.9n 0.4485 9900.0n 0.4485 10199.9n 0.4485 10200.0n 0.4485 10499.9n 0.4485 10500.0n 0.4485 10799.9n 0.4485 10800.0n 0.6995 11099.9n 0.6995 11100.0n 0.4485 11399.9n 0.4485 11400.0n 0.4485 11699.9n 0.4485 11700.0n 0.7274 11999.9n 0.7274 12000.0n 0.5880 12299.9n 0.5880 12300.0n 0.5043 12599.9n 0.5043 12600.0n 0.4485 12899.9n 0.4485 12900.0n 0.5601 13199.9n 0.5601 13200.0n 0.4485 13499.9n 0.4485 13500.0n 0.4485 13799.9n 0.4485 13800.0n 0.4485 14099.9n 0.4485 14100.0n 0.4485 14399.9n 0.4485 14400.0n 0.4485 14699.9n 0.4485 14700.0n 0.4485 14999.9n 0.4485 15000.0n 0.4485 15299.9n 0.4485 15300.0n 0.4485 15599.9n 0.4485 15600.0n 0.4485 15899.9n 0.4485 15900.0n 0.4485 16199.9n 0.4485 16200.0n 0.6995 16499.9n 0.6995 16500.0n 0.4485 16799.9n 0.4485 16800.0n 0.4485 17099.9n 0.4485 17100.0n 0.7274 17399.9n 0.7274 17400.0n 0.5880 17699.9n 0.5880 17700.0n 0.5043 17999.9n 0.5043 18000.0n 0.4485 18299.9n 0.4485 18300.0n 0.5601 18599.9n 0.5601 18600.0n 0.4485 18899.9n 0.4485 18900.0n 0.4485 19199.9n 0.4485 19200.0n 0.4485 19499.9n 0.4485 19500.0n 0.4485 19799.9n 0.4485 19800.0n 0.4485 20099.9n 0.4485 20100.0n 0.4485 20399.9n 0.4485 20400.0n 0.4485 20699.9n 0.4485 20700.0n 0.4485 20999.9n 0.4485 21000.0n 0.4485 21299.9n 0.4485 21300.0n 0.4485 21599.9n 0.4485 21600.0n 0.6995 21899.9n 0.6995 21900.0n 0.4485 22199.9n 0.4485 22200.0n 0.4485 22499.9n 0.4485 22500.0n 0.7274 22799.9n 0.7274 22800.0n 0.5880 23099.9n 0.5880 23100.0n 0.5043 23399.9n 0.5043 23400.0n 0.4485 23699.9n 0.4485 23700.0n 0.5601 23999.9n 0.5601 24000.0n 0.4485 24299.9n 0.4485 24300.0n 0.4485 24599.9n 0.4485 24600.0n 0.4485 24899.9n 0.4485 24900.0n 0.4485 25199.9n 0.4485 25200.0n 0.4485 25499.9n 0.4485 25500.0n 0.4485 25799.9n 0.4485 25800.0n 0.4485 26099.9n 0.4485 26100.0n 0.4485 26399.9n 0.4485 26400.0n 0.4485 26699.9n 0.4485 26700.0n 0.4485 26999.9n 0.4485 27000.0n 0.6995 27299.9n 0.6995 27300.0n 0.4485 27599.9n 0.4485 27600.0n 0.4485 27899.9n 0.4485 27900.0n 0.7274 28199.9n 0.7274 28200.0n 0.5880 28499.9n 0.5880 28500.0n 0.5043 28799.9n 0.5043 28800.0n 0.4485 29099.9n 0.4485 29100.0n 0.5601 29399.9n 0.5601 29400.0n 0.4485 29699.9n 0.4485 29700.0n 0.4485 29999.9n 0.4485 30000.0n 0.4485 30299.9n 0.4485 30300.0n 0.4485 30599.9n 0.4485 30600.0n 0.4485 30899.9n 0.4485 30900.0n 0.4485 31199.9n 0.4485 31200.0n 0.4485 31499.9n 0.4485 31500.0n 0.4485 31799.9n 0.4485 31800.0n 0.4485 32099.9n 0.4485 32100.0n 0.4485 32399.9n 0.4485 32400.0n 0.6995 32699.9n 0.6995 32700.0n 0.4485 32999.9n 0.4485 33000.0n 0.4485 33299.9n 0.4485 33300.0n 0.7274 33599.9n 0.7274 33600.0n 0.5880 33899.9n 0.5880 33900.0n 0.5043 34199.9n 0.5043 34200.0n 0.4485 34499.9n 0.4485 34500.0n 0.5601 34799.9n 0.5601 34800.0n 0.4485 35099.9n 0.4485 35100.0n 0.4485 35399.9n 0.4485 35400.0n 0.4485 35699.9n 0.4485 35700.0n 0.4485 35999.9n 0.4485 36000.0n 0.4485 36299.9n 0.4485 36300.0n 0.4485 36599.9n 0.4485 36600.0n 0.4485 36899.9n 0.4485 36900.0n 0.4485 37199.9n 0.4485 37200.0n 0.4485 37499.9n 0.4485 37500.0n 0.4485 37799.9n 0.4485 37800.0n 0.6995 38099.9n 0.6995 38100.0n 0.4485 38399.9n 0.4485 38400.0n 0.4485 38699.9n 0.4485 38700.0n 0.7274 38999.9n 0.7274 39000.0n 0.5880 39299.9n 0.5880 39300.0n 0.5043 39599.9n 0.5043 39600.0n 0.4485 39899.9n 0.4485 39900.0n 0.5601 40199.9n 0.5601 40200.0n 0.4485 40499.9n 0.4485 40500.0n 0.4485 40799.9n 0.4485 40800.0n 0.4485 41099.9n 0.4485 41100.0n 0.4485 41399.9n 0.4485 41400.0n 0.4485 41699.9n 0.4485 41700.0n 0.4485 41999.9n 0.4485 42000.0n 0.4485 42299.9n 0.4485 42300.0n 0.4485 42599.9n 0.4485 42600.0n 0.4485 42899.9n 0.4485 42900.0n 0.4485 43199.9n 0.4485 43200.0n 0.6995 43499.9n 0.6995 43500.0n 0.4485 43799.9n 0.4485 43800.0n 0.4485 44099.9n 0.4485 44100.0n 0.7274 44399.9n 0.7274 44400.0n 0.5880 44699.9n 0.5880 44700.0n 0.5043 44999.9n 0.5043 45000.0n 0.4485 45299.9n 0.4485 45300.0n 0.5601 45599.9n 0.5601 45600.0n 0.4485 45899.9n 0.4485 45900.0n 0.4485 46199.9n 0.4485 46200.0n 0.4485 46499.9n 0.4485 46500.0n 0.4485 46799.9n 0.4485 46800.0n 0.4485 47099.9n 0.4485 47100.0n 0.4485 47399.9n 0.4485 47400.0n 0.4485 47699.9n 0.4485 47700.0n 0.4485 47999.9n 0.4485 48000.0n 0.4485 48299.9n 0.4485 48300.0n 0.4485 48599.9n 0.4485 48600.0n 0.6995 48899.9n 0.6995 48900.0n 0.4485 49199.9n 0.4485 49200.0n 0.4485 49499.9n 0.4485 49500.0n 0.7274 49799.9n 0.7274 49800.0n 0.5880 50099.9n 0.5880 50100.0n 0.5043 50399.9n 0.5043 50400.0n 0.4485 50699.9n 0.4485 50700.0n 0.5601 50999.9n 0.5601 51000.0n 0.4485 51299.9n 0.4485 51300.0n 0.4485 51599.9n 0.4485 51600.0n 0.4485 51899.9n 0.4485 51900.0n 0.4485 52199.9n 0.4485 52200.0n 0.4485 52499.9n 0.4485 52500.0n 0.4485 52799.9n 0.4485 52800.0n 0.4485 53099.9n 0.4485 53100.0n 0.4485 53399.9n 0.4485 53400.0n 0.4485 53699.9n 0.4485 53700.0n 0.4485 53999.9n 0.4485 54000.0n 0.4485 54299.9n 0.4485 54300.0n 0.4485 54599.9n 0.4485 54600.0n 0.5043 54899.9n 0.5043 54900.0n 0.5322 55199.9n 0.5322 55200.0n 0.4485 55499.9n 0.4485 55500.0n 0.5043 55799.9n 0.5043 55800.0n 0.4485 56099.9n 0.4485 56100.0n 0.4485 56399.9n 0.4485 56400.0n 0.4485 56699.9n 0.4485 56700.0n 0.4485 56999.9n 0.4485 57000.0n 0.5322 57299.9n 0.5322 57300.0n 0.4485 57599.9n 0.4485 57600.0n 0.4485 57899.9n 0.4485 57900.0n 0.4485 58199.9n 0.4485 58200.0n 0.4485 58499.9n 0.4485 58500.0n 0.4485 58799.9n 0.4485 58800.0n 0.4485 59099.9n 0.4485 59100.0n 0.4485)
Vxn14 a_xn14 0 PWL(0.0n 0.3005 299.9n 0.3005 300.0n 0.5515 599.9n 0.5515 600.0n 0.5515 899.9n 0.5515 900.0n 0.2726 1199.9n 0.2726 1200.0n 0.4120 1499.9n 0.4120 1500.0n 0.4957 1799.9n 0.4957 1800.0n 0.5515 2099.9n 0.5515 2100.0n 0.4399 2399.9n 0.4399 2400.0n 0.5515 2699.9n 0.5515 2700.0n 0.5515 2999.9n 0.5515 3000.0n 0.5515 3299.9n 0.5515 3300.0n 0.5515 3599.9n 0.5515 3600.0n 0.5515 3899.9n 0.5515 3900.0n 0.5515 4199.9n 0.5515 4200.0n 0.5515 4499.9n 0.5515 4500.0n 0.5515 4799.9n 0.5515 4800.0n 0.5515 5099.9n 0.5515 5100.0n 0.5515 5399.9n 0.5515 5400.0n 0.3005 5699.9n 0.3005 5700.0n 0.5515 5999.9n 0.5515 6000.0n 0.5515 6299.9n 0.5515 6300.0n 0.2726 6599.9n 0.2726 6600.0n 0.4120 6899.9n 0.4120 6900.0n 0.4957 7199.9n 0.4957 7200.0n 0.5515 7499.9n 0.5515 7500.0n 0.4399 7799.9n 0.4399 7800.0n 0.5515 8099.9n 0.5515 8100.0n 0.5515 8399.9n 0.5515 8400.0n 0.5515 8699.9n 0.5515 8700.0n 0.5515 8999.9n 0.5515 9000.0n 0.5515 9299.9n 0.5515 9300.0n 0.5515 9599.9n 0.5515 9600.0n 0.5515 9899.9n 0.5515 9900.0n 0.5515 10199.9n 0.5515 10200.0n 0.5515 10499.9n 0.5515 10500.0n 0.5515 10799.9n 0.5515 10800.0n 0.3005 11099.9n 0.3005 11100.0n 0.5515 11399.9n 0.5515 11400.0n 0.5515 11699.9n 0.5515 11700.0n 0.2726 11999.9n 0.2726 12000.0n 0.4120 12299.9n 0.4120 12300.0n 0.4957 12599.9n 0.4957 12600.0n 0.5515 12899.9n 0.5515 12900.0n 0.4399 13199.9n 0.4399 13200.0n 0.5515 13499.9n 0.5515 13500.0n 0.5515 13799.9n 0.5515 13800.0n 0.5515 14099.9n 0.5515 14100.0n 0.5515 14399.9n 0.5515 14400.0n 0.5515 14699.9n 0.5515 14700.0n 0.5515 14999.9n 0.5515 15000.0n 0.5515 15299.9n 0.5515 15300.0n 0.5515 15599.9n 0.5515 15600.0n 0.5515 15899.9n 0.5515 15900.0n 0.5515 16199.9n 0.5515 16200.0n 0.3005 16499.9n 0.3005 16500.0n 0.5515 16799.9n 0.5515 16800.0n 0.5515 17099.9n 0.5515 17100.0n 0.2726 17399.9n 0.2726 17400.0n 0.4120 17699.9n 0.4120 17700.0n 0.4957 17999.9n 0.4957 18000.0n 0.5515 18299.9n 0.5515 18300.0n 0.4399 18599.9n 0.4399 18600.0n 0.5515 18899.9n 0.5515 18900.0n 0.5515 19199.9n 0.5515 19200.0n 0.5515 19499.9n 0.5515 19500.0n 0.5515 19799.9n 0.5515 19800.0n 0.5515 20099.9n 0.5515 20100.0n 0.5515 20399.9n 0.5515 20400.0n 0.5515 20699.9n 0.5515 20700.0n 0.5515 20999.9n 0.5515 21000.0n 0.5515 21299.9n 0.5515 21300.0n 0.5515 21599.9n 0.5515 21600.0n 0.3005 21899.9n 0.3005 21900.0n 0.5515 22199.9n 0.5515 22200.0n 0.5515 22499.9n 0.5515 22500.0n 0.2726 22799.9n 0.2726 22800.0n 0.4120 23099.9n 0.4120 23100.0n 0.4957 23399.9n 0.4957 23400.0n 0.5515 23699.9n 0.5515 23700.0n 0.4399 23999.9n 0.4399 24000.0n 0.5515 24299.9n 0.5515 24300.0n 0.5515 24599.9n 0.5515 24600.0n 0.5515 24899.9n 0.5515 24900.0n 0.5515 25199.9n 0.5515 25200.0n 0.5515 25499.9n 0.5515 25500.0n 0.5515 25799.9n 0.5515 25800.0n 0.5515 26099.9n 0.5515 26100.0n 0.5515 26399.9n 0.5515 26400.0n 0.5515 26699.9n 0.5515 26700.0n 0.5515 26999.9n 0.5515 27000.0n 0.3005 27299.9n 0.3005 27300.0n 0.5515 27599.9n 0.5515 27600.0n 0.5515 27899.9n 0.5515 27900.0n 0.2726 28199.9n 0.2726 28200.0n 0.4120 28499.9n 0.4120 28500.0n 0.4957 28799.9n 0.4957 28800.0n 0.5515 29099.9n 0.5515 29100.0n 0.4399 29399.9n 0.4399 29400.0n 0.5515 29699.9n 0.5515 29700.0n 0.5515 29999.9n 0.5515 30000.0n 0.5515 30299.9n 0.5515 30300.0n 0.5515 30599.9n 0.5515 30600.0n 0.5515 30899.9n 0.5515 30900.0n 0.5515 31199.9n 0.5515 31200.0n 0.5515 31499.9n 0.5515 31500.0n 0.5515 31799.9n 0.5515 31800.0n 0.5515 32099.9n 0.5515 32100.0n 0.5515 32399.9n 0.5515 32400.0n 0.3005 32699.9n 0.3005 32700.0n 0.5515 32999.9n 0.5515 33000.0n 0.5515 33299.9n 0.5515 33300.0n 0.2726 33599.9n 0.2726 33600.0n 0.4120 33899.9n 0.4120 33900.0n 0.4957 34199.9n 0.4957 34200.0n 0.5515 34499.9n 0.5515 34500.0n 0.4399 34799.9n 0.4399 34800.0n 0.5515 35099.9n 0.5515 35100.0n 0.5515 35399.9n 0.5515 35400.0n 0.5515 35699.9n 0.5515 35700.0n 0.5515 35999.9n 0.5515 36000.0n 0.5515 36299.9n 0.5515 36300.0n 0.5515 36599.9n 0.5515 36600.0n 0.5515 36899.9n 0.5515 36900.0n 0.5515 37199.9n 0.5515 37200.0n 0.5515 37499.9n 0.5515 37500.0n 0.5515 37799.9n 0.5515 37800.0n 0.3005 38099.9n 0.3005 38100.0n 0.5515 38399.9n 0.5515 38400.0n 0.5515 38699.9n 0.5515 38700.0n 0.2726 38999.9n 0.2726 39000.0n 0.4120 39299.9n 0.4120 39300.0n 0.4957 39599.9n 0.4957 39600.0n 0.5515 39899.9n 0.5515 39900.0n 0.4399 40199.9n 0.4399 40200.0n 0.5515 40499.9n 0.5515 40500.0n 0.5515 40799.9n 0.5515 40800.0n 0.5515 41099.9n 0.5515 41100.0n 0.5515 41399.9n 0.5515 41400.0n 0.5515 41699.9n 0.5515 41700.0n 0.5515 41999.9n 0.5515 42000.0n 0.5515 42299.9n 0.5515 42300.0n 0.5515 42599.9n 0.5515 42600.0n 0.5515 42899.9n 0.5515 42900.0n 0.5515 43199.9n 0.5515 43200.0n 0.3005 43499.9n 0.3005 43500.0n 0.5515 43799.9n 0.5515 43800.0n 0.5515 44099.9n 0.5515 44100.0n 0.2726 44399.9n 0.2726 44400.0n 0.4120 44699.9n 0.4120 44700.0n 0.4957 44999.9n 0.4957 45000.0n 0.5515 45299.9n 0.5515 45300.0n 0.4399 45599.9n 0.4399 45600.0n 0.5515 45899.9n 0.5515 45900.0n 0.5515 46199.9n 0.5515 46200.0n 0.5515 46499.9n 0.5515 46500.0n 0.5515 46799.9n 0.5515 46800.0n 0.5515 47099.9n 0.5515 47100.0n 0.5515 47399.9n 0.5515 47400.0n 0.5515 47699.9n 0.5515 47700.0n 0.5515 47999.9n 0.5515 48000.0n 0.5515 48299.9n 0.5515 48300.0n 0.5515 48599.9n 0.5515 48600.0n 0.3005 48899.9n 0.3005 48900.0n 0.5515 49199.9n 0.5515 49200.0n 0.5515 49499.9n 0.5515 49500.0n 0.2726 49799.9n 0.2726 49800.0n 0.4120 50099.9n 0.4120 50100.0n 0.4957 50399.9n 0.4957 50400.0n 0.5515 50699.9n 0.5515 50700.0n 0.4399 50999.9n 0.4399 51000.0n 0.5515 51299.9n 0.5515 51300.0n 0.5515 51599.9n 0.5515 51600.0n 0.5515 51899.9n 0.5515 51900.0n 0.5515 52199.9n 0.5515 52200.0n 0.5515 52499.9n 0.5515 52500.0n 0.5515 52799.9n 0.5515 52800.0n 0.5515 53099.9n 0.5515 53100.0n 0.5515 53399.9n 0.5515 53400.0n 0.5515 53699.9n 0.5515 53700.0n 0.5515 53999.9n 0.5515 54000.0n 0.5515 54299.9n 0.5515 54300.0n 0.5515 54599.9n 0.5515 54600.0n 0.4957 54899.9n 0.4957 54900.0n 0.4678 55199.9n 0.4678 55200.0n 0.5515 55499.9n 0.5515 55500.0n 0.4957 55799.9n 0.4957 55800.0n 0.5515 56099.9n 0.5515 56100.0n 0.5515 56399.9n 0.5515 56400.0n 0.5515 56699.9n 0.5515 56700.0n 0.5515 56999.9n 0.5515 57000.0n 0.4678 57299.9n 0.4678 57300.0n 0.5515 57599.9n 0.5515 57600.0n 0.5515 57899.9n 0.5515 57900.0n 0.5515 58199.9n 0.5515 58200.0n 0.5515 58499.9n 0.5515 58500.0n 0.5515 58799.9n 0.5515 58800.0n 0.5515 59099.9n 0.5515 59100.0n 0.5515)
Vxp15 a_xp15 0 PWL(0.0n 0.4870 299.9n 0.4870 300.0n 0.4870 599.9n 0.4870 600.0n 0.4870 899.9n 0.4870 900.0n 0.4870 1199.9n 0.4870 1200.0n 0.4870 1499.9n 0.4870 1500.0n 0.4870 1799.9n 0.4870 1800.0n 0.4870 2099.9n 0.4870 2100.0n 0.4870 2399.9n 0.4870 2400.0n 0.4870 2699.9n 0.4870 2700.0n 0.4870 2999.9n 0.4870 3000.0n 0.4870 3299.9n 0.4870 3300.0n 0.4870 3599.9n 0.4870 3600.0n 0.4870 3899.9n 0.4870 3900.0n 0.4870 4199.9n 0.4870 4200.0n 0.4870 4499.9n 0.4870 4500.0n 0.4870 4799.9n 0.4870 4800.0n 0.4870 5099.9n 0.4870 5100.0n 0.4870 5399.9n 0.4870 5400.0n 0.4870 5699.9n 0.4870 5700.0n 0.4870 5999.9n 0.4870 6000.0n 0.4870 6299.9n 0.4870 6300.0n 0.4870 6599.9n 0.4870 6600.0n 0.4870 6899.9n 0.4870 6900.0n 0.4870 7199.9n 0.4870 7200.0n 0.4870 7499.9n 0.4870 7500.0n 0.4870 7799.9n 0.4870 7800.0n 0.4870 8099.9n 0.4870 8100.0n 0.4870 8399.9n 0.4870 8400.0n 0.4870 8699.9n 0.4870 8700.0n 0.4870 8999.9n 0.4870 9000.0n 0.4870 9299.9n 0.4870 9300.0n 0.4870 9599.9n 0.4870 9600.0n 0.4870 9899.9n 0.4870 9900.0n 0.4870 10199.9n 0.4870 10200.0n 0.4870 10499.9n 0.4870 10500.0n 0.4870 10799.9n 0.4870 10800.0n 0.4870 11099.9n 0.4870 11100.0n 0.4870 11399.9n 0.4870 11400.0n 0.4870 11699.9n 0.4870 11700.0n 0.4870 11999.9n 0.4870 12000.0n 0.4870 12299.9n 0.4870 12300.0n 0.4870 12599.9n 0.4870 12600.0n 0.4870 12899.9n 0.4870 12900.0n 0.4870 13199.9n 0.4870 13200.0n 0.4870 13499.9n 0.4870 13500.0n 0.4870 13799.9n 0.4870 13800.0n 0.4870 14099.9n 0.4870 14100.0n 0.4870 14399.9n 0.4870 14400.0n 0.4870 14699.9n 0.4870 14700.0n 0.4870 14999.9n 0.4870 15000.0n 0.4870 15299.9n 0.4870 15300.0n 0.4870 15599.9n 0.4870 15600.0n 0.4870 15899.9n 0.4870 15900.0n 0.4870 16199.9n 0.4870 16200.0n 0.4870 16499.9n 0.4870 16500.0n 0.4870 16799.9n 0.4870 16800.0n 0.4870 17099.9n 0.4870 17100.0n 0.4870 17399.9n 0.4870 17400.0n 0.4870 17699.9n 0.4870 17700.0n 0.4870 17999.9n 0.4870 18000.0n 0.4870 18299.9n 0.4870 18300.0n 0.4870 18599.9n 0.4870 18600.0n 0.4870 18899.9n 0.4870 18900.0n 0.4870 19199.9n 0.4870 19200.0n 0.4870 19499.9n 0.4870 19500.0n 0.4870 19799.9n 0.4870 19800.0n 0.4870 20099.9n 0.4870 20100.0n 0.4870 20399.9n 0.4870 20400.0n 0.4870 20699.9n 0.4870 20700.0n 0.4870 20999.9n 0.4870 21000.0n 0.4870 21299.9n 0.4870 21300.0n 0.4870 21599.9n 0.4870 21600.0n 0.4870 21899.9n 0.4870 21900.0n 0.4870 22199.9n 0.4870 22200.0n 0.4870 22499.9n 0.4870 22500.0n 0.4870 22799.9n 0.4870 22800.0n 0.4870 23099.9n 0.4870 23100.0n 0.4870 23399.9n 0.4870 23400.0n 0.4870 23699.9n 0.4870 23700.0n 0.4870 23999.9n 0.4870 24000.0n 0.4870 24299.9n 0.4870 24300.0n 0.4870 24599.9n 0.4870 24600.0n 0.4870 24899.9n 0.4870 24900.0n 0.4870 25199.9n 0.4870 25200.0n 0.4870 25499.9n 0.4870 25500.0n 0.4870 25799.9n 0.4870 25800.0n 0.4870 26099.9n 0.4870 26100.0n 0.4870 26399.9n 0.4870 26400.0n 0.4870 26699.9n 0.4870 26700.0n 0.4870 26999.9n 0.4870 27000.0n 0.4870 27299.9n 0.4870 27300.0n 0.4870 27599.9n 0.4870 27600.0n 0.4870 27899.9n 0.4870 27900.0n 0.4870 28199.9n 0.4870 28200.0n 0.4870 28499.9n 0.4870 28500.0n 0.4870 28799.9n 0.4870 28800.0n 0.4870 29099.9n 0.4870 29100.0n 0.4870 29399.9n 0.4870 29400.0n 0.4870 29699.9n 0.4870 29700.0n 0.4870 29999.9n 0.4870 30000.0n 0.4870 30299.9n 0.4870 30300.0n 0.4870 30599.9n 0.4870 30600.0n 0.4870 30899.9n 0.4870 30900.0n 0.4870 31199.9n 0.4870 31200.0n 0.4870 31499.9n 0.4870 31500.0n 0.4870 31799.9n 0.4870 31800.0n 0.4870 32099.9n 0.4870 32100.0n 0.4870 32399.9n 0.4870 32400.0n 0.4870 32699.9n 0.4870 32700.0n 0.4870 32999.9n 0.4870 33000.0n 0.4870 33299.9n 0.4870 33300.0n 0.4870 33599.9n 0.4870 33600.0n 0.4870 33899.9n 0.4870 33900.0n 0.4870 34199.9n 0.4870 34200.0n 0.4870 34499.9n 0.4870 34500.0n 0.4870 34799.9n 0.4870 34800.0n 0.4870 35099.9n 0.4870 35100.0n 0.4870 35399.9n 0.4870 35400.0n 0.4870 35699.9n 0.4870 35700.0n 0.4870 35999.9n 0.4870 36000.0n 0.4870 36299.9n 0.4870 36300.0n 0.4870 36599.9n 0.4870 36600.0n 0.4870 36899.9n 0.4870 36900.0n 0.4870 37199.9n 0.4870 37200.0n 0.4870 37499.9n 0.4870 37500.0n 0.4870 37799.9n 0.4870 37800.0n 0.4870 38099.9n 0.4870 38100.0n 0.4870 38399.9n 0.4870 38400.0n 0.4870 38699.9n 0.4870 38700.0n 0.4870 38999.9n 0.4870 39000.0n 0.4870 39299.9n 0.4870 39300.0n 0.4870 39599.9n 0.4870 39600.0n 0.4870 39899.9n 0.4870 39900.0n 0.4870 40199.9n 0.4870 40200.0n 0.4870 40499.9n 0.4870 40500.0n 0.4870 40799.9n 0.4870 40800.0n 0.4870 41099.9n 0.4870 41100.0n 0.4870 41399.9n 0.4870 41400.0n 0.4870 41699.9n 0.4870 41700.0n 0.4870 41999.9n 0.4870 42000.0n 0.4870 42299.9n 0.4870 42300.0n 0.4870 42599.9n 0.4870 42600.0n 0.4870 42899.9n 0.4870 42900.0n 0.4870 43199.9n 0.4870 43200.0n 0.4870 43499.9n 0.4870 43500.0n 0.4870 43799.9n 0.4870 43800.0n 0.4870 44099.9n 0.4870 44100.0n 0.4870 44399.9n 0.4870 44400.0n 0.4870 44699.9n 0.4870 44700.0n 0.4870 44999.9n 0.4870 45000.0n 0.4870 45299.9n 0.4870 45300.0n 0.4870 45599.9n 0.4870 45600.0n 0.4870 45899.9n 0.4870 45900.0n 0.4870 46199.9n 0.4870 46200.0n 0.4870 46499.9n 0.4870 46500.0n 0.4870 46799.9n 0.4870 46800.0n 0.4870 47099.9n 0.4870 47100.0n 0.4870 47399.9n 0.4870 47400.0n 0.4870 47699.9n 0.4870 47700.0n 0.4870 47999.9n 0.4870 48000.0n 0.4870 48299.9n 0.4870 48300.0n 0.4870 48599.9n 0.4870 48600.0n 0.4870 48899.9n 0.4870 48900.0n 0.4870 49199.9n 0.4870 49200.0n 0.4870 49499.9n 0.4870 49500.0n 0.4870 49799.9n 0.4870 49800.0n 0.4870 50099.9n 0.4870 50100.0n 0.4870 50399.9n 0.4870 50400.0n 0.4870 50699.9n 0.4870 50700.0n 0.4870 50999.9n 0.4870 51000.0n 0.4870 51299.9n 0.4870 51300.0n 0.4870 51599.9n 0.4870 51600.0n 0.4870 51899.9n 0.4870 51900.0n 0.4870 52199.9n 0.4870 52200.0n 0.4870 52499.9n 0.4870 52500.0n 0.4870 52799.9n 0.4870 52800.0n 0.4870 53099.9n 0.4870 53100.0n 0.4870 53399.9n 0.4870 53400.0n 0.4870 53699.9n 0.4870 53700.0n 0.4870 53999.9n 0.4870 54000.0n 0.4870 54299.9n 0.4870 54300.0n 0.4870 54599.9n 0.4870 54600.0n 0.4870 54899.9n 0.4870 54900.0n 0.4870 55199.9n 0.4870 55200.0n 0.4870 55499.9n 0.4870 55500.0n 0.4870 55799.9n 0.4870 55800.0n 0.4870 56099.9n 0.4870 56100.0n 0.4870 56399.9n 0.4870 56400.0n 0.4870 56699.9n 0.4870 56700.0n 0.4870 56999.9n 0.4870 57000.0n 0.4870 57299.9n 0.4870 57300.0n 0.4870 57599.9n 0.4870 57600.0n 0.4870 57899.9n 0.4870 57900.0n 0.4870 58199.9n 0.4870 58200.0n 0.4870 58499.9n 0.4870 58500.0n 0.4870 58799.9n 0.4870 58800.0n 0.4870 59099.9n 0.4870 59100.0n 0.4870)
Vxn15 a_xn15 0 PWL(0.0n 0.5130 299.9n 0.5130 300.0n 0.5130 599.9n 0.5130 600.0n 0.5130 899.9n 0.5130 900.0n 0.5130 1199.9n 0.5130 1200.0n 0.5130 1499.9n 0.5130 1500.0n 0.5130 1799.9n 0.5130 1800.0n 0.5130 2099.9n 0.5130 2100.0n 0.5130 2399.9n 0.5130 2400.0n 0.5130 2699.9n 0.5130 2700.0n 0.5130 2999.9n 0.5130 3000.0n 0.5130 3299.9n 0.5130 3300.0n 0.5130 3599.9n 0.5130 3600.0n 0.5130 3899.9n 0.5130 3900.0n 0.5130 4199.9n 0.5130 4200.0n 0.5130 4499.9n 0.5130 4500.0n 0.5130 4799.9n 0.5130 4800.0n 0.5130 5099.9n 0.5130 5100.0n 0.5130 5399.9n 0.5130 5400.0n 0.5130 5699.9n 0.5130 5700.0n 0.5130 5999.9n 0.5130 6000.0n 0.5130 6299.9n 0.5130 6300.0n 0.5130 6599.9n 0.5130 6600.0n 0.5130 6899.9n 0.5130 6900.0n 0.5130 7199.9n 0.5130 7200.0n 0.5130 7499.9n 0.5130 7500.0n 0.5130 7799.9n 0.5130 7800.0n 0.5130 8099.9n 0.5130 8100.0n 0.5130 8399.9n 0.5130 8400.0n 0.5130 8699.9n 0.5130 8700.0n 0.5130 8999.9n 0.5130 9000.0n 0.5130 9299.9n 0.5130 9300.0n 0.5130 9599.9n 0.5130 9600.0n 0.5130 9899.9n 0.5130 9900.0n 0.5130 10199.9n 0.5130 10200.0n 0.5130 10499.9n 0.5130 10500.0n 0.5130 10799.9n 0.5130 10800.0n 0.5130 11099.9n 0.5130 11100.0n 0.5130 11399.9n 0.5130 11400.0n 0.5130 11699.9n 0.5130 11700.0n 0.5130 11999.9n 0.5130 12000.0n 0.5130 12299.9n 0.5130 12300.0n 0.5130 12599.9n 0.5130 12600.0n 0.5130 12899.9n 0.5130 12900.0n 0.5130 13199.9n 0.5130 13200.0n 0.5130 13499.9n 0.5130 13500.0n 0.5130 13799.9n 0.5130 13800.0n 0.5130 14099.9n 0.5130 14100.0n 0.5130 14399.9n 0.5130 14400.0n 0.5130 14699.9n 0.5130 14700.0n 0.5130 14999.9n 0.5130 15000.0n 0.5130 15299.9n 0.5130 15300.0n 0.5130 15599.9n 0.5130 15600.0n 0.5130 15899.9n 0.5130 15900.0n 0.5130 16199.9n 0.5130 16200.0n 0.5130 16499.9n 0.5130 16500.0n 0.5130 16799.9n 0.5130 16800.0n 0.5130 17099.9n 0.5130 17100.0n 0.5130 17399.9n 0.5130 17400.0n 0.5130 17699.9n 0.5130 17700.0n 0.5130 17999.9n 0.5130 18000.0n 0.5130 18299.9n 0.5130 18300.0n 0.5130 18599.9n 0.5130 18600.0n 0.5130 18899.9n 0.5130 18900.0n 0.5130 19199.9n 0.5130 19200.0n 0.5130 19499.9n 0.5130 19500.0n 0.5130 19799.9n 0.5130 19800.0n 0.5130 20099.9n 0.5130 20100.0n 0.5130 20399.9n 0.5130 20400.0n 0.5130 20699.9n 0.5130 20700.0n 0.5130 20999.9n 0.5130 21000.0n 0.5130 21299.9n 0.5130 21300.0n 0.5130 21599.9n 0.5130 21600.0n 0.5130 21899.9n 0.5130 21900.0n 0.5130 22199.9n 0.5130 22200.0n 0.5130 22499.9n 0.5130 22500.0n 0.5130 22799.9n 0.5130 22800.0n 0.5130 23099.9n 0.5130 23100.0n 0.5130 23399.9n 0.5130 23400.0n 0.5130 23699.9n 0.5130 23700.0n 0.5130 23999.9n 0.5130 24000.0n 0.5130 24299.9n 0.5130 24300.0n 0.5130 24599.9n 0.5130 24600.0n 0.5130 24899.9n 0.5130 24900.0n 0.5130 25199.9n 0.5130 25200.0n 0.5130 25499.9n 0.5130 25500.0n 0.5130 25799.9n 0.5130 25800.0n 0.5130 26099.9n 0.5130 26100.0n 0.5130 26399.9n 0.5130 26400.0n 0.5130 26699.9n 0.5130 26700.0n 0.5130 26999.9n 0.5130 27000.0n 0.5130 27299.9n 0.5130 27300.0n 0.5130 27599.9n 0.5130 27600.0n 0.5130 27899.9n 0.5130 27900.0n 0.5130 28199.9n 0.5130 28200.0n 0.5130 28499.9n 0.5130 28500.0n 0.5130 28799.9n 0.5130 28800.0n 0.5130 29099.9n 0.5130 29100.0n 0.5130 29399.9n 0.5130 29400.0n 0.5130 29699.9n 0.5130 29700.0n 0.5130 29999.9n 0.5130 30000.0n 0.5130 30299.9n 0.5130 30300.0n 0.5130 30599.9n 0.5130 30600.0n 0.5130 30899.9n 0.5130 30900.0n 0.5130 31199.9n 0.5130 31200.0n 0.5130 31499.9n 0.5130 31500.0n 0.5130 31799.9n 0.5130 31800.0n 0.5130 32099.9n 0.5130 32100.0n 0.5130 32399.9n 0.5130 32400.0n 0.5130 32699.9n 0.5130 32700.0n 0.5130 32999.9n 0.5130 33000.0n 0.5130 33299.9n 0.5130 33300.0n 0.5130 33599.9n 0.5130 33600.0n 0.5130 33899.9n 0.5130 33900.0n 0.5130 34199.9n 0.5130 34200.0n 0.5130 34499.9n 0.5130 34500.0n 0.5130 34799.9n 0.5130 34800.0n 0.5130 35099.9n 0.5130 35100.0n 0.5130 35399.9n 0.5130 35400.0n 0.5130 35699.9n 0.5130 35700.0n 0.5130 35999.9n 0.5130 36000.0n 0.5130 36299.9n 0.5130 36300.0n 0.5130 36599.9n 0.5130 36600.0n 0.5130 36899.9n 0.5130 36900.0n 0.5130 37199.9n 0.5130 37200.0n 0.5130 37499.9n 0.5130 37500.0n 0.5130 37799.9n 0.5130 37800.0n 0.5130 38099.9n 0.5130 38100.0n 0.5130 38399.9n 0.5130 38400.0n 0.5130 38699.9n 0.5130 38700.0n 0.5130 38999.9n 0.5130 39000.0n 0.5130 39299.9n 0.5130 39300.0n 0.5130 39599.9n 0.5130 39600.0n 0.5130 39899.9n 0.5130 39900.0n 0.5130 40199.9n 0.5130 40200.0n 0.5130 40499.9n 0.5130 40500.0n 0.5130 40799.9n 0.5130 40800.0n 0.5130 41099.9n 0.5130 41100.0n 0.5130 41399.9n 0.5130 41400.0n 0.5130 41699.9n 0.5130 41700.0n 0.5130 41999.9n 0.5130 42000.0n 0.5130 42299.9n 0.5130 42300.0n 0.5130 42599.9n 0.5130 42600.0n 0.5130 42899.9n 0.5130 42900.0n 0.5130 43199.9n 0.5130 43200.0n 0.5130 43499.9n 0.5130 43500.0n 0.5130 43799.9n 0.5130 43800.0n 0.5130 44099.9n 0.5130 44100.0n 0.5130 44399.9n 0.5130 44400.0n 0.5130 44699.9n 0.5130 44700.0n 0.5130 44999.9n 0.5130 45000.0n 0.5130 45299.9n 0.5130 45300.0n 0.5130 45599.9n 0.5130 45600.0n 0.5130 45899.9n 0.5130 45900.0n 0.5130 46199.9n 0.5130 46200.0n 0.5130 46499.9n 0.5130 46500.0n 0.5130 46799.9n 0.5130 46800.0n 0.5130 47099.9n 0.5130 47100.0n 0.5130 47399.9n 0.5130 47400.0n 0.5130 47699.9n 0.5130 47700.0n 0.5130 47999.9n 0.5130 48000.0n 0.5130 48299.9n 0.5130 48300.0n 0.5130 48599.9n 0.5130 48600.0n 0.5130 48899.9n 0.5130 48900.0n 0.5130 49199.9n 0.5130 49200.0n 0.5130 49499.9n 0.5130 49500.0n 0.5130 49799.9n 0.5130 49800.0n 0.5130 50099.9n 0.5130 50100.0n 0.5130 50399.9n 0.5130 50400.0n 0.5130 50699.9n 0.5130 50700.0n 0.5130 50999.9n 0.5130 51000.0n 0.5130 51299.9n 0.5130 51300.0n 0.5130 51599.9n 0.5130 51600.0n 0.5130 51899.9n 0.5130 51900.0n 0.5130 52199.9n 0.5130 52200.0n 0.5130 52499.9n 0.5130 52500.0n 0.5130 52799.9n 0.5130 52800.0n 0.5130 53099.9n 0.5130 53100.0n 0.5130 53399.9n 0.5130 53400.0n 0.5130 53699.9n 0.5130 53700.0n 0.5130 53999.9n 0.5130 54000.0n 0.5130 54299.9n 0.5130 54300.0n 0.5130 54599.9n 0.5130 54600.0n 0.5130 54899.9n 0.5130 54900.0n 0.5130 55199.9n 0.5130 55200.0n 0.5130 55499.9n 0.5130 55500.0n 0.5130 55799.9n 0.5130 55800.0n 0.5130 56099.9n 0.5130 56100.0n 0.5130 56399.9n 0.5130 56400.0n 0.5130 56699.9n 0.5130 56700.0n 0.5130 56999.9n 0.5130 57000.0n 0.5130 57299.9n 0.5130 57300.0n 0.5130 57599.9n 0.5130 57600.0n 0.5130 57899.9n 0.5130 57900.0n 0.5130 58199.9n 0.5130 58200.0n 0.5130 58499.9n 0.5130 58500.0n 0.5130 58799.9n 0.5130 58800.0n 0.5130 59099.9n 0.5130 59100.0n 0.5130)
Vxp16 a_xp16 0 PWL(0.0n 0.4955 299.9n 0.4955 300.0n 0.4955 599.9n 0.4955 600.0n 0.4955 899.9n 0.4955 900.0n 0.4955 1199.9n 0.4955 1200.0n 0.4955 1499.9n 0.4955 1500.0n 0.4955 1799.9n 0.4955 1800.0n 0.4955 2099.9n 0.4955 2100.0n 0.4955 2399.9n 0.4955 2400.0n 0.4955 2699.9n 0.4955 2700.0n 0.4955 2999.9n 0.4955 3000.0n 0.4955 3299.9n 0.4955 3300.0n 0.4955 3599.9n 0.4955 3600.0n 0.4955 3899.9n 0.4955 3900.0n 0.4955 4199.9n 0.4955 4200.0n 0.4955 4499.9n 0.4955 4500.0n 0.4955 4799.9n 0.4955 4800.0n 0.4955 5099.9n 0.4955 5100.0n 0.4955 5399.9n 0.4955 5400.0n 0.4955 5699.9n 0.4955 5700.0n 0.4955 5999.9n 0.4955 6000.0n 0.4955 6299.9n 0.4955 6300.0n 0.4955 6599.9n 0.4955 6600.0n 0.4955 6899.9n 0.4955 6900.0n 0.4955 7199.9n 0.4955 7200.0n 0.4955 7499.9n 0.4955 7500.0n 0.4955 7799.9n 0.4955 7800.0n 0.4955 8099.9n 0.4955 8100.0n 0.4955 8399.9n 0.4955 8400.0n 0.4955 8699.9n 0.4955 8700.0n 0.4955 8999.9n 0.4955 9000.0n 0.4955 9299.9n 0.4955 9300.0n 0.4955 9599.9n 0.4955 9600.0n 0.4955 9899.9n 0.4955 9900.0n 0.4955 10199.9n 0.4955 10200.0n 0.4955 10499.9n 0.4955 10500.0n 0.4955 10799.9n 0.4955 10800.0n 0.4955 11099.9n 0.4955 11100.0n 0.4955 11399.9n 0.4955 11400.0n 0.4955 11699.9n 0.4955 11700.0n 0.4955 11999.9n 0.4955 12000.0n 0.4955 12299.9n 0.4955 12300.0n 0.4955 12599.9n 0.4955 12600.0n 0.4955 12899.9n 0.4955 12900.0n 0.4955 13199.9n 0.4955 13200.0n 0.4955 13499.9n 0.4955 13500.0n 0.4955 13799.9n 0.4955 13800.0n 0.4955 14099.9n 0.4955 14100.0n 0.4955 14399.9n 0.4955 14400.0n 0.4955 14699.9n 0.4955 14700.0n 0.4955 14999.9n 0.4955 15000.0n 0.4955 15299.9n 0.4955 15300.0n 0.4955 15599.9n 0.4955 15600.0n 0.4955 15899.9n 0.4955 15900.0n 0.4955 16199.9n 0.4955 16200.0n 0.4955 16499.9n 0.4955 16500.0n 0.4955 16799.9n 0.4955 16800.0n 0.4955 17099.9n 0.4955 17100.0n 0.4955 17399.9n 0.4955 17400.0n 0.4955 17699.9n 0.4955 17700.0n 0.4955 17999.9n 0.4955 18000.0n 0.4955 18299.9n 0.4955 18300.0n 0.4955 18599.9n 0.4955 18600.0n 0.4955 18899.9n 0.4955 18900.0n 0.4955 19199.9n 0.4955 19200.0n 0.4955 19499.9n 0.4955 19500.0n 0.4955 19799.9n 0.4955 19800.0n 0.4955 20099.9n 0.4955 20100.0n 0.4955 20399.9n 0.4955 20400.0n 0.4955 20699.9n 0.4955 20700.0n 0.4955 20999.9n 0.4955 21000.0n 0.4955 21299.9n 0.4955 21300.0n 0.4955 21599.9n 0.4955 21600.0n 0.4955 21899.9n 0.4955 21900.0n 0.4955 22199.9n 0.4955 22200.0n 0.4955 22499.9n 0.4955 22500.0n 0.4955 22799.9n 0.4955 22800.0n 0.4955 23099.9n 0.4955 23100.0n 0.4955 23399.9n 0.4955 23400.0n 0.4955 23699.9n 0.4955 23700.0n 0.4955 23999.9n 0.4955 24000.0n 0.4955 24299.9n 0.4955 24300.0n 0.4955 24599.9n 0.4955 24600.0n 0.4955 24899.9n 0.4955 24900.0n 0.4955 25199.9n 0.4955 25200.0n 0.4955 25499.9n 0.4955 25500.0n 0.4955 25799.9n 0.4955 25800.0n 0.4955 26099.9n 0.4955 26100.0n 0.4955 26399.9n 0.4955 26400.0n 0.4955 26699.9n 0.4955 26700.0n 0.4955 26999.9n 0.4955 27000.0n 0.4955 27299.9n 0.4955 27300.0n 0.4955 27599.9n 0.4955 27600.0n 0.4955 27899.9n 0.4955 27900.0n 0.4955 28199.9n 0.4955 28200.0n 0.4955 28499.9n 0.4955 28500.0n 0.4955 28799.9n 0.4955 28800.0n 0.4955 29099.9n 0.4955 29100.0n 0.4955 29399.9n 0.4955 29400.0n 0.4955 29699.9n 0.4955 29700.0n 0.4955 29999.9n 0.4955 30000.0n 0.4955 30299.9n 0.4955 30300.0n 0.4955 30599.9n 0.4955 30600.0n 0.4955 30899.9n 0.4955 30900.0n 0.4955 31199.9n 0.4955 31200.0n 0.4955 31499.9n 0.4955 31500.0n 0.4955 31799.9n 0.4955 31800.0n 0.4955 32099.9n 0.4955 32100.0n 0.4955 32399.9n 0.4955 32400.0n 0.4955 32699.9n 0.4955 32700.0n 0.4955 32999.9n 0.4955 33000.0n 0.4955 33299.9n 0.4955 33300.0n 0.4955 33599.9n 0.4955 33600.0n 0.4955 33899.9n 0.4955 33900.0n 0.4955 34199.9n 0.4955 34200.0n 0.4955 34499.9n 0.4955 34500.0n 0.4955 34799.9n 0.4955 34800.0n 0.4955 35099.9n 0.4955 35100.0n 0.4955 35399.9n 0.4955 35400.0n 0.4955 35699.9n 0.4955 35700.0n 0.4955 35999.9n 0.4955 36000.0n 0.4955 36299.9n 0.4955 36300.0n 0.4955 36599.9n 0.4955 36600.0n 0.4955 36899.9n 0.4955 36900.0n 0.4955 37199.9n 0.4955 37200.0n 0.4955 37499.9n 0.4955 37500.0n 0.4955 37799.9n 0.4955 37800.0n 0.4955 38099.9n 0.4955 38100.0n 0.4955 38399.9n 0.4955 38400.0n 0.4955 38699.9n 0.4955 38700.0n 0.4955 38999.9n 0.4955 39000.0n 0.4955 39299.9n 0.4955 39300.0n 0.4955 39599.9n 0.4955 39600.0n 0.4955 39899.9n 0.4955 39900.0n 0.4955 40199.9n 0.4955 40200.0n 0.4955 40499.9n 0.4955 40500.0n 0.4955 40799.9n 0.4955 40800.0n 0.4955 41099.9n 0.4955 41100.0n 0.4955 41399.9n 0.4955 41400.0n 0.4955 41699.9n 0.4955 41700.0n 0.4955 41999.9n 0.4955 42000.0n 0.4955 42299.9n 0.4955 42300.0n 0.4955 42599.9n 0.4955 42600.0n 0.4955 42899.9n 0.4955 42900.0n 0.4955 43199.9n 0.4955 43200.0n 0.4955 43499.9n 0.4955 43500.0n 0.4955 43799.9n 0.4955 43800.0n 0.4955 44099.9n 0.4955 44100.0n 0.4955 44399.9n 0.4955 44400.0n 0.4955 44699.9n 0.4955 44700.0n 0.4955 44999.9n 0.4955 45000.0n 0.4955 45299.9n 0.4955 45300.0n 0.4955 45599.9n 0.4955 45600.0n 0.4955 45899.9n 0.4955 45900.0n 0.4955 46199.9n 0.4955 46200.0n 0.4955 46499.9n 0.4955 46500.0n 0.4955 46799.9n 0.4955 46800.0n 0.4955 47099.9n 0.4955 47100.0n 0.4955 47399.9n 0.4955 47400.0n 0.4955 47699.9n 0.4955 47700.0n 0.4955 47999.9n 0.4955 48000.0n 0.4955 48299.9n 0.4955 48300.0n 0.4955 48599.9n 0.4955 48600.0n 0.4955 48899.9n 0.4955 48900.0n 0.4955 49199.9n 0.4955 49200.0n 0.4955 49499.9n 0.4955 49500.0n 0.4955 49799.9n 0.4955 49800.0n 0.4955 50099.9n 0.4955 50100.0n 0.4955 50399.9n 0.4955 50400.0n 0.4955 50699.9n 0.4955 50700.0n 0.4955 50999.9n 0.4955 51000.0n 0.4955 51299.9n 0.4955 51300.0n 0.4955 51599.9n 0.4955 51600.0n 0.4955 51899.9n 0.4955 51900.0n 0.4955 52199.9n 0.4955 52200.0n 0.4955 52499.9n 0.4955 52500.0n 0.4955 52799.9n 0.4955 52800.0n 0.4955 53099.9n 0.4955 53100.0n 0.4955 53399.9n 0.4955 53400.0n 0.4955 53699.9n 0.4955 53700.0n 0.4955 53999.9n 0.4955 54000.0n 0.4955 54299.9n 0.4955 54300.0n 0.4955 54599.9n 0.4955 54600.0n 0.4955 54899.9n 0.4955 54900.0n 0.4955 55199.9n 0.4955 55200.0n 0.4955 55499.9n 0.4955 55500.0n 0.4955 55799.9n 0.4955 55800.0n 0.4955 56099.9n 0.4955 56100.0n 0.4955 56399.9n 0.4955 56400.0n 0.4955 56699.9n 0.4955 56700.0n 0.4955 56999.9n 0.4955 57000.0n 0.4955 57299.9n 0.4955 57300.0n 0.4955 57599.9n 0.4955 57600.0n 0.4955 57899.9n 0.4955 57900.0n 0.4955 58199.9n 0.4955 58200.0n 0.4955 58499.9n 0.4955 58500.0n 0.4955 58799.9n 0.4955 58800.0n 0.4955 59099.9n 0.4955 59100.0n 0.4955)
Vxn16 a_xn16 0 PWL(0.0n 0.5045 299.9n 0.5045 300.0n 0.5045 599.9n 0.5045 600.0n 0.5045 899.9n 0.5045 900.0n 0.5045 1199.9n 0.5045 1200.0n 0.5045 1499.9n 0.5045 1500.0n 0.5045 1799.9n 0.5045 1800.0n 0.5045 2099.9n 0.5045 2100.0n 0.5045 2399.9n 0.5045 2400.0n 0.5045 2699.9n 0.5045 2700.0n 0.5045 2999.9n 0.5045 3000.0n 0.5045 3299.9n 0.5045 3300.0n 0.5045 3599.9n 0.5045 3600.0n 0.5045 3899.9n 0.5045 3900.0n 0.5045 4199.9n 0.5045 4200.0n 0.5045 4499.9n 0.5045 4500.0n 0.5045 4799.9n 0.5045 4800.0n 0.5045 5099.9n 0.5045 5100.0n 0.5045 5399.9n 0.5045 5400.0n 0.5045 5699.9n 0.5045 5700.0n 0.5045 5999.9n 0.5045 6000.0n 0.5045 6299.9n 0.5045 6300.0n 0.5045 6599.9n 0.5045 6600.0n 0.5045 6899.9n 0.5045 6900.0n 0.5045 7199.9n 0.5045 7200.0n 0.5045 7499.9n 0.5045 7500.0n 0.5045 7799.9n 0.5045 7800.0n 0.5045 8099.9n 0.5045 8100.0n 0.5045 8399.9n 0.5045 8400.0n 0.5045 8699.9n 0.5045 8700.0n 0.5045 8999.9n 0.5045 9000.0n 0.5045 9299.9n 0.5045 9300.0n 0.5045 9599.9n 0.5045 9600.0n 0.5045 9899.9n 0.5045 9900.0n 0.5045 10199.9n 0.5045 10200.0n 0.5045 10499.9n 0.5045 10500.0n 0.5045 10799.9n 0.5045 10800.0n 0.5045 11099.9n 0.5045 11100.0n 0.5045 11399.9n 0.5045 11400.0n 0.5045 11699.9n 0.5045 11700.0n 0.5045 11999.9n 0.5045 12000.0n 0.5045 12299.9n 0.5045 12300.0n 0.5045 12599.9n 0.5045 12600.0n 0.5045 12899.9n 0.5045 12900.0n 0.5045 13199.9n 0.5045 13200.0n 0.5045 13499.9n 0.5045 13500.0n 0.5045 13799.9n 0.5045 13800.0n 0.5045 14099.9n 0.5045 14100.0n 0.5045 14399.9n 0.5045 14400.0n 0.5045 14699.9n 0.5045 14700.0n 0.5045 14999.9n 0.5045 15000.0n 0.5045 15299.9n 0.5045 15300.0n 0.5045 15599.9n 0.5045 15600.0n 0.5045 15899.9n 0.5045 15900.0n 0.5045 16199.9n 0.5045 16200.0n 0.5045 16499.9n 0.5045 16500.0n 0.5045 16799.9n 0.5045 16800.0n 0.5045 17099.9n 0.5045 17100.0n 0.5045 17399.9n 0.5045 17400.0n 0.5045 17699.9n 0.5045 17700.0n 0.5045 17999.9n 0.5045 18000.0n 0.5045 18299.9n 0.5045 18300.0n 0.5045 18599.9n 0.5045 18600.0n 0.5045 18899.9n 0.5045 18900.0n 0.5045 19199.9n 0.5045 19200.0n 0.5045 19499.9n 0.5045 19500.0n 0.5045 19799.9n 0.5045 19800.0n 0.5045 20099.9n 0.5045 20100.0n 0.5045 20399.9n 0.5045 20400.0n 0.5045 20699.9n 0.5045 20700.0n 0.5045 20999.9n 0.5045 21000.0n 0.5045 21299.9n 0.5045 21300.0n 0.5045 21599.9n 0.5045 21600.0n 0.5045 21899.9n 0.5045 21900.0n 0.5045 22199.9n 0.5045 22200.0n 0.5045 22499.9n 0.5045 22500.0n 0.5045 22799.9n 0.5045 22800.0n 0.5045 23099.9n 0.5045 23100.0n 0.5045 23399.9n 0.5045 23400.0n 0.5045 23699.9n 0.5045 23700.0n 0.5045 23999.9n 0.5045 24000.0n 0.5045 24299.9n 0.5045 24300.0n 0.5045 24599.9n 0.5045 24600.0n 0.5045 24899.9n 0.5045 24900.0n 0.5045 25199.9n 0.5045 25200.0n 0.5045 25499.9n 0.5045 25500.0n 0.5045 25799.9n 0.5045 25800.0n 0.5045 26099.9n 0.5045 26100.0n 0.5045 26399.9n 0.5045 26400.0n 0.5045 26699.9n 0.5045 26700.0n 0.5045 26999.9n 0.5045 27000.0n 0.5045 27299.9n 0.5045 27300.0n 0.5045 27599.9n 0.5045 27600.0n 0.5045 27899.9n 0.5045 27900.0n 0.5045 28199.9n 0.5045 28200.0n 0.5045 28499.9n 0.5045 28500.0n 0.5045 28799.9n 0.5045 28800.0n 0.5045 29099.9n 0.5045 29100.0n 0.5045 29399.9n 0.5045 29400.0n 0.5045 29699.9n 0.5045 29700.0n 0.5045 29999.9n 0.5045 30000.0n 0.5045 30299.9n 0.5045 30300.0n 0.5045 30599.9n 0.5045 30600.0n 0.5045 30899.9n 0.5045 30900.0n 0.5045 31199.9n 0.5045 31200.0n 0.5045 31499.9n 0.5045 31500.0n 0.5045 31799.9n 0.5045 31800.0n 0.5045 32099.9n 0.5045 32100.0n 0.5045 32399.9n 0.5045 32400.0n 0.5045 32699.9n 0.5045 32700.0n 0.5045 32999.9n 0.5045 33000.0n 0.5045 33299.9n 0.5045 33300.0n 0.5045 33599.9n 0.5045 33600.0n 0.5045 33899.9n 0.5045 33900.0n 0.5045 34199.9n 0.5045 34200.0n 0.5045 34499.9n 0.5045 34500.0n 0.5045 34799.9n 0.5045 34800.0n 0.5045 35099.9n 0.5045 35100.0n 0.5045 35399.9n 0.5045 35400.0n 0.5045 35699.9n 0.5045 35700.0n 0.5045 35999.9n 0.5045 36000.0n 0.5045 36299.9n 0.5045 36300.0n 0.5045 36599.9n 0.5045 36600.0n 0.5045 36899.9n 0.5045 36900.0n 0.5045 37199.9n 0.5045 37200.0n 0.5045 37499.9n 0.5045 37500.0n 0.5045 37799.9n 0.5045 37800.0n 0.5045 38099.9n 0.5045 38100.0n 0.5045 38399.9n 0.5045 38400.0n 0.5045 38699.9n 0.5045 38700.0n 0.5045 38999.9n 0.5045 39000.0n 0.5045 39299.9n 0.5045 39300.0n 0.5045 39599.9n 0.5045 39600.0n 0.5045 39899.9n 0.5045 39900.0n 0.5045 40199.9n 0.5045 40200.0n 0.5045 40499.9n 0.5045 40500.0n 0.5045 40799.9n 0.5045 40800.0n 0.5045 41099.9n 0.5045 41100.0n 0.5045 41399.9n 0.5045 41400.0n 0.5045 41699.9n 0.5045 41700.0n 0.5045 41999.9n 0.5045 42000.0n 0.5045 42299.9n 0.5045 42300.0n 0.5045 42599.9n 0.5045 42600.0n 0.5045 42899.9n 0.5045 42900.0n 0.5045 43199.9n 0.5045 43200.0n 0.5045 43499.9n 0.5045 43500.0n 0.5045 43799.9n 0.5045 43800.0n 0.5045 44099.9n 0.5045 44100.0n 0.5045 44399.9n 0.5045 44400.0n 0.5045 44699.9n 0.5045 44700.0n 0.5045 44999.9n 0.5045 45000.0n 0.5045 45299.9n 0.5045 45300.0n 0.5045 45599.9n 0.5045 45600.0n 0.5045 45899.9n 0.5045 45900.0n 0.5045 46199.9n 0.5045 46200.0n 0.5045 46499.9n 0.5045 46500.0n 0.5045 46799.9n 0.5045 46800.0n 0.5045 47099.9n 0.5045 47100.0n 0.5045 47399.9n 0.5045 47400.0n 0.5045 47699.9n 0.5045 47700.0n 0.5045 47999.9n 0.5045 48000.0n 0.5045 48299.9n 0.5045 48300.0n 0.5045 48599.9n 0.5045 48600.0n 0.5045 48899.9n 0.5045 48900.0n 0.5045 49199.9n 0.5045 49200.0n 0.5045 49499.9n 0.5045 49500.0n 0.5045 49799.9n 0.5045 49800.0n 0.5045 50099.9n 0.5045 50100.0n 0.5045 50399.9n 0.5045 50400.0n 0.5045 50699.9n 0.5045 50700.0n 0.5045 50999.9n 0.5045 51000.0n 0.5045 51299.9n 0.5045 51300.0n 0.5045 51599.9n 0.5045 51600.0n 0.5045 51899.9n 0.5045 51900.0n 0.5045 52199.9n 0.5045 52200.0n 0.5045 52499.9n 0.5045 52500.0n 0.5045 52799.9n 0.5045 52800.0n 0.5045 53099.9n 0.5045 53100.0n 0.5045 53399.9n 0.5045 53400.0n 0.5045 53699.9n 0.5045 53700.0n 0.5045 53999.9n 0.5045 54000.0n 0.5045 54299.9n 0.5045 54300.0n 0.5045 54599.9n 0.5045 54600.0n 0.5045 54899.9n 0.5045 54900.0n 0.5045 55199.9n 0.5045 55200.0n 0.5045 55499.9n 0.5045 55500.0n 0.5045 55799.9n 0.5045 55800.0n 0.5045 56099.9n 0.5045 56100.0n 0.5045 56399.9n 0.5045 56400.0n 0.5045 56699.9n 0.5045 56700.0n 0.5045 56999.9n 0.5045 57000.0n 0.5045 57299.9n 0.5045 57300.0n 0.5045 57599.9n 0.5045 57600.0n 0.5045 57899.9n 0.5045 57900.0n 0.5045 58199.9n 0.5045 58200.0n 0.5045 58499.9n 0.5045 58500.0n 0.5045 58799.9n 0.5045 58800.0n 0.5045 59099.9n 0.5045 59100.0n 0.5045)
Vxp17 a_xp17 0 PWL(0.0n 0.4272 299.9n 0.4272 300.0n 0.4272 599.9n 0.4272 600.0n 0.5671 899.9n 0.5671 900.0n 0.4272 1199.9n 0.4272 1200.0n 0.5671 1499.9n 0.5671 1500.0n 0.4272 1799.9n 0.4272 1800.0n 0.5391 2099.9n 0.5391 2100.0n 0.5111 2399.9n 0.5111 2400.0n 0.5111 2699.9n 0.5111 2700.0n 0.4832 2999.9n 0.4832 3000.0n 0.6510 3299.9n 0.6510 3300.0n 0.4272 3599.9n 0.4272 3600.0n 0.6510 3899.9n 0.6510 3900.0n 0.4272 4199.9n 0.4272 4200.0n 0.6790 4499.9n 0.6790 4500.0n 0.5391 4799.9n 0.5391 4800.0n 0.4832 5099.9n 0.4832 5100.0n 0.4272 5399.9n 0.4272 5400.0n 0.4272 5699.9n 0.4272 5700.0n 0.4272 5999.9n 0.4272 6000.0n 0.5671 6299.9n 0.5671 6300.0n 0.4272 6599.9n 0.4272 6600.0n 0.5671 6899.9n 0.5671 6900.0n 0.4272 7199.9n 0.4272 7200.0n 0.5391 7499.9n 0.5391 7500.0n 0.5111 7799.9n 0.5111 7800.0n 0.5111 8099.9n 0.5111 8100.0n 0.4832 8399.9n 0.4832 8400.0n 0.6510 8699.9n 0.6510 8700.0n 0.4272 8999.9n 0.4272 9000.0n 0.6510 9299.9n 0.6510 9300.0n 0.4272 9599.9n 0.4272 9600.0n 0.6790 9899.9n 0.6790 9900.0n 0.5391 10199.9n 0.5391 10200.0n 0.4832 10499.9n 0.4832 10500.0n 0.4272 10799.9n 0.4272 10800.0n 0.4272 11099.9n 0.4272 11100.0n 0.4272 11399.9n 0.4272 11400.0n 0.5671 11699.9n 0.5671 11700.0n 0.4272 11999.9n 0.4272 12000.0n 0.5671 12299.9n 0.5671 12300.0n 0.4272 12599.9n 0.4272 12600.0n 0.5391 12899.9n 0.5391 12900.0n 0.5111 13199.9n 0.5111 13200.0n 0.5111 13499.9n 0.5111 13500.0n 0.4832 13799.9n 0.4832 13800.0n 0.6510 14099.9n 0.6510 14100.0n 0.4272 14399.9n 0.4272 14400.0n 0.6510 14699.9n 0.6510 14700.0n 0.4272 14999.9n 0.4272 15000.0n 0.6790 15299.9n 0.6790 15300.0n 0.5391 15599.9n 0.5391 15600.0n 0.4832 15899.9n 0.4832 15900.0n 0.4272 16199.9n 0.4272 16200.0n 0.4272 16499.9n 0.4272 16500.0n 0.4272 16799.9n 0.4272 16800.0n 0.5671 17099.9n 0.5671 17100.0n 0.4272 17399.9n 0.4272 17400.0n 0.5671 17699.9n 0.5671 17700.0n 0.4272 17999.9n 0.4272 18000.0n 0.5391 18299.9n 0.5391 18300.0n 0.5111 18599.9n 0.5111 18600.0n 0.5111 18899.9n 0.5111 18900.0n 0.4832 19199.9n 0.4832 19200.0n 0.6510 19499.9n 0.6510 19500.0n 0.4272 19799.9n 0.4272 19800.0n 0.6510 20099.9n 0.6510 20100.0n 0.4272 20399.9n 0.4272 20400.0n 0.6790 20699.9n 0.6790 20700.0n 0.5391 20999.9n 0.5391 21000.0n 0.4832 21299.9n 0.4832 21300.0n 0.4272 21599.9n 0.4272 21600.0n 0.4272 21899.9n 0.4272 21900.0n 0.4272 22199.9n 0.4272 22200.0n 0.5671 22499.9n 0.5671 22500.0n 0.4272 22799.9n 0.4272 22800.0n 0.5671 23099.9n 0.5671 23100.0n 0.4272 23399.9n 0.4272 23400.0n 0.5391 23699.9n 0.5391 23700.0n 0.5111 23999.9n 0.5111 24000.0n 0.5111 24299.9n 0.5111 24300.0n 0.4832 24599.9n 0.4832 24600.0n 0.6510 24899.9n 0.6510 24900.0n 0.4272 25199.9n 0.4272 25200.0n 0.6510 25499.9n 0.6510 25500.0n 0.4272 25799.9n 0.4272 25800.0n 0.6790 26099.9n 0.6790 26100.0n 0.5391 26399.9n 0.5391 26400.0n 0.4832 26699.9n 0.4832 26700.0n 0.4272 26999.9n 0.4272 27000.0n 0.4272 27299.9n 0.4272 27300.0n 0.4272 27599.9n 0.4272 27600.0n 0.5671 27899.9n 0.5671 27900.0n 0.4272 28199.9n 0.4272 28200.0n 0.5671 28499.9n 0.5671 28500.0n 0.4272 28799.9n 0.4272 28800.0n 0.5391 29099.9n 0.5391 29100.0n 0.5111 29399.9n 0.5111 29400.0n 0.5111 29699.9n 0.5111 29700.0n 0.4832 29999.9n 0.4832 30000.0n 0.6510 30299.9n 0.6510 30300.0n 0.4272 30599.9n 0.4272 30600.0n 0.6510 30899.9n 0.6510 30900.0n 0.4272 31199.9n 0.4272 31200.0n 0.6790 31499.9n 0.6790 31500.0n 0.5391 31799.9n 0.5391 31800.0n 0.4832 32099.9n 0.4832 32100.0n 0.4272 32399.9n 0.4272 32400.0n 0.4272 32699.9n 0.4272 32700.0n 0.4272 32999.9n 0.4272 33000.0n 0.5671 33299.9n 0.5671 33300.0n 0.4272 33599.9n 0.4272 33600.0n 0.5671 33899.9n 0.5671 33900.0n 0.4272 34199.9n 0.4272 34200.0n 0.5391 34499.9n 0.5391 34500.0n 0.5111 34799.9n 0.5111 34800.0n 0.5111 35099.9n 0.5111 35100.0n 0.4832 35399.9n 0.4832 35400.0n 0.6510 35699.9n 0.6510 35700.0n 0.4272 35999.9n 0.4272 36000.0n 0.6510 36299.9n 0.6510 36300.0n 0.4272 36599.9n 0.4272 36600.0n 0.6790 36899.9n 0.6790 36900.0n 0.5391 37199.9n 0.5391 37200.0n 0.4832 37499.9n 0.4832 37500.0n 0.4272 37799.9n 0.4272 37800.0n 0.4272 38099.9n 0.4272 38100.0n 0.4272 38399.9n 0.4272 38400.0n 0.5671 38699.9n 0.5671 38700.0n 0.4272 38999.9n 0.4272 39000.0n 0.5671 39299.9n 0.5671 39300.0n 0.4272 39599.9n 0.4272 39600.0n 0.5391 39899.9n 0.5391 39900.0n 0.5111 40199.9n 0.5111 40200.0n 0.5111 40499.9n 0.5111 40500.0n 0.4832 40799.9n 0.4832 40800.0n 0.6510 41099.9n 0.6510 41100.0n 0.4272 41399.9n 0.4272 41400.0n 0.6510 41699.9n 0.6510 41700.0n 0.4272 41999.9n 0.4272 42000.0n 0.6790 42299.9n 0.6790 42300.0n 0.5391 42599.9n 0.5391 42600.0n 0.4832 42899.9n 0.4832 42900.0n 0.4272 43199.9n 0.4272 43200.0n 0.4272 43499.9n 0.4272 43500.0n 0.4272 43799.9n 0.4272 43800.0n 0.5671 44099.9n 0.5671 44100.0n 0.4272 44399.9n 0.4272 44400.0n 0.5671 44699.9n 0.5671 44700.0n 0.4272 44999.9n 0.4272 45000.0n 0.5391 45299.9n 0.5391 45300.0n 0.5111 45599.9n 0.5111 45600.0n 0.5111 45899.9n 0.5111 45900.0n 0.4832 46199.9n 0.4832 46200.0n 0.6510 46499.9n 0.6510 46500.0n 0.4272 46799.9n 0.4272 46800.0n 0.6510 47099.9n 0.6510 47100.0n 0.4272 47399.9n 0.4272 47400.0n 0.6790 47699.9n 0.6790 47700.0n 0.5391 47999.9n 0.5391 48000.0n 0.4832 48299.9n 0.4832 48300.0n 0.4272 48599.9n 0.4272 48600.0n 0.4272 48899.9n 0.4272 48900.0n 0.4272 49199.9n 0.4272 49200.0n 0.5671 49499.9n 0.5671 49500.0n 0.4272 49799.9n 0.4272 49800.0n 0.5671 50099.9n 0.5671 50100.0n 0.4272 50399.9n 0.4272 50400.0n 0.5391 50699.9n 0.5391 50700.0n 0.5111 50999.9n 0.5111 51000.0n 0.5111 51299.9n 0.5111 51300.0n 0.4832 51599.9n 0.4832 51600.0n 0.6510 51899.9n 0.6510 51900.0n 0.4272 52199.9n 0.4272 52200.0n 0.6510 52499.9n 0.6510 52500.0n 0.4272 52799.9n 0.4272 52800.0n 0.6790 53099.9n 0.6790 53100.0n 0.5391 53399.9n 0.5391 53400.0n 0.4832 53699.9n 0.4832 53700.0n 0.4272 53999.9n 0.4272 54000.0n 0.5391 54299.9n 0.5391 54300.0n 0.5111 54599.9n 0.5111 54600.0n 0.5111 54899.9n 0.5111 54900.0n 0.5111 55199.9n 0.5111 55200.0n 0.4832 55499.9n 0.4832 55500.0n 0.5391 55799.9n 0.5391 55800.0n 0.4272 56099.9n 0.4272 56100.0n 0.4272 56399.9n 0.4272 56400.0n 0.4272 56699.9n 0.4272 56700.0n 0.4272 56999.9n 0.4272 57000.0n 0.5671 57299.9n 0.5671 57300.0n 0.4272 57599.9n 0.4272 57600.0n 0.6790 57899.9n 0.6790 57900.0n 0.6230 58199.9n 0.6230 58200.0n 0.7349 58499.9n 0.7349 58500.0n 0.6230 58799.9n 0.6230 58800.0n 0.5671 59099.9n 0.5671 59100.0n 0.4272)
Vxn17 a_xn17 0 PWL(0.0n 0.5728 299.9n 0.5728 300.0n 0.5728 599.9n 0.5728 600.0n 0.4329 899.9n 0.4329 900.0n 0.5728 1199.9n 0.5728 1200.0n 0.4329 1499.9n 0.4329 1500.0n 0.5728 1799.9n 0.5728 1800.0n 0.4609 2099.9n 0.4609 2100.0n 0.4889 2399.9n 0.4889 2400.0n 0.4889 2699.9n 0.4889 2700.0n 0.5168 2999.9n 0.5168 3000.0n 0.3490 3299.9n 0.3490 3300.0n 0.5728 3599.9n 0.5728 3600.0n 0.3490 3899.9n 0.3490 3900.0n 0.5728 4199.9n 0.5728 4200.0n 0.3210 4499.9n 0.3210 4500.0n 0.4609 4799.9n 0.4609 4800.0n 0.5168 5099.9n 0.5168 5100.0n 0.5728 5399.9n 0.5728 5400.0n 0.5728 5699.9n 0.5728 5700.0n 0.5728 5999.9n 0.5728 6000.0n 0.4329 6299.9n 0.4329 6300.0n 0.5728 6599.9n 0.5728 6600.0n 0.4329 6899.9n 0.4329 6900.0n 0.5728 7199.9n 0.5728 7200.0n 0.4609 7499.9n 0.4609 7500.0n 0.4889 7799.9n 0.4889 7800.0n 0.4889 8099.9n 0.4889 8100.0n 0.5168 8399.9n 0.5168 8400.0n 0.3490 8699.9n 0.3490 8700.0n 0.5728 8999.9n 0.5728 9000.0n 0.3490 9299.9n 0.3490 9300.0n 0.5728 9599.9n 0.5728 9600.0n 0.3210 9899.9n 0.3210 9900.0n 0.4609 10199.9n 0.4609 10200.0n 0.5168 10499.9n 0.5168 10500.0n 0.5728 10799.9n 0.5728 10800.0n 0.5728 11099.9n 0.5728 11100.0n 0.5728 11399.9n 0.5728 11400.0n 0.4329 11699.9n 0.4329 11700.0n 0.5728 11999.9n 0.5728 12000.0n 0.4329 12299.9n 0.4329 12300.0n 0.5728 12599.9n 0.5728 12600.0n 0.4609 12899.9n 0.4609 12900.0n 0.4889 13199.9n 0.4889 13200.0n 0.4889 13499.9n 0.4889 13500.0n 0.5168 13799.9n 0.5168 13800.0n 0.3490 14099.9n 0.3490 14100.0n 0.5728 14399.9n 0.5728 14400.0n 0.3490 14699.9n 0.3490 14700.0n 0.5728 14999.9n 0.5728 15000.0n 0.3210 15299.9n 0.3210 15300.0n 0.4609 15599.9n 0.4609 15600.0n 0.5168 15899.9n 0.5168 15900.0n 0.5728 16199.9n 0.5728 16200.0n 0.5728 16499.9n 0.5728 16500.0n 0.5728 16799.9n 0.5728 16800.0n 0.4329 17099.9n 0.4329 17100.0n 0.5728 17399.9n 0.5728 17400.0n 0.4329 17699.9n 0.4329 17700.0n 0.5728 17999.9n 0.5728 18000.0n 0.4609 18299.9n 0.4609 18300.0n 0.4889 18599.9n 0.4889 18600.0n 0.4889 18899.9n 0.4889 18900.0n 0.5168 19199.9n 0.5168 19200.0n 0.3490 19499.9n 0.3490 19500.0n 0.5728 19799.9n 0.5728 19800.0n 0.3490 20099.9n 0.3490 20100.0n 0.5728 20399.9n 0.5728 20400.0n 0.3210 20699.9n 0.3210 20700.0n 0.4609 20999.9n 0.4609 21000.0n 0.5168 21299.9n 0.5168 21300.0n 0.5728 21599.9n 0.5728 21600.0n 0.5728 21899.9n 0.5728 21900.0n 0.5728 22199.9n 0.5728 22200.0n 0.4329 22499.9n 0.4329 22500.0n 0.5728 22799.9n 0.5728 22800.0n 0.4329 23099.9n 0.4329 23100.0n 0.5728 23399.9n 0.5728 23400.0n 0.4609 23699.9n 0.4609 23700.0n 0.4889 23999.9n 0.4889 24000.0n 0.4889 24299.9n 0.4889 24300.0n 0.5168 24599.9n 0.5168 24600.0n 0.3490 24899.9n 0.3490 24900.0n 0.5728 25199.9n 0.5728 25200.0n 0.3490 25499.9n 0.3490 25500.0n 0.5728 25799.9n 0.5728 25800.0n 0.3210 26099.9n 0.3210 26100.0n 0.4609 26399.9n 0.4609 26400.0n 0.5168 26699.9n 0.5168 26700.0n 0.5728 26999.9n 0.5728 27000.0n 0.5728 27299.9n 0.5728 27300.0n 0.5728 27599.9n 0.5728 27600.0n 0.4329 27899.9n 0.4329 27900.0n 0.5728 28199.9n 0.5728 28200.0n 0.4329 28499.9n 0.4329 28500.0n 0.5728 28799.9n 0.5728 28800.0n 0.4609 29099.9n 0.4609 29100.0n 0.4889 29399.9n 0.4889 29400.0n 0.4889 29699.9n 0.4889 29700.0n 0.5168 29999.9n 0.5168 30000.0n 0.3490 30299.9n 0.3490 30300.0n 0.5728 30599.9n 0.5728 30600.0n 0.3490 30899.9n 0.3490 30900.0n 0.5728 31199.9n 0.5728 31200.0n 0.3210 31499.9n 0.3210 31500.0n 0.4609 31799.9n 0.4609 31800.0n 0.5168 32099.9n 0.5168 32100.0n 0.5728 32399.9n 0.5728 32400.0n 0.5728 32699.9n 0.5728 32700.0n 0.5728 32999.9n 0.5728 33000.0n 0.4329 33299.9n 0.4329 33300.0n 0.5728 33599.9n 0.5728 33600.0n 0.4329 33899.9n 0.4329 33900.0n 0.5728 34199.9n 0.5728 34200.0n 0.4609 34499.9n 0.4609 34500.0n 0.4889 34799.9n 0.4889 34800.0n 0.4889 35099.9n 0.4889 35100.0n 0.5168 35399.9n 0.5168 35400.0n 0.3490 35699.9n 0.3490 35700.0n 0.5728 35999.9n 0.5728 36000.0n 0.3490 36299.9n 0.3490 36300.0n 0.5728 36599.9n 0.5728 36600.0n 0.3210 36899.9n 0.3210 36900.0n 0.4609 37199.9n 0.4609 37200.0n 0.5168 37499.9n 0.5168 37500.0n 0.5728 37799.9n 0.5728 37800.0n 0.5728 38099.9n 0.5728 38100.0n 0.5728 38399.9n 0.5728 38400.0n 0.4329 38699.9n 0.4329 38700.0n 0.5728 38999.9n 0.5728 39000.0n 0.4329 39299.9n 0.4329 39300.0n 0.5728 39599.9n 0.5728 39600.0n 0.4609 39899.9n 0.4609 39900.0n 0.4889 40199.9n 0.4889 40200.0n 0.4889 40499.9n 0.4889 40500.0n 0.5168 40799.9n 0.5168 40800.0n 0.3490 41099.9n 0.3490 41100.0n 0.5728 41399.9n 0.5728 41400.0n 0.3490 41699.9n 0.3490 41700.0n 0.5728 41999.9n 0.5728 42000.0n 0.3210 42299.9n 0.3210 42300.0n 0.4609 42599.9n 0.4609 42600.0n 0.5168 42899.9n 0.5168 42900.0n 0.5728 43199.9n 0.5728 43200.0n 0.5728 43499.9n 0.5728 43500.0n 0.5728 43799.9n 0.5728 43800.0n 0.4329 44099.9n 0.4329 44100.0n 0.5728 44399.9n 0.5728 44400.0n 0.4329 44699.9n 0.4329 44700.0n 0.5728 44999.9n 0.5728 45000.0n 0.4609 45299.9n 0.4609 45300.0n 0.4889 45599.9n 0.4889 45600.0n 0.4889 45899.9n 0.4889 45900.0n 0.5168 46199.9n 0.5168 46200.0n 0.3490 46499.9n 0.3490 46500.0n 0.5728 46799.9n 0.5728 46800.0n 0.3490 47099.9n 0.3490 47100.0n 0.5728 47399.9n 0.5728 47400.0n 0.3210 47699.9n 0.3210 47700.0n 0.4609 47999.9n 0.4609 48000.0n 0.5168 48299.9n 0.5168 48300.0n 0.5728 48599.9n 0.5728 48600.0n 0.5728 48899.9n 0.5728 48900.0n 0.5728 49199.9n 0.5728 49200.0n 0.4329 49499.9n 0.4329 49500.0n 0.5728 49799.9n 0.5728 49800.0n 0.4329 50099.9n 0.4329 50100.0n 0.5728 50399.9n 0.5728 50400.0n 0.4609 50699.9n 0.4609 50700.0n 0.4889 50999.9n 0.4889 51000.0n 0.4889 51299.9n 0.4889 51300.0n 0.5168 51599.9n 0.5168 51600.0n 0.3490 51899.9n 0.3490 51900.0n 0.5728 52199.9n 0.5728 52200.0n 0.3490 52499.9n 0.3490 52500.0n 0.5728 52799.9n 0.5728 52800.0n 0.3210 53099.9n 0.3210 53100.0n 0.4609 53399.9n 0.4609 53400.0n 0.5168 53699.9n 0.5168 53700.0n 0.5728 53999.9n 0.5728 54000.0n 0.4609 54299.9n 0.4609 54300.0n 0.4889 54599.9n 0.4889 54600.0n 0.4889 54899.9n 0.4889 54900.0n 0.4889 55199.9n 0.4889 55200.0n 0.5168 55499.9n 0.5168 55500.0n 0.4609 55799.9n 0.4609 55800.0n 0.5728 56099.9n 0.5728 56100.0n 0.5728 56399.9n 0.5728 56400.0n 0.5728 56699.9n 0.5728 56700.0n 0.5728 56999.9n 0.5728 57000.0n 0.4329 57299.9n 0.4329 57300.0n 0.5728 57599.9n 0.5728 57600.0n 0.3210 57899.9n 0.3210 57900.0n 0.3770 58199.9n 0.3770 58200.0n 0.2651 58499.9n 0.2651 58500.0n 0.3770 58799.9n 0.3770 58800.0n 0.4329 59099.9n 0.4329 59100.0n 0.5728)
Vxp18 a_xp18 0 PWL(0.0n 0.4314 299.9n 0.4314 300.0n 0.5544 599.9n 0.5544 600.0n 0.5369 899.9n 0.5369 900.0n 0.5720 1199.9n 0.5720 1200.0n 0.6072 1499.9n 0.6072 1500.0n 0.6072 1799.9n 0.6072 1800.0n 0.5544 2099.9n 0.5544 2100.0n 0.5193 2399.9n 0.5193 2400.0n 0.3435 2699.9n 0.3435 2700.0n 0.5720 2999.9n 0.5720 3000.0n 0.5017 3299.9n 0.5017 3300.0n 0.3787 3599.9n 0.3787 3600.0n 0.6072 3899.9n 0.6072 3900.0n 0.4490 4199.9n 0.4490 4200.0n 0.5017 4499.9n 0.5017 4500.0n 0.5369 4799.9n 0.5369 4800.0n 0.5720 5099.9n 0.5720 5100.0n 0.3259 5399.9n 0.3259 5400.0n 0.4314 5699.9n 0.4314 5700.0n 0.5544 5999.9n 0.5544 6000.0n 0.5369 6299.9n 0.5369 6300.0n 0.5720 6599.9n 0.5720 6600.0n 0.6072 6899.9n 0.6072 6900.0n 0.6072 7199.9n 0.6072 7200.0n 0.5544 7499.9n 0.5544 7500.0n 0.5193 7799.9n 0.5193 7800.0n 0.3435 8099.9n 0.3435 8100.0n 0.5720 8399.9n 0.5720 8400.0n 0.5017 8699.9n 0.5017 8700.0n 0.3787 8999.9n 0.3787 9000.0n 0.6072 9299.9n 0.6072 9300.0n 0.4490 9599.9n 0.4490 9600.0n 0.5017 9899.9n 0.5017 9900.0n 0.5369 10199.9n 0.5369 10200.0n 0.5720 10499.9n 0.5720 10500.0n 0.3259 10799.9n 0.3259 10800.0n 0.4314 11099.9n 0.4314 11100.0n 0.5544 11399.9n 0.5544 11400.0n 0.5369 11699.9n 0.5369 11700.0n 0.5720 11999.9n 0.5720 12000.0n 0.6072 12299.9n 0.6072 12300.0n 0.6072 12599.9n 0.6072 12600.0n 0.5544 12899.9n 0.5544 12900.0n 0.5193 13199.9n 0.5193 13200.0n 0.3435 13499.9n 0.3435 13500.0n 0.5720 13799.9n 0.5720 13800.0n 0.5017 14099.9n 0.5017 14100.0n 0.3787 14399.9n 0.3787 14400.0n 0.6072 14699.9n 0.6072 14700.0n 0.4490 14999.9n 0.4490 15000.0n 0.5017 15299.9n 0.5017 15300.0n 0.5369 15599.9n 0.5369 15600.0n 0.5720 15899.9n 0.5720 15900.0n 0.3259 16199.9n 0.3259 16200.0n 0.4314 16499.9n 0.4314 16500.0n 0.5544 16799.9n 0.5544 16800.0n 0.5369 17099.9n 0.5369 17100.0n 0.5720 17399.9n 0.5720 17400.0n 0.6072 17699.9n 0.6072 17700.0n 0.6072 17999.9n 0.6072 18000.0n 0.5544 18299.9n 0.5544 18300.0n 0.5193 18599.9n 0.5193 18600.0n 0.3435 18899.9n 0.3435 18900.0n 0.5720 19199.9n 0.5720 19200.0n 0.5017 19499.9n 0.5017 19500.0n 0.3787 19799.9n 0.3787 19800.0n 0.6072 20099.9n 0.6072 20100.0n 0.4490 20399.9n 0.4490 20400.0n 0.5017 20699.9n 0.5017 20700.0n 0.5369 20999.9n 0.5369 21000.0n 0.5720 21299.9n 0.5720 21300.0n 0.3259 21599.9n 0.3259 21600.0n 0.4314 21899.9n 0.4314 21900.0n 0.5544 22199.9n 0.5544 22200.0n 0.5369 22499.9n 0.5369 22500.0n 0.5720 22799.9n 0.5720 22800.0n 0.6072 23099.9n 0.6072 23100.0n 0.6072 23399.9n 0.6072 23400.0n 0.5544 23699.9n 0.5544 23700.0n 0.5193 23999.9n 0.5193 24000.0n 0.3435 24299.9n 0.3435 24300.0n 0.5720 24599.9n 0.5720 24600.0n 0.5017 24899.9n 0.5017 24900.0n 0.3787 25199.9n 0.3787 25200.0n 0.6072 25499.9n 0.6072 25500.0n 0.4490 25799.9n 0.4490 25800.0n 0.5017 26099.9n 0.5017 26100.0n 0.5369 26399.9n 0.5369 26400.0n 0.5720 26699.9n 0.5720 26700.0n 0.3259 26999.9n 0.3259 27000.0n 0.4314 27299.9n 0.4314 27300.0n 0.5544 27599.9n 0.5544 27600.0n 0.5369 27899.9n 0.5369 27900.0n 0.5720 28199.9n 0.5720 28200.0n 0.6072 28499.9n 0.6072 28500.0n 0.6072 28799.9n 0.6072 28800.0n 0.5544 29099.9n 0.5544 29100.0n 0.5193 29399.9n 0.5193 29400.0n 0.3435 29699.9n 0.3435 29700.0n 0.5720 29999.9n 0.5720 30000.0n 0.5017 30299.9n 0.5017 30300.0n 0.3787 30599.9n 0.3787 30600.0n 0.6072 30899.9n 0.6072 30900.0n 0.4490 31199.9n 0.4490 31200.0n 0.5017 31499.9n 0.5017 31500.0n 0.5369 31799.9n 0.5369 31800.0n 0.5720 32099.9n 0.5720 32100.0n 0.3259 32399.9n 0.3259 32400.0n 0.4314 32699.9n 0.4314 32700.0n 0.5544 32999.9n 0.5544 33000.0n 0.5369 33299.9n 0.5369 33300.0n 0.5720 33599.9n 0.5720 33600.0n 0.6072 33899.9n 0.6072 33900.0n 0.6072 34199.9n 0.6072 34200.0n 0.5544 34499.9n 0.5544 34500.0n 0.5193 34799.9n 0.5193 34800.0n 0.3435 35099.9n 0.3435 35100.0n 0.5720 35399.9n 0.5720 35400.0n 0.5017 35699.9n 0.5017 35700.0n 0.3787 35999.9n 0.3787 36000.0n 0.6072 36299.9n 0.6072 36300.0n 0.4490 36599.9n 0.4490 36600.0n 0.5017 36899.9n 0.5017 36900.0n 0.5369 37199.9n 0.5369 37200.0n 0.5720 37499.9n 0.5720 37500.0n 0.3259 37799.9n 0.3259 37800.0n 0.4314 38099.9n 0.4314 38100.0n 0.5544 38399.9n 0.5544 38400.0n 0.5369 38699.9n 0.5369 38700.0n 0.5720 38999.9n 0.5720 39000.0n 0.6072 39299.9n 0.6072 39300.0n 0.6072 39599.9n 0.6072 39600.0n 0.5544 39899.9n 0.5544 39900.0n 0.5193 40199.9n 0.5193 40200.0n 0.3435 40499.9n 0.3435 40500.0n 0.5720 40799.9n 0.5720 40800.0n 0.5017 41099.9n 0.5017 41100.0n 0.3787 41399.9n 0.3787 41400.0n 0.6072 41699.9n 0.6072 41700.0n 0.4490 41999.9n 0.4490 42000.0n 0.5017 42299.9n 0.5017 42300.0n 0.5369 42599.9n 0.5369 42600.0n 0.5720 42899.9n 0.5720 42900.0n 0.3259 43199.9n 0.3259 43200.0n 0.4314 43499.9n 0.4314 43500.0n 0.5544 43799.9n 0.5544 43800.0n 0.5369 44099.9n 0.5369 44100.0n 0.5720 44399.9n 0.5720 44400.0n 0.6072 44699.9n 0.6072 44700.0n 0.6072 44999.9n 0.6072 45000.0n 0.5544 45299.9n 0.5544 45300.0n 0.5193 45599.9n 0.5193 45600.0n 0.3435 45899.9n 0.3435 45900.0n 0.5720 46199.9n 0.5720 46200.0n 0.5017 46499.9n 0.5017 46500.0n 0.3787 46799.9n 0.3787 46800.0n 0.6072 47099.9n 0.6072 47100.0n 0.4490 47399.9n 0.4490 47400.0n 0.5017 47699.9n 0.5017 47700.0n 0.5369 47999.9n 0.5369 48000.0n 0.5720 48299.9n 0.5720 48300.0n 0.3259 48599.9n 0.3259 48600.0n 0.4314 48899.9n 0.4314 48900.0n 0.5544 49199.9n 0.5544 49200.0n 0.5369 49499.9n 0.5369 49500.0n 0.5720 49799.9n 0.5720 49800.0n 0.6072 50099.9n 0.6072 50100.0n 0.6072 50399.9n 0.6072 50400.0n 0.5544 50699.9n 0.5544 50700.0n 0.5193 50999.9n 0.5193 51000.0n 0.3435 51299.9n 0.3435 51300.0n 0.5720 51599.9n 0.5720 51600.0n 0.5017 51899.9n 0.5017 51900.0n 0.3787 52199.9n 0.3787 52200.0n 0.6072 52499.9n 0.6072 52500.0n 0.4490 52799.9n 0.4490 52800.0n 0.5017 53099.9n 0.5017 53100.0n 0.5369 53399.9n 0.5369 53400.0n 0.5720 53699.9n 0.5720 53700.0n 0.3259 53999.9n 0.3259 54000.0n 0.5720 54299.9n 0.5720 54300.0n 0.6072 54599.9n 0.6072 54600.0n 0.6072 54899.9n 0.6072 54900.0n 0.6072 55199.9n 0.6072 55200.0n 0.6072 55499.9n 0.6072 55500.0n 0.6072 55799.9n 0.6072 55800.0n 0.3787 56099.9n 0.3787 56100.0n 0.5369 56399.9n 0.5369 56400.0n 0.3259 56699.9n 0.3259 56700.0n 0.4138 56999.9n 0.4138 57000.0n 0.5193 57299.9n 0.5193 57300.0n 0.3611 57599.9n 0.3611 57600.0n 0.4841 57899.9n 0.4841 57900.0n 0.4314 58199.9n 0.4314 58200.0n 0.4138 58499.9n 0.4138 58500.0n 0.4138 58799.9n 0.4138 58800.0n 0.3787 59099.9n 0.3787 59100.0n 0.3259)
Vxn18 a_xn18 0 PWL(0.0n 0.5686 299.9n 0.5686 300.0n 0.4456 599.9n 0.4456 600.0n 0.4631 899.9n 0.4631 900.0n 0.4280 1199.9n 0.4280 1200.0n 0.3928 1499.9n 0.3928 1500.0n 0.3928 1799.9n 0.3928 1800.0n 0.4456 2099.9n 0.4456 2100.0n 0.4807 2399.9n 0.4807 2400.0n 0.6565 2699.9n 0.6565 2700.0n 0.4280 2999.9n 0.4280 3000.0n 0.4983 3299.9n 0.4983 3300.0n 0.6213 3599.9n 0.6213 3600.0n 0.3928 3899.9n 0.3928 3900.0n 0.5510 4199.9n 0.5510 4200.0n 0.4983 4499.9n 0.4983 4500.0n 0.4631 4799.9n 0.4631 4800.0n 0.4280 5099.9n 0.4280 5100.0n 0.6741 5399.9n 0.6741 5400.0n 0.5686 5699.9n 0.5686 5700.0n 0.4456 5999.9n 0.4456 6000.0n 0.4631 6299.9n 0.4631 6300.0n 0.4280 6599.9n 0.4280 6600.0n 0.3928 6899.9n 0.3928 6900.0n 0.3928 7199.9n 0.3928 7200.0n 0.4456 7499.9n 0.4456 7500.0n 0.4807 7799.9n 0.4807 7800.0n 0.6565 8099.9n 0.6565 8100.0n 0.4280 8399.9n 0.4280 8400.0n 0.4983 8699.9n 0.4983 8700.0n 0.6213 8999.9n 0.6213 9000.0n 0.3928 9299.9n 0.3928 9300.0n 0.5510 9599.9n 0.5510 9600.0n 0.4983 9899.9n 0.4983 9900.0n 0.4631 10199.9n 0.4631 10200.0n 0.4280 10499.9n 0.4280 10500.0n 0.6741 10799.9n 0.6741 10800.0n 0.5686 11099.9n 0.5686 11100.0n 0.4456 11399.9n 0.4456 11400.0n 0.4631 11699.9n 0.4631 11700.0n 0.4280 11999.9n 0.4280 12000.0n 0.3928 12299.9n 0.3928 12300.0n 0.3928 12599.9n 0.3928 12600.0n 0.4456 12899.9n 0.4456 12900.0n 0.4807 13199.9n 0.4807 13200.0n 0.6565 13499.9n 0.6565 13500.0n 0.4280 13799.9n 0.4280 13800.0n 0.4983 14099.9n 0.4983 14100.0n 0.6213 14399.9n 0.6213 14400.0n 0.3928 14699.9n 0.3928 14700.0n 0.5510 14999.9n 0.5510 15000.0n 0.4983 15299.9n 0.4983 15300.0n 0.4631 15599.9n 0.4631 15600.0n 0.4280 15899.9n 0.4280 15900.0n 0.6741 16199.9n 0.6741 16200.0n 0.5686 16499.9n 0.5686 16500.0n 0.4456 16799.9n 0.4456 16800.0n 0.4631 17099.9n 0.4631 17100.0n 0.4280 17399.9n 0.4280 17400.0n 0.3928 17699.9n 0.3928 17700.0n 0.3928 17999.9n 0.3928 18000.0n 0.4456 18299.9n 0.4456 18300.0n 0.4807 18599.9n 0.4807 18600.0n 0.6565 18899.9n 0.6565 18900.0n 0.4280 19199.9n 0.4280 19200.0n 0.4983 19499.9n 0.4983 19500.0n 0.6213 19799.9n 0.6213 19800.0n 0.3928 20099.9n 0.3928 20100.0n 0.5510 20399.9n 0.5510 20400.0n 0.4983 20699.9n 0.4983 20700.0n 0.4631 20999.9n 0.4631 21000.0n 0.4280 21299.9n 0.4280 21300.0n 0.6741 21599.9n 0.6741 21600.0n 0.5686 21899.9n 0.5686 21900.0n 0.4456 22199.9n 0.4456 22200.0n 0.4631 22499.9n 0.4631 22500.0n 0.4280 22799.9n 0.4280 22800.0n 0.3928 23099.9n 0.3928 23100.0n 0.3928 23399.9n 0.3928 23400.0n 0.4456 23699.9n 0.4456 23700.0n 0.4807 23999.9n 0.4807 24000.0n 0.6565 24299.9n 0.6565 24300.0n 0.4280 24599.9n 0.4280 24600.0n 0.4983 24899.9n 0.4983 24900.0n 0.6213 25199.9n 0.6213 25200.0n 0.3928 25499.9n 0.3928 25500.0n 0.5510 25799.9n 0.5510 25800.0n 0.4983 26099.9n 0.4983 26100.0n 0.4631 26399.9n 0.4631 26400.0n 0.4280 26699.9n 0.4280 26700.0n 0.6741 26999.9n 0.6741 27000.0n 0.5686 27299.9n 0.5686 27300.0n 0.4456 27599.9n 0.4456 27600.0n 0.4631 27899.9n 0.4631 27900.0n 0.4280 28199.9n 0.4280 28200.0n 0.3928 28499.9n 0.3928 28500.0n 0.3928 28799.9n 0.3928 28800.0n 0.4456 29099.9n 0.4456 29100.0n 0.4807 29399.9n 0.4807 29400.0n 0.6565 29699.9n 0.6565 29700.0n 0.4280 29999.9n 0.4280 30000.0n 0.4983 30299.9n 0.4983 30300.0n 0.6213 30599.9n 0.6213 30600.0n 0.3928 30899.9n 0.3928 30900.0n 0.5510 31199.9n 0.5510 31200.0n 0.4983 31499.9n 0.4983 31500.0n 0.4631 31799.9n 0.4631 31800.0n 0.4280 32099.9n 0.4280 32100.0n 0.6741 32399.9n 0.6741 32400.0n 0.5686 32699.9n 0.5686 32700.0n 0.4456 32999.9n 0.4456 33000.0n 0.4631 33299.9n 0.4631 33300.0n 0.4280 33599.9n 0.4280 33600.0n 0.3928 33899.9n 0.3928 33900.0n 0.3928 34199.9n 0.3928 34200.0n 0.4456 34499.9n 0.4456 34500.0n 0.4807 34799.9n 0.4807 34800.0n 0.6565 35099.9n 0.6565 35100.0n 0.4280 35399.9n 0.4280 35400.0n 0.4983 35699.9n 0.4983 35700.0n 0.6213 35999.9n 0.6213 36000.0n 0.3928 36299.9n 0.3928 36300.0n 0.5510 36599.9n 0.5510 36600.0n 0.4983 36899.9n 0.4983 36900.0n 0.4631 37199.9n 0.4631 37200.0n 0.4280 37499.9n 0.4280 37500.0n 0.6741 37799.9n 0.6741 37800.0n 0.5686 38099.9n 0.5686 38100.0n 0.4456 38399.9n 0.4456 38400.0n 0.4631 38699.9n 0.4631 38700.0n 0.4280 38999.9n 0.4280 39000.0n 0.3928 39299.9n 0.3928 39300.0n 0.3928 39599.9n 0.3928 39600.0n 0.4456 39899.9n 0.4456 39900.0n 0.4807 40199.9n 0.4807 40200.0n 0.6565 40499.9n 0.6565 40500.0n 0.4280 40799.9n 0.4280 40800.0n 0.4983 41099.9n 0.4983 41100.0n 0.6213 41399.9n 0.6213 41400.0n 0.3928 41699.9n 0.3928 41700.0n 0.5510 41999.9n 0.5510 42000.0n 0.4983 42299.9n 0.4983 42300.0n 0.4631 42599.9n 0.4631 42600.0n 0.4280 42899.9n 0.4280 42900.0n 0.6741 43199.9n 0.6741 43200.0n 0.5686 43499.9n 0.5686 43500.0n 0.4456 43799.9n 0.4456 43800.0n 0.4631 44099.9n 0.4631 44100.0n 0.4280 44399.9n 0.4280 44400.0n 0.3928 44699.9n 0.3928 44700.0n 0.3928 44999.9n 0.3928 45000.0n 0.4456 45299.9n 0.4456 45300.0n 0.4807 45599.9n 0.4807 45600.0n 0.6565 45899.9n 0.6565 45900.0n 0.4280 46199.9n 0.4280 46200.0n 0.4983 46499.9n 0.4983 46500.0n 0.6213 46799.9n 0.6213 46800.0n 0.3928 47099.9n 0.3928 47100.0n 0.5510 47399.9n 0.5510 47400.0n 0.4983 47699.9n 0.4983 47700.0n 0.4631 47999.9n 0.4631 48000.0n 0.4280 48299.9n 0.4280 48300.0n 0.6741 48599.9n 0.6741 48600.0n 0.5686 48899.9n 0.5686 48900.0n 0.4456 49199.9n 0.4456 49200.0n 0.4631 49499.9n 0.4631 49500.0n 0.4280 49799.9n 0.4280 49800.0n 0.3928 50099.9n 0.3928 50100.0n 0.3928 50399.9n 0.3928 50400.0n 0.4456 50699.9n 0.4456 50700.0n 0.4807 50999.9n 0.4807 51000.0n 0.6565 51299.9n 0.6565 51300.0n 0.4280 51599.9n 0.4280 51600.0n 0.4983 51899.9n 0.4983 51900.0n 0.6213 52199.9n 0.6213 52200.0n 0.3928 52499.9n 0.3928 52500.0n 0.5510 52799.9n 0.5510 52800.0n 0.4983 53099.9n 0.4983 53100.0n 0.4631 53399.9n 0.4631 53400.0n 0.4280 53699.9n 0.4280 53700.0n 0.6741 53999.9n 0.6741 54000.0n 0.4280 54299.9n 0.4280 54300.0n 0.3928 54599.9n 0.3928 54600.0n 0.3928 54899.9n 0.3928 54900.0n 0.3928 55199.9n 0.3928 55200.0n 0.3928 55499.9n 0.3928 55500.0n 0.3928 55799.9n 0.3928 55800.0n 0.6213 56099.9n 0.6213 56100.0n 0.4631 56399.9n 0.4631 56400.0n 0.6741 56699.9n 0.6741 56700.0n 0.5862 56999.9n 0.5862 57000.0n 0.4807 57299.9n 0.4807 57300.0n 0.6389 57599.9n 0.6389 57600.0n 0.5159 57899.9n 0.5159 57900.0n 0.5686 58199.9n 0.5686 58200.0n 0.5862 58499.9n 0.5862 58500.0n 0.5862 58799.9n 0.5862 58800.0n 0.6213 59099.9n 0.6213 59100.0n 0.6741)
Vxp19 a_xp19 0 PWL(0.0n 0.6380 299.9n 0.6380 300.0n 0.3795 599.9n 0.3795 600.0n 0.3795 899.9n 0.3795 900.0n 0.6553 1199.9n 0.6553 1200.0n 0.6553 1499.9n 0.6553 1500.0n 0.4656 1799.9n 0.4656 1800.0n 0.3795 2099.9n 0.3795 2100.0n 0.6553 2399.9n 0.6553 2400.0n 0.5001 2699.9n 0.5001 2700.0n 0.3795 2999.9n 0.3795 3000.0n 0.3795 3299.9n 0.3795 3300.0n 0.4656 3599.9n 0.4656 3600.0n 0.6553 3899.9n 0.6553 3900.0n 0.6553 4199.9n 0.6553 4200.0n 0.4829 4499.9n 0.4829 4500.0n 0.3967 4799.9n 0.3967 4800.0n 0.3795 5099.9n 0.3795 5100.0n 0.3795 5399.9n 0.3795 5400.0n 0.6380 5699.9n 0.6380 5700.0n 0.3795 5999.9n 0.3795 6000.0n 0.3795 6299.9n 0.3795 6300.0n 0.6553 6599.9n 0.6553 6600.0n 0.6553 6899.9n 0.6553 6900.0n 0.4656 7199.9n 0.4656 7200.0n 0.3795 7499.9n 0.3795 7500.0n 0.6553 7799.9n 0.6553 7800.0n 0.5001 8099.9n 0.5001 8100.0n 0.3795 8399.9n 0.3795 8400.0n 0.3795 8699.9n 0.3795 8700.0n 0.4656 8999.9n 0.4656 9000.0n 0.6553 9299.9n 0.6553 9300.0n 0.6553 9599.9n 0.6553 9600.0n 0.4829 9899.9n 0.4829 9900.0n 0.3967 10199.9n 0.3967 10200.0n 0.3795 10499.9n 0.3795 10500.0n 0.3795 10799.9n 0.3795 10800.0n 0.6380 11099.9n 0.6380 11100.0n 0.3795 11399.9n 0.3795 11400.0n 0.3795 11699.9n 0.3795 11700.0n 0.6553 11999.9n 0.6553 12000.0n 0.6553 12299.9n 0.6553 12300.0n 0.4656 12599.9n 0.4656 12600.0n 0.3795 12899.9n 0.3795 12900.0n 0.6553 13199.9n 0.6553 13200.0n 0.5001 13499.9n 0.5001 13500.0n 0.3795 13799.9n 0.3795 13800.0n 0.3795 14099.9n 0.3795 14100.0n 0.4656 14399.9n 0.4656 14400.0n 0.6553 14699.9n 0.6553 14700.0n 0.6553 14999.9n 0.6553 15000.0n 0.4829 15299.9n 0.4829 15300.0n 0.3967 15599.9n 0.3967 15600.0n 0.3795 15899.9n 0.3795 15900.0n 0.3795 16199.9n 0.3795 16200.0n 0.6380 16499.9n 0.6380 16500.0n 0.3795 16799.9n 0.3795 16800.0n 0.3795 17099.9n 0.3795 17100.0n 0.6553 17399.9n 0.6553 17400.0n 0.6553 17699.9n 0.6553 17700.0n 0.4656 17999.9n 0.4656 18000.0n 0.3795 18299.9n 0.3795 18300.0n 0.6553 18599.9n 0.6553 18600.0n 0.5001 18899.9n 0.5001 18900.0n 0.3795 19199.9n 0.3795 19200.0n 0.3795 19499.9n 0.3795 19500.0n 0.4656 19799.9n 0.4656 19800.0n 0.6553 20099.9n 0.6553 20100.0n 0.6553 20399.9n 0.6553 20400.0n 0.4829 20699.9n 0.4829 20700.0n 0.3967 20999.9n 0.3967 21000.0n 0.3795 21299.9n 0.3795 21300.0n 0.3795 21599.9n 0.3795 21600.0n 0.6380 21899.9n 0.6380 21900.0n 0.3795 22199.9n 0.3795 22200.0n 0.3795 22499.9n 0.3795 22500.0n 0.6553 22799.9n 0.6553 22800.0n 0.6553 23099.9n 0.6553 23100.0n 0.4656 23399.9n 0.4656 23400.0n 0.3795 23699.9n 0.3795 23700.0n 0.6553 23999.9n 0.6553 24000.0n 0.5001 24299.9n 0.5001 24300.0n 0.3795 24599.9n 0.3795 24600.0n 0.3795 24899.9n 0.3795 24900.0n 0.4656 25199.9n 0.4656 25200.0n 0.6553 25499.9n 0.6553 25500.0n 0.6553 25799.9n 0.6553 25800.0n 0.4829 26099.9n 0.4829 26100.0n 0.3967 26399.9n 0.3967 26400.0n 0.3795 26699.9n 0.3795 26700.0n 0.3795 26999.9n 0.3795 27000.0n 0.6380 27299.9n 0.6380 27300.0n 0.3795 27599.9n 0.3795 27600.0n 0.3795 27899.9n 0.3795 27900.0n 0.6553 28199.9n 0.6553 28200.0n 0.6553 28499.9n 0.6553 28500.0n 0.4656 28799.9n 0.4656 28800.0n 0.3795 29099.9n 0.3795 29100.0n 0.6553 29399.9n 0.6553 29400.0n 0.5001 29699.9n 0.5001 29700.0n 0.3795 29999.9n 0.3795 30000.0n 0.3795 30299.9n 0.3795 30300.0n 0.4656 30599.9n 0.4656 30600.0n 0.6553 30899.9n 0.6553 30900.0n 0.6553 31199.9n 0.6553 31200.0n 0.4829 31499.9n 0.4829 31500.0n 0.3967 31799.9n 0.3967 31800.0n 0.3795 32099.9n 0.3795 32100.0n 0.3795 32399.9n 0.3795 32400.0n 0.6380 32699.9n 0.6380 32700.0n 0.3795 32999.9n 0.3795 33000.0n 0.3795 33299.9n 0.3795 33300.0n 0.6553 33599.9n 0.6553 33600.0n 0.6553 33899.9n 0.6553 33900.0n 0.4656 34199.9n 0.4656 34200.0n 0.3795 34499.9n 0.3795 34500.0n 0.6553 34799.9n 0.6553 34800.0n 0.5001 35099.9n 0.5001 35100.0n 0.3795 35399.9n 0.3795 35400.0n 0.3795 35699.9n 0.3795 35700.0n 0.4656 35999.9n 0.4656 36000.0n 0.6553 36299.9n 0.6553 36300.0n 0.6553 36599.9n 0.6553 36600.0n 0.4829 36899.9n 0.4829 36900.0n 0.3967 37199.9n 0.3967 37200.0n 0.3795 37499.9n 0.3795 37500.0n 0.3795 37799.9n 0.3795 37800.0n 0.6380 38099.9n 0.6380 38100.0n 0.3795 38399.9n 0.3795 38400.0n 0.3795 38699.9n 0.3795 38700.0n 0.6553 38999.9n 0.6553 39000.0n 0.6553 39299.9n 0.6553 39300.0n 0.4656 39599.9n 0.4656 39600.0n 0.3795 39899.9n 0.3795 39900.0n 0.6553 40199.9n 0.6553 40200.0n 0.5001 40499.9n 0.5001 40500.0n 0.3795 40799.9n 0.3795 40800.0n 0.3795 41099.9n 0.3795 41100.0n 0.4656 41399.9n 0.4656 41400.0n 0.6553 41699.9n 0.6553 41700.0n 0.6553 41999.9n 0.6553 42000.0n 0.4829 42299.9n 0.4829 42300.0n 0.3967 42599.9n 0.3967 42600.0n 0.3795 42899.9n 0.3795 42900.0n 0.3795 43199.9n 0.3795 43200.0n 0.6380 43499.9n 0.6380 43500.0n 0.3795 43799.9n 0.3795 43800.0n 0.3795 44099.9n 0.3795 44100.0n 0.6553 44399.9n 0.6553 44400.0n 0.6553 44699.9n 0.6553 44700.0n 0.4656 44999.9n 0.4656 45000.0n 0.3795 45299.9n 0.3795 45300.0n 0.6553 45599.9n 0.6553 45600.0n 0.5001 45899.9n 0.5001 45900.0n 0.3795 46199.9n 0.3795 46200.0n 0.3795 46499.9n 0.3795 46500.0n 0.4656 46799.9n 0.4656 46800.0n 0.6553 47099.9n 0.6553 47100.0n 0.6553 47399.9n 0.6553 47400.0n 0.4829 47699.9n 0.4829 47700.0n 0.3967 47999.9n 0.3967 48000.0n 0.3795 48299.9n 0.3795 48300.0n 0.3795 48599.9n 0.3795 48600.0n 0.6380 48899.9n 0.6380 48900.0n 0.3795 49199.9n 0.3795 49200.0n 0.3795 49499.9n 0.3795 49500.0n 0.6553 49799.9n 0.6553 49800.0n 0.6553 50099.9n 0.6553 50100.0n 0.4656 50399.9n 0.4656 50400.0n 0.3795 50699.9n 0.3795 50700.0n 0.6553 50999.9n 0.6553 51000.0n 0.5001 51299.9n 0.5001 51300.0n 0.3795 51599.9n 0.3795 51600.0n 0.3795 51899.9n 0.3795 51900.0n 0.4656 52199.9n 0.4656 52200.0n 0.6553 52499.9n 0.6553 52500.0n 0.6553 52799.9n 0.6553 52800.0n 0.4829 53099.9n 0.4829 53100.0n 0.3967 53399.9n 0.3967 53400.0n 0.3795 53699.9n 0.3795 53700.0n 0.3795 53999.9n 0.3795 54000.0n 0.3967 54299.9n 0.3967 54300.0n 0.4829 54599.9n 0.4829 54600.0n 0.4312 54899.9n 0.4312 54900.0n 0.6208 55199.9n 0.6208 55200.0n 0.5518 55499.9n 0.5518 55500.0n 0.4312 55799.9n 0.4312 55800.0n 0.6553 56099.9n 0.6553 56100.0n 0.6553 56399.9n 0.6553 56400.0n 0.5691 56699.9n 0.5691 56700.0n 0.6553 56999.9n 0.6553 57000.0n 0.6380 57299.9n 0.6380 57300.0n 0.6553 57599.9n 0.6553 57600.0n 0.4829 57899.9n 0.4829 57900.0n 0.3795 58199.9n 0.3795 58200.0n 0.3795 58499.9n 0.3795 58500.0n 0.4139 58799.9n 0.4139 58800.0n 0.4139 59099.9n 0.4139 59100.0n 0.3795)
Vxn19 a_xn19 0 PWL(0.0n 0.3620 299.9n 0.3620 300.0n 0.6205 599.9n 0.6205 600.0n 0.6205 899.9n 0.6205 900.0n 0.3447 1199.9n 0.3447 1200.0n 0.3447 1499.9n 0.3447 1500.0n 0.5344 1799.9n 0.5344 1800.0n 0.6205 2099.9n 0.6205 2100.0n 0.3447 2399.9n 0.3447 2400.0n 0.4999 2699.9n 0.4999 2700.0n 0.6205 2999.9n 0.6205 3000.0n 0.6205 3299.9n 0.6205 3300.0n 0.5344 3599.9n 0.5344 3600.0n 0.3447 3899.9n 0.3447 3900.0n 0.3447 4199.9n 0.3447 4200.0n 0.5171 4499.9n 0.5171 4500.0n 0.6033 4799.9n 0.6033 4800.0n 0.6205 5099.9n 0.6205 5100.0n 0.6205 5399.9n 0.6205 5400.0n 0.3620 5699.9n 0.3620 5700.0n 0.6205 5999.9n 0.6205 6000.0n 0.6205 6299.9n 0.6205 6300.0n 0.3447 6599.9n 0.3447 6600.0n 0.3447 6899.9n 0.3447 6900.0n 0.5344 7199.9n 0.5344 7200.0n 0.6205 7499.9n 0.6205 7500.0n 0.3447 7799.9n 0.3447 7800.0n 0.4999 8099.9n 0.4999 8100.0n 0.6205 8399.9n 0.6205 8400.0n 0.6205 8699.9n 0.6205 8700.0n 0.5344 8999.9n 0.5344 9000.0n 0.3447 9299.9n 0.3447 9300.0n 0.3447 9599.9n 0.3447 9600.0n 0.5171 9899.9n 0.5171 9900.0n 0.6033 10199.9n 0.6033 10200.0n 0.6205 10499.9n 0.6205 10500.0n 0.6205 10799.9n 0.6205 10800.0n 0.3620 11099.9n 0.3620 11100.0n 0.6205 11399.9n 0.6205 11400.0n 0.6205 11699.9n 0.6205 11700.0n 0.3447 11999.9n 0.3447 12000.0n 0.3447 12299.9n 0.3447 12300.0n 0.5344 12599.9n 0.5344 12600.0n 0.6205 12899.9n 0.6205 12900.0n 0.3447 13199.9n 0.3447 13200.0n 0.4999 13499.9n 0.4999 13500.0n 0.6205 13799.9n 0.6205 13800.0n 0.6205 14099.9n 0.6205 14100.0n 0.5344 14399.9n 0.5344 14400.0n 0.3447 14699.9n 0.3447 14700.0n 0.3447 14999.9n 0.3447 15000.0n 0.5171 15299.9n 0.5171 15300.0n 0.6033 15599.9n 0.6033 15600.0n 0.6205 15899.9n 0.6205 15900.0n 0.6205 16199.9n 0.6205 16200.0n 0.3620 16499.9n 0.3620 16500.0n 0.6205 16799.9n 0.6205 16800.0n 0.6205 17099.9n 0.6205 17100.0n 0.3447 17399.9n 0.3447 17400.0n 0.3447 17699.9n 0.3447 17700.0n 0.5344 17999.9n 0.5344 18000.0n 0.6205 18299.9n 0.6205 18300.0n 0.3447 18599.9n 0.3447 18600.0n 0.4999 18899.9n 0.4999 18900.0n 0.6205 19199.9n 0.6205 19200.0n 0.6205 19499.9n 0.6205 19500.0n 0.5344 19799.9n 0.5344 19800.0n 0.3447 20099.9n 0.3447 20100.0n 0.3447 20399.9n 0.3447 20400.0n 0.5171 20699.9n 0.5171 20700.0n 0.6033 20999.9n 0.6033 21000.0n 0.6205 21299.9n 0.6205 21300.0n 0.6205 21599.9n 0.6205 21600.0n 0.3620 21899.9n 0.3620 21900.0n 0.6205 22199.9n 0.6205 22200.0n 0.6205 22499.9n 0.6205 22500.0n 0.3447 22799.9n 0.3447 22800.0n 0.3447 23099.9n 0.3447 23100.0n 0.5344 23399.9n 0.5344 23400.0n 0.6205 23699.9n 0.6205 23700.0n 0.3447 23999.9n 0.3447 24000.0n 0.4999 24299.9n 0.4999 24300.0n 0.6205 24599.9n 0.6205 24600.0n 0.6205 24899.9n 0.6205 24900.0n 0.5344 25199.9n 0.5344 25200.0n 0.3447 25499.9n 0.3447 25500.0n 0.3447 25799.9n 0.3447 25800.0n 0.5171 26099.9n 0.5171 26100.0n 0.6033 26399.9n 0.6033 26400.0n 0.6205 26699.9n 0.6205 26700.0n 0.6205 26999.9n 0.6205 27000.0n 0.3620 27299.9n 0.3620 27300.0n 0.6205 27599.9n 0.6205 27600.0n 0.6205 27899.9n 0.6205 27900.0n 0.3447 28199.9n 0.3447 28200.0n 0.3447 28499.9n 0.3447 28500.0n 0.5344 28799.9n 0.5344 28800.0n 0.6205 29099.9n 0.6205 29100.0n 0.3447 29399.9n 0.3447 29400.0n 0.4999 29699.9n 0.4999 29700.0n 0.6205 29999.9n 0.6205 30000.0n 0.6205 30299.9n 0.6205 30300.0n 0.5344 30599.9n 0.5344 30600.0n 0.3447 30899.9n 0.3447 30900.0n 0.3447 31199.9n 0.3447 31200.0n 0.5171 31499.9n 0.5171 31500.0n 0.6033 31799.9n 0.6033 31800.0n 0.6205 32099.9n 0.6205 32100.0n 0.6205 32399.9n 0.6205 32400.0n 0.3620 32699.9n 0.3620 32700.0n 0.6205 32999.9n 0.6205 33000.0n 0.6205 33299.9n 0.6205 33300.0n 0.3447 33599.9n 0.3447 33600.0n 0.3447 33899.9n 0.3447 33900.0n 0.5344 34199.9n 0.5344 34200.0n 0.6205 34499.9n 0.6205 34500.0n 0.3447 34799.9n 0.3447 34800.0n 0.4999 35099.9n 0.4999 35100.0n 0.6205 35399.9n 0.6205 35400.0n 0.6205 35699.9n 0.6205 35700.0n 0.5344 35999.9n 0.5344 36000.0n 0.3447 36299.9n 0.3447 36300.0n 0.3447 36599.9n 0.3447 36600.0n 0.5171 36899.9n 0.5171 36900.0n 0.6033 37199.9n 0.6033 37200.0n 0.6205 37499.9n 0.6205 37500.0n 0.6205 37799.9n 0.6205 37800.0n 0.3620 38099.9n 0.3620 38100.0n 0.6205 38399.9n 0.6205 38400.0n 0.6205 38699.9n 0.6205 38700.0n 0.3447 38999.9n 0.3447 39000.0n 0.3447 39299.9n 0.3447 39300.0n 0.5344 39599.9n 0.5344 39600.0n 0.6205 39899.9n 0.6205 39900.0n 0.3447 40199.9n 0.3447 40200.0n 0.4999 40499.9n 0.4999 40500.0n 0.6205 40799.9n 0.6205 40800.0n 0.6205 41099.9n 0.6205 41100.0n 0.5344 41399.9n 0.5344 41400.0n 0.3447 41699.9n 0.3447 41700.0n 0.3447 41999.9n 0.3447 42000.0n 0.5171 42299.9n 0.5171 42300.0n 0.6033 42599.9n 0.6033 42600.0n 0.6205 42899.9n 0.6205 42900.0n 0.6205 43199.9n 0.6205 43200.0n 0.3620 43499.9n 0.3620 43500.0n 0.6205 43799.9n 0.6205 43800.0n 0.6205 44099.9n 0.6205 44100.0n 0.3447 44399.9n 0.3447 44400.0n 0.3447 44699.9n 0.3447 44700.0n 0.5344 44999.9n 0.5344 45000.0n 0.6205 45299.9n 0.6205 45300.0n 0.3447 45599.9n 0.3447 45600.0n 0.4999 45899.9n 0.4999 45900.0n 0.6205 46199.9n 0.6205 46200.0n 0.6205 46499.9n 0.6205 46500.0n 0.5344 46799.9n 0.5344 46800.0n 0.3447 47099.9n 0.3447 47100.0n 0.3447 47399.9n 0.3447 47400.0n 0.5171 47699.9n 0.5171 47700.0n 0.6033 47999.9n 0.6033 48000.0n 0.6205 48299.9n 0.6205 48300.0n 0.6205 48599.9n 0.6205 48600.0n 0.3620 48899.9n 0.3620 48900.0n 0.6205 49199.9n 0.6205 49200.0n 0.6205 49499.9n 0.6205 49500.0n 0.3447 49799.9n 0.3447 49800.0n 0.3447 50099.9n 0.3447 50100.0n 0.5344 50399.9n 0.5344 50400.0n 0.6205 50699.9n 0.6205 50700.0n 0.3447 50999.9n 0.3447 51000.0n 0.4999 51299.9n 0.4999 51300.0n 0.6205 51599.9n 0.6205 51600.0n 0.6205 51899.9n 0.6205 51900.0n 0.5344 52199.9n 0.5344 52200.0n 0.3447 52499.9n 0.3447 52500.0n 0.3447 52799.9n 0.3447 52800.0n 0.5171 53099.9n 0.5171 53100.0n 0.6033 53399.9n 0.6033 53400.0n 0.6205 53699.9n 0.6205 53700.0n 0.6205 53999.9n 0.6205 54000.0n 0.6033 54299.9n 0.6033 54300.0n 0.5171 54599.9n 0.5171 54600.0n 0.5688 54899.9n 0.5688 54900.0n 0.3792 55199.9n 0.3792 55200.0n 0.4482 55499.9n 0.4482 55500.0n 0.5688 55799.9n 0.5688 55800.0n 0.3447 56099.9n 0.3447 56100.0n 0.3447 56399.9n 0.3447 56400.0n 0.4309 56699.9n 0.4309 56700.0n 0.3447 56999.9n 0.3447 57000.0n 0.3620 57299.9n 0.3620 57300.0n 0.3447 57599.9n 0.3447 57600.0n 0.5171 57899.9n 0.5171 57900.0n 0.6205 58199.9n 0.6205 58200.0n 0.6205 58499.9n 0.6205 58500.0n 0.5861 58799.9n 0.5861 58800.0n 0.5861 59099.9n 0.5861 59100.0n 0.6205)
Vxp20 a_xp20 0 PWL(0.0n 0.6442 299.9n 0.6442 300.0n 0.3850 599.9n 0.3850 600.0n 0.3850 899.9n 0.3850 900.0n 0.5470 1199.9n 0.5470 1200.0n 0.6442 1499.9n 0.6442 1500.0n 0.3850 1799.9n 0.3850 1800.0n 0.3850 2099.9n 0.3850 2100.0n 0.5470 2399.9n 0.5470 2400.0n 0.5956 2699.9n 0.5956 2700.0n 0.5956 2999.9n 0.5956 3000.0n 0.6442 3299.9n 0.6442 3300.0n 0.6442 3599.9n 0.6442 3600.0n 0.6442 3899.9n 0.6442 3900.0n 0.6442 4199.9n 0.6442 4200.0n 0.6118 4499.9n 0.6118 4500.0n 0.6442 4799.9n 0.6442 4800.0n 0.4012 5099.9n 0.4012 5100.0n 0.6442 5399.9n 0.6442 5400.0n 0.6442 5699.9n 0.6442 5700.0n 0.3850 5999.9n 0.3850 6000.0n 0.3850 6299.9n 0.3850 6300.0n 0.5470 6599.9n 0.5470 6600.0n 0.6442 6899.9n 0.6442 6900.0n 0.3850 7199.9n 0.3850 7200.0n 0.3850 7499.9n 0.3850 7500.0n 0.5470 7799.9n 0.5470 7800.0n 0.5956 8099.9n 0.5956 8100.0n 0.5956 8399.9n 0.5956 8400.0n 0.6442 8699.9n 0.6442 8700.0n 0.6442 8999.9n 0.6442 9000.0n 0.6442 9299.9n 0.6442 9300.0n 0.6442 9599.9n 0.6442 9600.0n 0.6118 9899.9n 0.6118 9900.0n 0.6442 10199.9n 0.6442 10200.0n 0.4012 10499.9n 0.4012 10500.0n 0.6442 10799.9n 0.6442 10800.0n 0.6442 11099.9n 0.6442 11100.0n 0.3850 11399.9n 0.3850 11400.0n 0.3850 11699.9n 0.3850 11700.0n 0.5470 11999.9n 0.5470 12000.0n 0.6442 12299.9n 0.6442 12300.0n 0.3850 12599.9n 0.3850 12600.0n 0.3850 12899.9n 0.3850 12900.0n 0.5470 13199.9n 0.5470 13200.0n 0.5956 13499.9n 0.5956 13500.0n 0.5956 13799.9n 0.5956 13800.0n 0.6442 14099.9n 0.6442 14100.0n 0.6442 14399.9n 0.6442 14400.0n 0.6442 14699.9n 0.6442 14700.0n 0.6442 14999.9n 0.6442 15000.0n 0.6118 15299.9n 0.6118 15300.0n 0.6442 15599.9n 0.6442 15600.0n 0.4012 15899.9n 0.4012 15900.0n 0.6442 16199.9n 0.6442 16200.0n 0.6442 16499.9n 0.6442 16500.0n 0.3850 16799.9n 0.3850 16800.0n 0.3850 17099.9n 0.3850 17100.0n 0.5470 17399.9n 0.5470 17400.0n 0.6442 17699.9n 0.6442 17700.0n 0.3850 17999.9n 0.3850 18000.0n 0.3850 18299.9n 0.3850 18300.0n 0.5470 18599.9n 0.5470 18600.0n 0.5956 18899.9n 0.5956 18900.0n 0.5956 19199.9n 0.5956 19200.0n 0.6442 19499.9n 0.6442 19500.0n 0.6442 19799.9n 0.6442 19800.0n 0.6442 20099.9n 0.6442 20100.0n 0.6442 20399.9n 0.6442 20400.0n 0.6118 20699.9n 0.6118 20700.0n 0.6442 20999.9n 0.6442 21000.0n 0.4012 21299.9n 0.4012 21300.0n 0.6442 21599.9n 0.6442 21600.0n 0.6442 21899.9n 0.6442 21900.0n 0.3850 22199.9n 0.3850 22200.0n 0.3850 22499.9n 0.3850 22500.0n 0.5470 22799.9n 0.5470 22800.0n 0.6442 23099.9n 0.6442 23100.0n 0.3850 23399.9n 0.3850 23400.0n 0.3850 23699.9n 0.3850 23700.0n 0.5470 23999.9n 0.5470 24000.0n 0.5956 24299.9n 0.5956 24300.0n 0.5956 24599.9n 0.5956 24600.0n 0.6442 24899.9n 0.6442 24900.0n 0.6442 25199.9n 0.6442 25200.0n 0.6442 25499.9n 0.6442 25500.0n 0.6442 25799.9n 0.6442 25800.0n 0.6118 26099.9n 0.6118 26100.0n 0.6442 26399.9n 0.6442 26400.0n 0.4012 26699.9n 0.4012 26700.0n 0.6442 26999.9n 0.6442 27000.0n 0.6442 27299.9n 0.6442 27300.0n 0.3850 27599.9n 0.3850 27600.0n 0.3850 27899.9n 0.3850 27900.0n 0.5470 28199.9n 0.5470 28200.0n 0.6442 28499.9n 0.6442 28500.0n 0.3850 28799.9n 0.3850 28800.0n 0.3850 29099.9n 0.3850 29100.0n 0.5470 29399.9n 0.5470 29400.0n 0.5956 29699.9n 0.5956 29700.0n 0.5956 29999.9n 0.5956 30000.0n 0.6442 30299.9n 0.6442 30300.0n 0.6442 30599.9n 0.6442 30600.0n 0.6442 30899.9n 0.6442 30900.0n 0.6442 31199.9n 0.6442 31200.0n 0.6118 31499.9n 0.6118 31500.0n 0.6442 31799.9n 0.6442 31800.0n 0.4012 32099.9n 0.4012 32100.0n 0.6442 32399.9n 0.6442 32400.0n 0.6442 32699.9n 0.6442 32700.0n 0.3850 32999.9n 0.3850 33000.0n 0.3850 33299.9n 0.3850 33300.0n 0.5470 33599.9n 0.5470 33600.0n 0.6442 33899.9n 0.6442 33900.0n 0.3850 34199.9n 0.3850 34200.0n 0.3850 34499.9n 0.3850 34500.0n 0.5470 34799.9n 0.5470 34800.0n 0.5956 35099.9n 0.5956 35100.0n 0.5956 35399.9n 0.5956 35400.0n 0.6442 35699.9n 0.6442 35700.0n 0.6442 35999.9n 0.6442 36000.0n 0.6442 36299.9n 0.6442 36300.0n 0.6442 36599.9n 0.6442 36600.0n 0.6118 36899.9n 0.6118 36900.0n 0.6442 37199.9n 0.6442 37200.0n 0.4012 37499.9n 0.4012 37500.0n 0.6442 37799.9n 0.6442 37800.0n 0.6442 38099.9n 0.6442 38100.0n 0.3850 38399.9n 0.3850 38400.0n 0.3850 38699.9n 0.3850 38700.0n 0.5470 38999.9n 0.5470 39000.0n 0.6442 39299.9n 0.6442 39300.0n 0.3850 39599.9n 0.3850 39600.0n 0.3850 39899.9n 0.3850 39900.0n 0.5470 40199.9n 0.5470 40200.0n 0.5956 40499.9n 0.5956 40500.0n 0.5956 40799.9n 0.5956 40800.0n 0.6442 41099.9n 0.6442 41100.0n 0.6442 41399.9n 0.6442 41400.0n 0.6442 41699.9n 0.6442 41700.0n 0.6442 41999.9n 0.6442 42000.0n 0.6118 42299.9n 0.6118 42300.0n 0.6442 42599.9n 0.6442 42600.0n 0.4012 42899.9n 0.4012 42900.0n 0.6442 43199.9n 0.6442 43200.0n 0.6442 43499.9n 0.6442 43500.0n 0.3850 43799.9n 0.3850 43800.0n 0.3850 44099.9n 0.3850 44100.0n 0.5470 44399.9n 0.5470 44400.0n 0.6442 44699.9n 0.6442 44700.0n 0.3850 44999.9n 0.3850 45000.0n 0.3850 45299.9n 0.3850 45300.0n 0.5470 45599.9n 0.5470 45600.0n 0.5956 45899.9n 0.5956 45900.0n 0.5956 46199.9n 0.5956 46200.0n 0.6442 46499.9n 0.6442 46500.0n 0.6442 46799.9n 0.6442 46800.0n 0.6442 47099.9n 0.6442 47100.0n 0.6442 47399.9n 0.6442 47400.0n 0.6118 47699.9n 0.6118 47700.0n 0.6442 47999.9n 0.6442 48000.0n 0.4012 48299.9n 0.4012 48300.0n 0.6442 48599.9n 0.6442 48600.0n 0.6442 48899.9n 0.6442 48900.0n 0.3850 49199.9n 0.3850 49200.0n 0.3850 49499.9n 0.3850 49500.0n 0.5470 49799.9n 0.5470 49800.0n 0.6442 50099.9n 0.6442 50100.0n 0.3850 50399.9n 0.3850 50400.0n 0.3850 50699.9n 0.3850 50700.0n 0.5470 50999.9n 0.5470 51000.0n 0.5956 51299.9n 0.5956 51300.0n 0.5956 51599.9n 0.5956 51600.0n 0.6442 51899.9n 0.6442 51900.0n 0.6442 52199.9n 0.6442 52200.0n 0.6442 52499.9n 0.6442 52500.0n 0.6442 52799.9n 0.6442 52800.0n 0.6118 53099.9n 0.6118 53100.0n 0.6442 53399.9n 0.6442 53400.0n 0.4012 53699.9n 0.4012 53700.0n 0.6442 53999.9n 0.6442 54000.0n 0.3850 54299.9n 0.3850 54300.0n 0.3850 54599.9n 0.3850 54600.0n 0.3850 54899.9n 0.3850 54900.0n 0.4174 55199.9n 0.4174 55200.0n 0.4012 55499.9n 0.4012 55500.0n 0.3850 55799.9n 0.3850 55800.0n 0.6442 56099.9n 0.6442 56100.0n 0.6442 56399.9n 0.6442 56400.0n 0.6442 56699.9n 0.6442 56700.0n 0.4984 56999.9n 0.4984 57000.0n 0.6442 57299.9n 0.6442 57300.0n 0.6442 57599.9n 0.6442 57600.0n 0.5956 57899.9n 0.5956 57900.0n 0.6118 58199.9n 0.6118 58200.0n 0.5632 58499.9n 0.5632 58500.0n 0.6442 58799.9n 0.6442 58800.0n 0.6442 59099.9n 0.6442 59100.0n 0.5632)
Vxn20 a_xn20 0 PWL(0.0n 0.3558 299.9n 0.3558 300.0n 0.6150 599.9n 0.6150 600.0n 0.6150 899.9n 0.6150 900.0n 0.4530 1199.9n 0.4530 1200.0n 0.3558 1499.9n 0.3558 1500.0n 0.6150 1799.9n 0.6150 1800.0n 0.6150 2099.9n 0.6150 2100.0n 0.4530 2399.9n 0.4530 2400.0n 0.4044 2699.9n 0.4044 2700.0n 0.4044 2999.9n 0.4044 3000.0n 0.3558 3299.9n 0.3558 3300.0n 0.3558 3599.9n 0.3558 3600.0n 0.3558 3899.9n 0.3558 3900.0n 0.3558 4199.9n 0.3558 4200.0n 0.3882 4499.9n 0.3882 4500.0n 0.3558 4799.9n 0.3558 4800.0n 0.5988 5099.9n 0.5988 5100.0n 0.3558 5399.9n 0.3558 5400.0n 0.3558 5699.9n 0.3558 5700.0n 0.6150 5999.9n 0.6150 6000.0n 0.6150 6299.9n 0.6150 6300.0n 0.4530 6599.9n 0.4530 6600.0n 0.3558 6899.9n 0.3558 6900.0n 0.6150 7199.9n 0.6150 7200.0n 0.6150 7499.9n 0.6150 7500.0n 0.4530 7799.9n 0.4530 7800.0n 0.4044 8099.9n 0.4044 8100.0n 0.4044 8399.9n 0.4044 8400.0n 0.3558 8699.9n 0.3558 8700.0n 0.3558 8999.9n 0.3558 9000.0n 0.3558 9299.9n 0.3558 9300.0n 0.3558 9599.9n 0.3558 9600.0n 0.3882 9899.9n 0.3882 9900.0n 0.3558 10199.9n 0.3558 10200.0n 0.5988 10499.9n 0.5988 10500.0n 0.3558 10799.9n 0.3558 10800.0n 0.3558 11099.9n 0.3558 11100.0n 0.6150 11399.9n 0.6150 11400.0n 0.6150 11699.9n 0.6150 11700.0n 0.4530 11999.9n 0.4530 12000.0n 0.3558 12299.9n 0.3558 12300.0n 0.6150 12599.9n 0.6150 12600.0n 0.6150 12899.9n 0.6150 12900.0n 0.4530 13199.9n 0.4530 13200.0n 0.4044 13499.9n 0.4044 13500.0n 0.4044 13799.9n 0.4044 13800.0n 0.3558 14099.9n 0.3558 14100.0n 0.3558 14399.9n 0.3558 14400.0n 0.3558 14699.9n 0.3558 14700.0n 0.3558 14999.9n 0.3558 15000.0n 0.3882 15299.9n 0.3882 15300.0n 0.3558 15599.9n 0.3558 15600.0n 0.5988 15899.9n 0.5988 15900.0n 0.3558 16199.9n 0.3558 16200.0n 0.3558 16499.9n 0.3558 16500.0n 0.6150 16799.9n 0.6150 16800.0n 0.6150 17099.9n 0.6150 17100.0n 0.4530 17399.9n 0.4530 17400.0n 0.3558 17699.9n 0.3558 17700.0n 0.6150 17999.9n 0.6150 18000.0n 0.6150 18299.9n 0.6150 18300.0n 0.4530 18599.9n 0.4530 18600.0n 0.4044 18899.9n 0.4044 18900.0n 0.4044 19199.9n 0.4044 19200.0n 0.3558 19499.9n 0.3558 19500.0n 0.3558 19799.9n 0.3558 19800.0n 0.3558 20099.9n 0.3558 20100.0n 0.3558 20399.9n 0.3558 20400.0n 0.3882 20699.9n 0.3882 20700.0n 0.3558 20999.9n 0.3558 21000.0n 0.5988 21299.9n 0.5988 21300.0n 0.3558 21599.9n 0.3558 21600.0n 0.3558 21899.9n 0.3558 21900.0n 0.6150 22199.9n 0.6150 22200.0n 0.6150 22499.9n 0.6150 22500.0n 0.4530 22799.9n 0.4530 22800.0n 0.3558 23099.9n 0.3558 23100.0n 0.6150 23399.9n 0.6150 23400.0n 0.6150 23699.9n 0.6150 23700.0n 0.4530 23999.9n 0.4530 24000.0n 0.4044 24299.9n 0.4044 24300.0n 0.4044 24599.9n 0.4044 24600.0n 0.3558 24899.9n 0.3558 24900.0n 0.3558 25199.9n 0.3558 25200.0n 0.3558 25499.9n 0.3558 25500.0n 0.3558 25799.9n 0.3558 25800.0n 0.3882 26099.9n 0.3882 26100.0n 0.3558 26399.9n 0.3558 26400.0n 0.5988 26699.9n 0.5988 26700.0n 0.3558 26999.9n 0.3558 27000.0n 0.3558 27299.9n 0.3558 27300.0n 0.6150 27599.9n 0.6150 27600.0n 0.6150 27899.9n 0.6150 27900.0n 0.4530 28199.9n 0.4530 28200.0n 0.3558 28499.9n 0.3558 28500.0n 0.6150 28799.9n 0.6150 28800.0n 0.6150 29099.9n 0.6150 29100.0n 0.4530 29399.9n 0.4530 29400.0n 0.4044 29699.9n 0.4044 29700.0n 0.4044 29999.9n 0.4044 30000.0n 0.3558 30299.9n 0.3558 30300.0n 0.3558 30599.9n 0.3558 30600.0n 0.3558 30899.9n 0.3558 30900.0n 0.3558 31199.9n 0.3558 31200.0n 0.3882 31499.9n 0.3882 31500.0n 0.3558 31799.9n 0.3558 31800.0n 0.5988 32099.9n 0.5988 32100.0n 0.3558 32399.9n 0.3558 32400.0n 0.3558 32699.9n 0.3558 32700.0n 0.6150 32999.9n 0.6150 33000.0n 0.6150 33299.9n 0.6150 33300.0n 0.4530 33599.9n 0.4530 33600.0n 0.3558 33899.9n 0.3558 33900.0n 0.6150 34199.9n 0.6150 34200.0n 0.6150 34499.9n 0.6150 34500.0n 0.4530 34799.9n 0.4530 34800.0n 0.4044 35099.9n 0.4044 35100.0n 0.4044 35399.9n 0.4044 35400.0n 0.3558 35699.9n 0.3558 35700.0n 0.3558 35999.9n 0.3558 36000.0n 0.3558 36299.9n 0.3558 36300.0n 0.3558 36599.9n 0.3558 36600.0n 0.3882 36899.9n 0.3882 36900.0n 0.3558 37199.9n 0.3558 37200.0n 0.5988 37499.9n 0.5988 37500.0n 0.3558 37799.9n 0.3558 37800.0n 0.3558 38099.9n 0.3558 38100.0n 0.6150 38399.9n 0.6150 38400.0n 0.6150 38699.9n 0.6150 38700.0n 0.4530 38999.9n 0.4530 39000.0n 0.3558 39299.9n 0.3558 39300.0n 0.6150 39599.9n 0.6150 39600.0n 0.6150 39899.9n 0.6150 39900.0n 0.4530 40199.9n 0.4530 40200.0n 0.4044 40499.9n 0.4044 40500.0n 0.4044 40799.9n 0.4044 40800.0n 0.3558 41099.9n 0.3558 41100.0n 0.3558 41399.9n 0.3558 41400.0n 0.3558 41699.9n 0.3558 41700.0n 0.3558 41999.9n 0.3558 42000.0n 0.3882 42299.9n 0.3882 42300.0n 0.3558 42599.9n 0.3558 42600.0n 0.5988 42899.9n 0.5988 42900.0n 0.3558 43199.9n 0.3558 43200.0n 0.3558 43499.9n 0.3558 43500.0n 0.6150 43799.9n 0.6150 43800.0n 0.6150 44099.9n 0.6150 44100.0n 0.4530 44399.9n 0.4530 44400.0n 0.3558 44699.9n 0.3558 44700.0n 0.6150 44999.9n 0.6150 45000.0n 0.6150 45299.9n 0.6150 45300.0n 0.4530 45599.9n 0.4530 45600.0n 0.4044 45899.9n 0.4044 45900.0n 0.4044 46199.9n 0.4044 46200.0n 0.3558 46499.9n 0.3558 46500.0n 0.3558 46799.9n 0.3558 46800.0n 0.3558 47099.9n 0.3558 47100.0n 0.3558 47399.9n 0.3558 47400.0n 0.3882 47699.9n 0.3882 47700.0n 0.3558 47999.9n 0.3558 48000.0n 0.5988 48299.9n 0.5988 48300.0n 0.3558 48599.9n 0.3558 48600.0n 0.3558 48899.9n 0.3558 48900.0n 0.6150 49199.9n 0.6150 49200.0n 0.6150 49499.9n 0.6150 49500.0n 0.4530 49799.9n 0.4530 49800.0n 0.3558 50099.9n 0.3558 50100.0n 0.6150 50399.9n 0.6150 50400.0n 0.6150 50699.9n 0.6150 50700.0n 0.4530 50999.9n 0.4530 51000.0n 0.4044 51299.9n 0.4044 51300.0n 0.4044 51599.9n 0.4044 51600.0n 0.3558 51899.9n 0.3558 51900.0n 0.3558 52199.9n 0.3558 52200.0n 0.3558 52499.9n 0.3558 52500.0n 0.3558 52799.9n 0.3558 52800.0n 0.3882 53099.9n 0.3882 53100.0n 0.3558 53399.9n 0.3558 53400.0n 0.5988 53699.9n 0.5988 53700.0n 0.3558 53999.9n 0.3558 54000.0n 0.6150 54299.9n 0.6150 54300.0n 0.6150 54599.9n 0.6150 54600.0n 0.6150 54899.9n 0.6150 54900.0n 0.5826 55199.9n 0.5826 55200.0n 0.5988 55499.9n 0.5988 55500.0n 0.6150 55799.9n 0.6150 55800.0n 0.3558 56099.9n 0.3558 56100.0n 0.3558 56399.9n 0.3558 56400.0n 0.3558 56699.9n 0.3558 56700.0n 0.5016 56999.9n 0.5016 57000.0n 0.3558 57299.9n 0.3558 57300.0n 0.3558 57599.9n 0.3558 57600.0n 0.4044 57899.9n 0.4044 57900.0n 0.3882 58199.9n 0.3882 58200.0n 0.4368 58499.9n 0.4368 58500.0n 0.3558 58799.9n 0.3558 58800.0n 0.3558 59099.9n 0.3558 59100.0n 0.4368)
Vxp21 a_xp21 0 PWL(0.0n 0.6322 299.9n 0.6322 300.0n 0.6000 599.9n 0.6000 600.0n 0.5677 899.9n 0.5677 900.0n 0.5354 1199.9n 0.5354 1200.0n 0.6322 1499.9n 0.6322 1500.0n 0.5677 1799.9n 0.5677 1800.0n 0.5677 2099.9n 0.5677 2100.0n 0.6322 2399.9n 0.6322 2400.0n 0.3740 2699.9n 0.3740 2700.0n 0.4708 2999.9n 0.4708 3000.0n 0.3740 3299.9n 0.3740 3300.0n 0.5031 3599.9n 0.5031 3600.0n 0.4386 3899.9n 0.4386 3900.0n 0.4870 4199.9n 0.4870 4200.0n 0.3740 4499.9n 0.3740 4500.0n 0.4386 4799.9n 0.4386 4800.0n 0.5838 5099.9n 0.5838 5100.0n 0.6000 5399.9n 0.6000 5400.0n 0.6322 5699.9n 0.6322 5700.0n 0.6000 5999.9n 0.6000 6000.0n 0.5677 6299.9n 0.5677 6300.0n 0.5354 6599.9n 0.5354 6600.0n 0.6322 6899.9n 0.6322 6900.0n 0.5677 7199.9n 0.5677 7200.0n 0.5677 7499.9n 0.5677 7500.0n 0.6322 7799.9n 0.6322 7800.0n 0.3740 8099.9n 0.3740 8100.0n 0.4708 8399.9n 0.4708 8400.0n 0.3740 8699.9n 0.3740 8700.0n 0.5031 8999.9n 0.5031 9000.0n 0.4386 9299.9n 0.4386 9300.0n 0.4870 9599.9n 0.4870 9600.0n 0.3740 9899.9n 0.3740 9900.0n 0.4386 10199.9n 0.4386 10200.0n 0.5838 10499.9n 0.5838 10500.0n 0.6000 10799.9n 0.6000 10800.0n 0.6322 11099.9n 0.6322 11100.0n 0.6000 11399.9n 0.6000 11400.0n 0.5677 11699.9n 0.5677 11700.0n 0.5354 11999.9n 0.5354 12000.0n 0.6322 12299.9n 0.6322 12300.0n 0.5677 12599.9n 0.5677 12600.0n 0.5677 12899.9n 0.5677 12900.0n 0.6322 13199.9n 0.6322 13200.0n 0.3740 13499.9n 0.3740 13500.0n 0.4708 13799.9n 0.4708 13800.0n 0.3740 14099.9n 0.3740 14100.0n 0.5031 14399.9n 0.5031 14400.0n 0.4386 14699.9n 0.4386 14700.0n 0.4870 14999.9n 0.4870 15000.0n 0.3740 15299.9n 0.3740 15300.0n 0.4386 15599.9n 0.4386 15600.0n 0.5838 15899.9n 0.5838 15900.0n 0.6000 16199.9n 0.6000 16200.0n 0.6322 16499.9n 0.6322 16500.0n 0.6000 16799.9n 0.6000 16800.0n 0.5677 17099.9n 0.5677 17100.0n 0.5354 17399.9n 0.5354 17400.0n 0.6322 17699.9n 0.6322 17700.0n 0.5677 17999.9n 0.5677 18000.0n 0.5677 18299.9n 0.5677 18300.0n 0.6322 18599.9n 0.6322 18600.0n 0.3740 18899.9n 0.3740 18900.0n 0.4708 19199.9n 0.4708 19200.0n 0.3740 19499.9n 0.3740 19500.0n 0.5031 19799.9n 0.5031 19800.0n 0.4386 20099.9n 0.4386 20100.0n 0.4870 20399.9n 0.4870 20400.0n 0.3740 20699.9n 0.3740 20700.0n 0.4386 20999.9n 0.4386 21000.0n 0.5838 21299.9n 0.5838 21300.0n 0.6000 21599.9n 0.6000 21600.0n 0.6322 21899.9n 0.6322 21900.0n 0.6000 22199.9n 0.6000 22200.0n 0.5677 22499.9n 0.5677 22500.0n 0.5354 22799.9n 0.5354 22800.0n 0.6322 23099.9n 0.6322 23100.0n 0.5677 23399.9n 0.5677 23400.0n 0.5677 23699.9n 0.5677 23700.0n 0.6322 23999.9n 0.6322 24000.0n 0.3740 24299.9n 0.3740 24300.0n 0.4708 24599.9n 0.4708 24600.0n 0.3740 24899.9n 0.3740 24900.0n 0.5031 25199.9n 0.5031 25200.0n 0.4386 25499.9n 0.4386 25500.0n 0.4870 25799.9n 0.4870 25800.0n 0.3740 26099.9n 0.3740 26100.0n 0.4386 26399.9n 0.4386 26400.0n 0.5838 26699.9n 0.5838 26700.0n 0.6000 26999.9n 0.6000 27000.0n 0.6322 27299.9n 0.6322 27300.0n 0.6000 27599.9n 0.6000 27600.0n 0.5677 27899.9n 0.5677 27900.0n 0.5354 28199.9n 0.5354 28200.0n 0.6322 28499.9n 0.6322 28500.0n 0.5677 28799.9n 0.5677 28800.0n 0.5677 29099.9n 0.5677 29100.0n 0.6322 29399.9n 0.6322 29400.0n 0.3740 29699.9n 0.3740 29700.0n 0.4708 29999.9n 0.4708 30000.0n 0.3740 30299.9n 0.3740 30300.0n 0.5031 30599.9n 0.5031 30600.0n 0.4386 30899.9n 0.4386 30900.0n 0.4870 31199.9n 0.4870 31200.0n 0.3740 31499.9n 0.3740 31500.0n 0.4386 31799.9n 0.4386 31800.0n 0.5838 32099.9n 0.5838 32100.0n 0.6000 32399.9n 0.6000 32400.0n 0.6322 32699.9n 0.6322 32700.0n 0.6000 32999.9n 0.6000 33000.0n 0.5677 33299.9n 0.5677 33300.0n 0.5354 33599.9n 0.5354 33600.0n 0.6322 33899.9n 0.6322 33900.0n 0.5677 34199.9n 0.5677 34200.0n 0.5677 34499.9n 0.5677 34500.0n 0.6322 34799.9n 0.6322 34800.0n 0.3740 35099.9n 0.3740 35100.0n 0.4708 35399.9n 0.4708 35400.0n 0.3740 35699.9n 0.3740 35700.0n 0.5031 35999.9n 0.5031 36000.0n 0.4386 36299.9n 0.4386 36300.0n 0.4870 36599.9n 0.4870 36600.0n 0.3740 36899.9n 0.3740 36900.0n 0.4386 37199.9n 0.4386 37200.0n 0.5838 37499.9n 0.5838 37500.0n 0.6000 37799.9n 0.6000 37800.0n 0.6322 38099.9n 0.6322 38100.0n 0.6000 38399.9n 0.6000 38400.0n 0.5677 38699.9n 0.5677 38700.0n 0.5354 38999.9n 0.5354 39000.0n 0.6322 39299.9n 0.6322 39300.0n 0.5677 39599.9n 0.5677 39600.0n 0.5677 39899.9n 0.5677 39900.0n 0.6322 40199.9n 0.6322 40200.0n 0.3740 40499.9n 0.3740 40500.0n 0.4708 40799.9n 0.4708 40800.0n 0.3740 41099.9n 0.3740 41100.0n 0.5031 41399.9n 0.5031 41400.0n 0.4386 41699.9n 0.4386 41700.0n 0.4870 41999.9n 0.4870 42000.0n 0.3740 42299.9n 0.3740 42300.0n 0.4386 42599.9n 0.4386 42600.0n 0.5838 42899.9n 0.5838 42900.0n 0.6000 43199.9n 0.6000 43200.0n 0.6322 43499.9n 0.6322 43500.0n 0.6000 43799.9n 0.6000 43800.0n 0.5677 44099.9n 0.5677 44100.0n 0.5354 44399.9n 0.5354 44400.0n 0.6322 44699.9n 0.6322 44700.0n 0.5677 44999.9n 0.5677 45000.0n 0.5677 45299.9n 0.5677 45300.0n 0.6322 45599.9n 0.6322 45600.0n 0.3740 45899.9n 0.3740 45900.0n 0.4708 46199.9n 0.4708 46200.0n 0.3740 46499.9n 0.3740 46500.0n 0.5031 46799.9n 0.5031 46800.0n 0.4386 47099.9n 0.4386 47100.0n 0.4870 47399.9n 0.4870 47400.0n 0.3740 47699.9n 0.3740 47700.0n 0.4386 47999.9n 0.4386 48000.0n 0.5838 48299.9n 0.5838 48300.0n 0.6000 48599.9n 0.6000 48600.0n 0.6322 48899.9n 0.6322 48900.0n 0.6000 49199.9n 0.6000 49200.0n 0.5677 49499.9n 0.5677 49500.0n 0.5354 49799.9n 0.5354 49800.0n 0.6322 50099.9n 0.6322 50100.0n 0.5677 50399.9n 0.5677 50400.0n 0.5677 50699.9n 0.5677 50700.0n 0.6322 50999.9n 0.6322 51000.0n 0.3740 51299.9n 0.3740 51300.0n 0.4708 51599.9n 0.4708 51600.0n 0.3740 51899.9n 0.3740 51900.0n 0.5031 52199.9n 0.5031 52200.0n 0.4386 52499.9n 0.4386 52500.0n 0.4870 52799.9n 0.4870 52800.0n 0.3740 53099.9n 0.3740 53100.0n 0.4386 53399.9n 0.4386 53400.0n 0.5838 53699.9n 0.5838 53700.0n 0.6000 53999.9n 0.6000 54000.0n 0.5838 54299.9n 0.5838 54300.0n 0.5354 54599.9n 0.5354 54600.0n 0.5677 54899.9n 0.5677 54900.0n 0.6322 55199.9n 0.6322 55200.0n 0.5677 55499.9n 0.5677 55500.0n 0.5515 55799.9n 0.5515 55800.0n 0.4708 56099.9n 0.4708 56100.0n 0.4224 56399.9n 0.4224 56400.0n 0.5515 56699.9n 0.5515 56700.0n 0.3740 56999.9n 0.3740 57000.0n 0.6322 57299.9n 0.6322 57300.0n 0.5354 57599.9n 0.5354 57600.0n 0.3740 57899.9n 0.3740 57900.0n 0.5031 58199.9n 0.5031 58200.0n 0.4386 58499.9n 0.4386 58500.0n 0.4547 58799.9n 0.4547 58800.0n 0.4063 59099.9n 0.4063 59100.0n 0.4870)
Vxn21 a_xn21 0 PWL(0.0n 0.3678 299.9n 0.3678 300.0n 0.4000 599.9n 0.4000 600.0n 0.4323 899.9n 0.4323 900.0n 0.4646 1199.9n 0.4646 1200.0n 0.3678 1499.9n 0.3678 1500.0n 0.4323 1799.9n 0.4323 1800.0n 0.4323 2099.9n 0.4323 2100.0n 0.3678 2399.9n 0.3678 2400.0n 0.6260 2699.9n 0.6260 2700.0n 0.5292 2999.9n 0.5292 3000.0n 0.6260 3299.9n 0.6260 3300.0n 0.4969 3599.9n 0.4969 3600.0n 0.5614 3899.9n 0.5614 3900.0n 0.5130 4199.9n 0.5130 4200.0n 0.6260 4499.9n 0.6260 4500.0n 0.5614 4799.9n 0.5614 4800.0n 0.4162 5099.9n 0.4162 5100.0n 0.4000 5399.9n 0.4000 5400.0n 0.3678 5699.9n 0.3678 5700.0n 0.4000 5999.9n 0.4000 6000.0n 0.4323 6299.9n 0.4323 6300.0n 0.4646 6599.9n 0.4646 6600.0n 0.3678 6899.9n 0.3678 6900.0n 0.4323 7199.9n 0.4323 7200.0n 0.4323 7499.9n 0.4323 7500.0n 0.3678 7799.9n 0.3678 7800.0n 0.6260 8099.9n 0.6260 8100.0n 0.5292 8399.9n 0.5292 8400.0n 0.6260 8699.9n 0.6260 8700.0n 0.4969 8999.9n 0.4969 9000.0n 0.5614 9299.9n 0.5614 9300.0n 0.5130 9599.9n 0.5130 9600.0n 0.6260 9899.9n 0.6260 9900.0n 0.5614 10199.9n 0.5614 10200.0n 0.4162 10499.9n 0.4162 10500.0n 0.4000 10799.9n 0.4000 10800.0n 0.3678 11099.9n 0.3678 11100.0n 0.4000 11399.9n 0.4000 11400.0n 0.4323 11699.9n 0.4323 11700.0n 0.4646 11999.9n 0.4646 12000.0n 0.3678 12299.9n 0.3678 12300.0n 0.4323 12599.9n 0.4323 12600.0n 0.4323 12899.9n 0.4323 12900.0n 0.3678 13199.9n 0.3678 13200.0n 0.6260 13499.9n 0.6260 13500.0n 0.5292 13799.9n 0.5292 13800.0n 0.6260 14099.9n 0.6260 14100.0n 0.4969 14399.9n 0.4969 14400.0n 0.5614 14699.9n 0.5614 14700.0n 0.5130 14999.9n 0.5130 15000.0n 0.6260 15299.9n 0.6260 15300.0n 0.5614 15599.9n 0.5614 15600.0n 0.4162 15899.9n 0.4162 15900.0n 0.4000 16199.9n 0.4000 16200.0n 0.3678 16499.9n 0.3678 16500.0n 0.4000 16799.9n 0.4000 16800.0n 0.4323 17099.9n 0.4323 17100.0n 0.4646 17399.9n 0.4646 17400.0n 0.3678 17699.9n 0.3678 17700.0n 0.4323 17999.9n 0.4323 18000.0n 0.4323 18299.9n 0.4323 18300.0n 0.3678 18599.9n 0.3678 18600.0n 0.6260 18899.9n 0.6260 18900.0n 0.5292 19199.9n 0.5292 19200.0n 0.6260 19499.9n 0.6260 19500.0n 0.4969 19799.9n 0.4969 19800.0n 0.5614 20099.9n 0.5614 20100.0n 0.5130 20399.9n 0.5130 20400.0n 0.6260 20699.9n 0.6260 20700.0n 0.5614 20999.9n 0.5614 21000.0n 0.4162 21299.9n 0.4162 21300.0n 0.4000 21599.9n 0.4000 21600.0n 0.3678 21899.9n 0.3678 21900.0n 0.4000 22199.9n 0.4000 22200.0n 0.4323 22499.9n 0.4323 22500.0n 0.4646 22799.9n 0.4646 22800.0n 0.3678 23099.9n 0.3678 23100.0n 0.4323 23399.9n 0.4323 23400.0n 0.4323 23699.9n 0.4323 23700.0n 0.3678 23999.9n 0.3678 24000.0n 0.6260 24299.9n 0.6260 24300.0n 0.5292 24599.9n 0.5292 24600.0n 0.6260 24899.9n 0.6260 24900.0n 0.4969 25199.9n 0.4969 25200.0n 0.5614 25499.9n 0.5614 25500.0n 0.5130 25799.9n 0.5130 25800.0n 0.6260 26099.9n 0.6260 26100.0n 0.5614 26399.9n 0.5614 26400.0n 0.4162 26699.9n 0.4162 26700.0n 0.4000 26999.9n 0.4000 27000.0n 0.3678 27299.9n 0.3678 27300.0n 0.4000 27599.9n 0.4000 27600.0n 0.4323 27899.9n 0.4323 27900.0n 0.4646 28199.9n 0.4646 28200.0n 0.3678 28499.9n 0.3678 28500.0n 0.4323 28799.9n 0.4323 28800.0n 0.4323 29099.9n 0.4323 29100.0n 0.3678 29399.9n 0.3678 29400.0n 0.6260 29699.9n 0.6260 29700.0n 0.5292 29999.9n 0.5292 30000.0n 0.6260 30299.9n 0.6260 30300.0n 0.4969 30599.9n 0.4969 30600.0n 0.5614 30899.9n 0.5614 30900.0n 0.5130 31199.9n 0.5130 31200.0n 0.6260 31499.9n 0.6260 31500.0n 0.5614 31799.9n 0.5614 31800.0n 0.4162 32099.9n 0.4162 32100.0n 0.4000 32399.9n 0.4000 32400.0n 0.3678 32699.9n 0.3678 32700.0n 0.4000 32999.9n 0.4000 33000.0n 0.4323 33299.9n 0.4323 33300.0n 0.4646 33599.9n 0.4646 33600.0n 0.3678 33899.9n 0.3678 33900.0n 0.4323 34199.9n 0.4323 34200.0n 0.4323 34499.9n 0.4323 34500.0n 0.3678 34799.9n 0.3678 34800.0n 0.6260 35099.9n 0.6260 35100.0n 0.5292 35399.9n 0.5292 35400.0n 0.6260 35699.9n 0.6260 35700.0n 0.4969 35999.9n 0.4969 36000.0n 0.5614 36299.9n 0.5614 36300.0n 0.5130 36599.9n 0.5130 36600.0n 0.6260 36899.9n 0.6260 36900.0n 0.5614 37199.9n 0.5614 37200.0n 0.4162 37499.9n 0.4162 37500.0n 0.4000 37799.9n 0.4000 37800.0n 0.3678 38099.9n 0.3678 38100.0n 0.4000 38399.9n 0.4000 38400.0n 0.4323 38699.9n 0.4323 38700.0n 0.4646 38999.9n 0.4646 39000.0n 0.3678 39299.9n 0.3678 39300.0n 0.4323 39599.9n 0.4323 39600.0n 0.4323 39899.9n 0.4323 39900.0n 0.3678 40199.9n 0.3678 40200.0n 0.6260 40499.9n 0.6260 40500.0n 0.5292 40799.9n 0.5292 40800.0n 0.6260 41099.9n 0.6260 41100.0n 0.4969 41399.9n 0.4969 41400.0n 0.5614 41699.9n 0.5614 41700.0n 0.5130 41999.9n 0.5130 42000.0n 0.6260 42299.9n 0.6260 42300.0n 0.5614 42599.9n 0.5614 42600.0n 0.4162 42899.9n 0.4162 42900.0n 0.4000 43199.9n 0.4000 43200.0n 0.3678 43499.9n 0.3678 43500.0n 0.4000 43799.9n 0.4000 43800.0n 0.4323 44099.9n 0.4323 44100.0n 0.4646 44399.9n 0.4646 44400.0n 0.3678 44699.9n 0.3678 44700.0n 0.4323 44999.9n 0.4323 45000.0n 0.4323 45299.9n 0.4323 45300.0n 0.3678 45599.9n 0.3678 45600.0n 0.6260 45899.9n 0.6260 45900.0n 0.5292 46199.9n 0.5292 46200.0n 0.6260 46499.9n 0.6260 46500.0n 0.4969 46799.9n 0.4969 46800.0n 0.5614 47099.9n 0.5614 47100.0n 0.5130 47399.9n 0.5130 47400.0n 0.6260 47699.9n 0.6260 47700.0n 0.5614 47999.9n 0.5614 48000.0n 0.4162 48299.9n 0.4162 48300.0n 0.4000 48599.9n 0.4000 48600.0n 0.3678 48899.9n 0.3678 48900.0n 0.4000 49199.9n 0.4000 49200.0n 0.4323 49499.9n 0.4323 49500.0n 0.4646 49799.9n 0.4646 49800.0n 0.3678 50099.9n 0.3678 50100.0n 0.4323 50399.9n 0.4323 50400.0n 0.4323 50699.9n 0.4323 50700.0n 0.3678 50999.9n 0.3678 51000.0n 0.6260 51299.9n 0.6260 51300.0n 0.5292 51599.9n 0.5292 51600.0n 0.6260 51899.9n 0.6260 51900.0n 0.4969 52199.9n 0.4969 52200.0n 0.5614 52499.9n 0.5614 52500.0n 0.5130 52799.9n 0.5130 52800.0n 0.6260 53099.9n 0.6260 53100.0n 0.5614 53399.9n 0.5614 53400.0n 0.4162 53699.9n 0.4162 53700.0n 0.4000 53999.9n 0.4000 54000.0n 0.4162 54299.9n 0.4162 54300.0n 0.4646 54599.9n 0.4646 54600.0n 0.4323 54899.9n 0.4323 54900.0n 0.3678 55199.9n 0.3678 55200.0n 0.4323 55499.9n 0.4323 55500.0n 0.4485 55799.9n 0.4485 55800.0n 0.5292 56099.9n 0.5292 56100.0n 0.5776 56399.9n 0.5776 56400.0n 0.4485 56699.9n 0.4485 56700.0n 0.6260 56999.9n 0.6260 57000.0n 0.3678 57299.9n 0.3678 57300.0n 0.4646 57599.9n 0.4646 57600.0n 0.6260 57899.9n 0.6260 57900.0n 0.4969 58199.9n 0.4969 58200.0n 0.5614 58499.9n 0.5614 58500.0n 0.5453 58799.9n 0.5453 58800.0n 0.5937 59099.9n 0.5937 59100.0n 0.5130)
Vxp22 a_xp22 0 PWL(0.0n 0.6292 299.9n 0.6292 300.0n 0.5985 599.9n 0.5985 600.0n 0.6292 899.9n 0.6292 900.0n 0.7520 1199.9n 0.7520 1200.0n 0.5679 1499.9n 0.5679 1500.0n 0.5679 1799.9n 0.5679 1800.0n 0.5372 2099.9n 0.5372 2100.0n 0.5679 2399.9n 0.5679 2400.0n 0.4451 2699.9n 0.4451 2700.0n 0.4451 2999.9n 0.4451 3000.0n 0.4451 3299.9n 0.4451 3300.0n 0.4451 3599.9n 0.4451 3600.0n 0.4451 3899.9n 0.4451 3900.0n 0.4451 4199.9n 0.4451 4200.0n 0.4451 4499.9n 0.4451 4500.0n 0.4451 4799.9n 0.4451 4800.0n 0.4451 5099.9n 0.4451 5100.0n 0.4451 5399.9n 0.4451 5400.0n 0.6292 5699.9n 0.6292 5700.0n 0.5985 5999.9n 0.5985 6000.0n 0.6292 6299.9n 0.6292 6300.0n 0.7520 6599.9n 0.7520 6600.0n 0.5679 6899.9n 0.5679 6900.0n 0.5679 7199.9n 0.5679 7200.0n 0.5372 7499.9n 0.5372 7500.0n 0.5679 7799.9n 0.5679 7800.0n 0.4451 8099.9n 0.4451 8100.0n 0.4451 8399.9n 0.4451 8400.0n 0.4451 8699.9n 0.4451 8700.0n 0.4451 8999.9n 0.4451 9000.0n 0.4451 9299.9n 0.4451 9300.0n 0.4451 9599.9n 0.4451 9600.0n 0.4451 9899.9n 0.4451 9900.0n 0.4451 10199.9n 0.4451 10200.0n 0.4451 10499.9n 0.4451 10500.0n 0.4451 10799.9n 0.4451 10800.0n 0.6292 11099.9n 0.6292 11100.0n 0.5985 11399.9n 0.5985 11400.0n 0.6292 11699.9n 0.6292 11700.0n 0.7520 11999.9n 0.7520 12000.0n 0.5679 12299.9n 0.5679 12300.0n 0.5679 12599.9n 0.5679 12600.0n 0.5372 12899.9n 0.5372 12900.0n 0.5679 13199.9n 0.5679 13200.0n 0.4451 13499.9n 0.4451 13500.0n 0.4451 13799.9n 0.4451 13800.0n 0.4451 14099.9n 0.4451 14100.0n 0.4451 14399.9n 0.4451 14400.0n 0.4451 14699.9n 0.4451 14700.0n 0.4451 14999.9n 0.4451 15000.0n 0.4451 15299.9n 0.4451 15300.0n 0.4451 15599.9n 0.4451 15600.0n 0.4451 15899.9n 0.4451 15900.0n 0.4451 16199.9n 0.4451 16200.0n 0.6292 16499.9n 0.6292 16500.0n 0.5985 16799.9n 0.5985 16800.0n 0.6292 17099.9n 0.6292 17100.0n 0.7520 17399.9n 0.7520 17400.0n 0.5679 17699.9n 0.5679 17700.0n 0.5679 17999.9n 0.5679 18000.0n 0.5372 18299.9n 0.5372 18300.0n 0.5679 18599.9n 0.5679 18600.0n 0.4451 18899.9n 0.4451 18900.0n 0.4451 19199.9n 0.4451 19200.0n 0.4451 19499.9n 0.4451 19500.0n 0.4451 19799.9n 0.4451 19800.0n 0.4451 20099.9n 0.4451 20100.0n 0.4451 20399.9n 0.4451 20400.0n 0.4451 20699.9n 0.4451 20700.0n 0.4451 20999.9n 0.4451 21000.0n 0.4451 21299.9n 0.4451 21300.0n 0.4451 21599.9n 0.4451 21600.0n 0.6292 21899.9n 0.6292 21900.0n 0.5985 22199.9n 0.5985 22200.0n 0.6292 22499.9n 0.6292 22500.0n 0.7520 22799.9n 0.7520 22800.0n 0.5679 23099.9n 0.5679 23100.0n 0.5679 23399.9n 0.5679 23400.0n 0.5372 23699.9n 0.5372 23700.0n 0.5679 23999.9n 0.5679 24000.0n 0.4451 24299.9n 0.4451 24300.0n 0.4451 24599.9n 0.4451 24600.0n 0.4451 24899.9n 0.4451 24900.0n 0.4451 25199.9n 0.4451 25200.0n 0.4451 25499.9n 0.4451 25500.0n 0.4451 25799.9n 0.4451 25800.0n 0.4451 26099.9n 0.4451 26100.0n 0.4451 26399.9n 0.4451 26400.0n 0.4451 26699.9n 0.4451 26700.0n 0.4451 26999.9n 0.4451 27000.0n 0.6292 27299.9n 0.6292 27300.0n 0.5985 27599.9n 0.5985 27600.0n 0.6292 27899.9n 0.6292 27900.0n 0.7520 28199.9n 0.7520 28200.0n 0.5679 28499.9n 0.5679 28500.0n 0.5679 28799.9n 0.5679 28800.0n 0.5372 29099.9n 0.5372 29100.0n 0.5679 29399.9n 0.5679 29400.0n 0.4451 29699.9n 0.4451 29700.0n 0.4451 29999.9n 0.4451 30000.0n 0.4451 30299.9n 0.4451 30300.0n 0.4451 30599.9n 0.4451 30600.0n 0.4451 30899.9n 0.4451 30900.0n 0.4451 31199.9n 0.4451 31200.0n 0.4451 31499.9n 0.4451 31500.0n 0.4451 31799.9n 0.4451 31800.0n 0.4451 32099.9n 0.4451 32100.0n 0.4451 32399.9n 0.4451 32400.0n 0.6292 32699.9n 0.6292 32700.0n 0.5985 32999.9n 0.5985 33000.0n 0.6292 33299.9n 0.6292 33300.0n 0.7520 33599.9n 0.7520 33600.0n 0.5679 33899.9n 0.5679 33900.0n 0.5679 34199.9n 0.5679 34200.0n 0.5372 34499.9n 0.5372 34500.0n 0.5679 34799.9n 0.5679 34800.0n 0.4451 35099.9n 0.4451 35100.0n 0.4451 35399.9n 0.4451 35400.0n 0.4451 35699.9n 0.4451 35700.0n 0.4451 35999.9n 0.4451 36000.0n 0.4451 36299.9n 0.4451 36300.0n 0.4451 36599.9n 0.4451 36600.0n 0.4451 36899.9n 0.4451 36900.0n 0.4451 37199.9n 0.4451 37200.0n 0.4451 37499.9n 0.4451 37500.0n 0.4451 37799.9n 0.4451 37800.0n 0.6292 38099.9n 0.6292 38100.0n 0.5985 38399.9n 0.5985 38400.0n 0.6292 38699.9n 0.6292 38700.0n 0.7520 38999.9n 0.7520 39000.0n 0.5679 39299.9n 0.5679 39300.0n 0.5679 39599.9n 0.5679 39600.0n 0.5372 39899.9n 0.5372 39900.0n 0.5679 40199.9n 0.5679 40200.0n 0.4451 40499.9n 0.4451 40500.0n 0.4451 40799.9n 0.4451 40800.0n 0.4451 41099.9n 0.4451 41100.0n 0.4451 41399.9n 0.4451 41400.0n 0.4451 41699.9n 0.4451 41700.0n 0.4451 41999.9n 0.4451 42000.0n 0.4451 42299.9n 0.4451 42300.0n 0.4451 42599.9n 0.4451 42600.0n 0.4451 42899.9n 0.4451 42900.0n 0.4451 43199.9n 0.4451 43200.0n 0.6292 43499.9n 0.6292 43500.0n 0.5985 43799.9n 0.5985 43800.0n 0.6292 44099.9n 0.6292 44100.0n 0.7520 44399.9n 0.7520 44400.0n 0.5679 44699.9n 0.5679 44700.0n 0.5679 44999.9n 0.5679 45000.0n 0.5372 45299.9n 0.5372 45300.0n 0.5679 45599.9n 0.5679 45600.0n 0.4451 45899.9n 0.4451 45900.0n 0.4451 46199.9n 0.4451 46200.0n 0.4451 46499.9n 0.4451 46500.0n 0.4451 46799.9n 0.4451 46800.0n 0.4451 47099.9n 0.4451 47100.0n 0.4451 47399.9n 0.4451 47400.0n 0.4451 47699.9n 0.4451 47700.0n 0.4451 47999.9n 0.4451 48000.0n 0.4451 48299.9n 0.4451 48300.0n 0.4451 48599.9n 0.4451 48600.0n 0.6292 48899.9n 0.6292 48900.0n 0.5985 49199.9n 0.5985 49200.0n 0.6292 49499.9n 0.6292 49500.0n 0.7520 49799.9n 0.7520 49800.0n 0.5679 50099.9n 0.5679 50100.0n 0.5679 50399.9n 0.5679 50400.0n 0.5372 50699.9n 0.5372 50700.0n 0.5679 50999.9n 0.5679 51000.0n 0.4451 51299.9n 0.4451 51300.0n 0.4451 51599.9n 0.4451 51600.0n 0.4451 51899.9n 0.4451 51900.0n 0.4451 52199.9n 0.4451 52200.0n 0.4451 52499.9n 0.4451 52500.0n 0.4451 52799.9n 0.4451 52800.0n 0.4451 53099.9n 0.4451 53100.0n 0.4451 53399.9n 0.4451 53400.0n 0.4451 53699.9n 0.4451 53700.0n 0.4451 53999.9n 0.4451 54000.0n 0.5372 54299.9n 0.5372 54300.0n 0.4451 54599.9n 0.4451 54600.0n 0.6292 54899.9n 0.6292 54900.0n 0.6599 55199.9n 0.6599 55200.0n 0.5679 55499.9n 0.5679 55500.0n 0.5679 55799.9n 0.5679 55800.0n 0.4451 56099.9n 0.4451 56100.0n 0.4451 56399.9n 0.4451 56400.0n 0.4451 56699.9n 0.4451 56700.0n 0.4451 56999.9n 0.4451 57000.0n 0.4451 57299.9n 0.4451 57300.0n 0.4451 57599.9n 0.4451 57600.0n 0.4451 57899.9n 0.4451 57900.0n 0.4451 58199.9n 0.4451 58200.0n 0.4451 58499.9n 0.4451 58500.0n 0.4451 58799.9n 0.4451 58800.0n 0.4451 59099.9n 0.4451 59100.0n 0.4451)
Vxn22 a_xn22 0 PWL(0.0n 0.3708 299.9n 0.3708 300.0n 0.4015 599.9n 0.4015 600.0n 0.3708 899.9n 0.3708 900.0n 0.2480 1199.9n 0.2480 1200.0n 0.4321 1499.9n 0.4321 1500.0n 0.4321 1799.9n 0.4321 1800.0n 0.4628 2099.9n 0.4628 2100.0n 0.4321 2399.9n 0.4321 2400.0n 0.5549 2699.9n 0.5549 2700.0n 0.5549 2999.9n 0.5549 3000.0n 0.5549 3299.9n 0.5549 3300.0n 0.5549 3599.9n 0.5549 3600.0n 0.5549 3899.9n 0.5549 3900.0n 0.5549 4199.9n 0.5549 4200.0n 0.5549 4499.9n 0.5549 4500.0n 0.5549 4799.9n 0.5549 4800.0n 0.5549 5099.9n 0.5549 5100.0n 0.5549 5399.9n 0.5549 5400.0n 0.3708 5699.9n 0.3708 5700.0n 0.4015 5999.9n 0.4015 6000.0n 0.3708 6299.9n 0.3708 6300.0n 0.2480 6599.9n 0.2480 6600.0n 0.4321 6899.9n 0.4321 6900.0n 0.4321 7199.9n 0.4321 7200.0n 0.4628 7499.9n 0.4628 7500.0n 0.4321 7799.9n 0.4321 7800.0n 0.5549 8099.9n 0.5549 8100.0n 0.5549 8399.9n 0.5549 8400.0n 0.5549 8699.9n 0.5549 8700.0n 0.5549 8999.9n 0.5549 9000.0n 0.5549 9299.9n 0.5549 9300.0n 0.5549 9599.9n 0.5549 9600.0n 0.5549 9899.9n 0.5549 9900.0n 0.5549 10199.9n 0.5549 10200.0n 0.5549 10499.9n 0.5549 10500.0n 0.5549 10799.9n 0.5549 10800.0n 0.3708 11099.9n 0.3708 11100.0n 0.4015 11399.9n 0.4015 11400.0n 0.3708 11699.9n 0.3708 11700.0n 0.2480 11999.9n 0.2480 12000.0n 0.4321 12299.9n 0.4321 12300.0n 0.4321 12599.9n 0.4321 12600.0n 0.4628 12899.9n 0.4628 12900.0n 0.4321 13199.9n 0.4321 13200.0n 0.5549 13499.9n 0.5549 13500.0n 0.5549 13799.9n 0.5549 13800.0n 0.5549 14099.9n 0.5549 14100.0n 0.5549 14399.9n 0.5549 14400.0n 0.5549 14699.9n 0.5549 14700.0n 0.5549 14999.9n 0.5549 15000.0n 0.5549 15299.9n 0.5549 15300.0n 0.5549 15599.9n 0.5549 15600.0n 0.5549 15899.9n 0.5549 15900.0n 0.5549 16199.9n 0.5549 16200.0n 0.3708 16499.9n 0.3708 16500.0n 0.4015 16799.9n 0.4015 16800.0n 0.3708 17099.9n 0.3708 17100.0n 0.2480 17399.9n 0.2480 17400.0n 0.4321 17699.9n 0.4321 17700.0n 0.4321 17999.9n 0.4321 18000.0n 0.4628 18299.9n 0.4628 18300.0n 0.4321 18599.9n 0.4321 18600.0n 0.5549 18899.9n 0.5549 18900.0n 0.5549 19199.9n 0.5549 19200.0n 0.5549 19499.9n 0.5549 19500.0n 0.5549 19799.9n 0.5549 19800.0n 0.5549 20099.9n 0.5549 20100.0n 0.5549 20399.9n 0.5549 20400.0n 0.5549 20699.9n 0.5549 20700.0n 0.5549 20999.9n 0.5549 21000.0n 0.5549 21299.9n 0.5549 21300.0n 0.5549 21599.9n 0.5549 21600.0n 0.3708 21899.9n 0.3708 21900.0n 0.4015 22199.9n 0.4015 22200.0n 0.3708 22499.9n 0.3708 22500.0n 0.2480 22799.9n 0.2480 22800.0n 0.4321 23099.9n 0.4321 23100.0n 0.4321 23399.9n 0.4321 23400.0n 0.4628 23699.9n 0.4628 23700.0n 0.4321 23999.9n 0.4321 24000.0n 0.5549 24299.9n 0.5549 24300.0n 0.5549 24599.9n 0.5549 24600.0n 0.5549 24899.9n 0.5549 24900.0n 0.5549 25199.9n 0.5549 25200.0n 0.5549 25499.9n 0.5549 25500.0n 0.5549 25799.9n 0.5549 25800.0n 0.5549 26099.9n 0.5549 26100.0n 0.5549 26399.9n 0.5549 26400.0n 0.5549 26699.9n 0.5549 26700.0n 0.5549 26999.9n 0.5549 27000.0n 0.3708 27299.9n 0.3708 27300.0n 0.4015 27599.9n 0.4015 27600.0n 0.3708 27899.9n 0.3708 27900.0n 0.2480 28199.9n 0.2480 28200.0n 0.4321 28499.9n 0.4321 28500.0n 0.4321 28799.9n 0.4321 28800.0n 0.4628 29099.9n 0.4628 29100.0n 0.4321 29399.9n 0.4321 29400.0n 0.5549 29699.9n 0.5549 29700.0n 0.5549 29999.9n 0.5549 30000.0n 0.5549 30299.9n 0.5549 30300.0n 0.5549 30599.9n 0.5549 30600.0n 0.5549 30899.9n 0.5549 30900.0n 0.5549 31199.9n 0.5549 31200.0n 0.5549 31499.9n 0.5549 31500.0n 0.5549 31799.9n 0.5549 31800.0n 0.5549 32099.9n 0.5549 32100.0n 0.5549 32399.9n 0.5549 32400.0n 0.3708 32699.9n 0.3708 32700.0n 0.4015 32999.9n 0.4015 33000.0n 0.3708 33299.9n 0.3708 33300.0n 0.2480 33599.9n 0.2480 33600.0n 0.4321 33899.9n 0.4321 33900.0n 0.4321 34199.9n 0.4321 34200.0n 0.4628 34499.9n 0.4628 34500.0n 0.4321 34799.9n 0.4321 34800.0n 0.5549 35099.9n 0.5549 35100.0n 0.5549 35399.9n 0.5549 35400.0n 0.5549 35699.9n 0.5549 35700.0n 0.5549 35999.9n 0.5549 36000.0n 0.5549 36299.9n 0.5549 36300.0n 0.5549 36599.9n 0.5549 36600.0n 0.5549 36899.9n 0.5549 36900.0n 0.5549 37199.9n 0.5549 37200.0n 0.5549 37499.9n 0.5549 37500.0n 0.5549 37799.9n 0.5549 37800.0n 0.3708 38099.9n 0.3708 38100.0n 0.4015 38399.9n 0.4015 38400.0n 0.3708 38699.9n 0.3708 38700.0n 0.2480 38999.9n 0.2480 39000.0n 0.4321 39299.9n 0.4321 39300.0n 0.4321 39599.9n 0.4321 39600.0n 0.4628 39899.9n 0.4628 39900.0n 0.4321 40199.9n 0.4321 40200.0n 0.5549 40499.9n 0.5549 40500.0n 0.5549 40799.9n 0.5549 40800.0n 0.5549 41099.9n 0.5549 41100.0n 0.5549 41399.9n 0.5549 41400.0n 0.5549 41699.9n 0.5549 41700.0n 0.5549 41999.9n 0.5549 42000.0n 0.5549 42299.9n 0.5549 42300.0n 0.5549 42599.9n 0.5549 42600.0n 0.5549 42899.9n 0.5549 42900.0n 0.5549 43199.9n 0.5549 43200.0n 0.3708 43499.9n 0.3708 43500.0n 0.4015 43799.9n 0.4015 43800.0n 0.3708 44099.9n 0.3708 44100.0n 0.2480 44399.9n 0.2480 44400.0n 0.4321 44699.9n 0.4321 44700.0n 0.4321 44999.9n 0.4321 45000.0n 0.4628 45299.9n 0.4628 45300.0n 0.4321 45599.9n 0.4321 45600.0n 0.5549 45899.9n 0.5549 45900.0n 0.5549 46199.9n 0.5549 46200.0n 0.5549 46499.9n 0.5549 46500.0n 0.5549 46799.9n 0.5549 46800.0n 0.5549 47099.9n 0.5549 47100.0n 0.5549 47399.9n 0.5549 47400.0n 0.5549 47699.9n 0.5549 47700.0n 0.5549 47999.9n 0.5549 48000.0n 0.5549 48299.9n 0.5549 48300.0n 0.5549 48599.9n 0.5549 48600.0n 0.3708 48899.9n 0.3708 48900.0n 0.4015 49199.9n 0.4015 49200.0n 0.3708 49499.9n 0.3708 49500.0n 0.2480 49799.9n 0.2480 49800.0n 0.4321 50099.9n 0.4321 50100.0n 0.4321 50399.9n 0.4321 50400.0n 0.4628 50699.9n 0.4628 50700.0n 0.4321 50999.9n 0.4321 51000.0n 0.5549 51299.9n 0.5549 51300.0n 0.5549 51599.9n 0.5549 51600.0n 0.5549 51899.9n 0.5549 51900.0n 0.5549 52199.9n 0.5549 52200.0n 0.5549 52499.9n 0.5549 52500.0n 0.5549 52799.9n 0.5549 52800.0n 0.5549 53099.9n 0.5549 53100.0n 0.5549 53399.9n 0.5549 53400.0n 0.5549 53699.9n 0.5549 53700.0n 0.5549 53999.9n 0.5549 54000.0n 0.4628 54299.9n 0.4628 54300.0n 0.5549 54599.9n 0.5549 54600.0n 0.3708 54899.9n 0.3708 54900.0n 0.3401 55199.9n 0.3401 55200.0n 0.4321 55499.9n 0.4321 55500.0n 0.4321 55799.9n 0.4321 55800.0n 0.5549 56099.9n 0.5549 56100.0n 0.5549 56399.9n 0.5549 56400.0n 0.5549 56699.9n 0.5549 56700.0n 0.5549 56999.9n 0.5549 57000.0n 0.5549 57299.9n 0.5549 57300.0n 0.5549 57599.9n 0.5549 57600.0n 0.5549 57899.9n 0.5549 57900.0n 0.5549 58199.9n 0.5549 58200.0n 0.5549 58499.9n 0.5549 58500.0n 0.5549 58799.9n 0.5549 58800.0n 0.5549 59099.9n 0.5549 59100.0n 0.5549)
Vxp23 a_xp23 0 PWL(0.0n 0.4886 299.9n 0.4886 300.0n 0.4886 599.9n 0.4886 600.0n 0.4886 899.9n 0.4886 900.0n 0.4886 1199.9n 0.4886 1200.0n 0.4886 1499.9n 0.4886 1500.0n 0.4886 1799.9n 0.4886 1800.0n 0.4886 2099.9n 0.4886 2100.0n 0.4886 2399.9n 0.4886 2400.0n 0.4886 2699.9n 0.4886 2700.0n 0.4886 2999.9n 0.4886 3000.0n 0.4886 3299.9n 0.4886 3300.0n 0.4886 3599.9n 0.4886 3600.0n 0.4886 3899.9n 0.4886 3900.0n 0.4886 4199.9n 0.4886 4200.0n 0.4886 4499.9n 0.4886 4500.0n 0.4886 4799.9n 0.4886 4800.0n 0.4886 5099.9n 0.4886 5100.0n 0.4886 5399.9n 0.4886 5400.0n 0.4886 5699.9n 0.4886 5700.0n 0.4886 5999.9n 0.4886 6000.0n 0.4886 6299.9n 0.4886 6300.0n 0.4886 6599.9n 0.4886 6600.0n 0.4886 6899.9n 0.4886 6900.0n 0.4886 7199.9n 0.4886 7200.0n 0.4886 7499.9n 0.4886 7500.0n 0.4886 7799.9n 0.4886 7800.0n 0.4886 8099.9n 0.4886 8100.0n 0.4886 8399.9n 0.4886 8400.0n 0.4886 8699.9n 0.4886 8700.0n 0.4886 8999.9n 0.4886 9000.0n 0.4886 9299.9n 0.4886 9300.0n 0.4886 9599.9n 0.4886 9600.0n 0.4886 9899.9n 0.4886 9900.0n 0.4886 10199.9n 0.4886 10200.0n 0.4886 10499.9n 0.4886 10500.0n 0.4886 10799.9n 0.4886 10800.0n 0.4886 11099.9n 0.4886 11100.0n 0.4886 11399.9n 0.4886 11400.0n 0.4886 11699.9n 0.4886 11700.0n 0.4886 11999.9n 0.4886 12000.0n 0.4886 12299.9n 0.4886 12300.0n 0.4886 12599.9n 0.4886 12600.0n 0.4886 12899.9n 0.4886 12900.0n 0.4886 13199.9n 0.4886 13200.0n 0.4886 13499.9n 0.4886 13500.0n 0.4886 13799.9n 0.4886 13800.0n 0.4886 14099.9n 0.4886 14100.0n 0.4886 14399.9n 0.4886 14400.0n 0.4886 14699.9n 0.4886 14700.0n 0.4886 14999.9n 0.4886 15000.0n 0.4886 15299.9n 0.4886 15300.0n 0.4886 15599.9n 0.4886 15600.0n 0.4886 15899.9n 0.4886 15900.0n 0.4886 16199.9n 0.4886 16200.0n 0.4886 16499.9n 0.4886 16500.0n 0.4886 16799.9n 0.4886 16800.0n 0.4886 17099.9n 0.4886 17100.0n 0.4886 17399.9n 0.4886 17400.0n 0.4886 17699.9n 0.4886 17700.0n 0.4886 17999.9n 0.4886 18000.0n 0.4886 18299.9n 0.4886 18300.0n 0.4886 18599.9n 0.4886 18600.0n 0.4886 18899.9n 0.4886 18900.0n 0.4886 19199.9n 0.4886 19200.0n 0.4886 19499.9n 0.4886 19500.0n 0.4886 19799.9n 0.4886 19800.0n 0.4886 20099.9n 0.4886 20100.0n 0.4886 20399.9n 0.4886 20400.0n 0.4886 20699.9n 0.4886 20700.0n 0.4886 20999.9n 0.4886 21000.0n 0.4886 21299.9n 0.4886 21300.0n 0.4886 21599.9n 0.4886 21600.0n 0.4886 21899.9n 0.4886 21900.0n 0.4886 22199.9n 0.4886 22200.0n 0.4886 22499.9n 0.4886 22500.0n 0.4886 22799.9n 0.4886 22800.0n 0.4886 23099.9n 0.4886 23100.0n 0.4886 23399.9n 0.4886 23400.0n 0.4886 23699.9n 0.4886 23700.0n 0.4886 23999.9n 0.4886 24000.0n 0.4886 24299.9n 0.4886 24300.0n 0.4886 24599.9n 0.4886 24600.0n 0.4886 24899.9n 0.4886 24900.0n 0.4886 25199.9n 0.4886 25200.0n 0.4886 25499.9n 0.4886 25500.0n 0.4886 25799.9n 0.4886 25800.0n 0.4886 26099.9n 0.4886 26100.0n 0.4886 26399.9n 0.4886 26400.0n 0.4886 26699.9n 0.4886 26700.0n 0.4886 26999.9n 0.4886 27000.0n 0.4886 27299.9n 0.4886 27300.0n 0.4886 27599.9n 0.4886 27600.0n 0.4886 27899.9n 0.4886 27900.0n 0.4886 28199.9n 0.4886 28200.0n 0.4886 28499.9n 0.4886 28500.0n 0.4886 28799.9n 0.4886 28800.0n 0.4886 29099.9n 0.4886 29100.0n 0.4886 29399.9n 0.4886 29400.0n 0.4886 29699.9n 0.4886 29700.0n 0.4886 29999.9n 0.4886 30000.0n 0.4886 30299.9n 0.4886 30300.0n 0.4886 30599.9n 0.4886 30600.0n 0.4886 30899.9n 0.4886 30900.0n 0.4886 31199.9n 0.4886 31200.0n 0.4886 31499.9n 0.4886 31500.0n 0.4886 31799.9n 0.4886 31800.0n 0.4886 32099.9n 0.4886 32100.0n 0.4886 32399.9n 0.4886 32400.0n 0.4886 32699.9n 0.4886 32700.0n 0.4886 32999.9n 0.4886 33000.0n 0.4886 33299.9n 0.4886 33300.0n 0.4886 33599.9n 0.4886 33600.0n 0.4886 33899.9n 0.4886 33900.0n 0.4886 34199.9n 0.4886 34200.0n 0.4886 34499.9n 0.4886 34500.0n 0.4886 34799.9n 0.4886 34800.0n 0.4886 35099.9n 0.4886 35100.0n 0.4886 35399.9n 0.4886 35400.0n 0.4886 35699.9n 0.4886 35700.0n 0.4886 35999.9n 0.4886 36000.0n 0.4886 36299.9n 0.4886 36300.0n 0.4886 36599.9n 0.4886 36600.0n 0.4886 36899.9n 0.4886 36900.0n 0.4886 37199.9n 0.4886 37200.0n 0.4886 37499.9n 0.4886 37500.0n 0.4886 37799.9n 0.4886 37800.0n 0.4886 38099.9n 0.4886 38100.0n 0.4886 38399.9n 0.4886 38400.0n 0.4886 38699.9n 0.4886 38700.0n 0.4886 38999.9n 0.4886 39000.0n 0.4886 39299.9n 0.4886 39300.0n 0.4886 39599.9n 0.4886 39600.0n 0.4886 39899.9n 0.4886 39900.0n 0.4886 40199.9n 0.4886 40200.0n 0.4886 40499.9n 0.4886 40500.0n 0.4886 40799.9n 0.4886 40800.0n 0.4886 41099.9n 0.4886 41100.0n 0.4886 41399.9n 0.4886 41400.0n 0.4886 41699.9n 0.4886 41700.0n 0.4886 41999.9n 0.4886 42000.0n 0.4886 42299.9n 0.4886 42300.0n 0.4886 42599.9n 0.4886 42600.0n 0.4886 42899.9n 0.4886 42900.0n 0.4886 43199.9n 0.4886 43200.0n 0.4886 43499.9n 0.4886 43500.0n 0.4886 43799.9n 0.4886 43800.0n 0.4886 44099.9n 0.4886 44100.0n 0.4886 44399.9n 0.4886 44400.0n 0.4886 44699.9n 0.4886 44700.0n 0.4886 44999.9n 0.4886 45000.0n 0.4886 45299.9n 0.4886 45300.0n 0.4886 45599.9n 0.4886 45600.0n 0.4886 45899.9n 0.4886 45900.0n 0.4886 46199.9n 0.4886 46200.0n 0.4886 46499.9n 0.4886 46500.0n 0.4886 46799.9n 0.4886 46800.0n 0.4886 47099.9n 0.4886 47100.0n 0.4886 47399.9n 0.4886 47400.0n 0.4886 47699.9n 0.4886 47700.0n 0.4886 47999.9n 0.4886 48000.0n 0.4886 48299.9n 0.4886 48300.0n 0.4886 48599.9n 0.4886 48600.0n 0.4886 48899.9n 0.4886 48900.0n 0.4886 49199.9n 0.4886 49200.0n 0.4886 49499.9n 0.4886 49500.0n 0.4886 49799.9n 0.4886 49800.0n 0.4886 50099.9n 0.4886 50100.0n 0.4886 50399.9n 0.4886 50400.0n 0.4886 50699.9n 0.4886 50700.0n 0.4886 50999.9n 0.4886 51000.0n 0.4886 51299.9n 0.4886 51300.0n 0.4886 51599.9n 0.4886 51600.0n 0.4886 51899.9n 0.4886 51900.0n 0.4886 52199.9n 0.4886 52200.0n 0.4886 52499.9n 0.4886 52500.0n 0.4886 52799.9n 0.4886 52800.0n 0.4886 53099.9n 0.4886 53100.0n 0.4886 53399.9n 0.4886 53400.0n 0.4886 53699.9n 0.4886 53700.0n 0.4886 53999.9n 0.4886 54000.0n 0.4886 54299.9n 0.4886 54300.0n 0.4886 54599.9n 0.4886 54600.0n 0.4886 54899.9n 0.4886 54900.0n 0.4886 55199.9n 0.4886 55200.0n 0.4886 55499.9n 0.4886 55500.0n 0.4886 55799.9n 0.4886 55800.0n 0.4886 56099.9n 0.4886 56100.0n 0.4886 56399.9n 0.4886 56400.0n 0.4886 56699.9n 0.4886 56700.0n 0.4886 56999.9n 0.4886 57000.0n 0.4886 57299.9n 0.4886 57300.0n 0.4886 57599.9n 0.4886 57600.0n 0.4886 57899.9n 0.4886 57900.0n 0.4886 58199.9n 0.4886 58200.0n 0.4886 58499.9n 0.4886 58500.0n 0.4886 58799.9n 0.4886 58800.0n 0.4886 59099.9n 0.4886 59100.0n 0.4886)
Vxn23 a_xn23 0 PWL(0.0n 0.5114 299.9n 0.5114 300.0n 0.5114 599.9n 0.5114 600.0n 0.5114 899.9n 0.5114 900.0n 0.5114 1199.9n 0.5114 1200.0n 0.5114 1499.9n 0.5114 1500.0n 0.5114 1799.9n 0.5114 1800.0n 0.5114 2099.9n 0.5114 2100.0n 0.5114 2399.9n 0.5114 2400.0n 0.5114 2699.9n 0.5114 2700.0n 0.5114 2999.9n 0.5114 3000.0n 0.5114 3299.9n 0.5114 3300.0n 0.5114 3599.9n 0.5114 3600.0n 0.5114 3899.9n 0.5114 3900.0n 0.5114 4199.9n 0.5114 4200.0n 0.5114 4499.9n 0.5114 4500.0n 0.5114 4799.9n 0.5114 4800.0n 0.5114 5099.9n 0.5114 5100.0n 0.5114 5399.9n 0.5114 5400.0n 0.5114 5699.9n 0.5114 5700.0n 0.5114 5999.9n 0.5114 6000.0n 0.5114 6299.9n 0.5114 6300.0n 0.5114 6599.9n 0.5114 6600.0n 0.5114 6899.9n 0.5114 6900.0n 0.5114 7199.9n 0.5114 7200.0n 0.5114 7499.9n 0.5114 7500.0n 0.5114 7799.9n 0.5114 7800.0n 0.5114 8099.9n 0.5114 8100.0n 0.5114 8399.9n 0.5114 8400.0n 0.5114 8699.9n 0.5114 8700.0n 0.5114 8999.9n 0.5114 9000.0n 0.5114 9299.9n 0.5114 9300.0n 0.5114 9599.9n 0.5114 9600.0n 0.5114 9899.9n 0.5114 9900.0n 0.5114 10199.9n 0.5114 10200.0n 0.5114 10499.9n 0.5114 10500.0n 0.5114 10799.9n 0.5114 10800.0n 0.5114 11099.9n 0.5114 11100.0n 0.5114 11399.9n 0.5114 11400.0n 0.5114 11699.9n 0.5114 11700.0n 0.5114 11999.9n 0.5114 12000.0n 0.5114 12299.9n 0.5114 12300.0n 0.5114 12599.9n 0.5114 12600.0n 0.5114 12899.9n 0.5114 12900.0n 0.5114 13199.9n 0.5114 13200.0n 0.5114 13499.9n 0.5114 13500.0n 0.5114 13799.9n 0.5114 13800.0n 0.5114 14099.9n 0.5114 14100.0n 0.5114 14399.9n 0.5114 14400.0n 0.5114 14699.9n 0.5114 14700.0n 0.5114 14999.9n 0.5114 15000.0n 0.5114 15299.9n 0.5114 15300.0n 0.5114 15599.9n 0.5114 15600.0n 0.5114 15899.9n 0.5114 15900.0n 0.5114 16199.9n 0.5114 16200.0n 0.5114 16499.9n 0.5114 16500.0n 0.5114 16799.9n 0.5114 16800.0n 0.5114 17099.9n 0.5114 17100.0n 0.5114 17399.9n 0.5114 17400.0n 0.5114 17699.9n 0.5114 17700.0n 0.5114 17999.9n 0.5114 18000.0n 0.5114 18299.9n 0.5114 18300.0n 0.5114 18599.9n 0.5114 18600.0n 0.5114 18899.9n 0.5114 18900.0n 0.5114 19199.9n 0.5114 19200.0n 0.5114 19499.9n 0.5114 19500.0n 0.5114 19799.9n 0.5114 19800.0n 0.5114 20099.9n 0.5114 20100.0n 0.5114 20399.9n 0.5114 20400.0n 0.5114 20699.9n 0.5114 20700.0n 0.5114 20999.9n 0.5114 21000.0n 0.5114 21299.9n 0.5114 21300.0n 0.5114 21599.9n 0.5114 21600.0n 0.5114 21899.9n 0.5114 21900.0n 0.5114 22199.9n 0.5114 22200.0n 0.5114 22499.9n 0.5114 22500.0n 0.5114 22799.9n 0.5114 22800.0n 0.5114 23099.9n 0.5114 23100.0n 0.5114 23399.9n 0.5114 23400.0n 0.5114 23699.9n 0.5114 23700.0n 0.5114 23999.9n 0.5114 24000.0n 0.5114 24299.9n 0.5114 24300.0n 0.5114 24599.9n 0.5114 24600.0n 0.5114 24899.9n 0.5114 24900.0n 0.5114 25199.9n 0.5114 25200.0n 0.5114 25499.9n 0.5114 25500.0n 0.5114 25799.9n 0.5114 25800.0n 0.5114 26099.9n 0.5114 26100.0n 0.5114 26399.9n 0.5114 26400.0n 0.5114 26699.9n 0.5114 26700.0n 0.5114 26999.9n 0.5114 27000.0n 0.5114 27299.9n 0.5114 27300.0n 0.5114 27599.9n 0.5114 27600.0n 0.5114 27899.9n 0.5114 27900.0n 0.5114 28199.9n 0.5114 28200.0n 0.5114 28499.9n 0.5114 28500.0n 0.5114 28799.9n 0.5114 28800.0n 0.5114 29099.9n 0.5114 29100.0n 0.5114 29399.9n 0.5114 29400.0n 0.5114 29699.9n 0.5114 29700.0n 0.5114 29999.9n 0.5114 30000.0n 0.5114 30299.9n 0.5114 30300.0n 0.5114 30599.9n 0.5114 30600.0n 0.5114 30899.9n 0.5114 30900.0n 0.5114 31199.9n 0.5114 31200.0n 0.5114 31499.9n 0.5114 31500.0n 0.5114 31799.9n 0.5114 31800.0n 0.5114 32099.9n 0.5114 32100.0n 0.5114 32399.9n 0.5114 32400.0n 0.5114 32699.9n 0.5114 32700.0n 0.5114 32999.9n 0.5114 33000.0n 0.5114 33299.9n 0.5114 33300.0n 0.5114 33599.9n 0.5114 33600.0n 0.5114 33899.9n 0.5114 33900.0n 0.5114 34199.9n 0.5114 34200.0n 0.5114 34499.9n 0.5114 34500.0n 0.5114 34799.9n 0.5114 34800.0n 0.5114 35099.9n 0.5114 35100.0n 0.5114 35399.9n 0.5114 35400.0n 0.5114 35699.9n 0.5114 35700.0n 0.5114 35999.9n 0.5114 36000.0n 0.5114 36299.9n 0.5114 36300.0n 0.5114 36599.9n 0.5114 36600.0n 0.5114 36899.9n 0.5114 36900.0n 0.5114 37199.9n 0.5114 37200.0n 0.5114 37499.9n 0.5114 37500.0n 0.5114 37799.9n 0.5114 37800.0n 0.5114 38099.9n 0.5114 38100.0n 0.5114 38399.9n 0.5114 38400.0n 0.5114 38699.9n 0.5114 38700.0n 0.5114 38999.9n 0.5114 39000.0n 0.5114 39299.9n 0.5114 39300.0n 0.5114 39599.9n 0.5114 39600.0n 0.5114 39899.9n 0.5114 39900.0n 0.5114 40199.9n 0.5114 40200.0n 0.5114 40499.9n 0.5114 40500.0n 0.5114 40799.9n 0.5114 40800.0n 0.5114 41099.9n 0.5114 41100.0n 0.5114 41399.9n 0.5114 41400.0n 0.5114 41699.9n 0.5114 41700.0n 0.5114 41999.9n 0.5114 42000.0n 0.5114 42299.9n 0.5114 42300.0n 0.5114 42599.9n 0.5114 42600.0n 0.5114 42899.9n 0.5114 42900.0n 0.5114 43199.9n 0.5114 43200.0n 0.5114 43499.9n 0.5114 43500.0n 0.5114 43799.9n 0.5114 43800.0n 0.5114 44099.9n 0.5114 44100.0n 0.5114 44399.9n 0.5114 44400.0n 0.5114 44699.9n 0.5114 44700.0n 0.5114 44999.9n 0.5114 45000.0n 0.5114 45299.9n 0.5114 45300.0n 0.5114 45599.9n 0.5114 45600.0n 0.5114 45899.9n 0.5114 45900.0n 0.5114 46199.9n 0.5114 46200.0n 0.5114 46499.9n 0.5114 46500.0n 0.5114 46799.9n 0.5114 46800.0n 0.5114 47099.9n 0.5114 47100.0n 0.5114 47399.9n 0.5114 47400.0n 0.5114 47699.9n 0.5114 47700.0n 0.5114 47999.9n 0.5114 48000.0n 0.5114 48299.9n 0.5114 48300.0n 0.5114 48599.9n 0.5114 48600.0n 0.5114 48899.9n 0.5114 48900.0n 0.5114 49199.9n 0.5114 49200.0n 0.5114 49499.9n 0.5114 49500.0n 0.5114 49799.9n 0.5114 49800.0n 0.5114 50099.9n 0.5114 50100.0n 0.5114 50399.9n 0.5114 50400.0n 0.5114 50699.9n 0.5114 50700.0n 0.5114 50999.9n 0.5114 51000.0n 0.5114 51299.9n 0.5114 51300.0n 0.5114 51599.9n 0.5114 51600.0n 0.5114 51899.9n 0.5114 51900.0n 0.5114 52199.9n 0.5114 52200.0n 0.5114 52499.9n 0.5114 52500.0n 0.5114 52799.9n 0.5114 52800.0n 0.5114 53099.9n 0.5114 53100.0n 0.5114 53399.9n 0.5114 53400.0n 0.5114 53699.9n 0.5114 53700.0n 0.5114 53999.9n 0.5114 54000.0n 0.5114 54299.9n 0.5114 54300.0n 0.5114 54599.9n 0.5114 54600.0n 0.5114 54899.9n 0.5114 54900.0n 0.5114 55199.9n 0.5114 55200.0n 0.5114 55499.9n 0.5114 55500.0n 0.5114 55799.9n 0.5114 55800.0n 0.5114 56099.9n 0.5114 56100.0n 0.5114 56399.9n 0.5114 56400.0n 0.5114 56699.9n 0.5114 56700.0n 0.5114 56999.9n 0.5114 57000.0n 0.5114 57299.9n 0.5114 57300.0n 0.5114 57599.9n 0.5114 57600.0n 0.5114 57899.9n 0.5114 57900.0n 0.5114 58199.9n 0.5114 58200.0n 0.5114 58499.9n 0.5114 58500.0n 0.5114 58799.9n 0.5114 58800.0n 0.5114 59099.9n 0.5114 59100.0n 0.5114)
Vxp24 a_xp24 0 PWL(0.0n 0.4967 299.9n 0.4967 300.0n 0.4967 599.9n 0.4967 600.0n 0.4967 899.9n 0.4967 900.0n 0.4967 1199.9n 0.4967 1200.0n 0.4967 1499.9n 0.4967 1500.0n 0.4967 1799.9n 0.4967 1800.0n 0.4967 2099.9n 0.4967 2100.0n 0.4967 2399.9n 0.4967 2400.0n 0.4967 2699.9n 0.4967 2700.0n 0.4967 2999.9n 0.4967 3000.0n 0.4967 3299.9n 0.4967 3300.0n 0.4967 3599.9n 0.4967 3600.0n 0.4967 3899.9n 0.4967 3900.0n 0.4967 4199.9n 0.4967 4200.0n 0.4967 4499.9n 0.4967 4500.0n 0.4967 4799.9n 0.4967 4800.0n 0.4967 5099.9n 0.4967 5100.0n 0.4967 5399.9n 0.4967 5400.0n 0.4967 5699.9n 0.4967 5700.0n 0.4967 5999.9n 0.4967 6000.0n 0.4967 6299.9n 0.4967 6300.0n 0.4967 6599.9n 0.4967 6600.0n 0.4967 6899.9n 0.4967 6900.0n 0.4967 7199.9n 0.4967 7200.0n 0.4967 7499.9n 0.4967 7500.0n 0.4967 7799.9n 0.4967 7800.0n 0.4967 8099.9n 0.4967 8100.0n 0.4967 8399.9n 0.4967 8400.0n 0.4967 8699.9n 0.4967 8700.0n 0.4967 8999.9n 0.4967 9000.0n 0.4967 9299.9n 0.4967 9300.0n 0.4967 9599.9n 0.4967 9600.0n 0.4967 9899.9n 0.4967 9900.0n 0.4967 10199.9n 0.4967 10200.0n 0.4967 10499.9n 0.4967 10500.0n 0.4967 10799.9n 0.4967 10800.0n 0.4967 11099.9n 0.4967 11100.0n 0.4967 11399.9n 0.4967 11400.0n 0.4967 11699.9n 0.4967 11700.0n 0.4967 11999.9n 0.4967 12000.0n 0.4967 12299.9n 0.4967 12300.0n 0.4967 12599.9n 0.4967 12600.0n 0.4967 12899.9n 0.4967 12900.0n 0.4967 13199.9n 0.4967 13200.0n 0.4967 13499.9n 0.4967 13500.0n 0.4967 13799.9n 0.4967 13800.0n 0.4967 14099.9n 0.4967 14100.0n 0.4967 14399.9n 0.4967 14400.0n 0.4967 14699.9n 0.4967 14700.0n 0.4967 14999.9n 0.4967 15000.0n 0.4967 15299.9n 0.4967 15300.0n 0.4967 15599.9n 0.4967 15600.0n 0.4967 15899.9n 0.4967 15900.0n 0.4967 16199.9n 0.4967 16200.0n 0.4967 16499.9n 0.4967 16500.0n 0.4967 16799.9n 0.4967 16800.0n 0.4967 17099.9n 0.4967 17100.0n 0.4967 17399.9n 0.4967 17400.0n 0.4967 17699.9n 0.4967 17700.0n 0.4967 17999.9n 0.4967 18000.0n 0.4967 18299.9n 0.4967 18300.0n 0.4967 18599.9n 0.4967 18600.0n 0.4967 18899.9n 0.4967 18900.0n 0.4967 19199.9n 0.4967 19200.0n 0.4967 19499.9n 0.4967 19500.0n 0.4967 19799.9n 0.4967 19800.0n 0.4967 20099.9n 0.4967 20100.0n 0.4967 20399.9n 0.4967 20400.0n 0.4967 20699.9n 0.4967 20700.0n 0.4967 20999.9n 0.4967 21000.0n 0.4967 21299.9n 0.4967 21300.0n 0.4967 21599.9n 0.4967 21600.0n 0.4967 21899.9n 0.4967 21900.0n 0.4967 22199.9n 0.4967 22200.0n 0.4967 22499.9n 0.4967 22500.0n 0.4967 22799.9n 0.4967 22800.0n 0.4967 23099.9n 0.4967 23100.0n 0.4967 23399.9n 0.4967 23400.0n 0.4967 23699.9n 0.4967 23700.0n 0.4967 23999.9n 0.4967 24000.0n 0.4967 24299.9n 0.4967 24300.0n 0.4967 24599.9n 0.4967 24600.0n 0.4967 24899.9n 0.4967 24900.0n 0.4967 25199.9n 0.4967 25200.0n 0.4967 25499.9n 0.4967 25500.0n 0.4967 25799.9n 0.4967 25800.0n 0.4967 26099.9n 0.4967 26100.0n 0.4967 26399.9n 0.4967 26400.0n 0.4967 26699.9n 0.4967 26700.0n 0.4967 26999.9n 0.4967 27000.0n 0.4967 27299.9n 0.4967 27300.0n 0.4967 27599.9n 0.4967 27600.0n 0.4967 27899.9n 0.4967 27900.0n 0.4967 28199.9n 0.4967 28200.0n 0.4967 28499.9n 0.4967 28500.0n 0.4967 28799.9n 0.4967 28800.0n 0.4967 29099.9n 0.4967 29100.0n 0.4967 29399.9n 0.4967 29400.0n 0.4967 29699.9n 0.4967 29700.0n 0.4967 29999.9n 0.4967 30000.0n 0.4967 30299.9n 0.4967 30300.0n 0.4967 30599.9n 0.4967 30600.0n 0.4967 30899.9n 0.4967 30900.0n 0.4967 31199.9n 0.4967 31200.0n 0.4967 31499.9n 0.4967 31500.0n 0.4967 31799.9n 0.4967 31800.0n 0.4967 32099.9n 0.4967 32100.0n 0.4967 32399.9n 0.4967 32400.0n 0.4967 32699.9n 0.4967 32700.0n 0.4967 32999.9n 0.4967 33000.0n 0.4967 33299.9n 0.4967 33300.0n 0.4967 33599.9n 0.4967 33600.0n 0.4967 33899.9n 0.4967 33900.0n 0.4967 34199.9n 0.4967 34200.0n 0.4967 34499.9n 0.4967 34500.0n 0.4967 34799.9n 0.4967 34800.0n 0.4967 35099.9n 0.4967 35100.0n 0.4967 35399.9n 0.4967 35400.0n 0.4967 35699.9n 0.4967 35700.0n 0.4967 35999.9n 0.4967 36000.0n 0.4967 36299.9n 0.4967 36300.0n 0.4967 36599.9n 0.4967 36600.0n 0.4967 36899.9n 0.4967 36900.0n 0.4967 37199.9n 0.4967 37200.0n 0.4967 37499.9n 0.4967 37500.0n 0.4967 37799.9n 0.4967 37800.0n 0.4967 38099.9n 0.4967 38100.0n 0.4967 38399.9n 0.4967 38400.0n 0.4967 38699.9n 0.4967 38700.0n 0.4967 38999.9n 0.4967 39000.0n 0.4967 39299.9n 0.4967 39300.0n 0.4967 39599.9n 0.4967 39600.0n 0.4967 39899.9n 0.4967 39900.0n 0.4967 40199.9n 0.4967 40200.0n 0.4967 40499.9n 0.4967 40500.0n 0.4967 40799.9n 0.4967 40800.0n 0.4967 41099.9n 0.4967 41100.0n 0.4967 41399.9n 0.4967 41400.0n 0.4967 41699.9n 0.4967 41700.0n 0.4967 41999.9n 0.4967 42000.0n 0.4967 42299.9n 0.4967 42300.0n 0.4967 42599.9n 0.4967 42600.0n 0.4967 42899.9n 0.4967 42900.0n 0.4967 43199.9n 0.4967 43200.0n 0.4967 43499.9n 0.4967 43500.0n 0.4967 43799.9n 0.4967 43800.0n 0.4967 44099.9n 0.4967 44100.0n 0.4967 44399.9n 0.4967 44400.0n 0.4967 44699.9n 0.4967 44700.0n 0.4967 44999.9n 0.4967 45000.0n 0.4967 45299.9n 0.4967 45300.0n 0.4967 45599.9n 0.4967 45600.0n 0.4967 45899.9n 0.4967 45900.0n 0.4967 46199.9n 0.4967 46200.0n 0.4967 46499.9n 0.4967 46500.0n 0.4967 46799.9n 0.4967 46800.0n 0.4967 47099.9n 0.4967 47100.0n 0.4967 47399.9n 0.4967 47400.0n 0.4967 47699.9n 0.4967 47700.0n 0.4967 47999.9n 0.4967 48000.0n 0.4967 48299.9n 0.4967 48300.0n 0.4967 48599.9n 0.4967 48600.0n 0.4967 48899.9n 0.4967 48900.0n 0.4967 49199.9n 0.4967 49200.0n 0.4967 49499.9n 0.4967 49500.0n 0.4967 49799.9n 0.4967 49800.0n 0.4967 50099.9n 0.4967 50100.0n 0.4967 50399.9n 0.4967 50400.0n 0.4967 50699.9n 0.4967 50700.0n 0.4967 50999.9n 0.4967 51000.0n 0.4967 51299.9n 0.4967 51300.0n 0.4967 51599.9n 0.4967 51600.0n 0.4967 51899.9n 0.4967 51900.0n 0.4967 52199.9n 0.4967 52200.0n 0.4967 52499.9n 0.4967 52500.0n 0.4967 52799.9n 0.4967 52800.0n 0.4967 53099.9n 0.4967 53100.0n 0.4967 53399.9n 0.4967 53400.0n 0.4967 53699.9n 0.4967 53700.0n 0.4967 53999.9n 0.4967 54000.0n 0.4967 54299.9n 0.4967 54300.0n 0.4967 54599.9n 0.4967 54600.0n 0.4967 54899.9n 0.4967 54900.0n 0.4967 55199.9n 0.4967 55200.0n 0.4967 55499.9n 0.4967 55500.0n 0.4967 55799.9n 0.4967 55800.0n 0.4967 56099.9n 0.4967 56100.0n 0.4967 56399.9n 0.4967 56400.0n 0.4967 56699.9n 0.4967 56700.0n 0.4967 56999.9n 0.4967 57000.0n 0.4967 57299.9n 0.4967 57300.0n 0.4967 57599.9n 0.4967 57600.0n 0.4967 57899.9n 0.4967 57900.0n 0.4967 58199.9n 0.4967 58200.0n 0.4967 58499.9n 0.4967 58500.0n 0.4967 58799.9n 0.4967 58800.0n 0.4967 59099.9n 0.4967 59100.0n 0.4967)
Vxn24 a_xn24 0 PWL(0.0n 0.5033 299.9n 0.5033 300.0n 0.5033 599.9n 0.5033 600.0n 0.5033 899.9n 0.5033 900.0n 0.5033 1199.9n 0.5033 1200.0n 0.5033 1499.9n 0.5033 1500.0n 0.5033 1799.9n 0.5033 1800.0n 0.5033 2099.9n 0.5033 2100.0n 0.5033 2399.9n 0.5033 2400.0n 0.5033 2699.9n 0.5033 2700.0n 0.5033 2999.9n 0.5033 3000.0n 0.5033 3299.9n 0.5033 3300.0n 0.5033 3599.9n 0.5033 3600.0n 0.5033 3899.9n 0.5033 3900.0n 0.5033 4199.9n 0.5033 4200.0n 0.5033 4499.9n 0.5033 4500.0n 0.5033 4799.9n 0.5033 4800.0n 0.5033 5099.9n 0.5033 5100.0n 0.5033 5399.9n 0.5033 5400.0n 0.5033 5699.9n 0.5033 5700.0n 0.5033 5999.9n 0.5033 6000.0n 0.5033 6299.9n 0.5033 6300.0n 0.5033 6599.9n 0.5033 6600.0n 0.5033 6899.9n 0.5033 6900.0n 0.5033 7199.9n 0.5033 7200.0n 0.5033 7499.9n 0.5033 7500.0n 0.5033 7799.9n 0.5033 7800.0n 0.5033 8099.9n 0.5033 8100.0n 0.5033 8399.9n 0.5033 8400.0n 0.5033 8699.9n 0.5033 8700.0n 0.5033 8999.9n 0.5033 9000.0n 0.5033 9299.9n 0.5033 9300.0n 0.5033 9599.9n 0.5033 9600.0n 0.5033 9899.9n 0.5033 9900.0n 0.5033 10199.9n 0.5033 10200.0n 0.5033 10499.9n 0.5033 10500.0n 0.5033 10799.9n 0.5033 10800.0n 0.5033 11099.9n 0.5033 11100.0n 0.5033 11399.9n 0.5033 11400.0n 0.5033 11699.9n 0.5033 11700.0n 0.5033 11999.9n 0.5033 12000.0n 0.5033 12299.9n 0.5033 12300.0n 0.5033 12599.9n 0.5033 12600.0n 0.5033 12899.9n 0.5033 12900.0n 0.5033 13199.9n 0.5033 13200.0n 0.5033 13499.9n 0.5033 13500.0n 0.5033 13799.9n 0.5033 13800.0n 0.5033 14099.9n 0.5033 14100.0n 0.5033 14399.9n 0.5033 14400.0n 0.5033 14699.9n 0.5033 14700.0n 0.5033 14999.9n 0.5033 15000.0n 0.5033 15299.9n 0.5033 15300.0n 0.5033 15599.9n 0.5033 15600.0n 0.5033 15899.9n 0.5033 15900.0n 0.5033 16199.9n 0.5033 16200.0n 0.5033 16499.9n 0.5033 16500.0n 0.5033 16799.9n 0.5033 16800.0n 0.5033 17099.9n 0.5033 17100.0n 0.5033 17399.9n 0.5033 17400.0n 0.5033 17699.9n 0.5033 17700.0n 0.5033 17999.9n 0.5033 18000.0n 0.5033 18299.9n 0.5033 18300.0n 0.5033 18599.9n 0.5033 18600.0n 0.5033 18899.9n 0.5033 18900.0n 0.5033 19199.9n 0.5033 19200.0n 0.5033 19499.9n 0.5033 19500.0n 0.5033 19799.9n 0.5033 19800.0n 0.5033 20099.9n 0.5033 20100.0n 0.5033 20399.9n 0.5033 20400.0n 0.5033 20699.9n 0.5033 20700.0n 0.5033 20999.9n 0.5033 21000.0n 0.5033 21299.9n 0.5033 21300.0n 0.5033 21599.9n 0.5033 21600.0n 0.5033 21899.9n 0.5033 21900.0n 0.5033 22199.9n 0.5033 22200.0n 0.5033 22499.9n 0.5033 22500.0n 0.5033 22799.9n 0.5033 22800.0n 0.5033 23099.9n 0.5033 23100.0n 0.5033 23399.9n 0.5033 23400.0n 0.5033 23699.9n 0.5033 23700.0n 0.5033 23999.9n 0.5033 24000.0n 0.5033 24299.9n 0.5033 24300.0n 0.5033 24599.9n 0.5033 24600.0n 0.5033 24899.9n 0.5033 24900.0n 0.5033 25199.9n 0.5033 25200.0n 0.5033 25499.9n 0.5033 25500.0n 0.5033 25799.9n 0.5033 25800.0n 0.5033 26099.9n 0.5033 26100.0n 0.5033 26399.9n 0.5033 26400.0n 0.5033 26699.9n 0.5033 26700.0n 0.5033 26999.9n 0.5033 27000.0n 0.5033 27299.9n 0.5033 27300.0n 0.5033 27599.9n 0.5033 27600.0n 0.5033 27899.9n 0.5033 27900.0n 0.5033 28199.9n 0.5033 28200.0n 0.5033 28499.9n 0.5033 28500.0n 0.5033 28799.9n 0.5033 28800.0n 0.5033 29099.9n 0.5033 29100.0n 0.5033 29399.9n 0.5033 29400.0n 0.5033 29699.9n 0.5033 29700.0n 0.5033 29999.9n 0.5033 30000.0n 0.5033 30299.9n 0.5033 30300.0n 0.5033 30599.9n 0.5033 30600.0n 0.5033 30899.9n 0.5033 30900.0n 0.5033 31199.9n 0.5033 31200.0n 0.5033 31499.9n 0.5033 31500.0n 0.5033 31799.9n 0.5033 31800.0n 0.5033 32099.9n 0.5033 32100.0n 0.5033 32399.9n 0.5033 32400.0n 0.5033 32699.9n 0.5033 32700.0n 0.5033 32999.9n 0.5033 33000.0n 0.5033 33299.9n 0.5033 33300.0n 0.5033 33599.9n 0.5033 33600.0n 0.5033 33899.9n 0.5033 33900.0n 0.5033 34199.9n 0.5033 34200.0n 0.5033 34499.9n 0.5033 34500.0n 0.5033 34799.9n 0.5033 34800.0n 0.5033 35099.9n 0.5033 35100.0n 0.5033 35399.9n 0.5033 35400.0n 0.5033 35699.9n 0.5033 35700.0n 0.5033 35999.9n 0.5033 36000.0n 0.5033 36299.9n 0.5033 36300.0n 0.5033 36599.9n 0.5033 36600.0n 0.5033 36899.9n 0.5033 36900.0n 0.5033 37199.9n 0.5033 37200.0n 0.5033 37499.9n 0.5033 37500.0n 0.5033 37799.9n 0.5033 37800.0n 0.5033 38099.9n 0.5033 38100.0n 0.5033 38399.9n 0.5033 38400.0n 0.5033 38699.9n 0.5033 38700.0n 0.5033 38999.9n 0.5033 39000.0n 0.5033 39299.9n 0.5033 39300.0n 0.5033 39599.9n 0.5033 39600.0n 0.5033 39899.9n 0.5033 39900.0n 0.5033 40199.9n 0.5033 40200.0n 0.5033 40499.9n 0.5033 40500.0n 0.5033 40799.9n 0.5033 40800.0n 0.5033 41099.9n 0.5033 41100.0n 0.5033 41399.9n 0.5033 41400.0n 0.5033 41699.9n 0.5033 41700.0n 0.5033 41999.9n 0.5033 42000.0n 0.5033 42299.9n 0.5033 42300.0n 0.5033 42599.9n 0.5033 42600.0n 0.5033 42899.9n 0.5033 42900.0n 0.5033 43199.9n 0.5033 43200.0n 0.5033 43499.9n 0.5033 43500.0n 0.5033 43799.9n 0.5033 43800.0n 0.5033 44099.9n 0.5033 44100.0n 0.5033 44399.9n 0.5033 44400.0n 0.5033 44699.9n 0.5033 44700.0n 0.5033 44999.9n 0.5033 45000.0n 0.5033 45299.9n 0.5033 45300.0n 0.5033 45599.9n 0.5033 45600.0n 0.5033 45899.9n 0.5033 45900.0n 0.5033 46199.9n 0.5033 46200.0n 0.5033 46499.9n 0.5033 46500.0n 0.5033 46799.9n 0.5033 46800.0n 0.5033 47099.9n 0.5033 47100.0n 0.5033 47399.9n 0.5033 47400.0n 0.5033 47699.9n 0.5033 47700.0n 0.5033 47999.9n 0.5033 48000.0n 0.5033 48299.9n 0.5033 48300.0n 0.5033 48599.9n 0.5033 48600.0n 0.5033 48899.9n 0.5033 48900.0n 0.5033 49199.9n 0.5033 49200.0n 0.5033 49499.9n 0.5033 49500.0n 0.5033 49799.9n 0.5033 49800.0n 0.5033 50099.9n 0.5033 50100.0n 0.5033 50399.9n 0.5033 50400.0n 0.5033 50699.9n 0.5033 50700.0n 0.5033 50999.9n 0.5033 51000.0n 0.5033 51299.9n 0.5033 51300.0n 0.5033 51599.9n 0.5033 51600.0n 0.5033 51899.9n 0.5033 51900.0n 0.5033 52199.9n 0.5033 52200.0n 0.5033 52499.9n 0.5033 52500.0n 0.5033 52799.9n 0.5033 52800.0n 0.5033 53099.9n 0.5033 53100.0n 0.5033 53399.9n 0.5033 53400.0n 0.5033 53699.9n 0.5033 53700.0n 0.5033 53999.9n 0.5033 54000.0n 0.5033 54299.9n 0.5033 54300.0n 0.5033 54599.9n 0.5033 54600.0n 0.5033 54899.9n 0.5033 54900.0n 0.5033 55199.9n 0.5033 55200.0n 0.5033 55499.9n 0.5033 55500.0n 0.5033 55799.9n 0.5033 55800.0n 0.5033 56099.9n 0.5033 56100.0n 0.5033 56399.9n 0.5033 56400.0n 0.5033 56699.9n 0.5033 56700.0n 0.5033 56999.9n 0.5033 57000.0n 0.5033 57299.9n 0.5033 57300.0n 0.5033 57599.9n 0.5033 57600.0n 0.5033 57899.9n 0.5033 57900.0n 0.5033 58199.9n 0.5033 58200.0n 0.5033 58499.9n 0.5033 58500.0n 0.5033 58799.9n 0.5033 58800.0n 0.5033 59099.9n 0.5033 59100.0n 0.5033)
Vxp25 a_xp25 0 PWL(0.0n 0.5804 299.9n 0.5804 300.0n 0.5169 599.9n 0.5169 600.0n 0.6758 899.9n 0.6758 900.0n 0.4851 1199.9n 0.4851 1200.0n 0.5486 1499.9n 0.5486 1500.0n 0.5169 1799.9n 0.5169 1800.0n 0.5804 2099.9n 0.5804 2100.0n 0.5486 2399.9n 0.5486 2400.0n 0.4215 2699.9n 0.4215 2700.0n 0.4215 2999.9n 0.4215 3000.0n 0.4533 3299.9n 0.4533 3300.0n 0.4215 3599.9n 0.4215 3600.0n 0.8000 3899.9n 0.8000 3900.0n 0.4215 4199.9n 0.4215 4200.0n 0.4215 4499.9n 0.4215 4500.0n 0.4215 4799.9n 0.4215 4800.0n 0.4533 5099.9n 0.4533 5100.0n 0.4215 5399.9n 0.4215 5400.0n 0.5804 5699.9n 0.5804 5700.0n 0.5169 5999.9n 0.5169 6000.0n 0.6758 6299.9n 0.6758 6300.0n 0.4851 6599.9n 0.4851 6600.0n 0.5486 6899.9n 0.5486 6900.0n 0.5169 7199.9n 0.5169 7200.0n 0.5804 7499.9n 0.5804 7500.0n 0.5486 7799.9n 0.5486 7800.0n 0.4215 8099.9n 0.4215 8100.0n 0.4215 8399.9n 0.4215 8400.0n 0.4533 8699.9n 0.4533 8700.0n 0.4215 8999.9n 0.4215 9000.0n 0.8000 9299.9n 0.8000 9300.0n 0.4215 9599.9n 0.4215 9600.0n 0.4215 9899.9n 0.4215 9900.0n 0.4215 10199.9n 0.4215 10200.0n 0.4533 10499.9n 0.4533 10500.0n 0.4215 10799.9n 0.4215 10800.0n 0.5804 11099.9n 0.5804 11100.0n 0.5169 11399.9n 0.5169 11400.0n 0.6758 11699.9n 0.6758 11700.0n 0.4851 11999.9n 0.4851 12000.0n 0.5486 12299.9n 0.5486 12300.0n 0.5169 12599.9n 0.5169 12600.0n 0.5804 12899.9n 0.5804 12900.0n 0.5486 13199.9n 0.5486 13200.0n 0.4215 13499.9n 0.4215 13500.0n 0.4215 13799.9n 0.4215 13800.0n 0.4533 14099.9n 0.4533 14100.0n 0.4215 14399.9n 0.4215 14400.0n 0.8000 14699.9n 0.8000 14700.0n 0.4215 14999.9n 0.4215 15000.0n 0.4215 15299.9n 0.4215 15300.0n 0.4215 15599.9n 0.4215 15600.0n 0.4533 15899.9n 0.4533 15900.0n 0.4215 16199.9n 0.4215 16200.0n 0.5804 16499.9n 0.5804 16500.0n 0.5169 16799.9n 0.5169 16800.0n 0.6758 17099.9n 0.6758 17100.0n 0.4851 17399.9n 0.4851 17400.0n 0.5486 17699.9n 0.5486 17700.0n 0.5169 17999.9n 0.5169 18000.0n 0.5804 18299.9n 0.5804 18300.0n 0.5486 18599.9n 0.5486 18600.0n 0.4215 18899.9n 0.4215 18900.0n 0.4215 19199.9n 0.4215 19200.0n 0.4533 19499.9n 0.4533 19500.0n 0.4215 19799.9n 0.4215 19800.0n 0.8000 20099.9n 0.8000 20100.0n 0.4215 20399.9n 0.4215 20400.0n 0.4215 20699.9n 0.4215 20700.0n 0.4215 20999.9n 0.4215 21000.0n 0.4533 21299.9n 0.4533 21300.0n 0.4215 21599.9n 0.4215 21600.0n 0.5804 21899.9n 0.5804 21900.0n 0.5169 22199.9n 0.5169 22200.0n 0.6758 22499.9n 0.6758 22500.0n 0.4851 22799.9n 0.4851 22800.0n 0.5486 23099.9n 0.5486 23100.0n 0.5169 23399.9n 0.5169 23400.0n 0.5804 23699.9n 0.5804 23700.0n 0.5486 23999.9n 0.5486 24000.0n 0.4215 24299.9n 0.4215 24300.0n 0.4215 24599.9n 0.4215 24600.0n 0.4533 24899.9n 0.4533 24900.0n 0.4215 25199.9n 0.4215 25200.0n 0.8000 25499.9n 0.8000 25500.0n 0.4215 25799.9n 0.4215 25800.0n 0.4215 26099.9n 0.4215 26100.0n 0.4215 26399.9n 0.4215 26400.0n 0.4533 26699.9n 0.4533 26700.0n 0.4215 26999.9n 0.4215 27000.0n 0.5804 27299.9n 0.5804 27300.0n 0.5169 27599.9n 0.5169 27600.0n 0.6758 27899.9n 0.6758 27900.0n 0.4851 28199.9n 0.4851 28200.0n 0.5486 28499.9n 0.5486 28500.0n 0.5169 28799.9n 0.5169 28800.0n 0.5804 29099.9n 0.5804 29100.0n 0.5486 29399.9n 0.5486 29400.0n 0.4215 29699.9n 0.4215 29700.0n 0.4215 29999.9n 0.4215 30000.0n 0.4533 30299.9n 0.4533 30300.0n 0.4215 30599.9n 0.4215 30600.0n 0.8000 30899.9n 0.8000 30900.0n 0.4215 31199.9n 0.4215 31200.0n 0.4215 31499.9n 0.4215 31500.0n 0.4215 31799.9n 0.4215 31800.0n 0.4533 32099.9n 0.4533 32100.0n 0.4215 32399.9n 0.4215 32400.0n 0.5804 32699.9n 0.5804 32700.0n 0.5169 32999.9n 0.5169 33000.0n 0.6758 33299.9n 0.6758 33300.0n 0.4851 33599.9n 0.4851 33600.0n 0.5486 33899.9n 0.5486 33900.0n 0.5169 34199.9n 0.5169 34200.0n 0.5804 34499.9n 0.5804 34500.0n 0.5486 34799.9n 0.5486 34800.0n 0.4215 35099.9n 0.4215 35100.0n 0.4215 35399.9n 0.4215 35400.0n 0.4533 35699.9n 0.4533 35700.0n 0.4215 35999.9n 0.4215 36000.0n 0.8000 36299.9n 0.8000 36300.0n 0.4215 36599.9n 0.4215 36600.0n 0.4215 36899.9n 0.4215 36900.0n 0.4215 37199.9n 0.4215 37200.0n 0.4533 37499.9n 0.4533 37500.0n 0.4215 37799.9n 0.4215 37800.0n 0.5804 38099.9n 0.5804 38100.0n 0.5169 38399.9n 0.5169 38400.0n 0.6758 38699.9n 0.6758 38700.0n 0.4851 38999.9n 0.4851 39000.0n 0.5486 39299.9n 0.5486 39300.0n 0.5169 39599.9n 0.5169 39600.0n 0.5804 39899.9n 0.5804 39900.0n 0.5486 40199.9n 0.5486 40200.0n 0.4215 40499.9n 0.4215 40500.0n 0.4215 40799.9n 0.4215 40800.0n 0.4533 41099.9n 0.4533 41100.0n 0.4215 41399.9n 0.4215 41400.0n 0.8000 41699.9n 0.8000 41700.0n 0.4215 41999.9n 0.4215 42000.0n 0.4215 42299.9n 0.4215 42300.0n 0.4215 42599.9n 0.4215 42600.0n 0.4533 42899.9n 0.4533 42900.0n 0.4215 43199.9n 0.4215 43200.0n 0.5804 43499.9n 0.5804 43500.0n 0.5169 43799.9n 0.5169 43800.0n 0.6758 44099.9n 0.6758 44100.0n 0.4851 44399.9n 0.4851 44400.0n 0.5486 44699.9n 0.5486 44700.0n 0.5169 44999.9n 0.5169 45000.0n 0.5804 45299.9n 0.5804 45300.0n 0.5486 45599.9n 0.5486 45600.0n 0.4215 45899.9n 0.4215 45900.0n 0.4215 46199.9n 0.4215 46200.0n 0.4533 46499.9n 0.4533 46500.0n 0.4215 46799.9n 0.4215 46800.0n 0.8000 47099.9n 0.8000 47100.0n 0.4215 47399.9n 0.4215 47400.0n 0.4215 47699.9n 0.4215 47700.0n 0.4215 47999.9n 0.4215 48000.0n 0.4533 48299.9n 0.4533 48300.0n 0.4215 48599.9n 0.4215 48600.0n 0.5804 48899.9n 0.5804 48900.0n 0.5169 49199.9n 0.5169 49200.0n 0.6758 49499.9n 0.6758 49500.0n 0.4851 49799.9n 0.4851 49800.0n 0.5486 50099.9n 0.5486 50100.0n 0.5169 50399.9n 0.5169 50400.0n 0.5804 50699.9n 0.5804 50700.0n 0.5486 50999.9n 0.5486 51000.0n 0.4215 51299.9n 0.4215 51300.0n 0.4215 51599.9n 0.4215 51600.0n 0.4533 51899.9n 0.4533 51900.0n 0.4215 52199.9n 0.4215 52200.0n 0.8000 52499.9n 0.8000 52500.0n 0.4215 52799.9n 0.4215 52800.0n 0.4215 53099.9n 0.4215 53100.0n 0.4215 53399.9n 0.4215 53400.0n 0.4533 53699.9n 0.4533 53700.0n 0.4215 53999.9n 0.4215 54000.0n 0.6758 54299.9n 0.6758 54300.0n 0.5486 54599.9n 0.5486 54600.0n 0.5169 54899.9n 0.5169 54900.0n 0.6758 55199.9n 0.6758 55200.0n 0.4851 55499.9n 0.4851 55500.0n 0.5486 55799.9n 0.5486 55800.0n 0.4215 56099.9n 0.4215 56100.0n 0.4215 56399.9n 0.4215 56400.0n 0.4215 56699.9n 0.4215 56700.0n 0.4215 56999.9n 0.4215 57000.0n 0.5486 57299.9n 0.5486 57300.0n 0.4215 57599.9n 0.4215 57600.0n 0.4533 57899.9n 0.4533 57900.0n 0.4215 58199.9n 0.4215 58200.0n 0.5486 58499.9n 0.5486 58500.0n 0.4215 58799.9n 0.4215 58800.0n 0.4215 59099.9n 0.4215 59100.0n 0.4215)
Vxn25 a_xn25 0 PWL(0.0n 0.4196 299.9n 0.4196 300.0n 0.4831 599.9n 0.4831 600.0n 0.3242 899.9n 0.3242 900.0n 0.5149 1199.9n 0.5149 1200.0n 0.4514 1499.9n 0.4514 1500.0n 0.4831 1799.9n 0.4831 1800.0n 0.4196 2099.9n 0.4196 2100.0n 0.4514 2399.9n 0.4514 2400.0n 0.5785 2699.9n 0.5785 2700.0n 0.5785 2999.9n 0.5785 3000.0n 0.5467 3299.9n 0.5467 3300.0n 0.5785 3599.9n 0.5785 3600.0n 0.2000 3899.9n 0.2000 3900.0n 0.5785 4199.9n 0.5785 4200.0n 0.5785 4499.9n 0.5785 4500.0n 0.5785 4799.9n 0.5785 4800.0n 0.5467 5099.9n 0.5467 5100.0n 0.5785 5399.9n 0.5785 5400.0n 0.4196 5699.9n 0.4196 5700.0n 0.4831 5999.9n 0.4831 6000.0n 0.3242 6299.9n 0.3242 6300.0n 0.5149 6599.9n 0.5149 6600.0n 0.4514 6899.9n 0.4514 6900.0n 0.4831 7199.9n 0.4831 7200.0n 0.4196 7499.9n 0.4196 7500.0n 0.4514 7799.9n 0.4514 7800.0n 0.5785 8099.9n 0.5785 8100.0n 0.5785 8399.9n 0.5785 8400.0n 0.5467 8699.9n 0.5467 8700.0n 0.5785 8999.9n 0.5785 9000.0n 0.2000 9299.9n 0.2000 9300.0n 0.5785 9599.9n 0.5785 9600.0n 0.5785 9899.9n 0.5785 9900.0n 0.5785 10199.9n 0.5785 10200.0n 0.5467 10499.9n 0.5467 10500.0n 0.5785 10799.9n 0.5785 10800.0n 0.4196 11099.9n 0.4196 11100.0n 0.4831 11399.9n 0.4831 11400.0n 0.3242 11699.9n 0.3242 11700.0n 0.5149 11999.9n 0.5149 12000.0n 0.4514 12299.9n 0.4514 12300.0n 0.4831 12599.9n 0.4831 12600.0n 0.4196 12899.9n 0.4196 12900.0n 0.4514 13199.9n 0.4514 13200.0n 0.5785 13499.9n 0.5785 13500.0n 0.5785 13799.9n 0.5785 13800.0n 0.5467 14099.9n 0.5467 14100.0n 0.5785 14399.9n 0.5785 14400.0n 0.2000 14699.9n 0.2000 14700.0n 0.5785 14999.9n 0.5785 15000.0n 0.5785 15299.9n 0.5785 15300.0n 0.5785 15599.9n 0.5785 15600.0n 0.5467 15899.9n 0.5467 15900.0n 0.5785 16199.9n 0.5785 16200.0n 0.4196 16499.9n 0.4196 16500.0n 0.4831 16799.9n 0.4831 16800.0n 0.3242 17099.9n 0.3242 17100.0n 0.5149 17399.9n 0.5149 17400.0n 0.4514 17699.9n 0.4514 17700.0n 0.4831 17999.9n 0.4831 18000.0n 0.4196 18299.9n 0.4196 18300.0n 0.4514 18599.9n 0.4514 18600.0n 0.5785 18899.9n 0.5785 18900.0n 0.5785 19199.9n 0.5785 19200.0n 0.5467 19499.9n 0.5467 19500.0n 0.5785 19799.9n 0.5785 19800.0n 0.2000 20099.9n 0.2000 20100.0n 0.5785 20399.9n 0.5785 20400.0n 0.5785 20699.9n 0.5785 20700.0n 0.5785 20999.9n 0.5785 21000.0n 0.5467 21299.9n 0.5467 21300.0n 0.5785 21599.9n 0.5785 21600.0n 0.4196 21899.9n 0.4196 21900.0n 0.4831 22199.9n 0.4831 22200.0n 0.3242 22499.9n 0.3242 22500.0n 0.5149 22799.9n 0.5149 22800.0n 0.4514 23099.9n 0.4514 23100.0n 0.4831 23399.9n 0.4831 23400.0n 0.4196 23699.9n 0.4196 23700.0n 0.4514 23999.9n 0.4514 24000.0n 0.5785 24299.9n 0.5785 24300.0n 0.5785 24599.9n 0.5785 24600.0n 0.5467 24899.9n 0.5467 24900.0n 0.5785 25199.9n 0.5785 25200.0n 0.2000 25499.9n 0.2000 25500.0n 0.5785 25799.9n 0.5785 25800.0n 0.5785 26099.9n 0.5785 26100.0n 0.5785 26399.9n 0.5785 26400.0n 0.5467 26699.9n 0.5467 26700.0n 0.5785 26999.9n 0.5785 27000.0n 0.4196 27299.9n 0.4196 27300.0n 0.4831 27599.9n 0.4831 27600.0n 0.3242 27899.9n 0.3242 27900.0n 0.5149 28199.9n 0.5149 28200.0n 0.4514 28499.9n 0.4514 28500.0n 0.4831 28799.9n 0.4831 28800.0n 0.4196 29099.9n 0.4196 29100.0n 0.4514 29399.9n 0.4514 29400.0n 0.5785 29699.9n 0.5785 29700.0n 0.5785 29999.9n 0.5785 30000.0n 0.5467 30299.9n 0.5467 30300.0n 0.5785 30599.9n 0.5785 30600.0n 0.2000 30899.9n 0.2000 30900.0n 0.5785 31199.9n 0.5785 31200.0n 0.5785 31499.9n 0.5785 31500.0n 0.5785 31799.9n 0.5785 31800.0n 0.5467 32099.9n 0.5467 32100.0n 0.5785 32399.9n 0.5785 32400.0n 0.4196 32699.9n 0.4196 32700.0n 0.4831 32999.9n 0.4831 33000.0n 0.3242 33299.9n 0.3242 33300.0n 0.5149 33599.9n 0.5149 33600.0n 0.4514 33899.9n 0.4514 33900.0n 0.4831 34199.9n 0.4831 34200.0n 0.4196 34499.9n 0.4196 34500.0n 0.4514 34799.9n 0.4514 34800.0n 0.5785 35099.9n 0.5785 35100.0n 0.5785 35399.9n 0.5785 35400.0n 0.5467 35699.9n 0.5467 35700.0n 0.5785 35999.9n 0.5785 36000.0n 0.2000 36299.9n 0.2000 36300.0n 0.5785 36599.9n 0.5785 36600.0n 0.5785 36899.9n 0.5785 36900.0n 0.5785 37199.9n 0.5785 37200.0n 0.5467 37499.9n 0.5467 37500.0n 0.5785 37799.9n 0.5785 37800.0n 0.4196 38099.9n 0.4196 38100.0n 0.4831 38399.9n 0.4831 38400.0n 0.3242 38699.9n 0.3242 38700.0n 0.5149 38999.9n 0.5149 39000.0n 0.4514 39299.9n 0.4514 39300.0n 0.4831 39599.9n 0.4831 39600.0n 0.4196 39899.9n 0.4196 39900.0n 0.4514 40199.9n 0.4514 40200.0n 0.5785 40499.9n 0.5785 40500.0n 0.5785 40799.9n 0.5785 40800.0n 0.5467 41099.9n 0.5467 41100.0n 0.5785 41399.9n 0.5785 41400.0n 0.2000 41699.9n 0.2000 41700.0n 0.5785 41999.9n 0.5785 42000.0n 0.5785 42299.9n 0.5785 42300.0n 0.5785 42599.9n 0.5785 42600.0n 0.5467 42899.9n 0.5467 42900.0n 0.5785 43199.9n 0.5785 43200.0n 0.4196 43499.9n 0.4196 43500.0n 0.4831 43799.9n 0.4831 43800.0n 0.3242 44099.9n 0.3242 44100.0n 0.5149 44399.9n 0.5149 44400.0n 0.4514 44699.9n 0.4514 44700.0n 0.4831 44999.9n 0.4831 45000.0n 0.4196 45299.9n 0.4196 45300.0n 0.4514 45599.9n 0.4514 45600.0n 0.5785 45899.9n 0.5785 45900.0n 0.5785 46199.9n 0.5785 46200.0n 0.5467 46499.9n 0.5467 46500.0n 0.5785 46799.9n 0.5785 46800.0n 0.2000 47099.9n 0.2000 47100.0n 0.5785 47399.9n 0.5785 47400.0n 0.5785 47699.9n 0.5785 47700.0n 0.5785 47999.9n 0.5785 48000.0n 0.5467 48299.9n 0.5467 48300.0n 0.5785 48599.9n 0.5785 48600.0n 0.4196 48899.9n 0.4196 48900.0n 0.4831 49199.9n 0.4831 49200.0n 0.3242 49499.9n 0.3242 49500.0n 0.5149 49799.9n 0.5149 49800.0n 0.4514 50099.9n 0.4514 50100.0n 0.4831 50399.9n 0.4831 50400.0n 0.4196 50699.9n 0.4196 50700.0n 0.4514 50999.9n 0.4514 51000.0n 0.5785 51299.9n 0.5785 51300.0n 0.5785 51599.9n 0.5785 51600.0n 0.5467 51899.9n 0.5467 51900.0n 0.5785 52199.9n 0.5785 52200.0n 0.2000 52499.9n 0.2000 52500.0n 0.5785 52799.9n 0.5785 52800.0n 0.5785 53099.9n 0.5785 53100.0n 0.5785 53399.9n 0.5785 53400.0n 0.5467 53699.9n 0.5467 53700.0n 0.5785 53999.9n 0.5785 54000.0n 0.3242 54299.9n 0.3242 54300.0n 0.4514 54599.9n 0.4514 54600.0n 0.4831 54899.9n 0.4831 54900.0n 0.3242 55199.9n 0.3242 55200.0n 0.5149 55499.9n 0.5149 55500.0n 0.4514 55799.9n 0.4514 55800.0n 0.5785 56099.9n 0.5785 56100.0n 0.5785 56399.9n 0.5785 56400.0n 0.5785 56699.9n 0.5785 56700.0n 0.5785 56999.9n 0.5785 57000.0n 0.4514 57299.9n 0.4514 57300.0n 0.5785 57599.9n 0.5785 57600.0n 0.5467 57899.9n 0.5467 57900.0n 0.5785 58199.9n 0.5785 58200.0n 0.4514 58499.9n 0.4514 58500.0n 0.5785 58799.9n 0.5785 58800.0n 0.5785 59099.9n 0.5785 59100.0n 0.5785)
Vxp26 a_xp26 0 PWL(0.0n 0.6116 299.9n 0.6116 300.0n 0.4985 599.9n 0.4985 600.0n 0.5793 899.9n 0.5793 900.0n 0.6116 1199.9n 0.6116 1200.0n 0.5147 1499.9n 0.5147 1500.0n 0.5955 1799.9n 0.5955 1800.0n 0.5308 2099.9n 0.5308 2100.0n 0.5308 2399.9n 0.5308 2400.0n 0.3531 2699.9n 0.3531 2700.0n 0.3854 2999.9n 0.3854 3000.0n 0.4016 3299.9n 0.4016 3300.0n 0.3531 3599.9n 0.3531 3600.0n 0.5308 3899.9n 0.5308 3900.0n 0.5470 4199.9n 0.5470 4200.0n 0.3531 4499.9n 0.3531 4500.0n 0.3854 4799.9n 0.3854 4800.0n 0.5470 5099.9n 0.5470 5100.0n 0.3531 5399.9n 0.3531 5400.0n 0.6116 5699.9n 0.6116 5700.0n 0.4985 5999.9n 0.4985 6000.0n 0.5793 6299.9n 0.5793 6300.0n 0.6116 6599.9n 0.6116 6600.0n 0.5147 6899.9n 0.5147 6900.0n 0.5955 7199.9n 0.5955 7200.0n 0.5308 7499.9n 0.5308 7500.0n 0.5308 7799.9n 0.5308 7800.0n 0.3531 8099.9n 0.3531 8100.0n 0.3854 8399.9n 0.3854 8400.0n 0.4016 8699.9n 0.4016 8700.0n 0.3531 8999.9n 0.3531 9000.0n 0.5308 9299.9n 0.5308 9300.0n 0.5470 9599.9n 0.5470 9600.0n 0.3531 9899.9n 0.3531 9900.0n 0.3854 10199.9n 0.3854 10200.0n 0.5470 10499.9n 0.5470 10500.0n 0.3531 10799.9n 0.3531 10800.0n 0.6116 11099.9n 0.6116 11100.0n 0.4985 11399.9n 0.4985 11400.0n 0.5793 11699.9n 0.5793 11700.0n 0.6116 11999.9n 0.6116 12000.0n 0.5147 12299.9n 0.5147 12300.0n 0.5955 12599.9n 0.5955 12600.0n 0.5308 12899.9n 0.5308 12900.0n 0.5308 13199.9n 0.5308 13200.0n 0.3531 13499.9n 0.3531 13500.0n 0.3854 13799.9n 0.3854 13800.0n 0.4016 14099.9n 0.4016 14100.0n 0.3531 14399.9n 0.3531 14400.0n 0.5308 14699.9n 0.5308 14700.0n 0.5470 14999.9n 0.5470 15000.0n 0.3531 15299.9n 0.3531 15300.0n 0.3854 15599.9n 0.3854 15600.0n 0.5470 15899.9n 0.5470 15900.0n 0.3531 16199.9n 0.3531 16200.0n 0.6116 16499.9n 0.6116 16500.0n 0.4985 16799.9n 0.4985 16800.0n 0.5793 17099.9n 0.5793 17100.0n 0.6116 17399.9n 0.6116 17400.0n 0.5147 17699.9n 0.5147 17700.0n 0.5955 17999.9n 0.5955 18000.0n 0.5308 18299.9n 0.5308 18300.0n 0.5308 18599.9n 0.5308 18600.0n 0.3531 18899.9n 0.3531 18900.0n 0.3854 19199.9n 0.3854 19200.0n 0.4016 19499.9n 0.4016 19500.0n 0.3531 19799.9n 0.3531 19800.0n 0.5308 20099.9n 0.5308 20100.0n 0.5470 20399.9n 0.5470 20400.0n 0.3531 20699.9n 0.3531 20700.0n 0.3854 20999.9n 0.3854 21000.0n 0.5470 21299.9n 0.5470 21300.0n 0.3531 21599.9n 0.3531 21600.0n 0.6116 21899.9n 0.6116 21900.0n 0.4985 22199.9n 0.4985 22200.0n 0.5793 22499.9n 0.5793 22500.0n 0.6116 22799.9n 0.6116 22800.0n 0.5147 23099.9n 0.5147 23100.0n 0.5955 23399.9n 0.5955 23400.0n 0.5308 23699.9n 0.5308 23700.0n 0.5308 23999.9n 0.5308 24000.0n 0.3531 24299.9n 0.3531 24300.0n 0.3854 24599.9n 0.3854 24600.0n 0.4016 24899.9n 0.4016 24900.0n 0.3531 25199.9n 0.3531 25200.0n 0.5308 25499.9n 0.5308 25500.0n 0.5470 25799.9n 0.5470 25800.0n 0.3531 26099.9n 0.3531 26100.0n 0.3854 26399.9n 0.3854 26400.0n 0.5470 26699.9n 0.5470 26700.0n 0.3531 26999.9n 0.3531 27000.0n 0.6116 27299.9n 0.6116 27300.0n 0.4985 27599.9n 0.4985 27600.0n 0.5793 27899.9n 0.5793 27900.0n 0.6116 28199.9n 0.6116 28200.0n 0.5147 28499.9n 0.5147 28500.0n 0.5955 28799.9n 0.5955 28800.0n 0.5308 29099.9n 0.5308 29100.0n 0.5308 29399.9n 0.5308 29400.0n 0.3531 29699.9n 0.3531 29700.0n 0.3854 29999.9n 0.3854 30000.0n 0.4016 30299.9n 0.4016 30300.0n 0.3531 30599.9n 0.3531 30600.0n 0.5308 30899.9n 0.5308 30900.0n 0.5470 31199.9n 0.5470 31200.0n 0.3531 31499.9n 0.3531 31500.0n 0.3854 31799.9n 0.3854 31800.0n 0.5470 32099.9n 0.5470 32100.0n 0.3531 32399.9n 0.3531 32400.0n 0.6116 32699.9n 0.6116 32700.0n 0.4985 32999.9n 0.4985 33000.0n 0.5793 33299.9n 0.5793 33300.0n 0.6116 33599.9n 0.6116 33600.0n 0.5147 33899.9n 0.5147 33900.0n 0.5955 34199.9n 0.5955 34200.0n 0.5308 34499.9n 0.5308 34500.0n 0.5308 34799.9n 0.5308 34800.0n 0.3531 35099.9n 0.3531 35100.0n 0.3854 35399.9n 0.3854 35400.0n 0.4016 35699.9n 0.4016 35700.0n 0.3531 35999.9n 0.3531 36000.0n 0.5308 36299.9n 0.5308 36300.0n 0.5470 36599.9n 0.5470 36600.0n 0.3531 36899.9n 0.3531 36900.0n 0.3854 37199.9n 0.3854 37200.0n 0.5470 37499.9n 0.5470 37500.0n 0.3531 37799.9n 0.3531 37800.0n 0.6116 38099.9n 0.6116 38100.0n 0.4985 38399.9n 0.4985 38400.0n 0.5793 38699.9n 0.5793 38700.0n 0.6116 38999.9n 0.6116 39000.0n 0.5147 39299.9n 0.5147 39300.0n 0.5955 39599.9n 0.5955 39600.0n 0.5308 39899.9n 0.5308 39900.0n 0.5308 40199.9n 0.5308 40200.0n 0.3531 40499.9n 0.3531 40500.0n 0.3854 40799.9n 0.3854 40800.0n 0.4016 41099.9n 0.4016 41100.0n 0.3531 41399.9n 0.3531 41400.0n 0.5308 41699.9n 0.5308 41700.0n 0.5470 41999.9n 0.5470 42000.0n 0.3531 42299.9n 0.3531 42300.0n 0.3854 42599.9n 0.3854 42600.0n 0.5470 42899.9n 0.5470 42900.0n 0.3531 43199.9n 0.3531 43200.0n 0.6116 43499.9n 0.6116 43500.0n 0.4985 43799.9n 0.4985 43800.0n 0.5793 44099.9n 0.5793 44100.0n 0.6116 44399.9n 0.6116 44400.0n 0.5147 44699.9n 0.5147 44700.0n 0.5955 44999.9n 0.5955 45000.0n 0.5308 45299.9n 0.5308 45300.0n 0.5308 45599.9n 0.5308 45600.0n 0.3531 45899.9n 0.3531 45900.0n 0.3854 46199.9n 0.3854 46200.0n 0.4016 46499.9n 0.4016 46500.0n 0.3531 46799.9n 0.3531 46800.0n 0.5308 47099.9n 0.5308 47100.0n 0.5470 47399.9n 0.5470 47400.0n 0.3531 47699.9n 0.3531 47700.0n 0.3854 47999.9n 0.3854 48000.0n 0.5470 48299.9n 0.5470 48300.0n 0.3531 48599.9n 0.3531 48600.0n 0.6116 48899.9n 0.6116 48900.0n 0.4985 49199.9n 0.4985 49200.0n 0.5793 49499.9n 0.5793 49500.0n 0.6116 49799.9n 0.6116 49800.0n 0.5147 50099.9n 0.5147 50100.0n 0.5955 50399.9n 0.5955 50400.0n 0.5308 50699.9n 0.5308 50700.0n 0.5308 50999.9n 0.5308 51000.0n 0.3531 51299.9n 0.3531 51300.0n 0.3854 51599.9n 0.3854 51600.0n 0.4016 51899.9n 0.4016 51900.0n 0.3531 52199.9n 0.3531 52200.0n 0.5308 52499.9n 0.5308 52500.0n 0.5470 52799.9n 0.5470 52800.0n 0.3531 53099.9n 0.3531 53100.0n 0.3854 53399.9n 0.3854 53400.0n 0.5470 53699.9n 0.5470 53700.0n 0.3531 53999.9n 0.3531 54000.0n 0.5631 54299.9n 0.5631 54300.0n 0.6116 54599.9n 0.6116 54600.0n 0.4985 54899.9n 0.4985 54900.0n 0.6116 55199.9n 0.6116 55200.0n 0.6116 55499.9n 0.6116 55500.0n 0.5793 55799.9n 0.5793 55800.0n 0.4016 56099.9n 0.4016 56100.0n 0.5793 56399.9n 0.5793 56400.0n 0.4985 56699.9n 0.4985 56700.0n 0.4824 56999.9n 0.4824 57000.0n 0.5955 57299.9n 0.5955 57300.0n 0.4339 57599.9n 0.4339 57600.0n 0.3531 57899.9n 0.3531 57900.0n 0.3531 58199.9n 0.3531 58200.0n 0.4501 58499.9n 0.4501 58500.0n 0.3531 58799.9n 0.3531 58800.0n 0.3531 59099.9n 0.3531 59100.0n 0.3531)
Vxn26 a_xn26 0 PWL(0.0n 0.3884 299.9n 0.3884 300.0n 0.5015 599.9n 0.5015 600.0n 0.4207 899.9n 0.4207 900.0n 0.3884 1199.9n 0.3884 1200.0n 0.4853 1499.9n 0.4853 1500.0n 0.4045 1799.9n 0.4045 1800.0n 0.4692 2099.9n 0.4692 2100.0n 0.4692 2399.9n 0.4692 2400.0n 0.6469 2699.9n 0.6469 2700.0n 0.6146 2999.9n 0.6146 3000.0n 0.5984 3299.9n 0.5984 3300.0n 0.6469 3599.9n 0.6469 3600.0n 0.4692 3899.9n 0.4692 3900.0n 0.4530 4199.9n 0.4530 4200.0n 0.6469 4499.9n 0.6469 4500.0n 0.6146 4799.9n 0.6146 4800.0n 0.4530 5099.9n 0.4530 5100.0n 0.6469 5399.9n 0.6469 5400.0n 0.3884 5699.9n 0.3884 5700.0n 0.5015 5999.9n 0.5015 6000.0n 0.4207 6299.9n 0.4207 6300.0n 0.3884 6599.9n 0.3884 6600.0n 0.4853 6899.9n 0.4853 6900.0n 0.4045 7199.9n 0.4045 7200.0n 0.4692 7499.9n 0.4692 7500.0n 0.4692 7799.9n 0.4692 7800.0n 0.6469 8099.9n 0.6469 8100.0n 0.6146 8399.9n 0.6146 8400.0n 0.5984 8699.9n 0.5984 8700.0n 0.6469 8999.9n 0.6469 9000.0n 0.4692 9299.9n 0.4692 9300.0n 0.4530 9599.9n 0.4530 9600.0n 0.6469 9899.9n 0.6469 9900.0n 0.6146 10199.9n 0.6146 10200.0n 0.4530 10499.9n 0.4530 10500.0n 0.6469 10799.9n 0.6469 10800.0n 0.3884 11099.9n 0.3884 11100.0n 0.5015 11399.9n 0.5015 11400.0n 0.4207 11699.9n 0.4207 11700.0n 0.3884 11999.9n 0.3884 12000.0n 0.4853 12299.9n 0.4853 12300.0n 0.4045 12599.9n 0.4045 12600.0n 0.4692 12899.9n 0.4692 12900.0n 0.4692 13199.9n 0.4692 13200.0n 0.6469 13499.9n 0.6469 13500.0n 0.6146 13799.9n 0.6146 13800.0n 0.5984 14099.9n 0.5984 14100.0n 0.6469 14399.9n 0.6469 14400.0n 0.4692 14699.9n 0.4692 14700.0n 0.4530 14999.9n 0.4530 15000.0n 0.6469 15299.9n 0.6469 15300.0n 0.6146 15599.9n 0.6146 15600.0n 0.4530 15899.9n 0.4530 15900.0n 0.6469 16199.9n 0.6469 16200.0n 0.3884 16499.9n 0.3884 16500.0n 0.5015 16799.9n 0.5015 16800.0n 0.4207 17099.9n 0.4207 17100.0n 0.3884 17399.9n 0.3884 17400.0n 0.4853 17699.9n 0.4853 17700.0n 0.4045 17999.9n 0.4045 18000.0n 0.4692 18299.9n 0.4692 18300.0n 0.4692 18599.9n 0.4692 18600.0n 0.6469 18899.9n 0.6469 18900.0n 0.6146 19199.9n 0.6146 19200.0n 0.5984 19499.9n 0.5984 19500.0n 0.6469 19799.9n 0.6469 19800.0n 0.4692 20099.9n 0.4692 20100.0n 0.4530 20399.9n 0.4530 20400.0n 0.6469 20699.9n 0.6469 20700.0n 0.6146 20999.9n 0.6146 21000.0n 0.4530 21299.9n 0.4530 21300.0n 0.6469 21599.9n 0.6469 21600.0n 0.3884 21899.9n 0.3884 21900.0n 0.5015 22199.9n 0.5015 22200.0n 0.4207 22499.9n 0.4207 22500.0n 0.3884 22799.9n 0.3884 22800.0n 0.4853 23099.9n 0.4853 23100.0n 0.4045 23399.9n 0.4045 23400.0n 0.4692 23699.9n 0.4692 23700.0n 0.4692 23999.9n 0.4692 24000.0n 0.6469 24299.9n 0.6469 24300.0n 0.6146 24599.9n 0.6146 24600.0n 0.5984 24899.9n 0.5984 24900.0n 0.6469 25199.9n 0.6469 25200.0n 0.4692 25499.9n 0.4692 25500.0n 0.4530 25799.9n 0.4530 25800.0n 0.6469 26099.9n 0.6469 26100.0n 0.6146 26399.9n 0.6146 26400.0n 0.4530 26699.9n 0.4530 26700.0n 0.6469 26999.9n 0.6469 27000.0n 0.3884 27299.9n 0.3884 27300.0n 0.5015 27599.9n 0.5015 27600.0n 0.4207 27899.9n 0.4207 27900.0n 0.3884 28199.9n 0.3884 28200.0n 0.4853 28499.9n 0.4853 28500.0n 0.4045 28799.9n 0.4045 28800.0n 0.4692 29099.9n 0.4692 29100.0n 0.4692 29399.9n 0.4692 29400.0n 0.6469 29699.9n 0.6469 29700.0n 0.6146 29999.9n 0.6146 30000.0n 0.5984 30299.9n 0.5984 30300.0n 0.6469 30599.9n 0.6469 30600.0n 0.4692 30899.9n 0.4692 30900.0n 0.4530 31199.9n 0.4530 31200.0n 0.6469 31499.9n 0.6469 31500.0n 0.6146 31799.9n 0.6146 31800.0n 0.4530 32099.9n 0.4530 32100.0n 0.6469 32399.9n 0.6469 32400.0n 0.3884 32699.9n 0.3884 32700.0n 0.5015 32999.9n 0.5015 33000.0n 0.4207 33299.9n 0.4207 33300.0n 0.3884 33599.9n 0.3884 33600.0n 0.4853 33899.9n 0.4853 33900.0n 0.4045 34199.9n 0.4045 34200.0n 0.4692 34499.9n 0.4692 34500.0n 0.4692 34799.9n 0.4692 34800.0n 0.6469 35099.9n 0.6469 35100.0n 0.6146 35399.9n 0.6146 35400.0n 0.5984 35699.9n 0.5984 35700.0n 0.6469 35999.9n 0.6469 36000.0n 0.4692 36299.9n 0.4692 36300.0n 0.4530 36599.9n 0.4530 36600.0n 0.6469 36899.9n 0.6469 36900.0n 0.6146 37199.9n 0.6146 37200.0n 0.4530 37499.9n 0.4530 37500.0n 0.6469 37799.9n 0.6469 37800.0n 0.3884 38099.9n 0.3884 38100.0n 0.5015 38399.9n 0.5015 38400.0n 0.4207 38699.9n 0.4207 38700.0n 0.3884 38999.9n 0.3884 39000.0n 0.4853 39299.9n 0.4853 39300.0n 0.4045 39599.9n 0.4045 39600.0n 0.4692 39899.9n 0.4692 39900.0n 0.4692 40199.9n 0.4692 40200.0n 0.6469 40499.9n 0.6469 40500.0n 0.6146 40799.9n 0.6146 40800.0n 0.5984 41099.9n 0.5984 41100.0n 0.6469 41399.9n 0.6469 41400.0n 0.4692 41699.9n 0.4692 41700.0n 0.4530 41999.9n 0.4530 42000.0n 0.6469 42299.9n 0.6469 42300.0n 0.6146 42599.9n 0.6146 42600.0n 0.4530 42899.9n 0.4530 42900.0n 0.6469 43199.9n 0.6469 43200.0n 0.3884 43499.9n 0.3884 43500.0n 0.5015 43799.9n 0.5015 43800.0n 0.4207 44099.9n 0.4207 44100.0n 0.3884 44399.9n 0.3884 44400.0n 0.4853 44699.9n 0.4853 44700.0n 0.4045 44999.9n 0.4045 45000.0n 0.4692 45299.9n 0.4692 45300.0n 0.4692 45599.9n 0.4692 45600.0n 0.6469 45899.9n 0.6469 45900.0n 0.6146 46199.9n 0.6146 46200.0n 0.5984 46499.9n 0.5984 46500.0n 0.6469 46799.9n 0.6469 46800.0n 0.4692 47099.9n 0.4692 47100.0n 0.4530 47399.9n 0.4530 47400.0n 0.6469 47699.9n 0.6469 47700.0n 0.6146 47999.9n 0.6146 48000.0n 0.4530 48299.9n 0.4530 48300.0n 0.6469 48599.9n 0.6469 48600.0n 0.3884 48899.9n 0.3884 48900.0n 0.5015 49199.9n 0.5015 49200.0n 0.4207 49499.9n 0.4207 49500.0n 0.3884 49799.9n 0.3884 49800.0n 0.4853 50099.9n 0.4853 50100.0n 0.4045 50399.9n 0.4045 50400.0n 0.4692 50699.9n 0.4692 50700.0n 0.4692 50999.9n 0.4692 51000.0n 0.6469 51299.9n 0.6469 51300.0n 0.6146 51599.9n 0.6146 51600.0n 0.5984 51899.9n 0.5984 51900.0n 0.6469 52199.9n 0.6469 52200.0n 0.4692 52499.9n 0.4692 52500.0n 0.4530 52799.9n 0.4530 52800.0n 0.6469 53099.9n 0.6469 53100.0n 0.6146 53399.9n 0.6146 53400.0n 0.4530 53699.9n 0.4530 53700.0n 0.6469 53999.9n 0.6469 54000.0n 0.4369 54299.9n 0.4369 54300.0n 0.3884 54599.9n 0.3884 54600.0n 0.5015 54899.9n 0.5015 54900.0n 0.3884 55199.9n 0.3884 55200.0n 0.3884 55499.9n 0.3884 55500.0n 0.4207 55799.9n 0.4207 55800.0n 0.5984 56099.9n 0.5984 56100.0n 0.4207 56399.9n 0.4207 56400.0n 0.5015 56699.9n 0.5015 56700.0n 0.5176 56999.9n 0.5176 57000.0n 0.4045 57299.9n 0.4045 57300.0n 0.5661 57599.9n 0.5661 57600.0n 0.6469 57899.9n 0.6469 57900.0n 0.6469 58199.9n 0.6469 58200.0n 0.5499 58499.9n 0.5499 58500.0n 0.6469 58799.9n 0.6469 58800.0n 0.6469 59099.9n 0.6469 59100.0n 0.6469)
Vxp27 a_xp27 0 PWL(0.0n 0.6221 299.9n 0.6221 300.0n 0.3500 599.9n 0.3500 600.0n 0.3840 899.9n 0.3840 900.0n 0.4010 1199.9n 0.4010 1200.0n 0.5030 1499.9n 0.5030 1500.0n 0.3500 1799.9n 0.3500 1800.0n 0.3500 2099.9n 0.3500 2100.0n 0.4010 2399.9n 0.4010 2400.0n 0.5200 2699.9n 0.5200 2700.0n 0.3500 2999.9n 0.3500 3000.0n 0.3840 3299.9n 0.3840 3300.0n 0.5030 3599.9n 0.5030 3600.0n 0.5370 3899.9n 0.5370 3900.0n 0.6221 4199.9n 0.6221 4200.0n 0.4690 4499.9n 0.4690 4500.0n 0.4010 4799.9n 0.4010 4800.0n 0.3500 5099.9n 0.3500 5100.0n 0.5200 5399.9n 0.5200 5400.0n 0.6221 5699.9n 0.6221 5700.0n 0.3500 5999.9n 0.3500 6000.0n 0.3840 6299.9n 0.3840 6300.0n 0.4010 6599.9n 0.4010 6600.0n 0.5030 6899.9n 0.5030 6900.0n 0.3500 7199.9n 0.3500 7200.0n 0.3500 7499.9n 0.3500 7500.0n 0.4010 7799.9n 0.4010 7800.0n 0.5200 8099.9n 0.5200 8100.0n 0.3500 8399.9n 0.3500 8400.0n 0.3840 8699.9n 0.3840 8700.0n 0.5030 8999.9n 0.5030 9000.0n 0.5370 9299.9n 0.5370 9300.0n 0.6221 9599.9n 0.6221 9600.0n 0.4690 9899.9n 0.4690 9900.0n 0.4010 10199.9n 0.4010 10200.0n 0.3500 10499.9n 0.3500 10500.0n 0.5200 10799.9n 0.5200 10800.0n 0.6221 11099.9n 0.6221 11100.0n 0.3500 11399.9n 0.3500 11400.0n 0.3840 11699.9n 0.3840 11700.0n 0.4010 11999.9n 0.4010 12000.0n 0.5030 12299.9n 0.5030 12300.0n 0.3500 12599.9n 0.3500 12600.0n 0.3500 12899.9n 0.3500 12900.0n 0.4010 13199.9n 0.4010 13200.0n 0.5200 13499.9n 0.5200 13500.0n 0.3500 13799.9n 0.3500 13800.0n 0.3840 14099.9n 0.3840 14100.0n 0.5030 14399.9n 0.5030 14400.0n 0.5370 14699.9n 0.5370 14700.0n 0.6221 14999.9n 0.6221 15000.0n 0.4690 15299.9n 0.4690 15300.0n 0.4010 15599.9n 0.4010 15600.0n 0.3500 15899.9n 0.3500 15900.0n 0.5200 16199.9n 0.5200 16200.0n 0.6221 16499.9n 0.6221 16500.0n 0.3500 16799.9n 0.3500 16800.0n 0.3840 17099.9n 0.3840 17100.0n 0.4010 17399.9n 0.4010 17400.0n 0.5030 17699.9n 0.5030 17700.0n 0.3500 17999.9n 0.3500 18000.0n 0.3500 18299.9n 0.3500 18300.0n 0.4010 18599.9n 0.4010 18600.0n 0.5200 18899.9n 0.5200 18900.0n 0.3500 19199.9n 0.3500 19200.0n 0.3840 19499.9n 0.3840 19500.0n 0.5030 19799.9n 0.5030 19800.0n 0.5370 20099.9n 0.5370 20100.0n 0.6221 20399.9n 0.6221 20400.0n 0.4690 20699.9n 0.4690 20700.0n 0.4010 20999.9n 0.4010 21000.0n 0.3500 21299.9n 0.3500 21300.0n 0.5200 21599.9n 0.5200 21600.0n 0.6221 21899.9n 0.6221 21900.0n 0.3500 22199.9n 0.3500 22200.0n 0.3840 22499.9n 0.3840 22500.0n 0.4010 22799.9n 0.4010 22800.0n 0.5030 23099.9n 0.5030 23100.0n 0.3500 23399.9n 0.3500 23400.0n 0.3500 23699.9n 0.3500 23700.0n 0.4010 23999.9n 0.4010 24000.0n 0.5200 24299.9n 0.5200 24300.0n 0.3500 24599.9n 0.3500 24600.0n 0.3840 24899.9n 0.3840 24900.0n 0.5030 25199.9n 0.5030 25200.0n 0.5370 25499.9n 0.5370 25500.0n 0.6221 25799.9n 0.6221 25800.0n 0.4690 26099.9n 0.4690 26100.0n 0.4010 26399.9n 0.4010 26400.0n 0.3500 26699.9n 0.3500 26700.0n 0.5200 26999.9n 0.5200 27000.0n 0.6221 27299.9n 0.6221 27300.0n 0.3500 27599.9n 0.3500 27600.0n 0.3840 27899.9n 0.3840 27900.0n 0.4010 28199.9n 0.4010 28200.0n 0.5030 28499.9n 0.5030 28500.0n 0.3500 28799.9n 0.3500 28800.0n 0.3500 29099.9n 0.3500 29100.0n 0.4010 29399.9n 0.4010 29400.0n 0.5200 29699.9n 0.5200 29700.0n 0.3500 29999.9n 0.3500 30000.0n 0.3840 30299.9n 0.3840 30300.0n 0.5030 30599.9n 0.5030 30600.0n 0.5370 30899.9n 0.5370 30900.0n 0.6221 31199.9n 0.6221 31200.0n 0.4690 31499.9n 0.4690 31500.0n 0.4010 31799.9n 0.4010 31800.0n 0.3500 32099.9n 0.3500 32100.0n 0.5200 32399.9n 0.5200 32400.0n 0.6221 32699.9n 0.6221 32700.0n 0.3500 32999.9n 0.3500 33000.0n 0.3840 33299.9n 0.3840 33300.0n 0.4010 33599.9n 0.4010 33600.0n 0.5030 33899.9n 0.5030 33900.0n 0.3500 34199.9n 0.3500 34200.0n 0.3500 34499.9n 0.3500 34500.0n 0.4010 34799.9n 0.4010 34800.0n 0.5200 35099.9n 0.5200 35100.0n 0.3500 35399.9n 0.3500 35400.0n 0.3840 35699.9n 0.3840 35700.0n 0.5030 35999.9n 0.5030 36000.0n 0.5370 36299.9n 0.5370 36300.0n 0.6221 36599.9n 0.6221 36600.0n 0.4690 36899.9n 0.4690 36900.0n 0.4010 37199.9n 0.4010 37200.0n 0.3500 37499.9n 0.3500 37500.0n 0.5200 37799.9n 0.5200 37800.0n 0.6221 38099.9n 0.6221 38100.0n 0.3500 38399.9n 0.3500 38400.0n 0.3840 38699.9n 0.3840 38700.0n 0.4010 38999.9n 0.4010 39000.0n 0.5030 39299.9n 0.5030 39300.0n 0.3500 39599.9n 0.3500 39600.0n 0.3500 39899.9n 0.3500 39900.0n 0.4010 40199.9n 0.4010 40200.0n 0.5200 40499.9n 0.5200 40500.0n 0.3500 40799.9n 0.3500 40800.0n 0.3840 41099.9n 0.3840 41100.0n 0.5030 41399.9n 0.5030 41400.0n 0.5370 41699.9n 0.5370 41700.0n 0.6221 41999.9n 0.6221 42000.0n 0.4690 42299.9n 0.4690 42300.0n 0.4010 42599.9n 0.4010 42600.0n 0.3500 42899.9n 0.3500 42900.0n 0.5200 43199.9n 0.5200 43200.0n 0.6221 43499.9n 0.6221 43500.0n 0.3500 43799.9n 0.3500 43800.0n 0.3840 44099.9n 0.3840 44100.0n 0.4010 44399.9n 0.4010 44400.0n 0.5030 44699.9n 0.5030 44700.0n 0.3500 44999.9n 0.3500 45000.0n 0.3500 45299.9n 0.3500 45300.0n 0.4010 45599.9n 0.4010 45600.0n 0.5200 45899.9n 0.5200 45900.0n 0.3500 46199.9n 0.3500 46200.0n 0.3840 46499.9n 0.3840 46500.0n 0.5030 46799.9n 0.5030 46800.0n 0.5370 47099.9n 0.5370 47100.0n 0.6221 47399.9n 0.6221 47400.0n 0.4690 47699.9n 0.4690 47700.0n 0.4010 47999.9n 0.4010 48000.0n 0.3500 48299.9n 0.3500 48300.0n 0.5200 48599.9n 0.5200 48600.0n 0.6221 48899.9n 0.6221 48900.0n 0.3500 49199.9n 0.3500 49200.0n 0.3840 49499.9n 0.3840 49500.0n 0.4010 49799.9n 0.4010 49800.0n 0.5030 50099.9n 0.5030 50100.0n 0.3500 50399.9n 0.3500 50400.0n 0.3500 50699.9n 0.3500 50700.0n 0.4010 50999.9n 0.4010 51000.0n 0.5200 51299.9n 0.5200 51300.0n 0.3500 51599.9n 0.3500 51600.0n 0.3840 51899.9n 0.3840 51900.0n 0.5030 52199.9n 0.5030 52200.0n 0.5370 52499.9n 0.5370 52500.0n 0.6221 52799.9n 0.6221 52800.0n 0.4690 53099.9n 0.4690 53100.0n 0.4010 53399.9n 0.4010 53400.0n 0.3500 53699.9n 0.3500 53700.0n 0.5200 53999.9n 0.5200 54000.0n 0.3500 54299.9n 0.3500 54300.0n 0.4860 54599.9n 0.4860 54600.0n 0.3500 54899.9n 0.3500 54900.0n 0.4690 55199.9n 0.4690 55200.0n 0.4010 55499.9n 0.4010 55500.0n 0.3500 55799.9n 0.3500 55800.0n 0.6221 56099.9n 0.6221 56100.0n 0.6221 56399.9n 0.6221 56400.0n 0.6221 56699.9n 0.6221 56700.0n 0.6221 56999.9n 0.6221 57000.0n 0.6221 57299.9n 0.6221 57300.0n 0.6221 57599.9n 0.6221 57600.0n 0.4860 57899.9n 0.4860 57900.0n 0.3670 58199.9n 0.3670 58200.0n 0.3840 58499.9n 0.3840 58500.0n 0.5540 58799.9n 0.5540 58800.0n 0.4010 59099.9n 0.4010 59100.0n 0.3840)
Vxn27 a_xn27 0 PWL(0.0n 0.3779 299.9n 0.3779 300.0n 0.6500 599.9n 0.6500 600.0n 0.6160 899.9n 0.6160 900.0n 0.5990 1199.9n 0.5990 1200.0n 0.4970 1499.9n 0.4970 1500.0n 0.6500 1799.9n 0.6500 1800.0n 0.6500 2099.9n 0.6500 2100.0n 0.5990 2399.9n 0.5990 2400.0n 0.4800 2699.9n 0.4800 2700.0n 0.6500 2999.9n 0.6500 3000.0n 0.6160 3299.9n 0.6160 3300.0n 0.4970 3599.9n 0.4970 3600.0n 0.4630 3899.9n 0.4630 3900.0n 0.3779 4199.9n 0.3779 4200.0n 0.5310 4499.9n 0.5310 4500.0n 0.5990 4799.9n 0.5990 4800.0n 0.6500 5099.9n 0.6500 5100.0n 0.4800 5399.9n 0.4800 5400.0n 0.3779 5699.9n 0.3779 5700.0n 0.6500 5999.9n 0.6500 6000.0n 0.6160 6299.9n 0.6160 6300.0n 0.5990 6599.9n 0.5990 6600.0n 0.4970 6899.9n 0.4970 6900.0n 0.6500 7199.9n 0.6500 7200.0n 0.6500 7499.9n 0.6500 7500.0n 0.5990 7799.9n 0.5990 7800.0n 0.4800 8099.9n 0.4800 8100.0n 0.6500 8399.9n 0.6500 8400.0n 0.6160 8699.9n 0.6160 8700.0n 0.4970 8999.9n 0.4970 9000.0n 0.4630 9299.9n 0.4630 9300.0n 0.3779 9599.9n 0.3779 9600.0n 0.5310 9899.9n 0.5310 9900.0n 0.5990 10199.9n 0.5990 10200.0n 0.6500 10499.9n 0.6500 10500.0n 0.4800 10799.9n 0.4800 10800.0n 0.3779 11099.9n 0.3779 11100.0n 0.6500 11399.9n 0.6500 11400.0n 0.6160 11699.9n 0.6160 11700.0n 0.5990 11999.9n 0.5990 12000.0n 0.4970 12299.9n 0.4970 12300.0n 0.6500 12599.9n 0.6500 12600.0n 0.6500 12899.9n 0.6500 12900.0n 0.5990 13199.9n 0.5990 13200.0n 0.4800 13499.9n 0.4800 13500.0n 0.6500 13799.9n 0.6500 13800.0n 0.6160 14099.9n 0.6160 14100.0n 0.4970 14399.9n 0.4970 14400.0n 0.4630 14699.9n 0.4630 14700.0n 0.3779 14999.9n 0.3779 15000.0n 0.5310 15299.9n 0.5310 15300.0n 0.5990 15599.9n 0.5990 15600.0n 0.6500 15899.9n 0.6500 15900.0n 0.4800 16199.9n 0.4800 16200.0n 0.3779 16499.9n 0.3779 16500.0n 0.6500 16799.9n 0.6500 16800.0n 0.6160 17099.9n 0.6160 17100.0n 0.5990 17399.9n 0.5990 17400.0n 0.4970 17699.9n 0.4970 17700.0n 0.6500 17999.9n 0.6500 18000.0n 0.6500 18299.9n 0.6500 18300.0n 0.5990 18599.9n 0.5990 18600.0n 0.4800 18899.9n 0.4800 18900.0n 0.6500 19199.9n 0.6500 19200.0n 0.6160 19499.9n 0.6160 19500.0n 0.4970 19799.9n 0.4970 19800.0n 0.4630 20099.9n 0.4630 20100.0n 0.3779 20399.9n 0.3779 20400.0n 0.5310 20699.9n 0.5310 20700.0n 0.5990 20999.9n 0.5990 21000.0n 0.6500 21299.9n 0.6500 21300.0n 0.4800 21599.9n 0.4800 21600.0n 0.3779 21899.9n 0.3779 21900.0n 0.6500 22199.9n 0.6500 22200.0n 0.6160 22499.9n 0.6160 22500.0n 0.5990 22799.9n 0.5990 22800.0n 0.4970 23099.9n 0.4970 23100.0n 0.6500 23399.9n 0.6500 23400.0n 0.6500 23699.9n 0.6500 23700.0n 0.5990 23999.9n 0.5990 24000.0n 0.4800 24299.9n 0.4800 24300.0n 0.6500 24599.9n 0.6500 24600.0n 0.6160 24899.9n 0.6160 24900.0n 0.4970 25199.9n 0.4970 25200.0n 0.4630 25499.9n 0.4630 25500.0n 0.3779 25799.9n 0.3779 25800.0n 0.5310 26099.9n 0.5310 26100.0n 0.5990 26399.9n 0.5990 26400.0n 0.6500 26699.9n 0.6500 26700.0n 0.4800 26999.9n 0.4800 27000.0n 0.3779 27299.9n 0.3779 27300.0n 0.6500 27599.9n 0.6500 27600.0n 0.6160 27899.9n 0.6160 27900.0n 0.5990 28199.9n 0.5990 28200.0n 0.4970 28499.9n 0.4970 28500.0n 0.6500 28799.9n 0.6500 28800.0n 0.6500 29099.9n 0.6500 29100.0n 0.5990 29399.9n 0.5990 29400.0n 0.4800 29699.9n 0.4800 29700.0n 0.6500 29999.9n 0.6500 30000.0n 0.6160 30299.9n 0.6160 30300.0n 0.4970 30599.9n 0.4970 30600.0n 0.4630 30899.9n 0.4630 30900.0n 0.3779 31199.9n 0.3779 31200.0n 0.5310 31499.9n 0.5310 31500.0n 0.5990 31799.9n 0.5990 31800.0n 0.6500 32099.9n 0.6500 32100.0n 0.4800 32399.9n 0.4800 32400.0n 0.3779 32699.9n 0.3779 32700.0n 0.6500 32999.9n 0.6500 33000.0n 0.6160 33299.9n 0.6160 33300.0n 0.5990 33599.9n 0.5990 33600.0n 0.4970 33899.9n 0.4970 33900.0n 0.6500 34199.9n 0.6500 34200.0n 0.6500 34499.9n 0.6500 34500.0n 0.5990 34799.9n 0.5990 34800.0n 0.4800 35099.9n 0.4800 35100.0n 0.6500 35399.9n 0.6500 35400.0n 0.6160 35699.9n 0.6160 35700.0n 0.4970 35999.9n 0.4970 36000.0n 0.4630 36299.9n 0.4630 36300.0n 0.3779 36599.9n 0.3779 36600.0n 0.5310 36899.9n 0.5310 36900.0n 0.5990 37199.9n 0.5990 37200.0n 0.6500 37499.9n 0.6500 37500.0n 0.4800 37799.9n 0.4800 37800.0n 0.3779 38099.9n 0.3779 38100.0n 0.6500 38399.9n 0.6500 38400.0n 0.6160 38699.9n 0.6160 38700.0n 0.5990 38999.9n 0.5990 39000.0n 0.4970 39299.9n 0.4970 39300.0n 0.6500 39599.9n 0.6500 39600.0n 0.6500 39899.9n 0.6500 39900.0n 0.5990 40199.9n 0.5990 40200.0n 0.4800 40499.9n 0.4800 40500.0n 0.6500 40799.9n 0.6500 40800.0n 0.6160 41099.9n 0.6160 41100.0n 0.4970 41399.9n 0.4970 41400.0n 0.4630 41699.9n 0.4630 41700.0n 0.3779 41999.9n 0.3779 42000.0n 0.5310 42299.9n 0.5310 42300.0n 0.5990 42599.9n 0.5990 42600.0n 0.6500 42899.9n 0.6500 42900.0n 0.4800 43199.9n 0.4800 43200.0n 0.3779 43499.9n 0.3779 43500.0n 0.6500 43799.9n 0.6500 43800.0n 0.6160 44099.9n 0.6160 44100.0n 0.5990 44399.9n 0.5990 44400.0n 0.4970 44699.9n 0.4970 44700.0n 0.6500 44999.9n 0.6500 45000.0n 0.6500 45299.9n 0.6500 45300.0n 0.5990 45599.9n 0.5990 45600.0n 0.4800 45899.9n 0.4800 45900.0n 0.6500 46199.9n 0.6500 46200.0n 0.6160 46499.9n 0.6160 46500.0n 0.4970 46799.9n 0.4970 46800.0n 0.4630 47099.9n 0.4630 47100.0n 0.3779 47399.9n 0.3779 47400.0n 0.5310 47699.9n 0.5310 47700.0n 0.5990 47999.9n 0.5990 48000.0n 0.6500 48299.9n 0.6500 48300.0n 0.4800 48599.9n 0.4800 48600.0n 0.3779 48899.9n 0.3779 48900.0n 0.6500 49199.9n 0.6500 49200.0n 0.6160 49499.9n 0.6160 49500.0n 0.5990 49799.9n 0.5990 49800.0n 0.4970 50099.9n 0.4970 50100.0n 0.6500 50399.9n 0.6500 50400.0n 0.6500 50699.9n 0.6500 50700.0n 0.5990 50999.9n 0.5990 51000.0n 0.4800 51299.9n 0.4800 51300.0n 0.6500 51599.9n 0.6500 51600.0n 0.6160 51899.9n 0.6160 51900.0n 0.4970 52199.9n 0.4970 52200.0n 0.4630 52499.9n 0.4630 52500.0n 0.3779 52799.9n 0.3779 52800.0n 0.5310 53099.9n 0.5310 53100.0n 0.5990 53399.9n 0.5990 53400.0n 0.6500 53699.9n 0.6500 53700.0n 0.4800 53999.9n 0.4800 54000.0n 0.6500 54299.9n 0.6500 54300.0n 0.5140 54599.9n 0.5140 54600.0n 0.6500 54899.9n 0.6500 54900.0n 0.5310 55199.9n 0.5310 55200.0n 0.5990 55499.9n 0.5990 55500.0n 0.6500 55799.9n 0.6500 55800.0n 0.3779 56099.9n 0.3779 56100.0n 0.3779 56399.9n 0.3779 56400.0n 0.3779 56699.9n 0.3779 56700.0n 0.3779 56999.9n 0.3779 57000.0n 0.3779 57299.9n 0.3779 57300.0n 0.3779 57599.9n 0.3779 57600.0n 0.5140 57899.9n 0.5140 57900.0n 0.6330 58199.9n 0.6330 58200.0n 0.6160 58499.9n 0.6160 58500.0n 0.4460 58799.9n 0.4460 58800.0n 0.5990 59099.9n 0.5990 59100.0n 0.6160)
Vxp28 a_xp28 0 PWL(0.0n 0.5987 299.9n 0.5987 300.0n 0.3386 599.9n 0.3386 600.0n 0.3386 899.9n 0.3386 900.0n 0.3386 1199.9n 0.3386 1200.0n 0.5987 1499.9n 0.5987 1500.0n 0.3386 1799.9n 0.3386 1800.0n 0.3386 2099.9n 0.3386 2100.0n 0.3386 2399.9n 0.3386 2400.0n 0.4687 2699.9n 0.4687 2700.0n 0.5174 2999.9n 0.5174 3000.0n 0.5987 3299.9n 0.5987 3300.0n 0.5987 3599.9n 0.5987 3600.0n 0.5987 3899.9n 0.5987 3900.0n 0.5987 4199.9n 0.5987 4200.0n 0.5825 4499.9n 0.5825 4500.0n 0.5987 4799.9n 0.5987 4800.0n 0.3386 5099.9n 0.3386 5100.0n 0.5987 5399.9n 0.5987 5400.0n 0.5987 5699.9n 0.5987 5700.0n 0.3386 5999.9n 0.3386 6000.0n 0.3386 6299.9n 0.3386 6300.0n 0.3386 6599.9n 0.3386 6600.0n 0.5987 6899.9n 0.5987 6900.0n 0.3386 7199.9n 0.3386 7200.0n 0.3386 7499.9n 0.3386 7500.0n 0.3386 7799.9n 0.3386 7800.0n 0.4687 8099.9n 0.4687 8100.0n 0.5174 8399.9n 0.5174 8400.0n 0.5987 8699.9n 0.5987 8700.0n 0.5987 8999.9n 0.5987 9000.0n 0.5987 9299.9n 0.5987 9300.0n 0.5987 9599.9n 0.5987 9600.0n 0.5825 9899.9n 0.5825 9900.0n 0.5987 10199.9n 0.5987 10200.0n 0.3386 10499.9n 0.3386 10500.0n 0.5987 10799.9n 0.5987 10800.0n 0.5987 11099.9n 0.5987 11100.0n 0.3386 11399.9n 0.3386 11400.0n 0.3386 11699.9n 0.3386 11700.0n 0.3386 11999.9n 0.3386 12000.0n 0.5987 12299.9n 0.5987 12300.0n 0.3386 12599.9n 0.3386 12600.0n 0.3386 12899.9n 0.3386 12900.0n 0.3386 13199.9n 0.3386 13200.0n 0.4687 13499.9n 0.4687 13500.0n 0.5174 13799.9n 0.5174 13800.0n 0.5987 14099.9n 0.5987 14100.0n 0.5987 14399.9n 0.5987 14400.0n 0.5987 14699.9n 0.5987 14700.0n 0.5987 14999.9n 0.5987 15000.0n 0.5825 15299.9n 0.5825 15300.0n 0.5987 15599.9n 0.5987 15600.0n 0.3386 15899.9n 0.3386 15900.0n 0.5987 16199.9n 0.5987 16200.0n 0.5987 16499.9n 0.5987 16500.0n 0.3386 16799.9n 0.3386 16800.0n 0.3386 17099.9n 0.3386 17100.0n 0.3386 17399.9n 0.3386 17400.0n 0.5987 17699.9n 0.5987 17700.0n 0.3386 17999.9n 0.3386 18000.0n 0.3386 18299.9n 0.3386 18300.0n 0.3386 18599.9n 0.3386 18600.0n 0.4687 18899.9n 0.4687 18900.0n 0.5174 19199.9n 0.5174 19200.0n 0.5987 19499.9n 0.5987 19500.0n 0.5987 19799.9n 0.5987 19800.0n 0.5987 20099.9n 0.5987 20100.0n 0.5987 20399.9n 0.5987 20400.0n 0.5825 20699.9n 0.5825 20700.0n 0.5987 20999.9n 0.5987 21000.0n 0.3386 21299.9n 0.3386 21300.0n 0.5987 21599.9n 0.5987 21600.0n 0.5987 21899.9n 0.5987 21900.0n 0.3386 22199.9n 0.3386 22200.0n 0.3386 22499.9n 0.3386 22500.0n 0.3386 22799.9n 0.3386 22800.0n 0.5987 23099.9n 0.5987 23100.0n 0.3386 23399.9n 0.3386 23400.0n 0.3386 23699.9n 0.3386 23700.0n 0.3386 23999.9n 0.3386 24000.0n 0.4687 24299.9n 0.4687 24300.0n 0.5174 24599.9n 0.5174 24600.0n 0.5987 24899.9n 0.5987 24900.0n 0.5987 25199.9n 0.5987 25200.0n 0.5987 25499.9n 0.5987 25500.0n 0.5987 25799.9n 0.5987 25800.0n 0.5825 26099.9n 0.5825 26100.0n 0.5987 26399.9n 0.5987 26400.0n 0.3386 26699.9n 0.3386 26700.0n 0.5987 26999.9n 0.5987 27000.0n 0.5987 27299.9n 0.5987 27300.0n 0.3386 27599.9n 0.3386 27600.0n 0.3386 27899.9n 0.3386 27900.0n 0.3386 28199.9n 0.3386 28200.0n 0.5987 28499.9n 0.5987 28500.0n 0.3386 28799.9n 0.3386 28800.0n 0.3386 29099.9n 0.3386 29100.0n 0.3386 29399.9n 0.3386 29400.0n 0.4687 29699.9n 0.4687 29700.0n 0.5174 29999.9n 0.5174 30000.0n 0.5987 30299.9n 0.5987 30300.0n 0.5987 30599.9n 0.5987 30600.0n 0.5987 30899.9n 0.5987 30900.0n 0.5987 31199.9n 0.5987 31200.0n 0.5825 31499.9n 0.5825 31500.0n 0.5987 31799.9n 0.5987 31800.0n 0.3386 32099.9n 0.3386 32100.0n 0.5987 32399.9n 0.5987 32400.0n 0.5987 32699.9n 0.5987 32700.0n 0.3386 32999.9n 0.3386 33000.0n 0.3386 33299.9n 0.3386 33300.0n 0.3386 33599.9n 0.3386 33600.0n 0.5987 33899.9n 0.5987 33900.0n 0.3386 34199.9n 0.3386 34200.0n 0.3386 34499.9n 0.3386 34500.0n 0.3386 34799.9n 0.3386 34800.0n 0.4687 35099.9n 0.4687 35100.0n 0.5174 35399.9n 0.5174 35400.0n 0.5987 35699.9n 0.5987 35700.0n 0.5987 35999.9n 0.5987 36000.0n 0.5987 36299.9n 0.5987 36300.0n 0.5987 36599.9n 0.5987 36600.0n 0.5825 36899.9n 0.5825 36900.0n 0.5987 37199.9n 0.5987 37200.0n 0.3386 37499.9n 0.3386 37500.0n 0.5987 37799.9n 0.5987 37800.0n 0.5987 38099.9n 0.5987 38100.0n 0.3386 38399.9n 0.3386 38400.0n 0.3386 38699.9n 0.3386 38700.0n 0.3386 38999.9n 0.3386 39000.0n 0.5987 39299.9n 0.5987 39300.0n 0.3386 39599.9n 0.3386 39600.0n 0.3386 39899.9n 0.3386 39900.0n 0.3386 40199.9n 0.3386 40200.0n 0.4687 40499.9n 0.4687 40500.0n 0.5174 40799.9n 0.5174 40800.0n 0.5987 41099.9n 0.5987 41100.0n 0.5987 41399.9n 0.5987 41400.0n 0.5987 41699.9n 0.5987 41700.0n 0.5987 41999.9n 0.5987 42000.0n 0.5825 42299.9n 0.5825 42300.0n 0.5987 42599.9n 0.5987 42600.0n 0.3386 42899.9n 0.3386 42900.0n 0.5987 43199.9n 0.5987 43200.0n 0.5987 43499.9n 0.5987 43500.0n 0.3386 43799.9n 0.3386 43800.0n 0.3386 44099.9n 0.3386 44100.0n 0.3386 44399.9n 0.3386 44400.0n 0.5987 44699.9n 0.5987 44700.0n 0.3386 44999.9n 0.3386 45000.0n 0.3386 45299.9n 0.3386 45300.0n 0.3386 45599.9n 0.3386 45600.0n 0.4687 45899.9n 0.4687 45900.0n 0.5174 46199.9n 0.5174 46200.0n 0.5987 46499.9n 0.5987 46500.0n 0.5987 46799.9n 0.5987 46800.0n 0.5987 47099.9n 0.5987 47100.0n 0.5987 47399.9n 0.5987 47400.0n 0.5825 47699.9n 0.5825 47700.0n 0.5987 47999.9n 0.5987 48000.0n 0.3386 48299.9n 0.3386 48300.0n 0.5987 48599.9n 0.5987 48600.0n 0.5987 48899.9n 0.5987 48900.0n 0.3386 49199.9n 0.3386 49200.0n 0.3386 49499.9n 0.3386 49500.0n 0.3386 49799.9n 0.3386 49800.0n 0.5987 50099.9n 0.5987 50100.0n 0.3386 50399.9n 0.3386 50400.0n 0.3386 50699.9n 0.3386 50700.0n 0.3386 50999.9n 0.3386 51000.0n 0.4687 51299.9n 0.4687 51300.0n 0.5174 51599.9n 0.5174 51600.0n 0.5987 51899.9n 0.5987 51900.0n 0.5987 52199.9n 0.5987 52200.0n 0.5987 52499.9n 0.5987 52500.0n 0.5987 52799.9n 0.5987 52800.0n 0.5825 53099.9n 0.5825 53100.0n 0.5987 53399.9n 0.5987 53400.0n 0.3386 53699.9n 0.3386 53700.0n 0.5987 53999.9n 0.5987 54000.0n 0.3386 54299.9n 0.3386 54300.0n 0.3386 54599.9n 0.3386 54600.0n 0.3386 54899.9n 0.3386 54900.0n 0.3386 55199.9n 0.3386 55200.0n 0.3386 55499.9n 0.3386 55500.0n 0.3386 55799.9n 0.3386 55800.0n 0.5825 56099.9n 0.5825 56100.0n 0.5987 56399.9n 0.5987 56400.0n 0.5987 56699.9n 0.5987 56700.0n 0.4849 56999.9n 0.4849 57000.0n 0.5987 57299.9n 0.5987 57300.0n 0.5987 57599.9n 0.5987 57600.0n 0.5337 57899.9n 0.5337 57900.0n 0.5987 58199.9n 0.5987 58200.0n 0.5987 58499.9n 0.5987 58500.0n 0.5500 58799.9n 0.5500 58800.0n 0.5987 59099.9n 0.5987 59100.0n 0.5825)
Vxn28 a_xn28 0 PWL(0.0n 0.4013 299.9n 0.4013 300.0n 0.6614 599.9n 0.6614 600.0n 0.6614 899.9n 0.6614 900.0n 0.6614 1199.9n 0.6614 1200.0n 0.4013 1499.9n 0.4013 1500.0n 0.6614 1799.9n 0.6614 1800.0n 0.6614 2099.9n 0.6614 2100.0n 0.6614 2399.9n 0.6614 2400.0n 0.5313 2699.9n 0.5313 2700.0n 0.4826 2999.9n 0.4826 3000.0n 0.4013 3299.9n 0.4013 3300.0n 0.4013 3599.9n 0.4013 3600.0n 0.4013 3899.9n 0.4013 3900.0n 0.4013 4199.9n 0.4013 4200.0n 0.4175 4499.9n 0.4175 4500.0n 0.4013 4799.9n 0.4013 4800.0n 0.6614 5099.9n 0.6614 5100.0n 0.4013 5399.9n 0.4013 5400.0n 0.4013 5699.9n 0.4013 5700.0n 0.6614 5999.9n 0.6614 6000.0n 0.6614 6299.9n 0.6614 6300.0n 0.6614 6599.9n 0.6614 6600.0n 0.4013 6899.9n 0.4013 6900.0n 0.6614 7199.9n 0.6614 7200.0n 0.6614 7499.9n 0.6614 7500.0n 0.6614 7799.9n 0.6614 7800.0n 0.5313 8099.9n 0.5313 8100.0n 0.4826 8399.9n 0.4826 8400.0n 0.4013 8699.9n 0.4013 8700.0n 0.4013 8999.9n 0.4013 9000.0n 0.4013 9299.9n 0.4013 9300.0n 0.4013 9599.9n 0.4013 9600.0n 0.4175 9899.9n 0.4175 9900.0n 0.4013 10199.9n 0.4013 10200.0n 0.6614 10499.9n 0.6614 10500.0n 0.4013 10799.9n 0.4013 10800.0n 0.4013 11099.9n 0.4013 11100.0n 0.6614 11399.9n 0.6614 11400.0n 0.6614 11699.9n 0.6614 11700.0n 0.6614 11999.9n 0.6614 12000.0n 0.4013 12299.9n 0.4013 12300.0n 0.6614 12599.9n 0.6614 12600.0n 0.6614 12899.9n 0.6614 12900.0n 0.6614 13199.9n 0.6614 13200.0n 0.5313 13499.9n 0.5313 13500.0n 0.4826 13799.9n 0.4826 13800.0n 0.4013 14099.9n 0.4013 14100.0n 0.4013 14399.9n 0.4013 14400.0n 0.4013 14699.9n 0.4013 14700.0n 0.4013 14999.9n 0.4013 15000.0n 0.4175 15299.9n 0.4175 15300.0n 0.4013 15599.9n 0.4013 15600.0n 0.6614 15899.9n 0.6614 15900.0n 0.4013 16199.9n 0.4013 16200.0n 0.4013 16499.9n 0.4013 16500.0n 0.6614 16799.9n 0.6614 16800.0n 0.6614 17099.9n 0.6614 17100.0n 0.6614 17399.9n 0.6614 17400.0n 0.4013 17699.9n 0.4013 17700.0n 0.6614 17999.9n 0.6614 18000.0n 0.6614 18299.9n 0.6614 18300.0n 0.6614 18599.9n 0.6614 18600.0n 0.5313 18899.9n 0.5313 18900.0n 0.4826 19199.9n 0.4826 19200.0n 0.4013 19499.9n 0.4013 19500.0n 0.4013 19799.9n 0.4013 19800.0n 0.4013 20099.9n 0.4013 20100.0n 0.4013 20399.9n 0.4013 20400.0n 0.4175 20699.9n 0.4175 20700.0n 0.4013 20999.9n 0.4013 21000.0n 0.6614 21299.9n 0.6614 21300.0n 0.4013 21599.9n 0.4013 21600.0n 0.4013 21899.9n 0.4013 21900.0n 0.6614 22199.9n 0.6614 22200.0n 0.6614 22499.9n 0.6614 22500.0n 0.6614 22799.9n 0.6614 22800.0n 0.4013 23099.9n 0.4013 23100.0n 0.6614 23399.9n 0.6614 23400.0n 0.6614 23699.9n 0.6614 23700.0n 0.6614 23999.9n 0.6614 24000.0n 0.5313 24299.9n 0.5313 24300.0n 0.4826 24599.9n 0.4826 24600.0n 0.4013 24899.9n 0.4013 24900.0n 0.4013 25199.9n 0.4013 25200.0n 0.4013 25499.9n 0.4013 25500.0n 0.4013 25799.9n 0.4013 25800.0n 0.4175 26099.9n 0.4175 26100.0n 0.4013 26399.9n 0.4013 26400.0n 0.6614 26699.9n 0.6614 26700.0n 0.4013 26999.9n 0.4013 27000.0n 0.4013 27299.9n 0.4013 27300.0n 0.6614 27599.9n 0.6614 27600.0n 0.6614 27899.9n 0.6614 27900.0n 0.6614 28199.9n 0.6614 28200.0n 0.4013 28499.9n 0.4013 28500.0n 0.6614 28799.9n 0.6614 28800.0n 0.6614 29099.9n 0.6614 29100.0n 0.6614 29399.9n 0.6614 29400.0n 0.5313 29699.9n 0.5313 29700.0n 0.4826 29999.9n 0.4826 30000.0n 0.4013 30299.9n 0.4013 30300.0n 0.4013 30599.9n 0.4013 30600.0n 0.4013 30899.9n 0.4013 30900.0n 0.4013 31199.9n 0.4013 31200.0n 0.4175 31499.9n 0.4175 31500.0n 0.4013 31799.9n 0.4013 31800.0n 0.6614 32099.9n 0.6614 32100.0n 0.4013 32399.9n 0.4013 32400.0n 0.4013 32699.9n 0.4013 32700.0n 0.6614 32999.9n 0.6614 33000.0n 0.6614 33299.9n 0.6614 33300.0n 0.6614 33599.9n 0.6614 33600.0n 0.4013 33899.9n 0.4013 33900.0n 0.6614 34199.9n 0.6614 34200.0n 0.6614 34499.9n 0.6614 34500.0n 0.6614 34799.9n 0.6614 34800.0n 0.5313 35099.9n 0.5313 35100.0n 0.4826 35399.9n 0.4826 35400.0n 0.4013 35699.9n 0.4013 35700.0n 0.4013 35999.9n 0.4013 36000.0n 0.4013 36299.9n 0.4013 36300.0n 0.4013 36599.9n 0.4013 36600.0n 0.4175 36899.9n 0.4175 36900.0n 0.4013 37199.9n 0.4013 37200.0n 0.6614 37499.9n 0.6614 37500.0n 0.4013 37799.9n 0.4013 37800.0n 0.4013 38099.9n 0.4013 38100.0n 0.6614 38399.9n 0.6614 38400.0n 0.6614 38699.9n 0.6614 38700.0n 0.6614 38999.9n 0.6614 39000.0n 0.4013 39299.9n 0.4013 39300.0n 0.6614 39599.9n 0.6614 39600.0n 0.6614 39899.9n 0.6614 39900.0n 0.6614 40199.9n 0.6614 40200.0n 0.5313 40499.9n 0.5313 40500.0n 0.4826 40799.9n 0.4826 40800.0n 0.4013 41099.9n 0.4013 41100.0n 0.4013 41399.9n 0.4013 41400.0n 0.4013 41699.9n 0.4013 41700.0n 0.4013 41999.9n 0.4013 42000.0n 0.4175 42299.9n 0.4175 42300.0n 0.4013 42599.9n 0.4013 42600.0n 0.6614 42899.9n 0.6614 42900.0n 0.4013 43199.9n 0.4013 43200.0n 0.4013 43499.9n 0.4013 43500.0n 0.6614 43799.9n 0.6614 43800.0n 0.6614 44099.9n 0.6614 44100.0n 0.6614 44399.9n 0.6614 44400.0n 0.4013 44699.9n 0.4013 44700.0n 0.6614 44999.9n 0.6614 45000.0n 0.6614 45299.9n 0.6614 45300.0n 0.6614 45599.9n 0.6614 45600.0n 0.5313 45899.9n 0.5313 45900.0n 0.4826 46199.9n 0.4826 46200.0n 0.4013 46499.9n 0.4013 46500.0n 0.4013 46799.9n 0.4013 46800.0n 0.4013 47099.9n 0.4013 47100.0n 0.4013 47399.9n 0.4013 47400.0n 0.4175 47699.9n 0.4175 47700.0n 0.4013 47999.9n 0.4013 48000.0n 0.6614 48299.9n 0.6614 48300.0n 0.4013 48599.9n 0.4013 48600.0n 0.4013 48899.9n 0.4013 48900.0n 0.6614 49199.9n 0.6614 49200.0n 0.6614 49499.9n 0.6614 49500.0n 0.6614 49799.9n 0.6614 49800.0n 0.4013 50099.9n 0.4013 50100.0n 0.6614 50399.9n 0.6614 50400.0n 0.6614 50699.9n 0.6614 50700.0n 0.6614 50999.9n 0.6614 51000.0n 0.5313 51299.9n 0.5313 51300.0n 0.4826 51599.9n 0.4826 51600.0n 0.4013 51899.9n 0.4013 51900.0n 0.4013 52199.9n 0.4013 52200.0n 0.4013 52499.9n 0.4013 52500.0n 0.4013 52799.9n 0.4013 52800.0n 0.4175 53099.9n 0.4175 53100.0n 0.4013 53399.9n 0.4013 53400.0n 0.6614 53699.9n 0.6614 53700.0n 0.4013 53999.9n 0.4013 54000.0n 0.6614 54299.9n 0.6614 54300.0n 0.6614 54599.9n 0.6614 54600.0n 0.6614 54899.9n 0.6614 54900.0n 0.6614 55199.9n 0.6614 55200.0n 0.6614 55499.9n 0.6614 55500.0n 0.6614 55799.9n 0.6614 55800.0n 0.4175 56099.9n 0.4175 56100.0n 0.4013 56399.9n 0.4013 56400.0n 0.4013 56699.9n 0.4013 56700.0n 0.5151 56999.9n 0.5151 57000.0n 0.4013 57299.9n 0.4013 57300.0n 0.4013 57599.9n 0.4013 57600.0n 0.4663 57899.9n 0.4663 57900.0n 0.4013 58199.9n 0.4013 58200.0n 0.4013 58499.9n 0.4013 58500.0n 0.4500 58799.9n 0.4500 58800.0n 0.4013 59099.9n 0.4013 59100.0n 0.4175)
Vxp29 a_xp29 0 PWL(0.0n 0.6439 299.9n 0.6439 300.0n 0.5247 599.9n 0.5247 600.0n 0.4906 899.9n 0.4906 900.0n 0.5076 1199.9n 0.5076 1200.0n 0.6439 1499.9n 0.6439 1500.0n 0.5076 1799.9n 0.5076 1800.0n 0.4906 2099.9n 0.4906 2100.0n 0.6439 2399.9n 0.6439 2400.0n 0.3714 2699.9n 0.3714 2700.0n 0.5417 2999.9n 0.5417 3000.0n 0.3714 3299.9n 0.3714 3300.0n 0.4054 3599.9n 0.4054 3600.0n 0.4054 3899.9n 0.4054 3900.0n 0.4565 4199.9n 0.4565 4200.0n 0.3714 4499.9n 0.3714 4500.0n 0.3884 4799.9n 0.3884 4800.0n 0.4906 5099.9n 0.4906 5100.0n 0.6269 5399.9n 0.6269 5400.0n 0.6439 5699.9n 0.6439 5700.0n 0.5247 5999.9n 0.5247 6000.0n 0.4906 6299.9n 0.4906 6300.0n 0.5076 6599.9n 0.5076 6600.0n 0.6439 6899.9n 0.6439 6900.0n 0.5076 7199.9n 0.5076 7200.0n 0.4906 7499.9n 0.4906 7500.0n 0.6439 7799.9n 0.6439 7800.0n 0.3714 8099.9n 0.3714 8100.0n 0.5417 8399.9n 0.5417 8400.0n 0.3714 8699.9n 0.3714 8700.0n 0.4054 8999.9n 0.4054 9000.0n 0.4054 9299.9n 0.4054 9300.0n 0.4565 9599.9n 0.4565 9600.0n 0.3714 9899.9n 0.3714 9900.0n 0.3884 10199.9n 0.3884 10200.0n 0.4906 10499.9n 0.4906 10500.0n 0.6269 10799.9n 0.6269 10800.0n 0.6439 11099.9n 0.6439 11100.0n 0.5247 11399.9n 0.5247 11400.0n 0.4906 11699.9n 0.4906 11700.0n 0.5076 11999.9n 0.5076 12000.0n 0.6439 12299.9n 0.6439 12300.0n 0.5076 12599.9n 0.5076 12600.0n 0.4906 12899.9n 0.4906 12900.0n 0.6439 13199.9n 0.6439 13200.0n 0.3714 13499.9n 0.3714 13500.0n 0.5417 13799.9n 0.5417 13800.0n 0.3714 14099.9n 0.3714 14100.0n 0.4054 14399.9n 0.4054 14400.0n 0.4054 14699.9n 0.4054 14700.0n 0.4565 14999.9n 0.4565 15000.0n 0.3714 15299.9n 0.3714 15300.0n 0.3884 15599.9n 0.3884 15600.0n 0.4906 15899.9n 0.4906 15900.0n 0.6269 16199.9n 0.6269 16200.0n 0.6439 16499.9n 0.6439 16500.0n 0.5247 16799.9n 0.5247 16800.0n 0.4906 17099.9n 0.4906 17100.0n 0.5076 17399.9n 0.5076 17400.0n 0.6439 17699.9n 0.6439 17700.0n 0.5076 17999.9n 0.5076 18000.0n 0.4906 18299.9n 0.4906 18300.0n 0.6439 18599.9n 0.6439 18600.0n 0.3714 18899.9n 0.3714 18900.0n 0.5417 19199.9n 0.5417 19200.0n 0.3714 19499.9n 0.3714 19500.0n 0.4054 19799.9n 0.4054 19800.0n 0.4054 20099.9n 0.4054 20100.0n 0.4565 20399.9n 0.4565 20400.0n 0.3714 20699.9n 0.3714 20700.0n 0.3884 20999.9n 0.3884 21000.0n 0.4906 21299.9n 0.4906 21300.0n 0.6269 21599.9n 0.6269 21600.0n 0.6439 21899.9n 0.6439 21900.0n 0.5247 22199.9n 0.5247 22200.0n 0.4906 22499.9n 0.4906 22500.0n 0.5076 22799.9n 0.5076 22800.0n 0.6439 23099.9n 0.6439 23100.0n 0.5076 23399.9n 0.5076 23400.0n 0.4906 23699.9n 0.4906 23700.0n 0.6439 23999.9n 0.6439 24000.0n 0.3714 24299.9n 0.3714 24300.0n 0.5417 24599.9n 0.5417 24600.0n 0.3714 24899.9n 0.3714 24900.0n 0.4054 25199.9n 0.4054 25200.0n 0.4054 25499.9n 0.4054 25500.0n 0.4565 25799.9n 0.4565 25800.0n 0.3714 26099.9n 0.3714 26100.0n 0.3884 26399.9n 0.3884 26400.0n 0.4906 26699.9n 0.4906 26700.0n 0.6269 26999.9n 0.6269 27000.0n 0.6439 27299.9n 0.6439 27300.0n 0.5247 27599.9n 0.5247 27600.0n 0.4906 27899.9n 0.4906 27900.0n 0.5076 28199.9n 0.5076 28200.0n 0.6439 28499.9n 0.6439 28500.0n 0.5076 28799.9n 0.5076 28800.0n 0.4906 29099.9n 0.4906 29100.0n 0.6439 29399.9n 0.6439 29400.0n 0.3714 29699.9n 0.3714 29700.0n 0.5417 29999.9n 0.5417 30000.0n 0.3714 30299.9n 0.3714 30300.0n 0.4054 30599.9n 0.4054 30600.0n 0.4054 30899.9n 0.4054 30900.0n 0.4565 31199.9n 0.4565 31200.0n 0.3714 31499.9n 0.3714 31500.0n 0.3884 31799.9n 0.3884 31800.0n 0.4906 32099.9n 0.4906 32100.0n 0.6269 32399.9n 0.6269 32400.0n 0.6439 32699.9n 0.6439 32700.0n 0.5247 32999.9n 0.5247 33000.0n 0.4906 33299.9n 0.4906 33300.0n 0.5076 33599.9n 0.5076 33600.0n 0.6439 33899.9n 0.6439 33900.0n 0.5076 34199.9n 0.5076 34200.0n 0.4906 34499.9n 0.4906 34500.0n 0.6439 34799.9n 0.6439 34800.0n 0.3714 35099.9n 0.3714 35100.0n 0.5417 35399.9n 0.5417 35400.0n 0.3714 35699.9n 0.3714 35700.0n 0.4054 35999.9n 0.4054 36000.0n 0.4054 36299.9n 0.4054 36300.0n 0.4565 36599.9n 0.4565 36600.0n 0.3714 36899.9n 0.3714 36900.0n 0.3884 37199.9n 0.3884 37200.0n 0.4906 37499.9n 0.4906 37500.0n 0.6269 37799.9n 0.6269 37800.0n 0.6439 38099.9n 0.6439 38100.0n 0.5247 38399.9n 0.5247 38400.0n 0.4906 38699.9n 0.4906 38700.0n 0.5076 38999.9n 0.5076 39000.0n 0.6439 39299.9n 0.6439 39300.0n 0.5076 39599.9n 0.5076 39600.0n 0.4906 39899.9n 0.4906 39900.0n 0.6439 40199.9n 0.6439 40200.0n 0.3714 40499.9n 0.3714 40500.0n 0.5417 40799.9n 0.5417 40800.0n 0.3714 41099.9n 0.3714 41100.0n 0.4054 41399.9n 0.4054 41400.0n 0.4054 41699.9n 0.4054 41700.0n 0.4565 41999.9n 0.4565 42000.0n 0.3714 42299.9n 0.3714 42300.0n 0.3884 42599.9n 0.3884 42600.0n 0.4906 42899.9n 0.4906 42900.0n 0.6269 43199.9n 0.6269 43200.0n 0.6439 43499.9n 0.6439 43500.0n 0.5247 43799.9n 0.5247 43800.0n 0.4906 44099.9n 0.4906 44100.0n 0.5076 44399.9n 0.5076 44400.0n 0.6439 44699.9n 0.6439 44700.0n 0.5076 44999.9n 0.5076 45000.0n 0.4906 45299.9n 0.4906 45300.0n 0.6439 45599.9n 0.6439 45600.0n 0.3714 45899.9n 0.3714 45900.0n 0.5417 46199.9n 0.5417 46200.0n 0.3714 46499.9n 0.3714 46500.0n 0.4054 46799.9n 0.4054 46800.0n 0.4054 47099.9n 0.4054 47100.0n 0.4565 47399.9n 0.4565 47400.0n 0.3714 47699.9n 0.3714 47700.0n 0.3884 47999.9n 0.3884 48000.0n 0.4906 48299.9n 0.4906 48300.0n 0.6269 48599.9n 0.6269 48600.0n 0.6439 48899.9n 0.6439 48900.0n 0.5247 49199.9n 0.5247 49200.0n 0.4906 49499.9n 0.4906 49500.0n 0.5076 49799.9n 0.5076 49800.0n 0.6439 50099.9n 0.6439 50100.0n 0.5076 50399.9n 0.5076 50400.0n 0.4906 50699.9n 0.4906 50700.0n 0.6439 50999.9n 0.6439 51000.0n 0.3714 51299.9n 0.3714 51300.0n 0.5417 51599.9n 0.5417 51600.0n 0.3714 51899.9n 0.3714 51900.0n 0.4054 52199.9n 0.4054 52200.0n 0.4054 52499.9n 0.4054 52500.0n 0.4565 52799.9n 0.4565 52800.0n 0.3714 53099.9n 0.3714 53100.0n 0.3884 53399.9n 0.3884 53400.0n 0.4906 53699.9n 0.4906 53700.0n 0.6269 53999.9n 0.6269 54000.0n 0.5417 54299.9n 0.5417 54300.0n 0.4225 54599.9n 0.4225 54600.0n 0.5247 54899.9n 0.5247 54900.0n 0.6439 55199.9n 0.6439 55200.0n 0.4395 55499.9n 0.4395 55500.0n 0.4906 55799.9n 0.4906 55800.0n 0.4054 56099.9n 0.4054 56100.0n 0.4054 56399.9n 0.4054 56400.0n 0.5417 56699.9n 0.5417 56700.0n 0.3714 56999.9n 0.3714 57000.0n 0.6269 57299.9n 0.6269 57300.0n 0.4906 57599.9n 0.4906 57600.0n 0.3714 57899.9n 0.3714 57900.0n 0.4736 58199.9n 0.4736 58200.0n 0.4054 58499.9n 0.4054 58500.0n 0.3714 58799.9n 0.3714 58800.0n 0.4054 59099.9n 0.4054 59100.0n 0.4054)
Vxn29 a_xn29 0 PWL(0.0n 0.3561 299.9n 0.3561 300.0n 0.4753 599.9n 0.4753 600.0n 0.5094 899.9n 0.5094 900.0n 0.4924 1199.9n 0.4924 1200.0n 0.3561 1499.9n 0.3561 1500.0n 0.4924 1799.9n 0.4924 1800.0n 0.5094 2099.9n 0.5094 2100.0n 0.3561 2399.9n 0.3561 2400.0n 0.6286 2699.9n 0.6286 2700.0n 0.4583 2999.9n 0.4583 3000.0n 0.6286 3299.9n 0.6286 3300.0n 0.5946 3599.9n 0.5946 3600.0n 0.5946 3899.9n 0.5946 3900.0n 0.5435 4199.9n 0.5435 4200.0n 0.6286 4499.9n 0.6286 4500.0n 0.6116 4799.9n 0.6116 4800.0n 0.5094 5099.9n 0.5094 5100.0n 0.3731 5399.9n 0.3731 5400.0n 0.3561 5699.9n 0.3561 5700.0n 0.4753 5999.9n 0.4753 6000.0n 0.5094 6299.9n 0.5094 6300.0n 0.4924 6599.9n 0.4924 6600.0n 0.3561 6899.9n 0.3561 6900.0n 0.4924 7199.9n 0.4924 7200.0n 0.5094 7499.9n 0.5094 7500.0n 0.3561 7799.9n 0.3561 7800.0n 0.6286 8099.9n 0.6286 8100.0n 0.4583 8399.9n 0.4583 8400.0n 0.6286 8699.9n 0.6286 8700.0n 0.5946 8999.9n 0.5946 9000.0n 0.5946 9299.9n 0.5946 9300.0n 0.5435 9599.9n 0.5435 9600.0n 0.6286 9899.9n 0.6286 9900.0n 0.6116 10199.9n 0.6116 10200.0n 0.5094 10499.9n 0.5094 10500.0n 0.3731 10799.9n 0.3731 10800.0n 0.3561 11099.9n 0.3561 11100.0n 0.4753 11399.9n 0.4753 11400.0n 0.5094 11699.9n 0.5094 11700.0n 0.4924 11999.9n 0.4924 12000.0n 0.3561 12299.9n 0.3561 12300.0n 0.4924 12599.9n 0.4924 12600.0n 0.5094 12899.9n 0.5094 12900.0n 0.3561 13199.9n 0.3561 13200.0n 0.6286 13499.9n 0.6286 13500.0n 0.4583 13799.9n 0.4583 13800.0n 0.6286 14099.9n 0.6286 14100.0n 0.5946 14399.9n 0.5946 14400.0n 0.5946 14699.9n 0.5946 14700.0n 0.5435 14999.9n 0.5435 15000.0n 0.6286 15299.9n 0.6286 15300.0n 0.6116 15599.9n 0.6116 15600.0n 0.5094 15899.9n 0.5094 15900.0n 0.3731 16199.9n 0.3731 16200.0n 0.3561 16499.9n 0.3561 16500.0n 0.4753 16799.9n 0.4753 16800.0n 0.5094 17099.9n 0.5094 17100.0n 0.4924 17399.9n 0.4924 17400.0n 0.3561 17699.9n 0.3561 17700.0n 0.4924 17999.9n 0.4924 18000.0n 0.5094 18299.9n 0.5094 18300.0n 0.3561 18599.9n 0.3561 18600.0n 0.6286 18899.9n 0.6286 18900.0n 0.4583 19199.9n 0.4583 19200.0n 0.6286 19499.9n 0.6286 19500.0n 0.5946 19799.9n 0.5946 19800.0n 0.5946 20099.9n 0.5946 20100.0n 0.5435 20399.9n 0.5435 20400.0n 0.6286 20699.9n 0.6286 20700.0n 0.6116 20999.9n 0.6116 21000.0n 0.5094 21299.9n 0.5094 21300.0n 0.3731 21599.9n 0.3731 21600.0n 0.3561 21899.9n 0.3561 21900.0n 0.4753 22199.9n 0.4753 22200.0n 0.5094 22499.9n 0.5094 22500.0n 0.4924 22799.9n 0.4924 22800.0n 0.3561 23099.9n 0.3561 23100.0n 0.4924 23399.9n 0.4924 23400.0n 0.5094 23699.9n 0.5094 23700.0n 0.3561 23999.9n 0.3561 24000.0n 0.6286 24299.9n 0.6286 24300.0n 0.4583 24599.9n 0.4583 24600.0n 0.6286 24899.9n 0.6286 24900.0n 0.5946 25199.9n 0.5946 25200.0n 0.5946 25499.9n 0.5946 25500.0n 0.5435 25799.9n 0.5435 25800.0n 0.6286 26099.9n 0.6286 26100.0n 0.6116 26399.9n 0.6116 26400.0n 0.5094 26699.9n 0.5094 26700.0n 0.3731 26999.9n 0.3731 27000.0n 0.3561 27299.9n 0.3561 27300.0n 0.4753 27599.9n 0.4753 27600.0n 0.5094 27899.9n 0.5094 27900.0n 0.4924 28199.9n 0.4924 28200.0n 0.3561 28499.9n 0.3561 28500.0n 0.4924 28799.9n 0.4924 28800.0n 0.5094 29099.9n 0.5094 29100.0n 0.3561 29399.9n 0.3561 29400.0n 0.6286 29699.9n 0.6286 29700.0n 0.4583 29999.9n 0.4583 30000.0n 0.6286 30299.9n 0.6286 30300.0n 0.5946 30599.9n 0.5946 30600.0n 0.5946 30899.9n 0.5946 30900.0n 0.5435 31199.9n 0.5435 31200.0n 0.6286 31499.9n 0.6286 31500.0n 0.6116 31799.9n 0.6116 31800.0n 0.5094 32099.9n 0.5094 32100.0n 0.3731 32399.9n 0.3731 32400.0n 0.3561 32699.9n 0.3561 32700.0n 0.4753 32999.9n 0.4753 33000.0n 0.5094 33299.9n 0.5094 33300.0n 0.4924 33599.9n 0.4924 33600.0n 0.3561 33899.9n 0.3561 33900.0n 0.4924 34199.9n 0.4924 34200.0n 0.5094 34499.9n 0.5094 34500.0n 0.3561 34799.9n 0.3561 34800.0n 0.6286 35099.9n 0.6286 35100.0n 0.4583 35399.9n 0.4583 35400.0n 0.6286 35699.9n 0.6286 35700.0n 0.5946 35999.9n 0.5946 36000.0n 0.5946 36299.9n 0.5946 36300.0n 0.5435 36599.9n 0.5435 36600.0n 0.6286 36899.9n 0.6286 36900.0n 0.6116 37199.9n 0.6116 37200.0n 0.5094 37499.9n 0.5094 37500.0n 0.3731 37799.9n 0.3731 37800.0n 0.3561 38099.9n 0.3561 38100.0n 0.4753 38399.9n 0.4753 38400.0n 0.5094 38699.9n 0.5094 38700.0n 0.4924 38999.9n 0.4924 39000.0n 0.3561 39299.9n 0.3561 39300.0n 0.4924 39599.9n 0.4924 39600.0n 0.5094 39899.9n 0.5094 39900.0n 0.3561 40199.9n 0.3561 40200.0n 0.6286 40499.9n 0.6286 40500.0n 0.4583 40799.9n 0.4583 40800.0n 0.6286 41099.9n 0.6286 41100.0n 0.5946 41399.9n 0.5946 41400.0n 0.5946 41699.9n 0.5946 41700.0n 0.5435 41999.9n 0.5435 42000.0n 0.6286 42299.9n 0.6286 42300.0n 0.6116 42599.9n 0.6116 42600.0n 0.5094 42899.9n 0.5094 42900.0n 0.3731 43199.9n 0.3731 43200.0n 0.3561 43499.9n 0.3561 43500.0n 0.4753 43799.9n 0.4753 43800.0n 0.5094 44099.9n 0.5094 44100.0n 0.4924 44399.9n 0.4924 44400.0n 0.3561 44699.9n 0.3561 44700.0n 0.4924 44999.9n 0.4924 45000.0n 0.5094 45299.9n 0.5094 45300.0n 0.3561 45599.9n 0.3561 45600.0n 0.6286 45899.9n 0.6286 45900.0n 0.4583 46199.9n 0.4583 46200.0n 0.6286 46499.9n 0.6286 46500.0n 0.5946 46799.9n 0.5946 46800.0n 0.5946 47099.9n 0.5946 47100.0n 0.5435 47399.9n 0.5435 47400.0n 0.6286 47699.9n 0.6286 47700.0n 0.6116 47999.9n 0.6116 48000.0n 0.5094 48299.9n 0.5094 48300.0n 0.3731 48599.9n 0.3731 48600.0n 0.3561 48899.9n 0.3561 48900.0n 0.4753 49199.9n 0.4753 49200.0n 0.5094 49499.9n 0.5094 49500.0n 0.4924 49799.9n 0.4924 49800.0n 0.3561 50099.9n 0.3561 50100.0n 0.4924 50399.9n 0.4924 50400.0n 0.5094 50699.9n 0.5094 50700.0n 0.3561 50999.9n 0.3561 51000.0n 0.6286 51299.9n 0.6286 51300.0n 0.4583 51599.9n 0.4583 51600.0n 0.6286 51899.9n 0.6286 51900.0n 0.5946 52199.9n 0.5946 52200.0n 0.5946 52499.9n 0.5946 52500.0n 0.5435 52799.9n 0.5435 52800.0n 0.6286 53099.9n 0.6286 53100.0n 0.6116 53399.9n 0.6116 53400.0n 0.5094 53699.9n 0.5094 53700.0n 0.3731 53999.9n 0.3731 54000.0n 0.4583 54299.9n 0.4583 54300.0n 0.5775 54599.9n 0.5775 54600.0n 0.4753 54899.9n 0.4753 54900.0n 0.3561 55199.9n 0.3561 55200.0n 0.5605 55499.9n 0.5605 55500.0n 0.5094 55799.9n 0.5094 55800.0n 0.5946 56099.9n 0.5946 56100.0n 0.5946 56399.9n 0.5946 56400.0n 0.4583 56699.9n 0.4583 56700.0n 0.6286 56999.9n 0.6286 57000.0n 0.3731 57299.9n 0.3731 57300.0n 0.5094 57599.9n 0.5094 57600.0n 0.6286 57899.9n 0.6286 57900.0n 0.5264 58199.9n 0.5264 58200.0n 0.5946 58499.9n 0.5946 58500.0n 0.6286 58799.9n 0.6286 58800.0n 0.5946 59099.9n 0.5946 59100.0n 0.5946)
Vxp30 a_xp30 0 PWL(0.0n 0.4914 299.9n 0.4914 300.0n 0.5999 599.9n 0.5999 600.0n 0.6542 899.9n 0.6542 900.0n 0.6542 1199.9n 0.6542 1200.0n 0.5456 1499.9n 0.5456 1500.0n 0.5456 1799.9n 0.5456 1800.0n 0.5999 2099.9n 0.5999 2100.0n 0.5456 2399.9n 0.5456 2400.0n 0.4371 2699.9n 0.4371 2700.0n 0.4371 2999.9n 0.4371 3000.0n 0.4371 3299.9n 0.4371 3300.0n 0.4371 3599.9n 0.4371 3600.0n 0.4371 3899.9n 0.4371 3900.0n 0.4371 4199.9n 0.4371 4200.0n 0.4371 4499.9n 0.4371 4500.0n 0.4371 4799.9n 0.4371 4800.0n 0.5728 5099.9n 0.5728 5100.0n 0.4371 5399.9n 0.4371 5400.0n 0.4914 5699.9n 0.4914 5700.0n 0.5999 5999.9n 0.5999 6000.0n 0.6542 6299.9n 0.6542 6300.0n 0.6542 6599.9n 0.6542 6600.0n 0.5456 6899.9n 0.5456 6900.0n 0.5456 7199.9n 0.5456 7200.0n 0.5999 7499.9n 0.5999 7500.0n 0.5456 7799.9n 0.5456 7800.0n 0.4371 8099.9n 0.4371 8100.0n 0.4371 8399.9n 0.4371 8400.0n 0.4371 8699.9n 0.4371 8700.0n 0.4371 8999.9n 0.4371 9000.0n 0.4371 9299.9n 0.4371 9300.0n 0.4371 9599.9n 0.4371 9600.0n 0.4371 9899.9n 0.4371 9900.0n 0.4371 10199.9n 0.4371 10200.0n 0.5728 10499.9n 0.5728 10500.0n 0.4371 10799.9n 0.4371 10800.0n 0.4914 11099.9n 0.4914 11100.0n 0.5999 11399.9n 0.5999 11400.0n 0.6542 11699.9n 0.6542 11700.0n 0.6542 11999.9n 0.6542 12000.0n 0.5456 12299.9n 0.5456 12300.0n 0.5456 12599.9n 0.5456 12600.0n 0.5999 12899.9n 0.5999 12900.0n 0.5456 13199.9n 0.5456 13200.0n 0.4371 13499.9n 0.4371 13500.0n 0.4371 13799.9n 0.4371 13800.0n 0.4371 14099.9n 0.4371 14100.0n 0.4371 14399.9n 0.4371 14400.0n 0.4371 14699.9n 0.4371 14700.0n 0.4371 14999.9n 0.4371 15000.0n 0.4371 15299.9n 0.4371 15300.0n 0.4371 15599.9n 0.4371 15600.0n 0.5728 15899.9n 0.5728 15900.0n 0.4371 16199.9n 0.4371 16200.0n 0.4914 16499.9n 0.4914 16500.0n 0.5999 16799.9n 0.5999 16800.0n 0.6542 17099.9n 0.6542 17100.0n 0.6542 17399.9n 0.6542 17400.0n 0.5456 17699.9n 0.5456 17700.0n 0.5456 17999.9n 0.5456 18000.0n 0.5999 18299.9n 0.5999 18300.0n 0.5456 18599.9n 0.5456 18600.0n 0.4371 18899.9n 0.4371 18900.0n 0.4371 19199.9n 0.4371 19200.0n 0.4371 19499.9n 0.4371 19500.0n 0.4371 19799.9n 0.4371 19800.0n 0.4371 20099.9n 0.4371 20100.0n 0.4371 20399.9n 0.4371 20400.0n 0.4371 20699.9n 0.4371 20700.0n 0.4371 20999.9n 0.4371 21000.0n 0.5728 21299.9n 0.5728 21300.0n 0.4371 21599.9n 0.4371 21600.0n 0.4914 21899.9n 0.4914 21900.0n 0.5999 22199.9n 0.5999 22200.0n 0.6542 22499.9n 0.6542 22500.0n 0.6542 22799.9n 0.6542 22800.0n 0.5456 23099.9n 0.5456 23100.0n 0.5456 23399.9n 0.5456 23400.0n 0.5999 23699.9n 0.5999 23700.0n 0.5456 23999.9n 0.5456 24000.0n 0.4371 24299.9n 0.4371 24300.0n 0.4371 24599.9n 0.4371 24600.0n 0.4371 24899.9n 0.4371 24900.0n 0.4371 25199.9n 0.4371 25200.0n 0.4371 25499.9n 0.4371 25500.0n 0.4371 25799.9n 0.4371 25800.0n 0.4371 26099.9n 0.4371 26100.0n 0.4371 26399.9n 0.4371 26400.0n 0.5728 26699.9n 0.5728 26700.0n 0.4371 26999.9n 0.4371 27000.0n 0.4914 27299.9n 0.4914 27300.0n 0.5999 27599.9n 0.5999 27600.0n 0.6542 27899.9n 0.6542 27900.0n 0.6542 28199.9n 0.6542 28200.0n 0.5456 28499.9n 0.5456 28500.0n 0.5456 28799.9n 0.5456 28800.0n 0.5999 29099.9n 0.5999 29100.0n 0.5456 29399.9n 0.5456 29400.0n 0.4371 29699.9n 0.4371 29700.0n 0.4371 29999.9n 0.4371 30000.0n 0.4371 30299.9n 0.4371 30300.0n 0.4371 30599.9n 0.4371 30600.0n 0.4371 30899.9n 0.4371 30900.0n 0.4371 31199.9n 0.4371 31200.0n 0.4371 31499.9n 0.4371 31500.0n 0.4371 31799.9n 0.4371 31800.0n 0.5728 32099.9n 0.5728 32100.0n 0.4371 32399.9n 0.4371 32400.0n 0.4914 32699.9n 0.4914 32700.0n 0.5999 32999.9n 0.5999 33000.0n 0.6542 33299.9n 0.6542 33300.0n 0.6542 33599.9n 0.6542 33600.0n 0.5456 33899.9n 0.5456 33900.0n 0.5456 34199.9n 0.5456 34200.0n 0.5999 34499.9n 0.5999 34500.0n 0.5456 34799.9n 0.5456 34800.0n 0.4371 35099.9n 0.4371 35100.0n 0.4371 35399.9n 0.4371 35400.0n 0.4371 35699.9n 0.4371 35700.0n 0.4371 35999.9n 0.4371 36000.0n 0.4371 36299.9n 0.4371 36300.0n 0.4371 36599.9n 0.4371 36600.0n 0.4371 36899.9n 0.4371 36900.0n 0.4371 37199.9n 0.4371 37200.0n 0.5728 37499.9n 0.5728 37500.0n 0.4371 37799.9n 0.4371 37800.0n 0.4914 38099.9n 0.4914 38100.0n 0.5999 38399.9n 0.5999 38400.0n 0.6542 38699.9n 0.6542 38700.0n 0.6542 38999.9n 0.6542 39000.0n 0.5456 39299.9n 0.5456 39300.0n 0.5456 39599.9n 0.5456 39600.0n 0.5999 39899.9n 0.5999 39900.0n 0.5456 40199.9n 0.5456 40200.0n 0.4371 40499.9n 0.4371 40500.0n 0.4371 40799.9n 0.4371 40800.0n 0.4371 41099.9n 0.4371 41100.0n 0.4371 41399.9n 0.4371 41400.0n 0.4371 41699.9n 0.4371 41700.0n 0.4371 41999.9n 0.4371 42000.0n 0.4371 42299.9n 0.4371 42300.0n 0.4371 42599.9n 0.4371 42600.0n 0.5728 42899.9n 0.5728 42900.0n 0.4371 43199.9n 0.4371 43200.0n 0.4914 43499.9n 0.4914 43500.0n 0.5999 43799.9n 0.5999 43800.0n 0.6542 44099.9n 0.6542 44100.0n 0.6542 44399.9n 0.6542 44400.0n 0.5456 44699.9n 0.5456 44700.0n 0.5456 44999.9n 0.5456 45000.0n 0.5999 45299.9n 0.5999 45300.0n 0.5456 45599.9n 0.5456 45600.0n 0.4371 45899.9n 0.4371 45900.0n 0.4371 46199.9n 0.4371 46200.0n 0.4371 46499.9n 0.4371 46500.0n 0.4371 46799.9n 0.4371 46800.0n 0.4371 47099.9n 0.4371 47100.0n 0.4371 47399.9n 0.4371 47400.0n 0.4371 47699.9n 0.4371 47700.0n 0.4371 47999.9n 0.4371 48000.0n 0.5728 48299.9n 0.5728 48300.0n 0.4371 48599.9n 0.4371 48600.0n 0.4914 48899.9n 0.4914 48900.0n 0.5999 49199.9n 0.5999 49200.0n 0.6542 49499.9n 0.6542 49500.0n 0.6542 49799.9n 0.6542 49800.0n 0.5456 50099.9n 0.5456 50100.0n 0.5456 50399.9n 0.5456 50400.0n 0.5999 50699.9n 0.5999 50700.0n 0.5456 50999.9n 0.5456 51000.0n 0.4371 51299.9n 0.4371 51300.0n 0.4371 51599.9n 0.4371 51600.0n 0.4371 51899.9n 0.4371 51900.0n 0.4371 52199.9n 0.4371 52200.0n 0.4371 52499.9n 0.4371 52500.0n 0.4371 52799.9n 0.4371 52800.0n 0.4371 53099.9n 0.4371 53100.0n 0.4371 53399.9n 0.4371 53400.0n 0.5728 53699.9n 0.5728 53700.0n 0.4371 53999.9n 0.4371 54000.0n 0.5999 54299.9n 0.5999 54300.0n 0.6542 54599.9n 0.6542 54600.0n 0.7084 54899.9n 0.7084 54900.0n 0.5999 55199.9n 0.5999 55200.0n 0.6542 55499.9n 0.6542 55500.0n 0.6542 55799.9n 0.6542 55800.0n 0.4371 56099.9n 0.4371 56100.0n 0.4371 56399.9n 0.4371 56400.0n 0.4371 56699.9n 0.4371 56700.0n 0.4371 56999.9n 0.4371 57000.0n 0.4371 57299.9n 0.4371 57300.0n 0.4371 57599.9n 0.4371 57600.0n 0.4371 57899.9n 0.4371 57900.0n 0.4371 58199.9n 0.4371 58200.0n 0.4371 58499.9n 0.4371 58500.0n 0.4371 58799.9n 0.4371 58800.0n 0.4371 59099.9n 0.4371 59100.0n 0.4371)
Vxn30 a_xn30 0 PWL(0.0n 0.5086 299.9n 0.5086 300.0n 0.4001 599.9n 0.4001 600.0n 0.3458 899.9n 0.3458 900.0n 0.3458 1199.9n 0.3458 1200.0n 0.4544 1499.9n 0.4544 1500.0n 0.4544 1799.9n 0.4544 1800.0n 0.4001 2099.9n 0.4001 2100.0n 0.4544 2399.9n 0.4544 2400.0n 0.5629 2699.9n 0.5629 2700.0n 0.5629 2999.9n 0.5629 3000.0n 0.5629 3299.9n 0.5629 3300.0n 0.5629 3599.9n 0.5629 3600.0n 0.5629 3899.9n 0.5629 3900.0n 0.5629 4199.9n 0.5629 4200.0n 0.5629 4499.9n 0.5629 4500.0n 0.5629 4799.9n 0.5629 4800.0n 0.4272 5099.9n 0.4272 5100.0n 0.5629 5399.9n 0.5629 5400.0n 0.5086 5699.9n 0.5086 5700.0n 0.4001 5999.9n 0.4001 6000.0n 0.3458 6299.9n 0.3458 6300.0n 0.3458 6599.9n 0.3458 6600.0n 0.4544 6899.9n 0.4544 6900.0n 0.4544 7199.9n 0.4544 7200.0n 0.4001 7499.9n 0.4001 7500.0n 0.4544 7799.9n 0.4544 7800.0n 0.5629 8099.9n 0.5629 8100.0n 0.5629 8399.9n 0.5629 8400.0n 0.5629 8699.9n 0.5629 8700.0n 0.5629 8999.9n 0.5629 9000.0n 0.5629 9299.9n 0.5629 9300.0n 0.5629 9599.9n 0.5629 9600.0n 0.5629 9899.9n 0.5629 9900.0n 0.5629 10199.9n 0.5629 10200.0n 0.4272 10499.9n 0.4272 10500.0n 0.5629 10799.9n 0.5629 10800.0n 0.5086 11099.9n 0.5086 11100.0n 0.4001 11399.9n 0.4001 11400.0n 0.3458 11699.9n 0.3458 11700.0n 0.3458 11999.9n 0.3458 12000.0n 0.4544 12299.9n 0.4544 12300.0n 0.4544 12599.9n 0.4544 12600.0n 0.4001 12899.9n 0.4001 12900.0n 0.4544 13199.9n 0.4544 13200.0n 0.5629 13499.9n 0.5629 13500.0n 0.5629 13799.9n 0.5629 13800.0n 0.5629 14099.9n 0.5629 14100.0n 0.5629 14399.9n 0.5629 14400.0n 0.5629 14699.9n 0.5629 14700.0n 0.5629 14999.9n 0.5629 15000.0n 0.5629 15299.9n 0.5629 15300.0n 0.5629 15599.9n 0.5629 15600.0n 0.4272 15899.9n 0.4272 15900.0n 0.5629 16199.9n 0.5629 16200.0n 0.5086 16499.9n 0.5086 16500.0n 0.4001 16799.9n 0.4001 16800.0n 0.3458 17099.9n 0.3458 17100.0n 0.3458 17399.9n 0.3458 17400.0n 0.4544 17699.9n 0.4544 17700.0n 0.4544 17999.9n 0.4544 18000.0n 0.4001 18299.9n 0.4001 18300.0n 0.4544 18599.9n 0.4544 18600.0n 0.5629 18899.9n 0.5629 18900.0n 0.5629 19199.9n 0.5629 19200.0n 0.5629 19499.9n 0.5629 19500.0n 0.5629 19799.9n 0.5629 19800.0n 0.5629 20099.9n 0.5629 20100.0n 0.5629 20399.9n 0.5629 20400.0n 0.5629 20699.9n 0.5629 20700.0n 0.5629 20999.9n 0.5629 21000.0n 0.4272 21299.9n 0.4272 21300.0n 0.5629 21599.9n 0.5629 21600.0n 0.5086 21899.9n 0.5086 21900.0n 0.4001 22199.9n 0.4001 22200.0n 0.3458 22499.9n 0.3458 22500.0n 0.3458 22799.9n 0.3458 22800.0n 0.4544 23099.9n 0.4544 23100.0n 0.4544 23399.9n 0.4544 23400.0n 0.4001 23699.9n 0.4001 23700.0n 0.4544 23999.9n 0.4544 24000.0n 0.5629 24299.9n 0.5629 24300.0n 0.5629 24599.9n 0.5629 24600.0n 0.5629 24899.9n 0.5629 24900.0n 0.5629 25199.9n 0.5629 25200.0n 0.5629 25499.9n 0.5629 25500.0n 0.5629 25799.9n 0.5629 25800.0n 0.5629 26099.9n 0.5629 26100.0n 0.5629 26399.9n 0.5629 26400.0n 0.4272 26699.9n 0.4272 26700.0n 0.5629 26999.9n 0.5629 27000.0n 0.5086 27299.9n 0.5086 27300.0n 0.4001 27599.9n 0.4001 27600.0n 0.3458 27899.9n 0.3458 27900.0n 0.3458 28199.9n 0.3458 28200.0n 0.4544 28499.9n 0.4544 28500.0n 0.4544 28799.9n 0.4544 28800.0n 0.4001 29099.9n 0.4001 29100.0n 0.4544 29399.9n 0.4544 29400.0n 0.5629 29699.9n 0.5629 29700.0n 0.5629 29999.9n 0.5629 30000.0n 0.5629 30299.9n 0.5629 30300.0n 0.5629 30599.9n 0.5629 30600.0n 0.5629 30899.9n 0.5629 30900.0n 0.5629 31199.9n 0.5629 31200.0n 0.5629 31499.9n 0.5629 31500.0n 0.5629 31799.9n 0.5629 31800.0n 0.4272 32099.9n 0.4272 32100.0n 0.5629 32399.9n 0.5629 32400.0n 0.5086 32699.9n 0.5086 32700.0n 0.4001 32999.9n 0.4001 33000.0n 0.3458 33299.9n 0.3458 33300.0n 0.3458 33599.9n 0.3458 33600.0n 0.4544 33899.9n 0.4544 33900.0n 0.4544 34199.9n 0.4544 34200.0n 0.4001 34499.9n 0.4001 34500.0n 0.4544 34799.9n 0.4544 34800.0n 0.5629 35099.9n 0.5629 35100.0n 0.5629 35399.9n 0.5629 35400.0n 0.5629 35699.9n 0.5629 35700.0n 0.5629 35999.9n 0.5629 36000.0n 0.5629 36299.9n 0.5629 36300.0n 0.5629 36599.9n 0.5629 36600.0n 0.5629 36899.9n 0.5629 36900.0n 0.5629 37199.9n 0.5629 37200.0n 0.4272 37499.9n 0.4272 37500.0n 0.5629 37799.9n 0.5629 37800.0n 0.5086 38099.9n 0.5086 38100.0n 0.4001 38399.9n 0.4001 38400.0n 0.3458 38699.9n 0.3458 38700.0n 0.3458 38999.9n 0.3458 39000.0n 0.4544 39299.9n 0.4544 39300.0n 0.4544 39599.9n 0.4544 39600.0n 0.4001 39899.9n 0.4001 39900.0n 0.4544 40199.9n 0.4544 40200.0n 0.5629 40499.9n 0.5629 40500.0n 0.5629 40799.9n 0.5629 40800.0n 0.5629 41099.9n 0.5629 41100.0n 0.5629 41399.9n 0.5629 41400.0n 0.5629 41699.9n 0.5629 41700.0n 0.5629 41999.9n 0.5629 42000.0n 0.5629 42299.9n 0.5629 42300.0n 0.5629 42599.9n 0.5629 42600.0n 0.4272 42899.9n 0.4272 42900.0n 0.5629 43199.9n 0.5629 43200.0n 0.5086 43499.9n 0.5086 43500.0n 0.4001 43799.9n 0.4001 43800.0n 0.3458 44099.9n 0.3458 44100.0n 0.3458 44399.9n 0.3458 44400.0n 0.4544 44699.9n 0.4544 44700.0n 0.4544 44999.9n 0.4544 45000.0n 0.4001 45299.9n 0.4001 45300.0n 0.4544 45599.9n 0.4544 45600.0n 0.5629 45899.9n 0.5629 45900.0n 0.5629 46199.9n 0.5629 46200.0n 0.5629 46499.9n 0.5629 46500.0n 0.5629 46799.9n 0.5629 46800.0n 0.5629 47099.9n 0.5629 47100.0n 0.5629 47399.9n 0.5629 47400.0n 0.5629 47699.9n 0.5629 47700.0n 0.5629 47999.9n 0.5629 48000.0n 0.4272 48299.9n 0.4272 48300.0n 0.5629 48599.9n 0.5629 48600.0n 0.5086 48899.9n 0.5086 48900.0n 0.4001 49199.9n 0.4001 49200.0n 0.3458 49499.9n 0.3458 49500.0n 0.3458 49799.9n 0.3458 49800.0n 0.4544 50099.9n 0.4544 50100.0n 0.4544 50399.9n 0.4544 50400.0n 0.4001 50699.9n 0.4001 50700.0n 0.4544 50999.9n 0.4544 51000.0n 0.5629 51299.9n 0.5629 51300.0n 0.5629 51599.9n 0.5629 51600.0n 0.5629 51899.9n 0.5629 51900.0n 0.5629 52199.9n 0.5629 52200.0n 0.5629 52499.9n 0.5629 52500.0n 0.5629 52799.9n 0.5629 52800.0n 0.5629 53099.9n 0.5629 53100.0n 0.5629 53399.9n 0.5629 53400.0n 0.4272 53699.9n 0.4272 53700.0n 0.5629 53999.9n 0.5629 54000.0n 0.4001 54299.9n 0.4001 54300.0n 0.3458 54599.9n 0.3458 54600.0n 0.2916 54899.9n 0.2916 54900.0n 0.4001 55199.9n 0.4001 55200.0n 0.3458 55499.9n 0.3458 55500.0n 0.3458 55799.9n 0.3458 55800.0n 0.5629 56099.9n 0.5629 56100.0n 0.5629 56399.9n 0.5629 56400.0n 0.5629 56699.9n 0.5629 56700.0n 0.5629 56999.9n 0.5629 57000.0n 0.5629 57299.9n 0.5629 57300.0n 0.5629 57599.9n 0.5629 57600.0n 0.5629 57899.9n 0.5629 57900.0n 0.5629 58199.9n 0.5629 58200.0n 0.5629 58499.9n 0.5629 58500.0n 0.5629 58799.9n 0.5629 58800.0n 0.5629 59099.9n 0.5629 59100.0n 0.5629)
Vxp31 a_xp31 0 PWL(0.0n 0.4953 299.9n 0.4953 300.0n 0.4953 599.9n 0.4953 600.0n 0.4953 899.9n 0.4953 900.0n 0.4953 1199.9n 0.4953 1200.0n 0.4953 1499.9n 0.4953 1500.0n 0.4953 1799.9n 0.4953 1800.0n 0.4953 2099.9n 0.4953 2100.0n 0.4953 2399.9n 0.4953 2400.0n 0.4953 2699.9n 0.4953 2700.0n 0.4953 2999.9n 0.4953 3000.0n 0.4953 3299.9n 0.4953 3300.0n 0.4953 3599.9n 0.4953 3600.0n 0.4953 3899.9n 0.4953 3900.0n 0.4953 4199.9n 0.4953 4200.0n 0.4953 4499.9n 0.4953 4500.0n 0.4953 4799.9n 0.4953 4800.0n 0.4953 5099.9n 0.4953 5100.0n 0.4953 5399.9n 0.4953 5400.0n 0.4953 5699.9n 0.4953 5700.0n 0.4953 5999.9n 0.4953 6000.0n 0.4953 6299.9n 0.4953 6300.0n 0.4953 6599.9n 0.4953 6600.0n 0.4953 6899.9n 0.4953 6900.0n 0.4953 7199.9n 0.4953 7200.0n 0.4953 7499.9n 0.4953 7500.0n 0.4953 7799.9n 0.4953 7800.0n 0.4953 8099.9n 0.4953 8100.0n 0.4953 8399.9n 0.4953 8400.0n 0.4953 8699.9n 0.4953 8700.0n 0.4953 8999.9n 0.4953 9000.0n 0.4953 9299.9n 0.4953 9300.0n 0.4953 9599.9n 0.4953 9600.0n 0.4953 9899.9n 0.4953 9900.0n 0.4953 10199.9n 0.4953 10200.0n 0.4953 10499.9n 0.4953 10500.0n 0.4953 10799.9n 0.4953 10800.0n 0.4953 11099.9n 0.4953 11100.0n 0.4953 11399.9n 0.4953 11400.0n 0.4953 11699.9n 0.4953 11700.0n 0.4953 11999.9n 0.4953 12000.0n 0.4953 12299.9n 0.4953 12300.0n 0.4953 12599.9n 0.4953 12600.0n 0.4953 12899.9n 0.4953 12900.0n 0.4953 13199.9n 0.4953 13200.0n 0.4953 13499.9n 0.4953 13500.0n 0.4953 13799.9n 0.4953 13800.0n 0.4953 14099.9n 0.4953 14100.0n 0.4953 14399.9n 0.4953 14400.0n 0.4953 14699.9n 0.4953 14700.0n 0.4953 14999.9n 0.4953 15000.0n 0.4953 15299.9n 0.4953 15300.0n 0.4953 15599.9n 0.4953 15600.0n 0.4953 15899.9n 0.4953 15900.0n 0.4953 16199.9n 0.4953 16200.0n 0.4953 16499.9n 0.4953 16500.0n 0.4953 16799.9n 0.4953 16800.0n 0.4953 17099.9n 0.4953 17100.0n 0.4953 17399.9n 0.4953 17400.0n 0.4953 17699.9n 0.4953 17700.0n 0.4953 17999.9n 0.4953 18000.0n 0.4953 18299.9n 0.4953 18300.0n 0.4953 18599.9n 0.4953 18600.0n 0.4953 18899.9n 0.4953 18900.0n 0.4953 19199.9n 0.4953 19200.0n 0.4953 19499.9n 0.4953 19500.0n 0.4953 19799.9n 0.4953 19800.0n 0.4953 20099.9n 0.4953 20100.0n 0.4953 20399.9n 0.4953 20400.0n 0.4953 20699.9n 0.4953 20700.0n 0.4953 20999.9n 0.4953 21000.0n 0.4953 21299.9n 0.4953 21300.0n 0.4953 21599.9n 0.4953 21600.0n 0.4953 21899.9n 0.4953 21900.0n 0.4953 22199.9n 0.4953 22200.0n 0.4953 22499.9n 0.4953 22500.0n 0.4953 22799.9n 0.4953 22800.0n 0.4953 23099.9n 0.4953 23100.0n 0.4953 23399.9n 0.4953 23400.0n 0.4953 23699.9n 0.4953 23700.0n 0.4953 23999.9n 0.4953 24000.0n 0.4953 24299.9n 0.4953 24300.0n 0.4953 24599.9n 0.4953 24600.0n 0.4953 24899.9n 0.4953 24900.0n 0.4953 25199.9n 0.4953 25200.0n 0.4953 25499.9n 0.4953 25500.0n 0.4953 25799.9n 0.4953 25800.0n 0.4953 26099.9n 0.4953 26100.0n 0.4953 26399.9n 0.4953 26400.0n 0.4953 26699.9n 0.4953 26700.0n 0.4953 26999.9n 0.4953 27000.0n 0.4953 27299.9n 0.4953 27300.0n 0.4953 27599.9n 0.4953 27600.0n 0.4953 27899.9n 0.4953 27900.0n 0.4953 28199.9n 0.4953 28200.0n 0.4953 28499.9n 0.4953 28500.0n 0.4953 28799.9n 0.4953 28800.0n 0.4953 29099.9n 0.4953 29100.0n 0.4953 29399.9n 0.4953 29400.0n 0.4953 29699.9n 0.4953 29700.0n 0.4953 29999.9n 0.4953 30000.0n 0.4953 30299.9n 0.4953 30300.0n 0.4953 30599.9n 0.4953 30600.0n 0.4953 30899.9n 0.4953 30900.0n 0.4953 31199.9n 0.4953 31200.0n 0.4953 31499.9n 0.4953 31500.0n 0.4953 31799.9n 0.4953 31800.0n 0.4953 32099.9n 0.4953 32100.0n 0.4953 32399.9n 0.4953 32400.0n 0.4953 32699.9n 0.4953 32700.0n 0.4953 32999.9n 0.4953 33000.0n 0.4953 33299.9n 0.4953 33300.0n 0.4953 33599.9n 0.4953 33600.0n 0.4953 33899.9n 0.4953 33900.0n 0.4953 34199.9n 0.4953 34200.0n 0.4953 34499.9n 0.4953 34500.0n 0.4953 34799.9n 0.4953 34800.0n 0.4953 35099.9n 0.4953 35100.0n 0.4953 35399.9n 0.4953 35400.0n 0.4953 35699.9n 0.4953 35700.0n 0.4953 35999.9n 0.4953 36000.0n 0.4953 36299.9n 0.4953 36300.0n 0.4953 36599.9n 0.4953 36600.0n 0.4953 36899.9n 0.4953 36900.0n 0.4953 37199.9n 0.4953 37200.0n 0.4953 37499.9n 0.4953 37500.0n 0.4953 37799.9n 0.4953 37800.0n 0.4953 38099.9n 0.4953 38100.0n 0.4953 38399.9n 0.4953 38400.0n 0.4953 38699.9n 0.4953 38700.0n 0.4953 38999.9n 0.4953 39000.0n 0.4953 39299.9n 0.4953 39300.0n 0.4953 39599.9n 0.4953 39600.0n 0.4953 39899.9n 0.4953 39900.0n 0.4953 40199.9n 0.4953 40200.0n 0.4953 40499.9n 0.4953 40500.0n 0.4953 40799.9n 0.4953 40800.0n 0.4953 41099.9n 0.4953 41100.0n 0.4953 41399.9n 0.4953 41400.0n 0.4953 41699.9n 0.4953 41700.0n 0.4953 41999.9n 0.4953 42000.0n 0.4953 42299.9n 0.4953 42300.0n 0.4953 42599.9n 0.4953 42600.0n 0.4953 42899.9n 0.4953 42900.0n 0.4953 43199.9n 0.4953 43200.0n 0.4953 43499.9n 0.4953 43500.0n 0.4953 43799.9n 0.4953 43800.0n 0.4953 44099.9n 0.4953 44100.0n 0.4953 44399.9n 0.4953 44400.0n 0.4953 44699.9n 0.4953 44700.0n 0.4953 44999.9n 0.4953 45000.0n 0.4953 45299.9n 0.4953 45300.0n 0.4953 45599.9n 0.4953 45600.0n 0.4953 45899.9n 0.4953 45900.0n 0.4953 46199.9n 0.4953 46200.0n 0.4953 46499.9n 0.4953 46500.0n 0.4953 46799.9n 0.4953 46800.0n 0.4953 47099.9n 0.4953 47100.0n 0.4953 47399.9n 0.4953 47400.0n 0.4953 47699.9n 0.4953 47700.0n 0.4953 47999.9n 0.4953 48000.0n 0.4953 48299.9n 0.4953 48300.0n 0.4953 48599.9n 0.4953 48600.0n 0.4953 48899.9n 0.4953 48900.0n 0.4953 49199.9n 0.4953 49200.0n 0.4953 49499.9n 0.4953 49500.0n 0.4953 49799.9n 0.4953 49800.0n 0.4953 50099.9n 0.4953 50100.0n 0.4953 50399.9n 0.4953 50400.0n 0.4953 50699.9n 0.4953 50700.0n 0.4953 50999.9n 0.4953 51000.0n 0.4953 51299.9n 0.4953 51300.0n 0.4953 51599.9n 0.4953 51600.0n 0.4953 51899.9n 0.4953 51900.0n 0.4953 52199.9n 0.4953 52200.0n 0.4953 52499.9n 0.4953 52500.0n 0.4953 52799.9n 0.4953 52800.0n 0.4953 53099.9n 0.4953 53100.0n 0.4953 53399.9n 0.4953 53400.0n 0.4953 53699.9n 0.4953 53700.0n 0.4953 53999.9n 0.4953 54000.0n 0.4953 54299.9n 0.4953 54300.0n 0.4953 54599.9n 0.4953 54600.0n 0.4953 54899.9n 0.4953 54900.0n 0.4953 55199.9n 0.4953 55200.0n 0.4953 55499.9n 0.4953 55500.0n 0.4953 55799.9n 0.4953 55800.0n 0.4953 56099.9n 0.4953 56100.0n 0.4953 56399.9n 0.4953 56400.0n 0.4953 56699.9n 0.4953 56700.0n 0.4953 56999.9n 0.4953 57000.0n 0.4953 57299.9n 0.4953 57300.0n 0.4953 57599.9n 0.4953 57600.0n 0.4953 57899.9n 0.4953 57900.0n 0.4953 58199.9n 0.4953 58200.0n 0.4953 58499.9n 0.4953 58500.0n 0.4953 58799.9n 0.4953 58800.0n 0.4953 59099.9n 0.4953 59100.0n 0.4953)
Vxn31 a_xn31 0 PWL(0.0n 0.5047 299.9n 0.5047 300.0n 0.5047 599.9n 0.5047 600.0n 0.5047 899.9n 0.5047 900.0n 0.5047 1199.9n 0.5047 1200.0n 0.5047 1499.9n 0.5047 1500.0n 0.5047 1799.9n 0.5047 1800.0n 0.5047 2099.9n 0.5047 2100.0n 0.5047 2399.9n 0.5047 2400.0n 0.5047 2699.9n 0.5047 2700.0n 0.5047 2999.9n 0.5047 3000.0n 0.5047 3299.9n 0.5047 3300.0n 0.5047 3599.9n 0.5047 3600.0n 0.5047 3899.9n 0.5047 3900.0n 0.5047 4199.9n 0.5047 4200.0n 0.5047 4499.9n 0.5047 4500.0n 0.5047 4799.9n 0.5047 4800.0n 0.5047 5099.9n 0.5047 5100.0n 0.5047 5399.9n 0.5047 5400.0n 0.5047 5699.9n 0.5047 5700.0n 0.5047 5999.9n 0.5047 6000.0n 0.5047 6299.9n 0.5047 6300.0n 0.5047 6599.9n 0.5047 6600.0n 0.5047 6899.9n 0.5047 6900.0n 0.5047 7199.9n 0.5047 7200.0n 0.5047 7499.9n 0.5047 7500.0n 0.5047 7799.9n 0.5047 7800.0n 0.5047 8099.9n 0.5047 8100.0n 0.5047 8399.9n 0.5047 8400.0n 0.5047 8699.9n 0.5047 8700.0n 0.5047 8999.9n 0.5047 9000.0n 0.5047 9299.9n 0.5047 9300.0n 0.5047 9599.9n 0.5047 9600.0n 0.5047 9899.9n 0.5047 9900.0n 0.5047 10199.9n 0.5047 10200.0n 0.5047 10499.9n 0.5047 10500.0n 0.5047 10799.9n 0.5047 10800.0n 0.5047 11099.9n 0.5047 11100.0n 0.5047 11399.9n 0.5047 11400.0n 0.5047 11699.9n 0.5047 11700.0n 0.5047 11999.9n 0.5047 12000.0n 0.5047 12299.9n 0.5047 12300.0n 0.5047 12599.9n 0.5047 12600.0n 0.5047 12899.9n 0.5047 12900.0n 0.5047 13199.9n 0.5047 13200.0n 0.5047 13499.9n 0.5047 13500.0n 0.5047 13799.9n 0.5047 13800.0n 0.5047 14099.9n 0.5047 14100.0n 0.5047 14399.9n 0.5047 14400.0n 0.5047 14699.9n 0.5047 14700.0n 0.5047 14999.9n 0.5047 15000.0n 0.5047 15299.9n 0.5047 15300.0n 0.5047 15599.9n 0.5047 15600.0n 0.5047 15899.9n 0.5047 15900.0n 0.5047 16199.9n 0.5047 16200.0n 0.5047 16499.9n 0.5047 16500.0n 0.5047 16799.9n 0.5047 16800.0n 0.5047 17099.9n 0.5047 17100.0n 0.5047 17399.9n 0.5047 17400.0n 0.5047 17699.9n 0.5047 17700.0n 0.5047 17999.9n 0.5047 18000.0n 0.5047 18299.9n 0.5047 18300.0n 0.5047 18599.9n 0.5047 18600.0n 0.5047 18899.9n 0.5047 18900.0n 0.5047 19199.9n 0.5047 19200.0n 0.5047 19499.9n 0.5047 19500.0n 0.5047 19799.9n 0.5047 19800.0n 0.5047 20099.9n 0.5047 20100.0n 0.5047 20399.9n 0.5047 20400.0n 0.5047 20699.9n 0.5047 20700.0n 0.5047 20999.9n 0.5047 21000.0n 0.5047 21299.9n 0.5047 21300.0n 0.5047 21599.9n 0.5047 21600.0n 0.5047 21899.9n 0.5047 21900.0n 0.5047 22199.9n 0.5047 22200.0n 0.5047 22499.9n 0.5047 22500.0n 0.5047 22799.9n 0.5047 22800.0n 0.5047 23099.9n 0.5047 23100.0n 0.5047 23399.9n 0.5047 23400.0n 0.5047 23699.9n 0.5047 23700.0n 0.5047 23999.9n 0.5047 24000.0n 0.5047 24299.9n 0.5047 24300.0n 0.5047 24599.9n 0.5047 24600.0n 0.5047 24899.9n 0.5047 24900.0n 0.5047 25199.9n 0.5047 25200.0n 0.5047 25499.9n 0.5047 25500.0n 0.5047 25799.9n 0.5047 25800.0n 0.5047 26099.9n 0.5047 26100.0n 0.5047 26399.9n 0.5047 26400.0n 0.5047 26699.9n 0.5047 26700.0n 0.5047 26999.9n 0.5047 27000.0n 0.5047 27299.9n 0.5047 27300.0n 0.5047 27599.9n 0.5047 27600.0n 0.5047 27899.9n 0.5047 27900.0n 0.5047 28199.9n 0.5047 28200.0n 0.5047 28499.9n 0.5047 28500.0n 0.5047 28799.9n 0.5047 28800.0n 0.5047 29099.9n 0.5047 29100.0n 0.5047 29399.9n 0.5047 29400.0n 0.5047 29699.9n 0.5047 29700.0n 0.5047 29999.9n 0.5047 30000.0n 0.5047 30299.9n 0.5047 30300.0n 0.5047 30599.9n 0.5047 30600.0n 0.5047 30899.9n 0.5047 30900.0n 0.5047 31199.9n 0.5047 31200.0n 0.5047 31499.9n 0.5047 31500.0n 0.5047 31799.9n 0.5047 31800.0n 0.5047 32099.9n 0.5047 32100.0n 0.5047 32399.9n 0.5047 32400.0n 0.5047 32699.9n 0.5047 32700.0n 0.5047 32999.9n 0.5047 33000.0n 0.5047 33299.9n 0.5047 33300.0n 0.5047 33599.9n 0.5047 33600.0n 0.5047 33899.9n 0.5047 33900.0n 0.5047 34199.9n 0.5047 34200.0n 0.5047 34499.9n 0.5047 34500.0n 0.5047 34799.9n 0.5047 34800.0n 0.5047 35099.9n 0.5047 35100.0n 0.5047 35399.9n 0.5047 35400.0n 0.5047 35699.9n 0.5047 35700.0n 0.5047 35999.9n 0.5047 36000.0n 0.5047 36299.9n 0.5047 36300.0n 0.5047 36599.9n 0.5047 36600.0n 0.5047 36899.9n 0.5047 36900.0n 0.5047 37199.9n 0.5047 37200.0n 0.5047 37499.9n 0.5047 37500.0n 0.5047 37799.9n 0.5047 37800.0n 0.5047 38099.9n 0.5047 38100.0n 0.5047 38399.9n 0.5047 38400.0n 0.5047 38699.9n 0.5047 38700.0n 0.5047 38999.9n 0.5047 39000.0n 0.5047 39299.9n 0.5047 39300.0n 0.5047 39599.9n 0.5047 39600.0n 0.5047 39899.9n 0.5047 39900.0n 0.5047 40199.9n 0.5047 40200.0n 0.5047 40499.9n 0.5047 40500.0n 0.5047 40799.9n 0.5047 40800.0n 0.5047 41099.9n 0.5047 41100.0n 0.5047 41399.9n 0.5047 41400.0n 0.5047 41699.9n 0.5047 41700.0n 0.5047 41999.9n 0.5047 42000.0n 0.5047 42299.9n 0.5047 42300.0n 0.5047 42599.9n 0.5047 42600.0n 0.5047 42899.9n 0.5047 42900.0n 0.5047 43199.9n 0.5047 43200.0n 0.5047 43499.9n 0.5047 43500.0n 0.5047 43799.9n 0.5047 43800.0n 0.5047 44099.9n 0.5047 44100.0n 0.5047 44399.9n 0.5047 44400.0n 0.5047 44699.9n 0.5047 44700.0n 0.5047 44999.9n 0.5047 45000.0n 0.5047 45299.9n 0.5047 45300.0n 0.5047 45599.9n 0.5047 45600.0n 0.5047 45899.9n 0.5047 45900.0n 0.5047 46199.9n 0.5047 46200.0n 0.5047 46499.9n 0.5047 46500.0n 0.5047 46799.9n 0.5047 46800.0n 0.5047 47099.9n 0.5047 47100.0n 0.5047 47399.9n 0.5047 47400.0n 0.5047 47699.9n 0.5047 47700.0n 0.5047 47999.9n 0.5047 48000.0n 0.5047 48299.9n 0.5047 48300.0n 0.5047 48599.9n 0.5047 48600.0n 0.5047 48899.9n 0.5047 48900.0n 0.5047 49199.9n 0.5047 49200.0n 0.5047 49499.9n 0.5047 49500.0n 0.5047 49799.9n 0.5047 49800.0n 0.5047 50099.9n 0.5047 50100.0n 0.5047 50399.9n 0.5047 50400.0n 0.5047 50699.9n 0.5047 50700.0n 0.5047 50999.9n 0.5047 51000.0n 0.5047 51299.9n 0.5047 51300.0n 0.5047 51599.9n 0.5047 51600.0n 0.5047 51899.9n 0.5047 51900.0n 0.5047 52199.9n 0.5047 52200.0n 0.5047 52499.9n 0.5047 52500.0n 0.5047 52799.9n 0.5047 52800.0n 0.5047 53099.9n 0.5047 53100.0n 0.5047 53399.9n 0.5047 53400.0n 0.5047 53699.9n 0.5047 53700.0n 0.5047 53999.9n 0.5047 54000.0n 0.5047 54299.9n 0.5047 54300.0n 0.5047 54599.9n 0.5047 54600.0n 0.5047 54899.9n 0.5047 54900.0n 0.5047 55199.9n 0.5047 55200.0n 0.5047 55499.9n 0.5047 55500.0n 0.5047 55799.9n 0.5047 55800.0n 0.5047 56099.9n 0.5047 56100.0n 0.5047 56399.9n 0.5047 56400.0n 0.5047 56699.9n 0.5047 56700.0n 0.5047 56999.9n 0.5047 57000.0n 0.5047 57299.9n 0.5047 57300.0n 0.5047 57599.9n 0.5047 57600.0n 0.5047 57899.9n 0.5047 57900.0n 0.5047 58199.9n 0.5047 58200.0n 0.5047 58499.9n 0.5047 58500.0n 0.5047 58799.9n 0.5047 58800.0n 0.5047 59099.9n 0.5047 59100.0n 0.5047)
Vxp32 a_xp32 0 PWL(0.0n 0.5000 299.9n 0.5000 300.0n 0.5000 599.9n 0.5000 600.0n 0.5000 899.9n 0.5000 900.0n 0.5000 1199.9n 0.5000 1200.0n 0.5000 1499.9n 0.5000 1500.0n 0.5000 1799.9n 0.5000 1800.0n 0.5000 2099.9n 0.5000 2100.0n 0.5000 2399.9n 0.5000 2400.0n 0.5000 2699.9n 0.5000 2700.0n 0.5000 2999.9n 0.5000 3000.0n 0.5000 3299.9n 0.5000 3300.0n 0.5000 3599.9n 0.5000 3600.0n 0.5000 3899.9n 0.5000 3900.0n 0.5000 4199.9n 0.5000 4200.0n 0.5000 4499.9n 0.5000 4500.0n 0.5000 4799.9n 0.5000 4800.0n 0.5000 5099.9n 0.5000 5100.0n 0.5000 5399.9n 0.5000 5400.0n 0.5000 5699.9n 0.5000 5700.0n 0.5000 5999.9n 0.5000 6000.0n 0.5000 6299.9n 0.5000 6300.0n 0.5000 6599.9n 0.5000 6600.0n 0.5000 6899.9n 0.5000 6900.0n 0.5000 7199.9n 0.5000 7200.0n 0.5000 7499.9n 0.5000 7500.0n 0.5000 7799.9n 0.5000 7800.0n 0.5000 8099.9n 0.5000 8100.0n 0.5000 8399.9n 0.5000 8400.0n 0.5000 8699.9n 0.5000 8700.0n 0.5000 8999.9n 0.5000 9000.0n 0.5000 9299.9n 0.5000 9300.0n 0.5000 9599.9n 0.5000 9600.0n 0.5000 9899.9n 0.5000 9900.0n 0.5000 10199.9n 0.5000 10200.0n 0.5000 10499.9n 0.5000 10500.0n 0.5000 10799.9n 0.5000 10800.0n 0.5000 11099.9n 0.5000 11100.0n 0.5000 11399.9n 0.5000 11400.0n 0.5000 11699.9n 0.5000 11700.0n 0.5000 11999.9n 0.5000 12000.0n 0.5000 12299.9n 0.5000 12300.0n 0.5000 12599.9n 0.5000 12600.0n 0.5000 12899.9n 0.5000 12900.0n 0.5000 13199.9n 0.5000 13200.0n 0.5000 13499.9n 0.5000 13500.0n 0.5000 13799.9n 0.5000 13800.0n 0.5000 14099.9n 0.5000 14100.0n 0.5000 14399.9n 0.5000 14400.0n 0.5000 14699.9n 0.5000 14700.0n 0.5000 14999.9n 0.5000 15000.0n 0.5000 15299.9n 0.5000 15300.0n 0.5000 15599.9n 0.5000 15600.0n 0.5000 15899.9n 0.5000 15900.0n 0.5000 16199.9n 0.5000 16200.0n 0.5000 16499.9n 0.5000 16500.0n 0.5000 16799.9n 0.5000 16800.0n 0.5000 17099.9n 0.5000 17100.0n 0.5000 17399.9n 0.5000 17400.0n 0.5000 17699.9n 0.5000 17700.0n 0.5000 17999.9n 0.5000 18000.0n 0.5000 18299.9n 0.5000 18300.0n 0.5000 18599.9n 0.5000 18600.0n 0.5000 18899.9n 0.5000 18900.0n 0.5000 19199.9n 0.5000 19200.0n 0.5000 19499.9n 0.5000 19500.0n 0.5000 19799.9n 0.5000 19800.0n 0.5000 20099.9n 0.5000 20100.0n 0.5000 20399.9n 0.5000 20400.0n 0.5000 20699.9n 0.5000 20700.0n 0.5000 20999.9n 0.5000 21000.0n 0.5000 21299.9n 0.5000 21300.0n 0.5000 21599.9n 0.5000 21600.0n 0.5000 21899.9n 0.5000 21900.0n 0.5000 22199.9n 0.5000 22200.0n 0.5000 22499.9n 0.5000 22500.0n 0.5000 22799.9n 0.5000 22800.0n 0.5000 23099.9n 0.5000 23100.0n 0.5000 23399.9n 0.5000 23400.0n 0.5000 23699.9n 0.5000 23700.0n 0.5000 23999.9n 0.5000 24000.0n 0.5000 24299.9n 0.5000 24300.0n 0.5000 24599.9n 0.5000 24600.0n 0.5000 24899.9n 0.5000 24900.0n 0.5000 25199.9n 0.5000 25200.0n 0.5000 25499.9n 0.5000 25500.0n 0.5000 25799.9n 0.5000 25800.0n 0.5000 26099.9n 0.5000 26100.0n 0.5000 26399.9n 0.5000 26400.0n 0.5000 26699.9n 0.5000 26700.0n 0.5000 26999.9n 0.5000 27000.0n 0.5000 27299.9n 0.5000 27300.0n 0.5000 27599.9n 0.5000 27600.0n 0.5000 27899.9n 0.5000 27900.0n 0.5000 28199.9n 0.5000 28200.0n 0.5000 28499.9n 0.5000 28500.0n 0.5000 28799.9n 0.5000 28800.0n 0.5000 29099.9n 0.5000 29100.0n 0.5000 29399.9n 0.5000 29400.0n 0.5000 29699.9n 0.5000 29700.0n 0.5000 29999.9n 0.5000 30000.0n 0.5000 30299.9n 0.5000 30300.0n 0.5000 30599.9n 0.5000 30600.0n 0.5000 30899.9n 0.5000 30900.0n 0.5000 31199.9n 0.5000 31200.0n 0.5000 31499.9n 0.5000 31500.0n 0.5000 31799.9n 0.5000 31800.0n 0.5000 32099.9n 0.5000 32100.0n 0.5000 32399.9n 0.5000 32400.0n 0.5000 32699.9n 0.5000 32700.0n 0.5000 32999.9n 0.5000 33000.0n 0.5000 33299.9n 0.5000 33300.0n 0.5000 33599.9n 0.5000 33600.0n 0.5000 33899.9n 0.5000 33900.0n 0.5000 34199.9n 0.5000 34200.0n 0.5000 34499.9n 0.5000 34500.0n 0.5000 34799.9n 0.5000 34800.0n 0.5000 35099.9n 0.5000 35100.0n 0.5000 35399.9n 0.5000 35400.0n 0.5000 35699.9n 0.5000 35700.0n 0.5000 35999.9n 0.5000 36000.0n 0.5000 36299.9n 0.5000 36300.0n 0.5000 36599.9n 0.5000 36600.0n 0.5000 36899.9n 0.5000 36900.0n 0.5000 37199.9n 0.5000 37200.0n 0.5000 37499.9n 0.5000 37500.0n 0.5000 37799.9n 0.5000 37800.0n 0.5000 38099.9n 0.5000 38100.0n 0.5000 38399.9n 0.5000 38400.0n 0.5000 38699.9n 0.5000 38700.0n 0.5000 38999.9n 0.5000 39000.0n 0.5000 39299.9n 0.5000 39300.0n 0.5000 39599.9n 0.5000 39600.0n 0.5000 39899.9n 0.5000 39900.0n 0.5000 40199.9n 0.5000 40200.0n 0.5000 40499.9n 0.5000 40500.0n 0.5000 40799.9n 0.5000 40800.0n 0.5000 41099.9n 0.5000 41100.0n 0.5000 41399.9n 0.5000 41400.0n 0.5000 41699.9n 0.5000 41700.0n 0.5000 41999.9n 0.5000 42000.0n 0.5000 42299.9n 0.5000 42300.0n 0.5000 42599.9n 0.5000 42600.0n 0.5000 42899.9n 0.5000 42900.0n 0.5000 43199.9n 0.5000 43200.0n 0.5000 43499.9n 0.5000 43500.0n 0.5000 43799.9n 0.5000 43800.0n 0.5000 44099.9n 0.5000 44100.0n 0.5000 44399.9n 0.5000 44400.0n 0.5000 44699.9n 0.5000 44700.0n 0.5000 44999.9n 0.5000 45000.0n 0.5000 45299.9n 0.5000 45300.0n 0.5000 45599.9n 0.5000 45600.0n 0.5000 45899.9n 0.5000 45900.0n 0.5000 46199.9n 0.5000 46200.0n 0.5000 46499.9n 0.5000 46500.0n 0.5000 46799.9n 0.5000 46800.0n 0.5000 47099.9n 0.5000 47100.0n 0.5000 47399.9n 0.5000 47400.0n 0.5000 47699.9n 0.5000 47700.0n 0.5000 47999.9n 0.5000 48000.0n 0.5000 48299.9n 0.5000 48300.0n 0.5000 48599.9n 0.5000 48600.0n 0.5000 48899.9n 0.5000 48900.0n 0.5000 49199.9n 0.5000 49200.0n 0.5000 49499.9n 0.5000 49500.0n 0.5000 49799.9n 0.5000 49800.0n 0.5000 50099.9n 0.5000 50100.0n 0.5000 50399.9n 0.5000 50400.0n 0.5000 50699.9n 0.5000 50700.0n 0.5000 50999.9n 0.5000 51000.0n 0.5000 51299.9n 0.5000 51300.0n 0.5000 51599.9n 0.5000 51600.0n 0.5000 51899.9n 0.5000 51900.0n 0.5000 52199.9n 0.5000 52200.0n 0.5000 52499.9n 0.5000 52500.0n 0.5000 52799.9n 0.5000 52800.0n 0.5000 53099.9n 0.5000 53100.0n 0.5000 53399.9n 0.5000 53400.0n 0.5000 53699.9n 0.5000 53700.0n 0.5000 53999.9n 0.5000 54000.0n 0.5000 54299.9n 0.5000 54300.0n 0.5000 54599.9n 0.5000 54600.0n 0.5000 54899.9n 0.5000 54900.0n 0.5000 55199.9n 0.5000 55200.0n 0.5000 55499.9n 0.5000 55500.0n 0.5000 55799.9n 0.5000 55800.0n 0.5000 56099.9n 0.5000 56100.0n 0.5000 56399.9n 0.5000 56400.0n 0.5000 56699.9n 0.5000 56700.0n 0.5000 56999.9n 0.5000 57000.0n 0.5000 57299.9n 0.5000 57300.0n 0.5000 57599.9n 0.5000 57600.0n 0.5000 57899.9n 0.5000 57900.0n 0.5000 58199.9n 0.5000 58200.0n 0.5000 58499.9n 0.5000 58500.0n 0.5000 58799.9n 0.5000 58800.0n 0.5000 59099.9n 0.5000 59100.0n 0.5000)
Vxn32 a_xn32 0 PWL(0.0n 0.5000 299.9n 0.5000 300.0n 0.5000 599.9n 0.5000 600.0n 0.5000 899.9n 0.5000 900.0n 0.5000 1199.9n 0.5000 1200.0n 0.5000 1499.9n 0.5000 1500.0n 0.5000 1799.9n 0.5000 1800.0n 0.5000 2099.9n 0.5000 2100.0n 0.5000 2399.9n 0.5000 2400.0n 0.5000 2699.9n 0.5000 2700.0n 0.5000 2999.9n 0.5000 3000.0n 0.5000 3299.9n 0.5000 3300.0n 0.5000 3599.9n 0.5000 3600.0n 0.5000 3899.9n 0.5000 3900.0n 0.5000 4199.9n 0.5000 4200.0n 0.5000 4499.9n 0.5000 4500.0n 0.5000 4799.9n 0.5000 4800.0n 0.5000 5099.9n 0.5000 5100.0n 0.5000 5399.9n 0.5000 5400.0n 0.5000 5699.9n 0.5000 5700.0n 0.5000 5999.9n 0.5000 6000.0n 0.5000 6299.9n 0.5000 6300.0n 0.5000 6599.9n 0.5000 6600.0n 0.5000 6899.9n 0.5000 6900.0n 0.5000 7199.9n 0.5000 7200.0n 0.5000 7499.9n 0.5000 7500.0n 0.5000 7799.9n 0.5000 7800.0n 0.5000 8099.9n 0.5000 8100.0n 0.5000 8399.9n 0.5000 8400.0n 0.5000 8699.9n 0.5000 8700.0n 0.5000 8999.9n 0.5000 9000.0n 0.5000 9299.9n 0.5000 9300.0n 0.5000 9599.9n 0.5000 9600.0n 0.5000 9899.9n 0.5000 9900.0n 0.5000 10199.9n 0.5000 10200.0n 0.5000 10499.9n 0.5000 10500.0n 0.5000 10799.9n 0.5000 10800.0n 0.5000 11099.9n 0.5000 11100.0n 0.5000 11399.9n 0.5000 11400.0n 0.5000 11699.9n 0.5000 11700.0n 0.5000 11999.9n 0.5000 12000.0n 0.5000 12299.9n 0.5000 12300.0n 0.5000 12599.9n 0.5000 12600.0n 0.5000 12899.9n 0.5000 12900.0n 0.5000 13199.9n 0.5000 13200.0n 0.5000 13499.9n 0.5000 13500.0n 0.5000 13799.9n 0.5000 13800.0n 0.5000 14099.9n 0.5000 14100.0n 0.5000 14399.9n 0.5000 14400.0n 0.5000 14699.9n 0.5000 14700.0n 0.5000 14999.9n 0.5000 15000.0n 0.5000 15299.9n 0.5000 15300.0n 0.5000 15599.9n 0.5000 15600.0n 0.5000 15899.9n 0.5000 15900.0n 0.5000 16199.9n 0.5000 16200.0n 0.5000 16499.9n 0.5000 16500.0n 0.5000 16799.9n 0.5000 16800.0n 0.5000 17099.9n 0.5000 17100.0n 0.5000 17399.9n 0.5000 17400.0n 0.5000 17699.9n 0.5000 17700.0n 0.5000 17999.9n 0.5000 18000.0n 0.5000 18299.9n 0.5000 18300.0n 0.5000 18599.9n 0.5000 18600.0n 0.5000 18899.9n 0.5000 18900.0n 0.5000 19199.9n 0.5000 19200.0n 0.5000 19499.9n 0.5000 19500.0n 0.5000 19799.9n 0.5000 19800.0n 0.5000 20099.9n 0.5000 20100.0n 0.5000 20399.9n 0.5000 20400.0n 0.5000 20699.9n 0.5000 20700.0n 0.5000 20999.9n 0.5000 21000.0n 0.5000 21299.9n 0.5000 21300.0n 0.5000 21599.9n 0.5000 21600.0n 0.5000 21899.9n 0.5000 21900.0n 0.5000 22199.9n 0.5000 22200.0n 0.5000 22499.9n 0.5000 22500.0n 0.5000 22799.9n 0.5000 22800.0n 0.5000 23099.9n 0.5000 23100.0n 0.5000 23399.9n 0.5000 23400.0n 0.5000 23699.9n 0.5000 23700.0n 0.5000 23999.9n 0.5000 24000.0n 0.5000 24299.9n 0.5000 24300.0n 0.5000 24599.9n 0.5000 24600.0n 0.5000 24899.9n 0.5000 24900.0n 0.5000 25199.9n 0.5000 25200.0n 0.5000 25499.9n 0.5000 25500.0n 0.5000 25799.9n 0.5000 25800.0n 0.5000 26099.9n 0.5000 26100.0n 0.5000 26399.9n 0.5000 26400.0n 0.5000 26699.9n 0.5000 26700.0n 0.5000 26999.9n 0.5000 27000.0n 0.5000 27299.9n 0.5000 27300.0n 0.5000 27599.9n 0.5000 27600.0n 0.5000 27899.9n 0.5000 27900.0n 0.5000 28199.9n 0.5000 28200.0n 0.5000 28499.9n 0.5000 28500.0n 0.5000 28799.9n 0.5000 28800.0n 0.5000 29099.9n 0.5000 29100.0n 0.5000 29399.9n 0.5000 29400.0n 0.5000 29699.9n 0.5000 29700.0n 0.5000 29999.9n 0.5000 30000.0n 0.5000 30299.9n 0.5000 30300.0n 0.5000 30599.9n 0.5000 30600.0n 0.5000 30899.9n 0.5000 30900.0n 0.5000 31199.9n 0.5000 31200.0n 0.5000 31499.9n 0.5000 31500.0n 0.5000 31799.9n 0.5000 31800.0n 0.5000 32099.9n 0.5000 32100.0n 0.5000 32399.9n 0.5000 32400.0n 0.5000 32699.9n 0.5000 32700.0n 0.5000 32999.9n 0.5000 33000.0n 0.5000 33299.9n 0.5000 33300.0n 0.5000 33599.9n 0.5000 33600.0n 0.5000 33899.9n 0.5000 33900.0n 0.5000 34199.9n 0.5000 34200.0n 0.5000 34499.9n 0.5000 34500.0n 0.5000 34799.9n 0.5000 34800.0n 0.5000 35099.9n 0.5000 35100.0n 0.5000 35399.9n 0.5000 35400.0n 0.5000 35699.9n 0.5000 35700.0n 0.5000 35999.9n 0.5000 36000.0n 0.5000 36299.9n 0.5000 36300.0n 0.5000 36599.9n 0.5000 36600.0n 0.5000 36899.9n 0.5000 36900.0n 0.5000 37199.9n 0.5000 37200.0n 0.5000 37499.9n 0.5000 37500.0n 0.5000 37799.9n 0.5000 37800.0n 0.5000 38099.9n 0.5000 38100.0n 0.5000 38399.9n 0.5000 38400.0n 0.5000 38699.9n 0.5000 38700.0n 0.5000 38999.9n 0.5000 39000.0n 0.5000 39299.9n 0.5000 39300.0n 0.5000 39599.9n 0.5000 39600.0n 0.5000 39899.9n 0.5000 39900.0n 0.5000 40199.9n 0.5000 40200.0n 0.5000 40499.9n 0.5000 40500.0n 0.5000 40799.9n 0.5000 40800.0n 0.5000 41099.9n 0.5000 41100.0n 0.5000 41399.9n 0.5000 41400.0n 0.5000 41699.9n 0.5000 41700.0n 0.5000 41999.9n 0.5000 42000.0n 0.5000 42299.9n 0.5000 42300.0n 0.5000 42599.9n 0.5000 42600.0n 0.5000 42899.9n 0.5000 42900.0n 0.5000 43199.9n 0.5000 43200.0n 0.5000 43499.9n 0.5000 43500.0n 0.5000 43799.9n 0.5000 43800.0n 0.5000 44099.9n 0.5000 44100.0n 0.5000 44399.9n 0.5000 44400.0n 0.5000 44699.9n 0.5000 44700.0n 0.5000 44999.9n 0.5000 45000.0n 0.5000 45299.9n 0.5000 45300.0n 0.5000 45599.9n 0.5000 45600.0n 0.5000 45899.9n 0.5000 45900.0n 0.5000 46199.9n 0.5000 46200.0n 0.5000 46499.9n 0.5000 46500.0n 0.5000 46799.9n 0.5000 46800.0n 0.5000 47099.9n 0.5000 47100.0n 0.5000 47399.9n 0.5000 47400.0n 0.5000 47699.9n 0.5000 47700.0n 0.5000 47999.9n 0.5000 48000.0n 0.5000 48299.9n 0.5000 48300.0n 0.5000 48599.9n 0.5000 48600.0n 0.5000 48899.9n 0.5000 48900.0n 0.5000 49199.9n 0.5000 49200.0n 0.5000 49499.9n 0.5000 49500.0n 0.5000 49799.9n 0.5000 49800.0n 0.5000 50099.9n 0.5000 50100.0n 0.5000 50399.9n 0.5000 50400.0n 0.5000 50699.9n 0.5000 50700.0n 0.5000 50999.9n 0.5000 51000.0n 0.5000 51299.9n 0.5000 51300.0n 0.5000 51599.9n 0.5000 51600.0n 0.5000 51899.9n 0.5000 51900.0n 0.5000 52199.9n 0.5000 52200.0n 0.5000 52499.9n 0.5000 52500.0n 0.5000 52799.9n 0.5000 52800.0n 0.5000 53099.9n 0.5000 53100.0n 0.5000 53399.9n 0.5000 53400.0n 0.5000 53699.9n 0.5000 53700.0n 0.5000 53999.9n 0.5000 54000.0n 0.5000 54299.9n 0.5000 54300.0n 0.5000 54599.9n 0.5000 54600.0n 0.5000 54899.9n 0.5000 54900.0n 0.5000 55199.9n 0.5000 55200.0n 0.5000 55499.9n 0.5000 55500.0n 0.5000 55799.9n 0.5000 55800.0n 0.5000 56099.9n 0.5000 56100.0n 0.5000 56399.9n 0.5000 56400.0n 0.5000 56699.9n 0.5000 56700.0n 0.5000 56999.9n 0.5000 57000.0n 0.5000 57299.9n 0.5000 57300.0n 0.5000 57599.9n 0.5000 57600.0n 0.5000 57899.9n 0.5000 57900.0n 0.5000 58199.9n 0.5000 58200.0n 0.5000 58499.9n 0.5000 58500.0n 0.5000 58799.9n 0.5000 58800.0n 0.5000 59099.9n 0.5000 59100.0n 0.5000)
Vxp33 a_xp33 0 PWL(0.0n 0.5477 299.9n 0.5477 300.0n 0.5765 599.9n 0.5765 600.0n 0.6339 899.9n 0.6339 900.0n 0.5765 1199.9n 0.5765 1200.0n 0.4328 1499.9n 0.4328 1500.0n 0.6339 1799.9n 0.6339 1800.0n 0.5477 2099.9n 0.5477 2100.0n 0.4328 2399.9n 0.4328 2400.0n 0.4328 2699.9n 0.4328 2700.0n 0.4328 2999.9n 0.4328 3000.0n 0.4328 3299.9n 0.4328 3300.0n 0.4328 3599.9n 0.4328 3600.0n 0.4328 3899.9n 0.4328 3900.0n 0.4328 4199.9n 0.4328 4200.0n 0.4328 4499.9n 0.4328 4500.0n 0.4328 4799.9n 0.4328 4800.0n 0.4902 5099.9n 0.4902 5100.0n 0.4328 5399.9n 0.4328 5400.0n 0.5477 5699.9n 0.5477 5700.0n 0.5765 5999.9n 0.5765 6000.0n 0.6339 6299.9n 0.6339 6300.0n 0.5765 6599.9n 0.5765 6600.0n 0.4328 6899.9n 0.4328 6900.0n 0.6339 7199.9n 0.6339 7200.0n 0.5477 7499.9n 0.5477 7500.0n 0.4328 7799.9n 0.4328 7800.0n 0.4328 8099.9n 0.4328 8100.0n 0.4328 8399.9n 0.4328 8400.0n 0.4328 8699.9n 0.4328 8700.0n 0.4328 8999.9n 0.4328 9000.0n 0.4328 9299.9n 0.4328 9300.0n 0.4328 9599.9n 0.4328 9600.0n 0.4328 9899.9n 0.4328 9900.0n 0.4328 10199.9n 0.4328 10200.0n 0.4902 10499.9n 0.4902 10500.0n 0.4328 10799.9n 0.4328 10800.0n 0.5477 11099.9n 0.5477 11100.0n 0.5765 11399.9n 0.5765 11400.0n 0.6339 11699.9n 0.6339 11700.0n 0.5765 11999.9n 0.5765 12000.0n 0.4328 12299.9n 0.4328 12300.0n 0.6339 12599.9n 0.6339 12600.0n 0.5477 12899.9n 0.5477 12900.0n 0.4328 13199.9n 0.4328 13200.0n 0.4328 13499.9n 0.4328 13500.0n 0.4328 13799.9n 0.4328 13800.0n 0.4328 14099.9n 0.4328 14100.0n 0.4328 14399.9n 0.4328 14400.0n 0.4328 14699.9n 0.4328 14700.0n 0.4328 14999.9n 0.4328 15000.0n 0.4328 15299.9n 0.4328 15300.0n 0.4328 15599.9n 0.4328 15600.0n 0.4902 15899.9n 0.4902 15900.0n 0.4328 16199.9n 0.4328 16200.0n 0.5477 16499.9n 0.5477 16500.0n 0.5765 16799.9n 0.5765 16800.0n 0.6339 17099.9n 0.6339 17100.0n 0.5765 17399.9n 0.5765 17400.0n 0.4328 17699.9n 0.4328 17700.0n 0.6339 17999.9n 0.6339 18000.0n 0.5477 18299.9n 0.5477 18300.0n 0.4328 18599.9n 0.4328 18600.0n 0.4328 18899.9n 0.4328 18900.0n 0.4328 19199.9n 0.4328 19200.0n 0.4328 19499.9n 0.4328 19500.0n 0.4328 19799.9n 0.4328 19800.0n 0.4328 20099.9n 0.4328 20100.0n 0.4328 20399.9n 0.4328 20400.0n 0.4328 20699.9n 0.4328 20700.0n 0.4328 20999.9n 0.4328 21000.0n 0.4902 21299.9n 0.4902 21300.0n 0.4328 21599.9n 0.4328 21600.0n 0.5477 21899.9n 0.5477 21900.0n 0.5765 22199.9n 0.5765 22200.0n 0.6339 22499.9n 0.6339 22500.0n 0.5765 22799.9n 0.5765 22800.0n 0.4328 23099.9n 0.4328 23100.0n 0.6339 23399.9n 0.6339 23400.0n 0.5477 23699.9n 0.5477 23700.0n 0.4328 23999.9n 0.4328 24000.0n 0.4328 24299.9n 0.4328 24300.0n 0.4328 24599.9n 0.4328 24600.0n 0.4328 24899.9n 0.4328 24900.0n 0.4328 25199.9n 0.4328 25200.0n 0.4328 25499.9n 0.4328 25500.0n 0.4328 25799.9n 0.4328 25800.0n 0.4328 26099.9n 0.4328 26100.0n 0.4328 26399.9n 0.4328 26400.0n 0.4902 26699.9n 0.4902 26700.0n 0.4328 26999.9n 0.4328 27000.0n 0.5477 27299.9n 0.5477 27300.0n 0.5765 27599.9n 0.5765 27600.0n 0.6339 27899.9n 0.6339 27900.0n 0.5765 28199.9n 0.5765 28200.0n 0.4328 28499.9n 0.4328 28500.0n 0.6339 28799.9n 0.6339 28800.0n 0.5477 29099.9n 0.5477 29100.0n 0.4328 29399.9n 0.4328 29400.0n 0.4328 29699.9n 0.4328 29700.0n 0.4328 29999.9n 0.4328 30000.0n 0.4328 30299.9n 0.4328 30300.0n 0.4328 30599.9n 0.4328 30600.0n 0.4328 30899.9n 0.4328 30900.0n 0.4328 31199.9n 0.4328 31200.0n 0.4328 31499.9n 0.4328 31500.0n 0.4328 31799.9n 0.4328 31800.0n 0.4902 32099.9n 0.4902 32100.0n 0.4328 32399.9n 0.4328 32400.0n 0.5477 32699.9n 0.5477 32700.0n 0.5765 32999.9n 0.5765 33000.0n 0.6339 33299.9n 0.6339 33300.0n 0.5765 33599.9n 0.5765 33600.0n 0.4328 33899.9n 0.4328 33900.0n 0.6339 34199.9n 0.6339 34200.0n 0.5477 34499.9n 0.5477 34500.0n 0.4328 34799.9n 0.4328 34800.0n 0.4328 35099.9n 0.4328 35100.0n 0.4328 35399.9n 0.4328 35400.0n 0.4328 35699.9n 0.4328 35700.0n 0.4328 35999.9n 0.4328 36000.0n 0.4328 36299.9n 0.4328 36300.0n 0.4328 36599.9n 0.4328 36600.0n 0.4328 36899.9n 0.4328 36900.0n 0.4328 37199.9n 0.4328 37200.0n 0.4902 37499.9n 0.4902 37500.0n 0.4328 37799.9n 0.4328 37800.0n 0.5477 38099.9n 0.5477 38100.0n 0.5765 38399.9n 0.5765 38400.0n 0.6339 38699.9n 0.6339 38700.0n 0.5765 38999.9n 0.5765 39000.0n 0.4328 39299.9n 0.4328 39300.0n 0.6339 39599.9n 0.6339 39600.0n 0.5477 39899.9n 0.5477 39900.0n 0.4328 40199.9n 0.4328 40200.0n 0.4328 40499.9n 0.4328 40500.0n 0.4328 40799.9n 0.4328 40800.0n 0.4328 41099.9n 0.4328 41100.0n 0.4328 41399.9n 0.4328 41400.0n 0.4328 41699.9n 0.4328 41700.0n 0.4328 41999.9n 0.4328 42000.0n 0.4328 42299.9n 0.4328 42300.0n 0.4328 42599.9n 0.4328 42600.0n 0.4902 42899.9n 0.4902 42900.0n 0.4328 43199.9n 0.4328 43200.0n 0.5477 43499.9n 0.5477 43500.0n 0.5765 43799.9n 0.5765 43800.0n 0.6339 44099.9n 0.6339 44100.0n 0.5765 44399.9n 0.5765 44400.0n 0.4328 44699.9n 0.4328 44700.0n 0.6339 44999.9n 0.6339 45000.0n 0.5477 45299.9n 0.5477 45300.0n 0.4328 45599.9n 0.4328 45600.0n 0.4328 45899.9n 0.4328 45900.0n 0.4328 46199.9n 0.4328 46200.0n 0.4328 46499.9n 0.4328 46500.0n 0.4328 46799.9n 0.4328 46800.0n 0.4328 47099.9n 0.4328 47100.0n 0.4328 47399.9n 0.4328 47400.0n 0.4328 47699.9n 0.4328 47700.0n 0.4328 47999.9n 0.4328 48000.0n 0.4902 48299.9n 0.4902 48300.0n 0.4328 48599.9n 0.4328 48600.0n 0.5477 48899.9n 0.5477 48900.0n 0.5765 49199.9n 0.5765 49200.0n 0.6339 49499.9n 0.6339 49500.0n 0.5765 49799.9n 0.5765 49800.0n 0.4328 50099.9n 0.4328 50100.0n 0.6339 50399.9n 0.6339 50400.0n 0.5477 50699.9n 0.5477 50700.0n 0.4328 50999.9n 0.4328 51000.0n 0.4328 51299.9n 0.4328 51300.0n 0.4328 51599.9n 0.4328 51600.0n 0.4328 51899.9n 0.4328 51900.0n 0.4328 52199.9n 0.4328 52200.0n 0.4328 52499.9n 0.4328 52500.0n 0.4328 52799.9n 0.4328 52800.0n 0.4328 53099.9n 0.4328 53100.0n 0.4328 53399.9n 0.4328 53400.0n 0.4902 53699.9n 0.4902 53700.0n 0.4328 53999.9n 0.4328 54000.0n 0.5765 54299.9n 0.5765 54300.0n 0.6627 54599.9n 0.6627 54600.0n 0.7202 54899.9n 0.7202 54900.0n 0.5477 55199.9n 0.5477 55200.0n 0.5765 55499.9n 0.5765 55500.0n 0.6339 55799.9n 0.6339 55800.0n 0.4328 56099.9n 0.4328 56100.0n 0.4615 56399.9n 0.4615 56400.0n 0.5477 56699.9n 0.5477 56700.0n 0.4328 56999.9n 0.4328 57000.0n 0.4328 57299.9n 0.4328 57300.0n 0.4328 57599.9n 0.4328 57600.0n 0.4328 57899.9n 0.4328 57900.0n 0.4328 58199.9n 0.4328 58200.0n 0.4328 58499.9n 0.4328 58500.0n 0.4328 58799.9n 0.4328 58800.0n 0.4328 59099.9n 0.4328 59100.0n 0.4328)
Vxn33 a_xn33 0 PWL(0.0n 0.4523 299.9n 0.4523 300.0n 0.4235 599.9n 0.4235 600.0n 0.3661 899.9n 0.3661 900.0n 0.4235 1199.9n 0.4235 1200.0n 0.5672 1499.9n 0.5672 1500.0n 0.3661 1799.9n 0.3661 1800.0n 0.4523 2099.9n 0.4523 2100.0n 0.5672 2399.9n 0.5672 2400.0n 0.5672 2699.9n 0.5672 2700.0n 0.5672 2999.9n 0.5672 3000.0n 0.5672 3299.9n 0.5672 3300.0n 0.5672 3599.9n 0.5672 3600.0n 0.5672 3899.9n 0.5672 3900.0n 0.5672 4199.9n 0.5672 4200.0n 0.5672 4499.9n 0.5672 4500.0n 0.5672 4799.9n 0.5672 4800.0n 0.5098 5099.9n 0.5098 5100.0n 0.5672 5399.9n 0.5672 5400.0n 0.4523 5699.9n 0.4523 5700.0n 0.4235 5999.9n 0.4235 6000.0n 0.3661 6299.9n 0.3661 6300.0n 0.4235 6599.9n 0.4235 6600.0n 0.5672 6899.9n 0.5672 6900.0n 0.3661 7199.9n 0.3661 7200.0n 0.4523 7499.9n 0.4523 7500.0n 0.5672 7799.9n 0.5672 7800.0n 0.5672 8099.9n 0.5672 8100.0n 0.5672 8399.9n 0.5672 8400.0n 0.5672 8699.9n 0.5672 8700.0n 0.5672 8999.9n 0.5672 9000.0n 0.5672 9299.9n 0.5672 9300.0n 0.5672 9599.9n 0.5672 9600.0n 0.5672 9899.9n 0.5672 9900.0n 0.5672 10199.9n 0.5672 10200.0n 0.5098 10499.9n 0.5098 10500.0n 0.5672 10799.9n 0.5672 10800.0n 0.4523 11099.9n 0.4523 11100.0n 0.4235 11399.9n 0.4235 11400.0n 0.3661 11699.9n 0.3661 11700.0n 0.4235 11999.9n 0.4235 12000.0n 0.5672 12299.9n 0.5672 12300.0n 0.3661 12599.9n 0.3661 12600.0n 0.4523 12899.9n 0.4523 12900.0n 0.5672 13199.9n 0.5672 13200.0n 0.5672 13499.9n 0.5672 13500.0n 0.5672 13799.9n 0.5672 13800.0n 0.5672 14099.9n 0.5672 14100.0n 0.5672 14399.9n 0.5672 14400.0n 0.5672 14699.9n 0.5672 14700.0n 0.5672 14999.9n 0.5672 15000.0n 0.5672 15299.9n 0.5672 15300.0n 0.5672 15599.9n 0.5672 15600.0n 0.5098 15899.9n 0.5098 15900.0n 0.5672 16199.9n 0.5672 16200.0n 0.4523 16499.9n 0.4523 16500.0n 0.4235 16799.9n 0.4235 16800.0n 0.3661 17099.9n 0.3661 17100.0n 0.4235 17399.9n 0.4235 17400.0n 0.5672 17699.9n 0.5672 17700.0n 0.3661 17999.9n 0.3661 18000.0n 0.4523 18299.9n 0.4523 18300.0n 0.5672 18599.9n 0.5672 18600.0n 0.5672 18899.9n 0.5672 18900.0n 0.5672 19199.9n 0.5672 19200.0n 0.5672 19499.9n 0.5672 19500.0n 0.5672 19799.9n 0.5672 19800.0n 0.5672 20099.9n 0.5672 20100.0n 0.5672 20399.9n 0.5672 20400.0n 0.5672 20699.9n 0.5672 20700.0n 0.5672 20999.9n 0.5672 21000.0n 0.5098 21299.9n 0.5098 21300.0n 0.5672 21599.9n 0.5672 21600.0n 0.4523 21899.9n 0.4523 21900.0n 0.4235 22199.9n 0.4235 22200.0n 0.3661 22499.9n 0.3661 22500.0n 0.4235 22799.9n 0.4235 22800.0n 0.5672 23099.9n 0.5672 23100.0n 0.3661 23399.9n 0.3661 23400.0n 0.4523 23699.9n 0.4523 23700.0n 0.5672 23999.9n 0.5672 24000.0n 0.5672 24299.9n 0.5672 24300.0n 0.5672 24599.9n 0.5672 24600.0n 0.5672 24899.9n 0.5672 24900.0n 0.5672 25199.9n 0.5672 25200.0n 0.5672 25499.9n 0.5672 25500.0n 0.5672 25799.9n 0.5672 25800.0n 0.5672 26099.9n 0.5672 26100.0n 0.5672 26399.9n 0.5672 26400.0n 0.5098 26699.9n 0.5098 26700.0n 0.5672 26999.9n 0.5672 27000.0n 0.4523 27299.9n 0.4523 27300.0n 0.4235 27599.9n 0.4235 27600.0n 0.3661 27899.9n 0.3661 27900.0n 0.4235 28199.9n 0.4235 28200.0n 0.5672 28499.9n 0.5672 28500.0n 0.3661 28799.9n 0.3661 28800.0n 0.4523 29099.9n 0.4523 29100.0n 0.5672 29399.9n 0.5672 29400.0n 0.5672 29699.9n 0.5672 29700.0n 0.5672 29999.9n 0.5672 30000.0n 0.5672 30299.9n 0.5672 30300.0n 0.5672 30599.9n 0.5672 30600.0n 0.5672 30899.9n 0.5672 30900.0n 0.5672 31199.9n 0.5672 31200.0n 0.5672 31499.9n 0.5672 31500.0n 0.5672 31799.9n 0.5672 31800.0n 0.5098 32099.9n 0.5098 32100.0n 0.5672 32399.9n 0.5672 32400.0n 0.4523 32699.9n 0.4523 32700.0n 0.4235 32999.9n 0.4235 33000.0n 0.3661 33299.9n 0.3661 33300.0n 0.4235 33599.9n 0.4235 33600.0n 0.5672 33899.9n 0.5672 33900.0n 0.3661 34199.9n 0.3661 34200.0n 0.4523 34499.9n 0.4523 34500.0n 0.5672 34799.9n 0.5672 34800.0n 0.5672 35099.9n 0.5672 35100.0n 0.5672 35399.9n 0.5672 35400.0n 0.5672 35699.9n 0.5672 35700.0n 0.5672 35999.9n 0.5672 36000.0n 0.5672 36299.9n 0.5672 36300.0n 0.5672 36599.9n 0.5672 36600.0n 0.5672 36899.9n 0.5672 36900.0n 0.5672 37199.9n 0.5672 37200.0n 0.5098 37499.9n 0.5098 37500.0n 0.5672 37799.9n 0.5672 37800.0n 0.4523 38099.9n 0.4523 38100.0n 0.4235 38399.9n 0.4235 38400.0n 0.3661 38699.9n 0.3661 38700.0n 0.4235 38999.9n 0.4235 39000.0n 0.5672 39299.9n 0.5672 39300.0n 0.3661 39599.9n 0.3661 39600.0n 0.4523 39899.9n 0.4523 39900.0n 0.5672 40199.9n 0.5672 40200.0n 0.5672 40499.9n 0.5672 40500.0n 0.5672 40799.9n 0.5672 40800.0n 0.5672 41099.9n 0.5672 41100.0n 0.5672 41399.9n 0.5672 41400.0n 0.5672 41699.9n 0.5672 41700.0n 0.5672 41999.9n 0.5672 42000.0n 0.5672 42299.9n 0.5672 42300.0n 0.5672 42599.9n 0.5672 42600.0n 0.5098 42899.9n 0.5098 42900.0n 0.5672 43199.9n 0.5672 43200.0n 0.4523 43499.9n 0.4523 43500.0n 0.4235 43799.9n 0.4235 43800.0n 0.3661 44099.9n 0.3661 44100.0n 0.4235 44399.9n 0.4235 44400.0n 0.5672 44699.9n 0.5672 44700.0n 0.3661 44999.9n 0.3661 45000.0n 0.4523 45299.9n 0.4523 45300.0n 0.5672 45599.9n 0.5672 45600.0n 0.5672 45899.9n 0.5672 45900.0n 0.5672 46199.9n 0.5672 46200.0n 0.5672 46499.9n 0.5672 46500.0n 0.5672 46799.9n 0.5672 46800.0n 0.5672 47099.9n 0.5672 47100.0n 0.5672 47399.9n 0.5672 47400.0n 0.5672 47699.9n 0.5672 47700.0n 0.5672 47999.9n 0.5672 48000.0n 0.5098 48299.9n 0.5098 48300.0n 0.5672 48599.9n 0.5672 48600.0n 0.4523 48899.9n 0.4523 48900.0n 0.4235 49199.9n 0.4235 49200.0n 0.3661 49499.9n 0.3661 49500.0n 0.4235 49799.9n 0.4235 49800.0n 0.5672 50099.9n 0.5672 50100.0n 0.3661 50399.9n 0.3661 50400.0n 0.4523 50699.9n 0.4523 50700.0n 0.5672 50999.9n 0.5672 51000.0n 0.5672 51299.9n 0.5672 51300.0n 0.5672 51599.9n 0.5672 51600.0n 0.5672 51899.9n 0.5672 51900.0n 0.5672 52199.9n 0.5672 52200.0n 0.5672 52499.9n 0.5672 52500.0n 0.5672 52799.9n 0.5672 52800.0n 0.5672 53099.9n 0.5672 53100.0n 0.5672 53399.9n 0.5672 53400.0n 0.5098 53699.9n 0.5098 53700.0n 0.5672 53999.9n 0.5672 54000.0n 0.4235 54299.9n 0.4235 54300.0n 0.3373 54599.9n 0.3373 54600.0n 0.2798 54899.9n 0.2798 54900.0n 0.4523 55199.9n 0.4523 55200.0n 0.4235 55499.9n 0.4235 55500.0n 0.3661 55799.9n 0.3661 55800.0n 0.5672 56099.9n 0.5672 56100.0n 0.5385 56399.9n 0.5385 56400.0n 0.4523 56699.9n 0.4523 56700.0n 0.5672 56999.9n 0.5672 57000.0n 0.5672 57299.9n 0.5672 57300.0n 0.5672 57599.9n 0.5672 57600.0n 0.5672 57899.9n 0.5672 57900.0n 0.5672 58199.9n 0.5672 58200.0n 0.5672 58499.9n 0.5672 58500.0n 0.5672 58799.9n 0.5672 58800.0n 0.5672 59099.9n 0.5672 59100.0n 0.5672)
Vxp34 a_xp34 0 PWL(0.0n 0.5053 299.9n 0.5053 300.0n 0.5211 599.9n 0.5211 600.0n 0.5685 899.9n 0.5685 900.0n 0.5843 1199.9n 0.5843 1200.0n 0.3787 1499.9n 0.3787 1500.0n 0.5685 1799.9n 0.5685 1800.0n 0.5527 2099.9n 0.5527 2100.0n 0.3787 2399.9n 0.3787 2400.0n 0.3787 2699.9n 0.3787 2700.0n 0.3787 2999.9n 0.3787 3000.0n 0.3787 3299.9n 0.3787 3300.0n 0.3946 3599.9n 0.3946 3600.0n 0.3787 3899.9n 0.3787 3900.0n 0.4420 4199.9n 0.4420 4200.0n 0.3787 4499.9n 0.3787 4500.0n 0.3787 4799.9n 0.3787 4800.0n 0.5843 5099.9n 0.5843 5100.0n 0.5685 5399.9n 0.5685 5400.0n 0.5053 5699.9n 0.5053 5700.0n 0.5211 5999.9n 0.5211 6000.0n 0.5685 6299.9n 0.5685 6300.0n 0.5843 6599.9n 0.5843 6600.0n 0.3787 6899.9n 0.3787 6900.0n 0.5685 7199.9n 0.5685 7200.0n 0.5527 7499.9n 0.5527 7500.0n 0.3787 7799.9n 0.3787 7800.0n 0.3787 8099.9n 0.3787 8100.0n 0.3787 8399.9n 0.3787 8400.0n 0.3787 8699.9n 0.3787 8700.0n 0.3946 8999.9n 0.3946 9000.0n 0.3787 9299.9n 0.3787 9300.0n 0.4420 9599.9n 0.4420 9600.0n 0.3787 9899.9n 0.3787 9900.0n 0.3787 10199.9n 0.3787 10200.0n 0.5843 10499.9n 0.5843 10500.0n 0.5685 10799.9n 0.5685 10800.0n 0.5053 11099.9n 0.5053 11100.0n 0.5211 11399.9n 0.5211 11400.0n 0.5685 11699.9n 0.5685 11700.0n 0.5843 11999.9n 0.5843 12000.0n 0.3787 12299.9n 0.3787 12300.0n 0.5685 12599.9n 0.5685 12600.0n 0.5527 12899.9n 0.5527 12900.0n 0.3787 13199.9n 0.3787 13200.0n 0.3787 13499.9n 0.3787 13500.0n 0.3787 13799.9n 0.3787 13800.0n 0.3787 14099.9n 0.3787 14100.0n 0.3946 14399.9n 0.3946 14400.0n 0.3787 14699.9n 0.3787 14700.0n 0.4420 14999.9n 0.4420 15000.0n 0.3787 15299.9n 0.3787 15300.0n 0.3787 15599.9n 0.3787 15600.0n 0.5843 15899.9n 0.5843 15900.0n 0.5685 16199.9n 0.5685 16200.0n 0.5053 16499.9n 0.5053 16500.0n 0.5211 16799.9n 0.5211 16800.0n 0.5685 17099.9n 0.5685 17100.0n 0.5843 17399.9n 0.5843 17400.0n 0.3787 17699.9n 0.3787 17700.0n 0.5685 17999.9n 0.5685 18000.0n 0.5527 18299.9n 0.5527 18300.0n 0.3787 18599.9n 0.3787 18600.0n 0.3787 18899.9n 0.3787 18900.0n 0.3787 19199.9n 0.3787 19200.0n 0.3787 19499.9n 0.3787 19500.0n 0.3946 19799.9n 0.3946 19800.0n 0.3787 20099.9n 0.3787 20100.0n 0.4420 20399.9n 0.4420 20400.0n 0.3787 20699.9n 0.3787 20700.0n 0.3787 20999.9n 0.3787 21000.0n 0.5843 21299.9n 0.5843 21300.0n 0.5685 21599.9n 0.5685 21600.0n 0.5053 21899.9n 0.5053 21900.0n 0.5211 22199.9n 0.5211 22200.0n 0.5685 22499.9n 0.5685 22500.0n 0.5843 22799.9n 0.5843 22800.0n 0.3787 23099.9n 0.3787 23100.0n 0.5685 23399.9n 0.5685 23400.0n 0.5527 23699.9n 0.5527 23700.0n 0.3787 23999.9n 0.3787 24000.0n 0.3787 24299.9n 0.3787 24300.0n 0.3787 24599.9n 0.3787 24600.0n 0.3787 24899.9n 0.3787 24900.0n 0.3946 25199.9n 0.3946 25200.0n 0.3787 25499.9n 0.3787 25500.0n 0.4420 25799.9n 0.4420 25800.0n 0.3787 26099.9n 0.3787 26100.0n 0.3787 26399.9n 0.3787 26400.0n 0.5843 26699.9n 0.5843 26700.0n 0.5685 26999.9n 0.5685 27000.0n 0.5053 27299.9n 0.5053 27300.0n 0.5211 27599.9n 0.5211 27600.0n 0.5685 27899.9n 0.5685 27900.0n 0.5843 28199.9n 0.5843 28200.0n 0.3787 28499.9n 0.3787 28500.0n 0.5685 28799.9n 0.5685 28800.0n 0.5527 29099.9n 0.5527 29100.0n 0.3787 29399.9n 0.3787 29400.0n 0.3787 29699.9n 0.3787 29700.0n 0.3787 29999.9n 0.3787 30000.0n 0.3787 30299.9n 0.3787 30300.0n 0.3946 30599.9n 0.3946 30600.0n 0.3787 30899.9n 0.3787 30900.0n 0.4420 31199.9n 0.4420 31200.0n 0.3787 31499.9n 0.3787 31500.0n 0.3787 31799.9n 0.3787 31800.0n 0.5843 32099.9n 0.5843 32100.0n 0.5685 32399.9n 0.5685 32400.0n 0.5053 32699.9n 0.5053 32700.0n 0.5211 32999.9n 0.5211 33000.0n 0.5685 33299.9n 0.5685 33300.0n 0.5843 33599.9n 0.5843 33600.0n 0.3787 33899.9n 0.3787 33900.0n 0.5685 34199.9n 0.5685 34200.0n 0.5527 34499.9n 0.5527 34500.0n 0.3787 34799.9n 0.3787 34800.0n 0.3787 35099.9n 0.3787 35100.0n 0.3787 35399.9n 0.3787 35400.0n 0.3787 35699.9n 0.3787 35700.0n 0.3946 35999.9n 0.3946 36000.0n 0.3787 36299.9n 0.3787 36300.0n 0.4420 36599.9n 0.4420 36600.0n 0.3787 36899.9n 0.3787 36900.0n 0.3787 37199.9n 0.3787 37200.0n 0.5843 37499.9n 0.5843 37500.0n 0.5685 37799.9n 0.5685 37800.0n 0.5053 38099.9n 0.5053 38100.0n 0.5211 38399.9n 0.5211 38400.0n 0.5685 38699.9n 0.5685 38700.0n 0.5843 38999.9n 0.5843 39000.0n 0.3787 39299.9n 0.3787 39300.0n 0.5685 39599.9n 0.5685 39600.0n 0.5527 39899.9n 0.5527 39900.0n 0.3787 40199.9n 0.3787 40200.0n 0.3787 40499.9n 0.3787 40500.0n 0.3787 40799.9n 0.3787 40800.0n 0.3787 41099.9n 0.3787 41100.0n 0.3946 41399.9n 0.3946 41400.0n 0.3787 41699.9n 0.3787 41700.0n 0.4420 41999.9n 0.4420 42000.0n 0.3787 42299.9n 0.3787 42300.0n 0.3787 42599.9n 0.3787 42600.0n 0.5843 42899.9n 0.5843 42900.0n 0.5685 43199.9n 0.5685 43200.0n 0.5053 43499.9n 0.5053 43500.0n 0.5211 43799.9n 0.5211 43800.0n 0.5685 44099.9n 0.5685 44100.0n 0.5843 44399.9n 0.5843 44400.0n 0.3787 44699.9n 0.3787 44700.0n 0.5685 44999.9n 0.5685 45000.0n 0.5527 45299.9n 0.5527 45300.0n 0.3787 45599.9n 0.3787 45600.0n 0.3787 45899.9n 0.3787 45900.0n 0.3787 46199.9n 0.3787 46200.0n 0.3787 46499.9n 0.3787 46500.0n 0.3946 46799.9n 0.3946 46800.0n 0.3787 47099.9n 0.3787 47100.0n 0.4420 47399.9n 0.4420 47400.0n 0.3787 47699.9n 0.3787 47700.0n 0.3787 47999.9n 0.3787 48000.0n 0.5843 48299.9n 0.5843 48300.0n 0.5685 48599.9n 0.5685 48600.0n 0.5053 48899.9n 0.5053 48900.0n 0.5211 49199.9n 0.5211 49200.0n 0.5685 49499.9n 0.5685 49500.0n 0.5843 49799.9n 0.5843 49800.0n 0.3787 50099.9n 0.3787 50100.0n 0.5685 50399.9n 0.5685 50400.0n 0.5527 50699.9n 0.5527 50700.0n 0.3787 50999.9n 0.3787 51000.0n 0.3787 51299.9n 0.3787 51300.0n 0.3787 51599.9n 0.3787 51600.0n 0.3787 51899.9n 0.3787 51900.0n 0.3946 52199.9n 0.3946 52200.0n 0.3787 52499.9n 0.3787 52500.0n 0.4420 52799.9n 0.4420 52800.0n 0.3787 53099.9n 0.3787 53100.0n 0.3787 53399.9n 0.3787 53400.0n 0.5843 53699.9n 0.5843 53700.0n 0.5685 53999.9n 0.5685 54000.0n 0.6318 54299.9n 0.6318 54300.0n 0.6002 54599.9n 0.6002 54600.0n 0.5527 54899.9n 0.5527 54900.0n 0.6318 55199.9n 0.6318 55200.0n 0.5685 55499.9n 0.5685 55500.0n 0.5685 55799.9n 0.5685 55800.0n 0.4104 56099.9n 0.4104 56100.0n 0.6160 56399.9n 0.6160 56400.0n 0.6318 56699.9n 0.6318 56700.0n 0.6160 56999.9n 0.6160 57000.0n 0.3787 57299.9n 0.3787 57300.0n 0.6002 57599.9n 0.6002 57600.0n 0.3787 57899.9n 0.3787 57900.0n 0.3787 58199.9n 0.3787 58200.0n 0.3787 58499.9n 0.3787 58500.0n 0.5053 58799.9n 0.5053 58800.0n 0.3787 59099.9n 0.3787 59100.0n 0.3787)
Vxn34 a_xn34 0 PWL(0.0n 0.4947 299.9n 0.4947 300.0n 0.4789 599.9n 0.4789 600.0n 0.4315 899.9n 0.4315 900.0n 0.4157 1199.9n 0.4157 1200.0n 0.6213 1499.9n 0.6213 1500.0n 0.4315 1799.9n 0.4315 1800.0n 0.4473 2099.9n 0.4473 2100.0n 0.6213 2399.9n 0.6213 2400.0n 0.6213 2699.9n 0.6213 2700.0n 0.6213 2999.9n 0.6213 3000.0n 0.6213 3299.9n 0.6213 3300.0n 0.6054 3599.9n 0.6054 3600.0n 0.6213 3899.9n 0.6213 3900.0n 0.5580 4199.9n 0.5580 4200.0n 0.6213 4499.9n 0.6213 4500.0n 0.6213 4799.9n 0.6213 4800.0n 0.4157 5099.9n 0.4157 5100.0n 0.4315 5399.9n 0.4315 5400.0n 0.4947 5699.9n 0.4947 5700.0n 0.4789 5999.9n 0.4789 6000.0n 0.4315 6299.9n 0.4315 6300.0n 0.4157 6599.9n 0.4157 6600.0n 0.6213 6899.9n 0.6213 6900.0n 0.4315 7199.9n 0.4315 7200.0n 0.4473 7499.9n 0.4473 7500.0n 0.6213 7799.9n 0.6213 7800.0n 0.6213 8099.9n 0.6213 8100.0n 0.6213 8399.9n 0.6213 8400.0n 0.6213 8699.9n 0.6213 8700.0n 0.6054 8999.9n 0.6054 9000.0n 0.6213 9299.9n 0.6213 9300.0n 0.5580 9599.9n 0.5580 9600.0n 0.6213 9899.9n 0.6213 9900.0n 0.6213 10199.9n 0.6213 10200.0n 0.4157 10499.9n 0.4157 10500.0n 0.4315 10799.9n 0.4315 10800.0n 0.4947 11099.9n 0.4947 11100.0n 0.4789 11399.9n 0.4789 11400.0n 0.4315 11699.9n 0.4315 11700.0n 0.4157 11999.9n 0.4157 12000.0n 0.6213 12299.9n 0.6213 12300.0n 0.4315 12599.9n 0.4315 12600.0n 0.4473 12899.9n 0.4473 12900.0n 0.6213 13199.9n 0.6213 13200.0n 0.6213 13499.9n 0.6213 13500.0n 0.6213 13799.9n 0.6213 13800.0n 0.6213 14099.9n 0.6213 14100.0n 0.6054 14399.9n 0.6054 14400.0n 0.6213 14699.9n 0.6213 14700.0n 0.5580 14999.9n 0.5580 15000.0n 0.6213 15299.9n 0.6213 15300.0n 0.6213 15599.9n 0.6213 15600.0n 0.4157 15899.9n 0.4157 15900.0n 0.4315 16199.9n 0.4315 16200.0n 0.4947 16499.9n 0.4947 16500.0n 0.4789 16799.9n 0.4789 16800.0n 0.4315 17099.9n 0.4315 17100.0n 0.4157 17399.9n 0.4157 17400.0n 0.6213 17699.9n 0.6213 17700.0n 0.4315 17999.9n 0.4315 18000.0n 0.4473 18299.9n 0.4473 18300.0n 0.6213 18599.9n 0.6213 18600.0n 0.6213 18899.9n 0.6213 18900.0n 0.6213 19199.9n 0.6213 19200.0n 0.6213 19499.9n 0.6213 19500.0n 0.6054 19799.9n 0.6054 19800.0n 0.6213 20099.9n 0.6213 20100.0n 0.5580 20399.9n 0.5580 20400.0n 0.6213 20699.9n 0.6213 20700.0n 0.6213 20999.9n 0.6213 21000.0n 0.4157 21299.9n 0.4157 21300.0n 0.4315 21599.9n 0.4315 21600.0n 0.4947 21899.9n 0.4947 21900.0n 0.4789 22199.9n 0.4789 22200.0n 0.4315 22499.9n 0.4315 22500.0n 0.4157 22799.9n 0.4157 22800.0n 0.6213 23099.9n 0.6213 23100.0n 0.4315 23399.9n 0.4315 23400.0n 0.4473 23699.9n 0.4473 23700.0n 0.6213 23999.9n 0.6213 24000.0n 0.6213 24299.9n 0.6213 24300.0n 0.6213 24599.9n 0.6213 24600.0n 0.6213 24899.9n 0.6213 24900.0n 0.6054 25199.9n 0.6054 25200.0n 0.6213 25499.9n 0.6213 25500.0n 0.5580 25799.9n 0.5580 25800.0n 0.6213 26099.9n 0.6213 26100.0n 0.6213 26399.9n 0.6213 26400.0n 0.4157 26699.9n 0.4157 26700.0n 0.4315 26999.9n 0.4315 27000.0n 0.4947 27299.9n 0.4947 27300.0n 0.4789 27599.9n 0.4789 27600.0n 0.4315 27899.9n 0.4315 27900.0n 0.4157 28199.9n 0.4157 28200.0n 0.6213 28499.9n 0.6213 28500.0n 0.4315 28799.9n 0.4315 28800.0n 0.4473 29099.9n 0.4473 29100.0n 0.6213 29399.9n 0.6213 29400.0n 0.6213 29699.9n 0.6213 29700.0n 0.6213 29999.9n 0.6213 30000.0n 0.6213 30299.9n 0.6213 30300.0n 0.6054 30599.9n 0.6054 30600.0n 0.6213 30899.9n 0.6213 30900.0n 0.5580 31199.9n 0.5580 31200.0n 0.6213 31499.9n 0.6213 31500.0n 0.6213 31799.9n 0.6213 31800.0n 0.4157 32099.9n 0.4157 32100.0n 0.4315 32399.9n 0.4315 32400.0n 0.4947 32699.9n 0.4947 32700.0n 0.4789 32999.9n 0.4789 33000.0n 0.4315 33299.9n 0.4315 33300.0n 0.4157 33599.9n 0.4157 33600.0n 0.6213 33899.9n 0.6213 33900.0n 0.4315 34199.9n 0.4315 34200.0n 0.4473 34499.9n 0.4473 34500.0n 0.6213 34799.9n 0.6213 34800.0n 0.6213 35099.9n 0.6213 35100.0n 0.6213 35399.9n 0.6213 35400.0n 0.6213 35699.9n 0.6213 35700.0n 0.6054 35999.9n 0.6054 36000.0n 0.6213 36299.9n 0.6213 36300.0n 0.5580 36599.9n 0.5580 36600.0n 0.6213 36899.9n 0.6213 36900.0n 0.6213 37199.9n 0.6213 37200.0n 0.4157 37499.9n 0.4157 37500.0n 0.4315 37799.9n 0.4315 37800.0n 0.4947 38099.9n 0.4947 38100.0n 0.4789 38399.9n 0.4789 38400.0n 0.4315 38699.9n 0.4315 38700.0n 0.4157 38999.9n 0.4157 39000.0n 0.6213 39299.9n 0.6213 39300.0n 0.4315 39599.9n 0.4315 39600.0n 0.4473 39899.9n 0.4473 39900.0n 0.6213 40199.9n 0.6213 40200.0n 0.6213 40499.9n 0.6213 40500.0n 0.6213 40799.9n 0.6213 40800.0n 0.6213 41099.9n 0.6213 41100.0n 0.6054 41399.9n 0.6054 41400.0n 0.6213 41699.9n 0.6213 41700.0n 0.5580 41999.9n 0.5580 42000.0n 0.6213 42299.9n 0.6213 42300.0n 0.6213 42599.9n 0.6213 42600.0n 0.4157 42899.9n 0.4157 42900.0n 0.4315 43199.9n 0.4315 43200.0n 0.4947 43499.9n 0.4947 43500.0n 0.4789 43799.9n 0.4789 43800.0n 0.4315 44099.9n 0.4315 44100.0n 0.4157 44399.9n 0.4157 44400.0n 0.6213 44699.9n 0.6213 44700.0n 0.4315 44999.9n 0.4315 45000.0n 0.4473 45299.9n 0.4473 45300.0n 0.6213 45599.9n 0.6213 45600.0n 0.6213 45899.9n 0.6213 45900.0n 0.6213 46199.9n 0.6213 46200.0n 0.6213 46499.9n 0.6213 46500.0n 0.6054 46799.9n 0.6054 46800.0n 0.6213 47099.9n 0.6213 47100.0n 0.5580 47399.9n 0.5580 47400.0n 0.6213 47699.9n 0.6213 47700.0n 0.6213 47999.9n 0.6213 48000.0n 0.4157 48299.9n 0.4157 48300.0n 0.4315 48599.9n 0.4315 48600.0n 0.4947 48899.9n 0.4947 48900.0n 0.4789 49199.9n 0.4789 49200.0n 0.4315 49499.9n 0.4315 49500.0n 0.4157 49799.9n 0.4157 49800.0n 0.6213 50099.9n 0.6213 50100.0n 0.4315 50399.9n 0.4315 50400.0n 0.4473 50699.9n 0.4473 50700.0n 0.6213 50999.9n 0.6213 51000.0n 0.6213 51299.9n 0.6213 51300.0n 0.6213 51599.9n 0.6213 51600.0n 0.6213 51899.9n 0.6213 51900.0n 0.6054 52199.9n 0.6054 52200.0n 0.6213 52499.9n 0.6213 52500.0n 0.5580 52799.9n 0.5580 52800.0n 0.6213 53099.9n 0.6213 53100.0n 0.6213 53399.9n 0.6213 53400.0n 0.4157 53699.9n 0.4157 53700.0n 0.4315 53999.9n 0.4315 54000.0n 0.3682 54299.9n 0.3682 54300.0n 0.3998 54599.9n 0.3998 54600.0n 0.4473 54899.9n 0.4473 54900.0n 0.3682 55199.9n 0.3682 55200.0n 0.4315 55499.9n 0.4315 55500.0n 0.4315 55799.9n 0.4315 55800.0n 0.5896 56099.9n 0.5896 56100.0n 0.3840 56399.9n 0.3840 56400.0n 0.3682 56699.9n 0.3682 56700.0n 0.3840 56999.9n 0.3840 57000.0n 0.6213 57299.9n 0.6213 57300.0n 0.3998 57599.9n 0.3998 57600.0n 0.6213 57899.9n 0.6213 57900.0n 0.6213 58199.9n 0.6213 58200.0n 0.6213 58499.9n 0.6213 58500.0n 0.4947 58799.9n 0.4947 58800.0n 0.6213 59099.9n 0.6213 59100.0n 0.6213)
Vxp35 a_xp35 0 PWL(0.0n 0.4829 299.9n 0.4829 300.0n 0.3552 599.9n 0.3552 600.0n 0.3872 899.9n 0.3872 900.0n 0.3552 1199.9n 0.3552 1200.0n 0.3552 1499.9n 0.3552 1500.0n 0.3552 1799.9n 0.3552 1800.0n 0.3552 2099.9n 0.3552 2100.0n 0.3552 2399.9n 0.3552 2400.0n 0.5946 2699.9n 0.5946 2700.0n 0.3552 2999.9n 0.3552 3000.0n 0.4191 3299.9n 0.4191 3300.0n 0.6106 3599.9n 0.6106 3600.0n 0.4669 3899.9n 0.4669 3900.0n 0.5946 4199.9n 0.5946 4200.0n 0.5627 4499.9n 0.5627 4500.0n 0.4191 4799.9n 0.4191 4800.0n 0.3552 5099.9n 0.3552 5100.0n 0.6106 5399.9n 0.6106 5400.0n 0.4829 5699.9n 0.4829 5700.0n 0.3552 5999.9n 0.3552 6000.0n 0.3872 6299.9n 0.3872 6300.0n 0.3552 6599.9n 0.3552 6600.0n 0.3552 6899.9n 0.3552 6900.0n 0.3552 7199.9n 0.3552 7200.0n 0.3552 7499.9n 0.3552 7500.0n 0.3552 7799.9n 0.3552 7800.0n 0.5946 8099.9n 0.5946 8100.0n 0.3552 8399.9n 0.3552 8400.0n 0.4191 8699.9n 0.4191 8700.0n 0.6106 8999.9n 0.6106 9000.0n 0.4669 9299.9n 0.4669 9300.0n 0.5946 9599.9n 0.5946 9600.0n 0.5627 9899.9n 0.5627 9900.0n 0.4191 10199.9n 0.4191 10200.0n 0.3552 10499.9n 0.3552 10500.0n 0.6106 10799.9n 0.6106 10800.0n 0.4829 11099.9n 0.4829 11100.0n 0.3552 11399.9n 0.3552 11400.0n 0.3872 11699.9n 0.3872 11700.0n 0.3552 11999.9n 0.3552 12000.0n 0.3552 12299.9n 0.3552 12300.0n 0.3552 12599.9n 0.3552 12600.0n 0.3552 12899.9n 0.3552 12900.0n 0.3552 13199.9n 0.3552 13200.0n 0.5946 13499.9n 0.5946 13500.0n 0.3552 13799.9n 0.3552 13800.0n 0.4191 14099.9n 0.4191 14100.0n 0.6106 14399.9n 0.6106 14400.0n 0.4669 14699.9n 0.4669 14700.0n 0.5946 14999.9n 0.5946 15000.0n 0.5627 15299.9n 0.5627 15300.0n 0.4191 15599.9n 0.4191 15600.0n 0.3552 15899.9n 0.3552 15900.0n 0.6106 16199.9n 0.6106 16200.0n 0.4829 16499.9n 0.4829 16500.0n 0.3552 16799.9n 0.3552 16800.0n 0.3872 17099.9n 0.3872 17100.0n 0.3552 17399.9n 0.3552 17400.0n 0.3552 17699.9n 0.3552 17700.0n 0.3552 17999.9n 0.3552 18000.0n 0.3552 18299.9n 0.3552 18300.0n 0.3552 18599.9n 0.3552 18600.0n 0.5946 18899.9n 0.5946 18900.0n 0.3552 19199.9n 0.3552 19200.0n 0.4191 19499.9n 0.4191 19500.0n 0.6106 19799.9n 0.6106 19800.0n 0.4669 20099.9n 0.4669 20100.0n 0.5946 20399.9n 0.5946 20400.0n 0.5627 20699.9n 0.5627 20700.0n 0.4191 20999.9n 0.4191 21000.0n 0.3552 21299.9n 0.3552 21300.0n 0.6106 21599.9n 0.6106 21600.0n 0.4829 21899.9n 0.4829 21900.0n 0.3552 22199.9n 0.3552 22200.0n 0.3872 22499.9n 0.3872 22500.0n 0.3552 22799.9n 0.3552 22800.0n 0.3552 23099.9n 0.3552 23100.0n 0.3552 23399.9n 0.3552 23400.0n 0.3552 23699.9n 0.3552 23700.0n 0.3552 23999.9n 0.3552 24000.0n 0.5946 24299.9n 0.5946 24300.0n 0.3552 24599.9n 0.3552 24600.0n 0.4191 24899.9n 0.4191 24900.0n 0.6106 25199.9n 0.6106 25200.0n 0.4669 25499.9n 0.4669 25500.0n 0.5946 25799.9n 0.5946 25800.0n 0.5627 26099.9n 0.5627 26100.0n 0.4191 26399.9n 0.4191 26400.0n 0.3552 26699.9n 0.3552 26700.0n 0.6106 26999.9n 0.6106 27000.0n 0.4829 27299.9n 0.4829 27300.0n 0.3552 27599.9n 0.3552 27600.0n 0.3872 27899.9n 0.3872 27900.0n 0.3552 28199.9n 0.3552 28200.0n 0.3552 28499.9n 0.3552 28500.0n 0.3552 28799.9n 0.3552 28800.0n 0.3552 29099.9n 0.3552 29100.0n 0.3552 29399.9n 0.3552 29400.0n 0.5946 29699.9n 0.5946 29700.0n 0.3552 29999.9n 0.3552 30000.0n 0.4191 30299.9n 0.4191 30300.0n 0.6106 30599.9n 0.6106 30600.0n 0.4669 30899.9n 0.4669 30900.0n 0.5946 31199.9n 0.5946 31200.0n 0.5627 31499.9n 0.5627 31500.0n 0.4191 31799.9n 0.4191 31800.0n 0.3552 32099.9n 0.3552 32100.0n 0.6106 32399.9n 0.6106 32400.0n 0.4829 32699.9n 0.4829 32700.0n 0.3552 32999.9n 0.3552 33000.0n 0.3872 33299.9n 0.3872 33300.0n 0.3552 33599.9n 0.3552 33600.0n 0.3552 33899.9n 0.3552 33900.0n 0.3552 34199.9n 0.3552 34200.0n 0.3552 34499.9n 0.3552 34500.0n 0.3552 34799.9n 0.3552 34800.0n 0.5946 35099.9n 0.5946 35100.0n 0.3552 35399.9n 0.3552 35400.0n 0.4191 35699.9n 0.4191 35700.0n 0.6106 35999.9n 0.6106 36000.0n 0.4669 36299.9n 0.4669 36300.0n 0.5946 36599.9n 0.5946 36600.0n 0.5627 36899.9n 0.5627 36900.0n 0.4191 37199.9n 0.4191 37200.0n 0.3552 37499.9n 0.3552 37500.0n 0.6106 37799.9n 0.6106 37800.0n 0.4829 38099.9n 0.4829 38100.0n 0.3552 38399.9n 0.3552 38400.0n 0.3872 38699.9n 0.3872 38700.0n 0.3552 38999.9n 0.3552 39000.0n 0.3552 39299.9n 0.3552 39300.0n 0.3552 39599.9n 0.3552 39600.0n 0.3552 39899.9n 0.3552 39900.0n 0.3552 40199.9n 0.3552 40200.0n 0.5946 40499.9n 0.5946 40500.0n 0.3552 40799.9n 0.3552 40800.0n 0.4191 41099.9n 0.4191 41100.0n 0.6106 41399.9n 0.6106 41400.0n 0.4669 41699.9n 0.4669 41700.0n 0.5946 41999.9n 0.5946 42000.0n 0.5627 42299.9n 0.5627 42300.0n 0.4191 42599.9n 0.4191 42600.0n 0.3552 42899.9n 0.3552 42900.0n 0.6106 43199.9n 0.6106 43200.0n 0.4829 43499.9n 0.4829 43500.0n 0.3552 43799.9n 0.3552 43800.0n 0.3872 44099.9n 0.3872 44100.0n 0.3552 44399.9n 0.3552 44400.0n 0.3552 44699.9n 0.3552 44700.0n 0.3552 44999.9n 0.3552 45000.0n 0.3552 45299.9n 0.3552 45300.0n 0.3552 45599.9n 0.3552 45600.0n 0.5946 45899.9n 0.5946 45900.0n 0.3552 46199.9n 0.3552 46200.0n 0.4191 46499.9n 0.4191 46500.0n 0.6106 46799.9n 0.6106 46800.0n 0.4669 47099.9n 0.4669 47100.0n 0.5946 47399.9n 0.5946 47400.0n 0.5627 47699.9n 0.5627 47700.0n 0.4191 47999.9n 0.4191 48000.0n 0.3552 48299.9n 0.3552 48300.0n 0.6106 48599.9n 0.6106 48600.0n 0.4829 48899.9n 0.4829 48900.0n 0.3552 49199.9n 0.3552 49200.0n 0.3872 49499.9n 0.3872 49500.0n 0.3552 49799.9n 0.3552 49800.0n 0.3552 50099.9n 0.3552 50100.0n 0.3552 50399.9n 0.3552 50400.0n 0.3552 50699.9n 0.3552 50700.0n 0.3552 50999.9n 0.3552 51000.0n 0.5946 51299.9n 0.5946 51300.0n 0.3552 51599.9n 0.3552 51600.0n 0.4191 51899.9n 0.4191 51900.0n 0.6106 52199.9n 0.6106 52200.0n 0.4669 52499.9n 0.4669 52500.0n 0.5946 52799.9n 0.5946 52800.0n 0.5627 53099.9n 0.5627 53100.0n 0.4191 53399.9n 0.4191 53400.0n 0.3552 53699.9n 0.3552 53700.0n 0.6106 53999.9n 0.6106 54000.0n 0.3712 54299.9n 0.3712 54300.0n 0.4031 54599.9n 0.4031 54600.0n 0.3552 54899.9n 0.3552 54900.0n 0.4191 55199.9n 0.4191 55200.0n 0.3552 55499.9n 0.3552 55500.0n 0.3552 55799.9n 0.3552 55800.0n 0.6106 56099.9n 0.6106 56100.0n 0.6106 56399.9n 0.6106 56400.0n 0.5467 56699.9n 0.5467 56700.0n 0.6106 56999.9n 0.6106 57000.0n 0.4829 57299.9n 0.4829 57300.0n 0.6106 57599.9n 0.6106 57600.0n 0.4829 57899.9n 0.4829 57900.0n 0.5148 58199.9n 0.5148 58200.0n 0.5627 58499.9n 0.5627 58500.0n 0.5946 58799.9n 0.5946 58800.0n 0.4989 59099.9n 0.4989 59100.0n 0.5467)
Vxn35 a_xn35 0 PWL(0.0n 0.5171 299.9n 0.5171 300.0n 0.6448 599.9n 0.6448 600.0n 0.6128 899.9n 0.6128 900.0n 0.6448 1199.9n 0.6448 1200.0n 0.6448 1499.9n 0.6448 1500.0n 0.6448 1799.9n 0.6448 1800.0n 0.6448 2099.9n 0.6448 2100.0n 0.6448 2399.9n 0.6448 2400.0n 0.4054 2699.9n 0.4054 2700.0n 0.6448 2999.9n 0.6448 3000.0n 0.5809 3299.9n 0.5809 3300.0n 0.3894 3599.9n 0.3894 3600.0n 0.5331 3899.9n 0.5331 3900.0n 0.4054 4199.9n 0.4054 4200.0n 0.4373 4499.9n 0.4373 4500.0n 0.5809 4799.9n 0.5809 4800.0n 0.6448 5099.9n 0.6448 5100.0n 0.3894 5399.9n 0.3894 5400.0n 0.5171 5699.9n 0.5171 5700.0n 0.6448 5999.9n 0.6448 6000.0n 0.6128 6299.9n 0.6128 6300.0n 0.6448 6599.9n 0.6448 6600.0n 0.6448 6899.9n 0.6448 6900.0n 0.6448 7199.9n 0.6448 7200.0n 0.6448 7499.9n 0.6448 7500.0n 0.6448 7799.9n 0.6448 7800.0n 0.4054 8099.9n 0.4054 8100.0n 0.6448 8399.9n 0.6448 8400.0n 0.5809 8699.9n 0.5809 8700.0n 0.3894 8999.9n 0.3894 9000.0n 0.5331 9299.9n 0.5331 9300.0n 0.4054 9599.9n 0.4054 9600.0n 0.4373 9899.9n 0.4373 9900.0n 0.5809 10199.9n 0.5809 10200.0n 0.6448 10499.9n 0.6448 10500.0n 0.3894 10799.9n 0.3894 10800.0n 0.5171 11099.9n 0.5171 11100.0n 0.6448 11399.9n 0.6448 11400.0n 0.6128 11699.9n 0.6128 11700.0n 0.6448 11999.9n 0.6448 12000.0n 0.6448 12299.9n 0.6448 12300.0n 0.6448 12599.9n 0.6448 12600.0n 0.6448 12899.9n 0.6448 12900.0n 0.6448 13199.9n 0.6448 13200.0n 0.4054 13499.9n 0.4054 13500.0n 0.6448 13799.9n 0.6448 13800.0n 0.5809 14099.9n 0.5809 14100.0n 0.3894 14399.9n 0.3894 14400.0n 0.5331 14699.9n 0.5331 14700.0n 0.4054 14999.9n 0.4054 15000.0n 0.4373 15299.9n 0.4373 15300.0n 0.5809 15599.9n 0.5809 15600.0n 0.6448 15899.9n 0.6448 15900.0n 0.3894 16199.9n 0.3894 16200.0n 0.5171 16499.9n 0.5171 16500.0n 0.6448 16799.9n 0.6448 16800.0n 0.6128 17099.9n 0.6128 17100.0n 0.6448 17399.9n 0.6448 17400.0n 0.6448 17699.9n 0.6448 17700.0n 0.6448 17999.9n 0.6448 18000.0n 0.6448 18299.9n 0.6448 18300.0n 0.6448 18599.9n 0.6448 18600.0n 0.4054 18899.9n 0.4054 18900.0n 0.6448 19199.9n 0.6448 19200.0n 0.5809 19499.9n 0.5809 19500.0n 0.3894 19799.9n 0.3894 19800.0n 0.5331 20099.9n 0.5331 20100.0n 0.4054 20399.9n 0.4054 20400.0n 0.4373 20699.9n 0.4373 20700.0n 0.5809 20999.9n 0.5809 21000.0n 0.6448 21299.9n 0.6448 21300.0n 0.3894 21599.9n 0.3894 21600.0n 0.5171 21899.9n 0.5171 21900.0n 0.6448 22199.9n 0.6448 22200.0n 0.6128 22499.9n 0.6128 22500.0n 0.6448 22799.9n 0.6448 22800.0n 0.6448 23099.9n 0.6448 23100.0n 0.6448 23399.9n 0.6448 23400.0n 0.6448 23699.9n 0.6448 23700.0n 0.6448 23999.9n 0.6448 24000.0n 0.4054 24299.9n 0.4054 24300.0n 0.6448 24599.9n 0.6448 24600.0n 0.5809 24899.9n 0.5809 24900.0n 0.3894 25199.9n 0.3894 25200.0n 0.5331 25499.9n 0.5331 25500.0n 0.4054 25799.9n 0.4054 25800.0n 0.4373 26099.9n 0.4373 26100.0n 0.5809 26399.9n 0.5809 26400.0n 0.6448 26699.9n 0.6448 26700.0n 0.3894 26999.9n 0.3894 27000.0n 0.5171 27299.9n 0.5171 27300.0n 0.6448 27599.9n 0.6448 27600.0n 0.6128 27899.9n 0.6128 27900.0n 0.6448 28199.9n 0.6448 28200.0n 0.6448 28499.9n 0.6448 28500.0n 0.6448 28799.9n 0.6448 28800.0n 0.6448 29099.9n 0.6448 29100.0n 0.6448 29399.9n 0.6448 29400.0n 0.4054 29699.9n 0.4054 29700.0n 0.6448 29999.9n 0.6448 30000.0n 0.5809 30299.9n 0.5809 30300.0n 0.3894 30599.9n 0.3894 30600.0n 0.5331 30899.9n 0.5331 30900.0n 0.4054 31199.9n 0.4054 31200.0n 0.4373 31499.9n 0.4373 31500.0n 0.5809 31799.9n 0.5809 31800.0n 0.6448 32099.9n 0.6448 32100.0n 0.3894 32399.9n 0.3894 32400.0n 0.5171 32699.9n 0.5171 32700.0n 0.6448 32999.9n 0.6448 33000.0n 0.6128 33299.9n 0.6128 33300.0n 0.6448 33599.9n 0.6448 33600.0n 0.6448 33899.9n 0.6448 33900.0n 0.6448 34199.9n 0.6448 34200.0n 0.6448 34499.9n 0.6448 34500.0n 0.6448 34799.9n 0.6448 34800.0n 0.4054 35099.9n 0.4054 35100.0n 0.6448 35399.9n 0.6448 35400.0n 0.5809 35699.9n 0.5809 35700.0n 0.3894 35999.9n 0.3894 36000.0n 0.5331 36299.9n 0.5331 36300.0n 0.4054 36599.9n 0.4054 36600.0n 0.4373 36899.9n 0.4373 36900.0n 0.5809 37199.9n 0.5809 37200.0n 0.6448 37499.9n 0.6448 37500.0n 0.3894 37799.9n 0.3894 37800.0n 0.5171 38099.9n 0.5171 38100.0n 0.6448 38399.9n 0.6448 38400.0n 0.6128 38699.9n 0.6128 38700.0n 0.6448 38999.9n 0.6448 39000.0n 0.6448 39299.9n 0.6448 39300.0n 0.6448 39599.9n 0.6448 39600.0n 0.6448 39899.9n 0.6448 39900.0n 0.6448 40199.9n 0.6448 40200.0n 0.4054 40499.9n 0.4054 40500.0n 0.6448 40799.9n 0.6448 40800.0n 0.5809 41099.9n 0.5809 41100.0n 0.3894 41399.9n 0.3894 41400.0n 0.5331 41699.9n 0.5331 41700.0n 0.4054 41999.9n 0.4054 42000.0n 0.4373 42299.9n 0.4373 42300.0n 0.5809 42599.9n 0.5809 42600.0n 0.6448 42899.9n 0.6448 42900.0n 0.3894 43199.9n 0.3894 43200.0n 0.5171 43499.9n 0.5171 43500.0n 0.6448 43799.9n 0.6448 43800.0n 0.6128 44099.9n 0.6128 44100.0n 0.6448 44399.9n 0.6448 44400.0n 0.6448 44699.9n 0.6448 44700.0n 0.6448 44999.9n 0.6448 45000.0n 0.6448 45299.9n 0.6448 45300.0n 0.6448 45599.9n 0.6448 45600.0n 0.4054 45899.9n 0.4054 45900.0n 0.6448 46199.9n 0.6448 46200.0n 0.5809 46499.9n 0.5809 46500.0n 0.3894 46799.9n 0.3894 46800.0n 0.5331 47099.9n 0.5331 47100.0n 0.4054 47399.9n 0.4054 47400.0n 0.4373 47699.9n 0.4373 47700.0n 0.5809 47999.9n 0.5809 48000.0n 0.6448 48299.9n 0.6448 48300.0n 0.3894 48599.9n 0.3894 48600.0n 0.5171 48899.9n 0.5171 48900.0n 0.6448 49199.9n 0.6448 49200.0n 0.6128 49499.9n 0.6128 49500.0n 0.6448 49799.9n 0.6448 49800.0n 0.6448 50099.9n 0.6448 50100.0n 0.6448 50399.9n 0.6448 50400.0n 0.6448 50699.9n 0.6448 50700.0n 0.6448 50999.9n 0.6448 51000.0n 0.4054 51299.9n 0.4054 51300.0n 0.6448 51599.9n 0.6448 51600.0n 0.5809 51899.9n 0.5809 51900.0n 0.3894 52199.9n 0.3894 52200.0n 0.5331 52499.9n 0.5331 52500.0n 0.4054 52799.9n 0.4054 52800.0n 0.4373 53099.9n 0.4373 53100.0n 0.5809 53399.9n 0.5809 53400.0n 0.6448 53699.9n 0.6448 53700.0n 0.3894 53999.9n 0.3894 54000.0n 0.6288 54299.9n 0.6288 54300.0n 0.5969 54599.9n 0.5969 54600.0n 0.6448 54899.9n 0.6448 54900.0n 0.5809 55199.9n 0.5809 55200.0n 0.6448 55499.9n 0.6448 55500.0n 0.6448 55799.9n 0.6448 55800.0n 0.3894 56099.9n 0.3894 56100.0n 0.3894 56399.9n 0.3894 56400.0n 0.4533 56699.9n 0.4533 56700.0n 0.3894 56999.9n 0.3894 57000.0n 0.5171 57299.9n 0.5171 57300.0n 0.3894 57599.9n 0.3894 57600.0n 0.5171 57899.9n 0.5171 57900.0n 0.4852 58199.9n 0.4852 58200.0n 0.4373 58499.9n 0.4373 58500.0n 0.4054 58799.9n 0.4054 58800.0n 0.5011 59099.9n 0.5011 59100.0n 0.4533)
Vxp36 a_xp36 0 PWL(0.0n 0.5961 299.9n 0.5961 300.0n 0.3263 599.9n 0.3263 600.0n 0.3263 899.9n 0.3263 900.0n 0.3263 1199.9n 0.3263 1200.0n 0.5455 1499.9n 0.5455 1500.0n 0.3263 1799.9n 0.3263 1800.0n 0.3263 2099.9n 0.3263 2100.0n 0.3432 2399.9n 0.3432 2400.0n 0.4106 2699.9n 0.4106 2700.0n 0.5455 2999.9n 0.5455 3000.0n 0.5286 3299.9n 0.5286 3300.0n 0.4781 3599.9n 0.4781 3600.0n 0.5961 3899.9n 0.5961 3900.0n 0.5961 4199.9n 0.5961 4200.0n 0.4949 4499.9n 0.4949 4500.0n 0.5792 4799.9n 0.5792 4800.0n 0.3263 5099.9n 0.3263 5100.0n 0.5961 5399.9n 0.5961 5400.0n 0.5961 5699.9n 0.5961 5700.0n 0.3263 5999.9n 0.3263 6000.0n 0.3263 6299.9n 0.3263 6300.0n 0.3263 6599.9n 0.3263 6600.0n 0.5455 6899.9n 0.5455 6900.0n 0.3263 7199.9n 0.3263 7200.0n 0.3263 7499.9n 0.3263 7500.0n 0.3432 7799.9n 0.3432 7800.0n 0.4106 8099.9n 0.4106 8100.0n 0.5455 8399.9n 0.5455 8400.0n 0.5286 8699.9n 0.5286 8700.0n 0.4781 8999.9n 0.4781 9000.0n 0.5961 9299.9n 0.5961 9300.0n 0.5961 9599.9n 0.5961 9600.0n 0.4949 9899.9n 0.4949 9900.0n 0.5792 10199.9n 0.5792 10200.0n 0.3263 10499.9n 0.3263 10500.0n 0.5961 10799.9n 0.5961 10800.0n 0.5961 11099.9n 0.5961 11100.0n 0.3263 11399.9n 0.3263 11400.0n 0.3263 11699.9n 0.3263 11700.0n 0.3263 11999.9n 0.3263 12000.0n 0.5455 12299.9n 0.5455 12300.0n 0.3263 12599.9n 0.3263 12600.0n 0.3263 12899.9n 0.3263 12900.0n 0.3432 13199.9n 0.3432 13200.0n 0.4106 13499.9n 0.4106 13500.0n 0.5455 13799.9n 0.5455 13800.0n 0.5286 14099.9n 0.5286 14100.0n 0.4781 14399.9n 0.4781 14400.0n 0.5961 14699.9n 0.5961 14700.0n 0.5961 14999.9n 0.5961 15000.0n 0.4949 15299.9n 0.4949 15300.0n 0.5792 15599.9n 0.5792 15600.0n 0.3263 15899.9n 0.3263 15900.0n 0.5961 16199.9n 0.5961 16200.0n 0.5961 16499.9n 0.5961 16500.0n 0.3263 16799.9n 0.3263 16800.0n 0.3263 17099.9n 0.3263 17100.0n 0.3263 17399.9n 0.3263 17400.0n 0.5455 17699.9n 0.5455 17700.0n 0.3263 17999.9n 0.3263 18000.0n 0.3263 18299.9n 0.3263 18300.0n 0.3432 18599.9n 0.3432 18600.0n 0.4106 18899.9n 0.4106 18900.0n 0.5455 19199.9n 0.5455 19200.0n 0.5286 19499.9n 0.5286 19500.0n 0.4781 19799.9n 0.4781 19800.0n 0.5961 20099.9n 0.5961 20100.0n 0.5961 20399.9n 0.5961 20400.0n 0.4949 20699.9n 0.4949 20700.0n 0.5792 20999.9n 0.5792 21000.0n 0.3263 21299.9n 0.3263 21300.0n 0.5961 21599.9n 0.5961 21600.0n 0.5961 21899.9n 0.5961 21900.0n 0.3263 22199.9n 0.3263 22200.0n 0.3263 22499.9n 0.3263 22500.0n 0.3263 22799.9n 0.3263 22800.0n 0.5455 23099.9n 0.5455 23100.0n 0.3263 23399.9n 0.3263 23400.0n 0.3263 23699.9n 0.3263 23700.0n 0.3432 23999.9n 0.3432 24000.0n 0.4106 24299.9n 0.4106 24300.0n 0.5455 24599.9n 0.5455 24600.0n 0.5286 24899.9n 0.5286 24900.0n 0.4781 25199.9n 0.4781 25200.0n 0.5961 25499.9n 0.5961 25500.0n 0.5961 25799.9n 0.5961 25800.0n 0.4949 26099.9n 0.4949 26100.0n 0.5792 26399.9n 0.5792 26400.0n 0.3263 26699.9n 0.3263 26700.0n 0.5961 26999.9n 0.5961 27000.0n 0.5961 27299.9n 0.5961 27300.0n 0.3263 27599.9n 0.3263 27600.0n 0.3263 27899.9n 0.3263 27900.0n 0.3263 28199.9n 0.3263 28200.0n 0.5455 28499.9n 0.5455 28500.0n 0.3263 28799.9n 0.3263 28800.0n 0.3263 29099.9n 0.3263 29100.0n 0.3432 29399.9n 0.3432 29400.0n 0.4106 29699.9n 0.4106 29700.0n 0.5455 29999.9n 0.5455 30000.0n 0.5286 30299.9n 0.5286 30300.0n 0.4781 30599.9n 0.4781 30600.0n 0.5961 30899.9n 0.5961 30900.0n 0.5961 31199.9n 0.5961 31200.0n 0.4949 31499.9n 0.4949 31500.0n 0.5792 31799.9n 0.5792 31800.0n 0.3263 32099.9n 0.3263 32100.0n 0.5961 32399.9n 0.5961 32400.0n 0.5961 32699.9n 0.5961 32700.0n 0.3263 32999.9n 0.3263 33000.0n 0.3263 33299.9n 0.3263 33300.0n 0.3263 33599.9n 0.3263 33600.0n 0.5455 33899.9n 0.5455 33900.0n 0.3263 34199.9n 0.3263 34200.0n 0.3263 34499.9n 0.3263 34500.0n 0.3432 34799.9n 0.3432 34800.0n 0.4106 35099.9n 0.4106 35100.0n 0.5455 35399.9n 0.5455 35400.0n 0.5286 35699.9n 0.5286 35700.0n 0.4781 35999.9n 0.4781 36000.0n 0.5961 36299.9n 0.5961 36300.0n 0.5961 36599.9n 0.5961 36600.0n 0.4949 36899.9n 0.4949 36900.0n 0.5792 37199.9n 0.5792 37200.0n 0.3263 37499.9n 0.3263 37500.0n 0.5961 37799.9n 0.5961 37800.0n 0.5961 38099.9n 0.5961 38100.0n 0.3263 38399.9n 0.3263 38400.0n 0.3263 38699.9n 0.3263 38700.0n 0.3263 38999.9n 0.3263 39000.0n 0.5455 39299.9n 0.5455 39300.0n 0.3263 39599.9n 0.3263 39600.0n 0.3263 39899.9n 0.3263 39900.0n 0.3432 40199.9n 0.3432 40200.0n 0.4106 40499.9n 0.4106 40500.0n 0.5455 40799.9n 0.5455 40800.0n 0.5286 41099.9n 0.5286 41100.0n 0.4781 41399.9n 0.4781 41400.0n 0.5961 41699.9n 0.5961 41700.0n 0.5961 41999.9n 0.5961 42000.0n 0.4949 42299.9n 0.4949 42300.0n 0.5792 42599.9n 0.5792 42600.0n 0.3263 42899.9n 0.3263 42900.0n 0.5961 43199.9n 0.5961 43200.0n 0.5961 43499.9n 0.5961 43500.0n 0.3263 43799.9n 0.3263 43800.0n 0.3263 44099.9n 0.3263 44100.0n 0.3263 44399.9n 0.3263 44400.0n 0.5455 44699.9n 0.5455 44700.0n 0.3263 44999.9n 0.3263 45000.0n 0.3263 45299.9n 0.3263 45300.0n 0.3432 45599.9n 0.3432 45600.0n 0.4106 45899.9n 0.4106 45900.0n 0.5455 46199.9n 0.5455 46200.0n 0.5286 46499.9n 0.5286 46500.0n 0.4781 46799.9n 0.4781 46800.0n 0.5961 47099.9n 0.5961 47100.0n 0.5961 47399.9n 0.5961 47400.0n 0.4949 47699.9n 0.4949 47700.0n 0.5792 47999.9n 0.5792 48000.0n 0.3263 48299.9n 0.3263 48300.0n 0.5961 48599.9n 0.5961 48600.0n 0.5961 48899.9n 0.5961 48900.0n 0.3263 49199.9n 0.3263 49200.0n 0.3263 49499.9n 0.3263 49500.0n 0.3263 49799.9n 0.3263 49800.0n 0.5455 50099.9n 0.5455 50100.0n 0.3263 50399.9n 0.3263 50400.0n 0.3263 50699.9n 0.3263 50700.0n 0.3432 50999.9n 0.3432 51000.0n 0.4106 51299.9n 0.4106 51300.0n 0.5455 51599.9n 0.5455 51600.0n 0.5286 51899.9n 0.5286 51900.0n 0.4781 52199.9n 0.4781 52200.0n 0.5961 52499.9n 0.5961 52500.0n 0.5961 52799.9n 0.5961 52800.0n 0.4949 53099.9n 0.4949 53100.0n 0.5792 53399.9n 0.5792 53400.0n 0.3263 53699.9n 0.3263 53700.0n 0.5961 53999.9n 0.5961 54000.0n 0.3263 54299.9n 0.3263 54300.0n 0.3263 54599.9n 0.3263 54600.0n 0.3263 54899.9n 0.3263 54900.0n 0.3769 55199.9n 0.3769 55200.0n 0.3263 55499.9n 0.3263 55500.0n 0.3263 55799.9n 0.3263 55800.0n 0.5961 56099.9n 0.5961 56100.0n 0.5961 56399.9n 0.5961 56400.0n 0.5961 56699.9n 0.5961 56700.0n 0.5623 56999.9n 0.5623 57000.0n 0.5961 57299.9n 0.5961 57300.0n 0.5623 57599.9n 0.5623 57600.0n 0.5286 57899.9n 0.5286 57900.0n 0.4949 58199.9n 0.4949 58200.0n 0.4443 58499.9n 0.4443 58500.0n 0.3432 58799.9n 0.3432 58800.0n 0.5286 59099.9n 0.5286 59100.0n 0.4443)
Vxn36 a_xn36 0 PWL(0.0n 0.4039 299.9n 0.4039 300.0n 0.6737 599.9n 0.6737 600.0n 0.6737 899.9n 0.6737 900.0n 0.6737 1199.9n 0.6737 1200.0n 0.4545 1499.9n 0.4545 1500.0n 0.6737 1799.9n 0.6737 1800.0n 0.6737 2099.9n 0.6737 2100.0n 0.6568 2399.9n 0.6568 2400.0n 0.5894 2699.9n 0.5894 2700.0n 0.4545 2999.9n 0.4545 3000.0n 0.4714 3299.9n 0.4714 3300.0n 0.5219 3599.9n 0.5219 3600.0n 0.4039 3899.9n 0.4039 3900.0n 0.4039 4199.9n 0.4039 4200.0n 0.5051 4499.9n 0.5051 4500.0n 0.4208 4799.9n 0.4208 4800.0n 0.6737 5099.9n 0.6737 5100.0n 0.4039 5399.9n 0.4039 5400.0n 0.4039 5699.9n 0.4039 5700.0n 0.6737 5999.9n 0.6737 6000.0n 0.6737 6299.9n 0.6737 6300.0n 0.6737 6599.9n 0.6737 6600.0n 0.4545 6899.9n 0.4545 6900.0n 0.6737 7199.9n 0.6737 7200.0n 0.6737 7499.9n 0.6737 7500.0n 0.6568 7799.9n 0.6568 7800.0n 0.5894 8099.9n 0.5894 8100.0n 0.4545 8399.9n 0.4545 8400.0n 0.4714 8699.9n 0.4714 8700.0n 0.5219 8999.9n 0.5219 9000.0n 0.4039 9299.9n 0.4039 9300.0n 0.4039 9599.9n 0.4039 9600.0n 0.5051 9899.9n 0.5051 9900.0n 0.4208 10199.9n 0.4208 10200.0n 0.6737 10499.9n 0.6737 10500.0n 0.4039 10799.9n 0.4039 10800.0n 0.4039 11099.9n 0.4039 11100.0n 0.6737 11399.9n 0.6737 11400.0n 0.6737 11699.9n 0.6737 11700.0n 0.6737 11999.9n 0.6737 12000.0n 0.4545 12299.9n 0.4545 12300.0n 0.6737 12599.9n 0.6737 12600.0n 0.6737 12899.9n 0.6737 12900.0n 0.6568 13199.9n 0.6568 13200.0n 0.5894 13499.9n 0.5894 13500.0n 0.4545 13799.9n 0.4545 13800.0n 0.4714 14099.9n 0.4714 14100.0n 0.5219 14399.9n 0.5219 14400.0n 0.4039 14699.9n 0.4039 14700.0n 0.4039 14999.9n 0.4039 15000.0n 0.5051 15299.9n 0.5051 15300.0n 0.4208 15599.9n 0.4208 15600.0n 0.6737 15899.9n 0.6737 15900.0n 0.4039 16199.9n 0.4039 16200.0n 0.4039 16499.9n 0.4039 16500.0n 0.6737 16799.9n 0.6737 16800.0n 0.6737 17099.9n 0.6737 17100.0n 0.6737 17399.9n 0.6737 17400.0n 0.4545 17699.9n 0.4545 17700.0n 0.6737 17999.9n 0.6737 18000.0n 0.6737 18299.9n 0.6737 18300.0n 0.6568 18599.9n 0.6568 18600.0n 0.5894 18899.9n 0.5894 18900.0n 0.4545 19199.9n 0.4545 19200.0n 0.4714 19499.9n 0.4714 19500.0n 0.5219 19799.9n 0.5219 19800.0n 0.4039 20099.9n 0.4039 20100.0n 0.4039 20399.9n 0.4039 20400.0n 0.5051 20699.9n 0.5051 20700.0n 0.4208 20999.9n 0.4208 21000.0n 0.6737 21299.9n 0.6737 21300.0n 0.4039 21599.9n 0.4039 21600.0n 0.4039 21899.9n 0.4039 21900.0n 0.6737 22199.9n 0.6737 22200.0n 0.6737 22499.9n 0.6737 22500.0n 0.6737 22799.9n 0.6737 22800.0n 0.4545 23099.9n 0.4545 23100.0n 0.6737 23399.9n 0.6737 23400.0n 0.6737 23699.9n 0.6737 23700.0n 0.6568 23999.9n 0.6568 24000.0n 0.5894 24299.9n 0.5894 24300.0n 0.4545 24599.9n 0.4545 24600.0n 0.4714 24899.9n 0.4714 24900.0n 0.5219 25199.9n 0.5219 25200.0n 0.4039 25499.9n 0.4039 25500.0n 0.4039 25799.9n 0.4039 25800.0n 0.5051 26099.9n 0.5051 26100.0n 0.4208 26399.9n 0.4208 26400.0n 0.6737 26699.9n 0.6737 26700.0n 0.4039 26999.9n 0.4039 27000.0n 0.4039 27299.9n 0.4039 27300.0n 0.6737 27599.9n 0.6737 27600.0n 0.6737 27899.9n 0.6737 27900.0n 0.6737 28199.9n 0.6737 28200.0n 0.4545 28499.9n 0.4545 28500.0n 0.6737 28799.9n 0.6737 28800.0n 0.6737 29099.9n 0.6737 29100.0n 0.6568 29399.9n 0.6568 29400.0n 0.5894 29699.9n 0.5894 29700.0n 0.4545 29999.9n 0.4545 30000.0n 0.4714 30299.9n 0.4714 30300.0n 0.5219 30599.9n 0.5219 30600.0n 0.4039 30899.9n 0.4039 30900.0n 0.4039 31199.9n 0.4039 31200.0n 0.5051 31499.9n 0.5051 31500.0n 0.4208 31799.9n 0.4208 31800.0n 0.6737 32099.9n 0.6737 32100.0n 0.4039 32399.9n 0.4039 32400.0n 0.4039 32699.9n 0.4039 32700.0n 0.6737 32999.9n 0.6737 33000.0n 0.6737 33299.9n 0.6737 33300.0n 0.6737 33599.9n 0.6737 33600.0n 0.4545 33899.9n 0.4545 33900.0n 0.6737 34199.9n 0.6737 34200.0n 0.6737 34499.9n 0.6737 34500.0n 0.6568 34799.9n 0.6568 34800.0n 0.5894 35099.9n 0.5894 35100.0n 0.4545 35399.9n 0.4545 35400.0n 0.4714 35699.9n 0.4714 35700.0n 0.5219 35999.9n 0.5219 36000.0n 0.4039 36299.9n 0.4039 36300.0n 0.4039 36599.9n 0.4039 36600.0n 0.5051 36899.9n 0.5051 36900.0n 0.4208 37199.9n 0.4208 37200.0n 0.6737 37499.9n 0.6737 37500.0n 0.4039 37799.9n 0.4039 37800.0n 0.4039 38099.9n 0.4039 38100.0n 0.6737 38399.9n 0.6737 38400.0n 0.6737 38699.9n 0.6737 38700.0n 0.6737 38999.9n 0.6737 39000.0n 0.4545 39299.9n 0.4545 39300.0n 0.6737 39599.9n 0.6737 39600.0n 0.6737 39899.9n 0.6737 39900.0n 0.6568 40199.9n 0.6568 40200.0n 0.5894 40499.9n 0.5894 40500.0n 0.4545 40799.9n 0.4545 40800.0n 0.4714 41099.9n 0.4714 41100.0n 0.5219 41399.9n 0.5219 41400.0n 0.4039 41699.9n 0.4039 41700.0n 0.4039 41999.9n 0.4039 42000.0n 0.5051 42299.9n 0.5051 42300.0n 0.4208 42599.9n 0.4208 42600.0n 0.6737 42899.9n 0.6737 42900.0n 0.4039 43199.9n 0.4039 43200.0n 0.4039 43499.9n 0.4039 43500.0n 0.6737 43799.9n 0.6737 43800.0n 0.6737 44099.9n 0.6737 44100.0n 0.6737 44399.9n 0.6737 44400.0n 0.4545 44699.9n 0.4545 44700.0n 0.6737 44999.9n 0.6737 45000.0n 0.6737 45299.9n 0.6737 45300.0n 0.6568 45599.9n 0.6568 45600.0n 0.5894 45899.9n 0.5894 45900.0n 0.4545 46199.9n 0.4545 46200.0n 0.4714 46499.9n 0.4714 46500.0n 0.5219 46799.9n 0.5219 46800.0n 0.4039 47099.9n 0.4039 47100.0n 0.4039 47399.9n 0.4039 47400.0n 0.5051 47699.9n 0.5051 47700.0n 0.4208 47999.9n 0.4208 48000.0n 0.6737 48299.9n 0.6737 48300.0n 0.4039 48599.9n 0.4039 48600.0n 0.4039 48899.9n 0.4039 48900.0n 0.6737 49199.9n 0.6737 49200.0n 0.6737 49499.9n 0.6737 49500.0n 0.6737 49799.9n 0.6737 49800.0n 0.4545 50099.9n 0.4545 50100.0n 0.6737 50399.9n 0.6737 50400.0n 0.6737 50699.9n 0.6737 50700.0n 0.6568 50999.9n 0.6568 51000.0n 0.5894 51299.9n 0.5894 51300.0n 0.4545 51599.9n 0.4545 51600.0n 0.4714 51899.9n 0.4714 51900.0n 0.5219 52199.9n 0.5219 52200.0n 0.4039 52499.9n 0.4039 52500.0n 0.4039 52799.9n 0.4039 52800.0n 0.5051 53099.9n 0.5051 53100.0n 0.4208 53399.9n 0.4208 53400.0n 0.6737 53699.9n 0.6737 53700.0n 0.4039 53999.9n 0.4039 54000.0n 0.6737 54299.9n 0.6737 54300.0n 0.6737 54599.9n 0.6737 54600.0n 0.6737 54899.9n 0.6737 54900.0n 0.6231 55199.9n 0.6231 55200.0n 0.6737 55499.9n 0.6737 55500.0n 0.6737 55799.9n 0.6737 55800.0n 0.4039 56099.9n 0.4039 56100.0n 0.4039 56399.9n 0.4039 56400.0n 0.4039 56699.9n 0.4039 56700.0n 0.4377 56999.9n 0.4377 57000.0n 0.4039 57299.9n 0.4039 57300.0n 0.4377 57599.9n 0.4377 57600.0n 0.4714 57899.9n 0.4714 57900.0n 0.5051 58199.9n 0.5051 58200.0n 0.5557 58499.9n 0.5557 58500.0n 0.6568 58799.9n 0.6568 58800.0n 0.4714 59099.9n 0.4714 59100.0n 0.5557)
Vxp37 a_xp37 0 PWL(0.0n 0.6236 299.9n 0.6236 300.0n 0.4362 599.9n 0.4362 600.0n 0.4192 899.9n 0.4192 900.0n 0.5044 1199.9n 0.5044 1200.0n 0.6236 1499.9n 0.6236 1500.0n 0.4192 1799.9n 0.4192 1800.0n 0.4192 2099.9n 0.4192 2100.0n 0.6236 2399.9n 0.6236 2400.0n 0.3510 2699.9n 0.3510 2700.0n 0.4532 2999.9n 0.4532 3000.0n 0.3510 3299.9n 0.3510 3300.0n 0.3510 3599.9n 0.3510 3600.0n 0.3510 3899.9n 0.3510 3900.0n 0.4532 4199.9n 0.4532 4200.0n 0.3510 4499.9n 0.3510 4500.0n 0.3510 4799.9n 0.3510 4800.0n 0.3851 5099.9n 0.3851 5100.0n 0.5384 5399.9n 0.5384 5400.0n 0.6236 5699.9n 0.6236 5700.0n 0.4362 5999.9n 0.4362 6000.0n 0.4192 6299.9n 0.4192 6300.0n 0.5044 6599.9n 0.5044 6600.0n 0.6236 6899.9n 0.6236 6900.0n 0.4192 7199.9n 0.4192 7200.0n 0.4192 7499.9n 0.4192 7500.0n 0.6236 7799.9n 0.6236 7800.0n 0.3510 8099.9n 0.3510 8100.0n 0.4532 8399.9n 0.4532 8400.0n 0.3510 8699.9n 0.3510 8700.0n 0.3510 8999.9n 0.3510 9000.0n 0.3510 9299.9n 0.3510 9300.0n 0.4532 9599.9n 0.4532 9600.0n 0.3510 9899.9n 0.3510 9900.0n 0.3510 10199.9n 0.3510 10200.0n 0.3851 10499.9n 0.3851 10500.0n 0.5384 10799.9n 0.5384 10800.0n 0.6236 11099.9n 0.6236 11100.0n 0.4362 11399.9n 0.4362 11400.0n 0.4192 11699.9n 0.4192 11700.0n 0.5044 11999.9n 0.5044 12000.0n 0.6236 12299.9n 0.6236 12300.0n 0.4192 12599.9n 0.4192 12600.0n 0.4192 12899.9n 0.4192 12900.0n 0.6236 13199.9n 0.6236 13200.0n 0.3510 13499.9n 0.3510 13500.0n 0.4532 13799.9n 0.4532 13800.0n 0.3510 14099.9n 0.3510 14100.0n 0.3510 14399.9n 0.3510 14400.0n 0.3510 14699.9n 0.3510 14700.0n 0.4532 14999.9n 0.4532 15000.0n 0.3510 15299.9n 0.3510 15300.0n 0.3510 15599.9n 0.3510 15600.0n 0.3851 15899.9n 0.3851 15900.0n 0.5384 16199.9n 0.5384 16200.0n 0.6236 16499.9n 0.6236 16500.0n 0.4362 16799.9n 0.4362 16800.0n 0.4192 17099.9n 0.4192 17100.0n 0.5044 17399.9n 0.5044 17400.0n 0.6236 17699.9n 0.6236 17700.0n 0.4192 17999.9n 0.4192 18000.0n 0.4192 18299.9n 0.4192 18300.0n 0.6236 18599.9n 0.6236 18600.0n 0.3510 18899.9n 0.3510 18900.0n 0.4532 19199.9n 0.4532 19200.0n 0.3510 19499.9n 0.3510 19500.0n 0.3510 19799.9n 0.3510 19800.0n 0.3510 20099.9n 0.3510 20100.0n 0.4532 20399.9n 0.4532 20400.0n 0.3510 20699.9n 0.3510 20700.0n 0.3510 20999.9n 0.3510 21000.0n 0.3851 21299.9n 0.3851 21300.0n 0.5384 21599.9n 0.5384 21600.0n 0.6236 21899.9n 0.6236 21900.0n 0.4362 22199.9n 0.4362 22200.0n 0.4192 22499.9n 0.4192 22500.0n 0.5044 22799.9n 0.5044 22800.0n 0.6236 23099.9n 0.6236 23100.0n 0.4192 23399.9n 0.4192 23400.0n 0.4192 23699.9n 0.4192 23700.0n 0.6236 23999.9n 0.6236 24000.0n 0.3510 24299.9n 0.3510 24300.0n 0.4532 24599.9n 0.4532 24600.0n 0.3510 24899.9n 0.3510 24900.0n 0.3510 25199.9n 0.3510 25200.0n 0.3510 25499.9n 0.3510 25500.0n 0.4532 25799.9n 0.4532 25800.0n 0.3510 26099.9n 0.3510 26100.0n 0.3510 26399.9n 0.3510 26400.0n 0.3851 26699.9n 0.3851 26700.0n 0.5384 26999.9n 0.5384 27000.0n 0.6236 27299.9n 0.6236 27300.0n 0.4362 27599.9n 0.4362 27600.0n 0.4192 27899.9n 0.4192 27900.0n 0.5044 28199.9n 0.5044 28200.0n 0.6236 28499.9n 0.6236 28500.0n 0.4192 28799.9n 0.4192 28800.0n 0.4192 29099.9n 0.4192 29100.0n 0.6236 29399.9n 0.6236 29400.0n 0.3510 29699.9n 0.3510 29700.0n 0.4532 29999.9n 0.4532 30000.0n 0.3510 30299.9n 0.3510 30300.0n 0.3510 30599.9n 0.3510 30600.0n 0.3510 30899.9n 0.3510 30900.0n 0.4532 31199.9n 0.4532 31200.0n 0.3510 31499.9n 0.3510 31500.0n 0.3510 31799.9n 0.3510 31800.0n 0.3851 32099.9n 0.3851 32100.0n 0.5384 32399.9n 0.5384 32400.0n 0.6236 32699.9n 0.6236 32700.0n 0.4362 32999.9n 0.4362 33000.0n 0.4192 33299.9n 0.4192 33300.0n 0.5044 33599.9n 0.5044 33600.0n 0.6236 33899.9n 0.6236 33900.0n 0.4192 34199.9n 0.4192 34200.0n 0.4192 34499.9n 0.4192 34500.0n 0.6236 34799.9n 0.6236 34800.0n 0.3510 35099.9n 0.3510 35100.0n 0.4532 35399.9n 0.4532 35400.0n 0.3510 35699.9n 0.3510 35700.0n 0.3510 35999.9n 0.3510 36000.0n 0.3510 36299.9n 0.3510 36300.0n 0.4532 36599.9n 0.4532 36600.0n 0.3510 36899.9n 0.3510 36900.0n 0.3510 37199.9n 0.3510 37200.0n 0.3851 37499.9n 0.3851 37500.0n 0.5384 37799.9n 0.5384 37800.0n 0.6236 38099.9n 0.6236 38100.0n 0.4362 38399.9n 0.4362 38400.0n 0.4192 38699.9n 0.4192 38700.0n 0.5044 38999.9n 0.5044 39000.0n 0.6236 39299.9n 0.6236 39300.0n 0.4192 39599.9n 0.4192 39600.0n 0.4192 39899.9n 0.4192 39900.0n 0.6236 40199.9n 0.6236 40200.0n 0.3510 40499.9n 0.3510 40500.0n 0.4532 40799.9n 0.4532 40800.0n 0.3510 41099.9n 0.3510 41100.0n 0.3510 41399.9n 0.3510 41400.0n 0.3510 41699.9n 0.3510 41700.0n 0.4532 41999.9n 0.4532 42000.0n 0.3510 42299.9n 0.3510 42300.0n 0.3510 42599.9n 0.3510 42600.0n 0.3851 42899.9n 0.3851 42900.0n 0.5384 43199.9n 0.5384 43200.0n 0.6236 43499.9n 0.6236 43500.0n 0.4362 43799.9n 0.4362 43800.0n 0.4192 44099.9n 0.4192 44100.0n 0.5044 44399.9n 0.5044 44400.0n 0.6236 44699.9n 0.6236 44700.0n 0.4192 44999.9n 0.4192 45000.0n 0.4192 45299.9n 0.4192 45300.0n 0.6236 45599.9n 0.6236 45600.0n 0.3510 45899.9n 0.3510 45900.0n 0.4532 46199.9n 0.4532 46200.0n 0.3510 46499.9n 0.3510 46500.0n 0.3510 46799.9n 0.3510 46800.0n 0.3510 47099.9n 0.3510 47100.0n 0.4532 47399.9n 0.4532 47400.0n 0.3510 47699.9n 0.3510 47700.0n 0.3510 47999.9n 0.3510 48000.0n 0.3851 48299.9n 0.3851 48300.0n 0.5384 48599.9n 0.5384 48600.0n 0.6236 48899.9n 0.6236 48900.0n 0.4362 49199.9n 0.4362 49200.0n 0.4192 49499.9n 0.4192 49500.0n 0.5044 49799.9n 0.5044 49800.0n 0.6236 50099.9n 0.6236 50100.0n 0.4192 50399.9n 0.4192 50400.0n 0.4192 50699.9n 0.4192 50700.0n 0.6236 50999.9n 0.6236 51000.0n 0.3510 51299.9n 0.3510 51300.0n 0.4532 51599.9n 0.4532 51600.0n 0.3510 51899.9n 0.3510 51900.0n 0.3510 52199.9n 0.3510 52200.0n 0.3510 52499.9n 0.3510 52500.0n 0.4532 52799.9n 0.4532 52800.0n 0.3510 53099.9n 0.3510 53100.0n 0.3510 53399.9n 0.3510 53400.0n 0.3851 53699.9n 0.3851 53700.0n 0.5384 53999.9n 0.5384 54000.0n 0.4873 54299.9n 0.4873 54300.0n 0.4192 54599.9n 0.4192 54600.0n 0.4873 54899.9n 0.4873 54900.0n 0.6236 55199.9n 0.6236 55200.0n 0.4532 55499.9n 0.4532 55500.0n 0.4532 55799.9n 0.4532 55800.0n 0.3851 56099.9n 0.3851 56100.0n 0.4362 56399.9n 0.4362 56400.0n 0.5555 56699.9n 0.5555 56700.0n 0.3851 56999.9n 0.3851 57000.0n 0.4703 57299.9n 0.4703 57300.0n 0.3851 57599.9n 0.3851 57600.0n 0.3510 57899.9n 0.3510 57900.0n 0.3510 58199.9n 0.3510 58200.0n 0.3510 58499.9n 0.3510 58500.0n 0.3510 58799.9n 0.3510 58800.0n 0.3510 59099.9n 0.3510 59100.0n 0.3510)
Vxn37 a_xn37 0 PWL(0.0n 0.3764 299.9n 0.3764 300.0n 0.5638 599.9n 0.5638 600.0n 0.5808 899.9n 0.5808 900.0n 0.4956 1199.9n 0.4956 1200.0n 0.3764 1499.9n 0.3764 1500.0n 0.5808 1799.9n 0.5808 1800.0n 0.5808 2099.9n 0.5808 2100.0n 0.3764 2399.9n 0.3764 2400.0n 0.6490 2699.9n 0.6490 2700.0n 0.5468 2999.9n 0.5468 3000.0n 0.6490 3299.9n 0.6490 3300.0n 0.6490 3599.9n 0.6490 3600.0n 0.6490 3899.9n 0.6490 3900.0n 0.5468 4199.9n 0.5468 4200.0n 0.6490 4499.9n 0.6490 4500.0n 0.6490 4799.9n 0.6490 4800.0n 0.6149 5099.9n 0.6149 5100.0n 0.4616 5399.9n 0.4616 5400.0n 0.3764 5699.9n 0.3764 5700.0n 0.5638 5999.9n 0.5638 6000.0n 0.5808 6299.9n 0.5808 6300.0n 0.4956 6599.9n 0.4956 6600.0n 0.3764 6899.9n 0.3764 6900.0n 0.5808 7199.9n 0.5808 7200.0n 0.5808 7499.9n 0.5808 7500.0n 0.3764 7799.9n 0.3764 7800.0n 0.6490 8099.9n 0.6490 8100.0n 0.5468 8399.9n 0.5468 8400.0n 0.6490 8699.9n 0.6490 8700.0n 0.6490 8999.9n 0.6490 9000.0n 0.6490 9299.9n 0.6490 9300.0n 0.5468 9599.9n 0.5468 9600.0n 0.6490 9899.9n 0.6490 9900.0n 0.6490 10199.9n 0.6490 10200.0n 0.6149 10499.9n 0.6149 10500.0n 0.4616 10799.9n 0.4616 10800.0n 0.3764 11099.9n 0.3764 11100.0n 0.5638 11399.9n 0.5638 11400.0n 0.5808 11699.9n 0.5808 11700.0n 0.4956 11999.9n 0.4956 12000.0n 0.3764 12299.9n 0.3764 12300.0n 0.5808 12599.9n 0.5808 12600.0n 0.5808 12899.9n 0.5808 12900.0n 0.3764 13199.9n 0.3764 13200.0n 0.6490 13499.9n 0.6490 13500.0n 0.5468 13799.9n 0.5468 13800.0n 0.6490 14099.9n 0.6490 14100.0n 0.6490 14399.9n 0.6490 14400.0n 0.6490 14699.9n 0.6490 14700.0n 0.5468 14999.9n 0.5468 15000.0n 0.6490 15299.9n 0.6490 15300.0n 0.6490 15599.9n 0.6490 15600.0n 0.6149 15899.9n 0.6149 15900.0n 0.4616 16199.9n 0.4616 16200.0n 0.3764 16499.9n 0.3764 16500.0n 0.5638 16799.9n 0.5638 16800.0n 0.5808 17099.9n 0.5808 17100.0n 0.4956 17399.9n 0.4956 17400.0n 0.3764 17699.9n 0.3764 17700.0n 0.5808 17999.9n 0.5808 18000.0n 0.5808 18299.9n 0.5808 18300.0n 0.3764 18599.9n 0.3764 18600.0n 0.6490 18899.9n 0.6490 18900.0n 0.5468 19199.9n 0.5468 19200.0n 0.6490 19499.9n 0.6490 19500.0n 0.6490 19799.9n 0.6490 19800.0n 0.6490 20099.9n 0.6490 20100.0n 0.5468 20399.9n 0.5468 20400.0n 0.6490 20699.9n 0.6490 20700.0n 0.6490 20999.9n 0.6490 21000.0n 0.6149 21299.9n 0.6149 21300.0n 0.4616 21599.9n 0.4616 21600.0n 0.3764 21899.9n 0.3764 21900.0n 0.5638 22199.9n 0.5638 22200.0n 0.5808 22499.9n 0.5808 22500.0n 0.4956 22799.9n 0.4956 22800.0n 0.3764 23099.9n 0.3764 23100.0n 0.5808 23399.9n 0.5808 23400.0n 0.5808 23699.9n 0.5808 23700.0n 0.3764 23999.9n 0.3764 24000.0n 0.6490 24299.9n 0.6490 24300.0n 0.5468 24599.9n 0.5468 24600.0n 0.6490 24899.9n 0.6490 24900.0n 0.6490 25199.9n 0.6490 25200.0n 0.6490 25499.9n 0.6490 25500.0n 0.5468 25799.9n 0.5468 25800.0n 0.6490 26099.9n 0.6490 26100.0n 0.6490 26399.9n 0.6490 26400.0n 0.6149 26699.9n 0.6149 26700.0n 0.4616 26999.9n 0.4616 27000.0n 0.3764 27299.9n 0.3764 27300.0n 0.5638 27599.9n 0.5638 27600.0n 0.5808 27899.9n 0.5808 27900.0n 0.4956 28199.9n 0.4956 28200.0n 0.3764 28499.9n 0.3764 28500.0n 0.5808 28799.9n 0.5808 28800.0n 0.5808 29099.9n 0.5808 29100.0n 0.3764 29399.9n 0.3764 29400.0n 0.6490 29699.9n 0.6490 29700.0n 0.5468 29999.9n 0.5468 30000.0n 0.6490 30299.9n 0.6490 30300.0n 0.6490 30599.9n 0.6490 30600.0n 0.6490 30899.9n 0.6490 30900.0n 0.5468 31199.9n 0.5468 31200.0n 0.6490 31499.9n 0.6490 31500.0n 0.6490 31799.9n 0.6490 31800.0n 0.6149 32099.9n 0.6149 32100.0n 0.4616 32399.9n 0.4616 32400.0n 0.3764 32699.9n 0.3764 32700.0n 0.5638 32999.9n 0.5638 33000.0n 0.5808 33299.9n 0.5808 33300.0n 0.4956 33599.9n 0.4956 33600.0n 0.3764 33899.9n 0.3764 33900.0n 0.5808 34199.9n 0.5808 34200.0n 0.5808 34499.9n 0.5808 34500.0n 0.3764 34799.9n 0.3764 34800.0n 0.6490 35099.9n 0.6490 35100.0n 0.5468 35399.9n 0.5468 35400.0n 0.6490 35699.9n 0.6490 35700.0n 0.6490 35999.9n 0.6490 36000.0n 0.6490 36299.9n 0.6490 36300.0n 0.5468 36599.9n 0.5468 36600.0n 0.6490 36899.9n 0.6490 36900.0n 0.6490 37199.9n 0.6490 37200.0n 0.6149 37499.9n 0.6149 37500.0n 0.4616 37799.9n 0.4616 37800.0n 0.3764 38099.9n 0.3764 38100.0n 0.5638 38399.9n 0.5638 38400.0n 0.5808 38699.9n 0.5808 38700.0n 0.4956 38999.9n 0.4956 39000.0n 0.3764 39299.9n 0.3764 39300.0n 0.5808 39599.9n 0.5808 39600.0n 0.5808 39899.9n 0.5808 39900.0n 0.3764 40199.9n 0.3764 40200.0n 0.6490 40499.9n 0.6490 40500.0n 0.5468 40799.9n 0.5468 40800.0n 0.6490 41099.9n 0.6490 41100.0n 0.6490 41399.9n 0.6490 41400.0n 0.6490 41699.9n 0.6490 41700.0n 0.5468 41999.9n 0.5468 42000.0n 0.6490 42299.9n 0.6490 42300.0n 0.6490 42599.9n 0.6490 42600.0n 0.6149 42899.9n 0.6149 42900.0n 0.4616 43199.9n 0.4616 43200.0n 0.3764 43499.9n 0.3764 43500.0n 0.5638 43799.9n 0.5638 43800.0n 0.5808 44099.9n 0.5808 44100.0n 0.4956 44399.9n 0.4956 44400.0n 0.3764 44699.9n 0.3764 44700.0n 0.5808 44999.9n 0.5808 45000.0n 0.5808 45299.9n 0.5808 45300.0n 0.3764 45599.9n 0.3764 45600.0n 0.6490 45899.9n 0.6490 45900.0n 0.5468 46199.9n 0.5468 46200.0n 0.6490 46499.9n 0.6490 46500.0n 0.6490 46799.9n 0.6490 46800.0n 0.6490 47099.9n 0.6490 47100.0n 0.5468 47399.9n 0.5468 47400.0n 0.6490 47699.9n 0.6490 47700.0n 0.6490 47999.9n 0.6490 48000.0n 0.6149 48299.9n 0.6149 48300.0n 0.4616 48599.9n 0.4616 48600.0n 0.3764 48899.9n 0.3764 48900.0n 0.5638 49199.9n 0.5638 49200.0n 0.5808 49499.9n 0.5808 49500.0n 0.4956 49799.9n 0.4956 49800.0n 0.3764 50099.9n 0.3764 50100.0n 0.5808 50399.9n 0.5808 50400.0n 0.5808 50699.9n 0.5808 50700.0n 0.3764 50999.9n 0.3764 51000.0n 0.6490 51299.9n 0.6490 51300.0n 0.5468 51599.9n 0.5468 51600.0n 0.6490 51899.9n 0.6490 51900.0n 0.6490 52199.9n 0.6490 52200.0n 0.6490 52499.9n 0.6490 52500.0n 0.5468 52799.9n 0.5468 52800.0n 0.6490 53099.9n 0.6490 53100.0n 0.6490 53399.9n 0.6490 53400.0n 0.6149 53699.9n 0.6149 53700.0n 0.4616 53999.9n 0.4616 54000.0n 0.5127 54299.9n 0.5127 54300.0n 0.5808 54599.9n 0.5808 54600.0n 0.5127 54899.9n 0.5127 54900.0n 0.3764 55199.9n 0.3764 55200.0n 0.5468 55499.9n 0.5468 55500.0n 0.5468 55799.9n 0.5468 55800.0n 0.6149 56099.9n 0.6149 56100.0n 0.5638 56399.9n 0.5638 56400.0n 0.4445 56699.9n 0.4445 56700.0n 0.6149 56999.9n 0.6149 57000.0n 0.5297 57299.9n 0.5297 57300.0n 0.6149 57599.9n 0.6149 57600.0n 0.6490 57899.9n 0.6490 57900.0n 0.6490 58199.9n 0.6490 58200.0n 0.6490 58499.9n 0.6490 58500.0n 0.6490 58799.9n 0.6490 58800.0n 0.6490 59099.9n 0.6490 59100.0n 0.6490)
Vxp38 a_xp38 0 PWL(0.0n 0.4177 299.9n 0.4177 300.0n 0.6440 599.9n 0.6440 600.0n 0.6440 899.9n 0.6440 900.0n 0.6440 1199.9n 0.6440 1200.0n 0.5308 1499.9n 0.5308 1500.0n 0.6157 1799.9n 0.6157 1800.0n 0.6440 2099.9n 0.6440 2100.0n 0.5308 2399.9n 0.5308 2400.0n 0.4177 2699.9n 0.4177 2700.0n 0.4177 2999.9n 0.4177 3000.0n 0.4177 3299.9n 0.4177 3300.0n 0.4177 3599.9n 0.4177 3600.0n 0.4177 3899.9n 0.4177 3900.0n 0.4177 4199.9n 0.4177 4200.0n 0.4177 4499.9n 0.4177 4500.0n 0.4177 4799.9n 0.4177 4800.0n 0.7005 5099.9n 0.7005 5100.0n 0.4177 5399.9n 0.4177 5400.0n 0.4177 5699.9n 0.4177 5700.0n 0.6440 5999.9n 0.6440 6000.0n 0.6440 6299.9n 0.6440 6300.0n 0.6440 6599.9n 0.6440 6600.0n 0.5308 6899.9n 0.5308 6900.0n 0.6157 7199.9n 0.6157 7200.0n 0.6440 7499.9n 0.6440 7500.0n 0.5308 7799.9n 0.5308 7800.0n 0.4177 8099.9n 0.4177 8100.0n 0.4177 8399.9n 0.4177 8400.0n 0.4177 8699.9n 0.4177 8700.0n 0.4177 8999.9n 0.4177 9000.0n 0.4177 9299.9n 0.4177 9300.0n 0.4177 9599.9n 0.4177 9600.0n 0.4177 9899.9n 0.4177 9900.0n 0.4177 10199.9n 0.4177 10200.0n 0.7005 10499.9n 0.7005 10500.0n 0.4177 10799.9n 0.4177 10800.0n 0.4177 11099.9n 0.4177 11100.0n 0.6440 11399.9n 0.6440 11400.0n 0.6440 11699.9n 0.6440 11700.0n 0.6440 11999.9n 0.6440 12000.0n 0.5308 12299.9n 0.5308 12300.0n 0.6157 12599.9n 0.6157 12600.0n 0.6440 12899.9n 0.6440 12900.0n 0.5308 13199.9n 0.5308 13200.0n 0.4177 13499.9n 0.4177 13500.0n 0.4177 13799.9n 0.4177 13800.0n 0.4177 14099.9n 0.4177 14100.0n 0.4177 14399.9n 0.4177 14400.0n 0.4177 14699.9n 0.4177 14700.0n 0.4177 14999.9n 0.4177 15000.0n 0.4177 15299.9n 0.4177 15300.0n 0.4177 15599.9n 0.4177 15600.0n 0.7005 15899.9n 0.7005 15900.0n 0.4177 16199.9n 0.4177 16200.0n 0.4177 16499.9n 0.4177 16500.0n 0.6440 16799.9n 0.6440 16800.0n 0.6440 17099.9n 0.6440 17100.0n 0.6440 17399.9n 0.6440 17400.0n 0.5308 17699.9n 0.5308 17700.0n 0.6157 17999.9n 0.6157 18000.0n 0.6440 18299.9n 0.6440 18300.0n 0.5308 18599.9n 0.5308 18600.0n 0.4177 18899.9n 0.4177 18900.0n 0.4177 19199.9n 0.4177 19200.0n 0.4177 19499.9n 0.4177 19500.0n 0.4177 19799.9n 0.4177 19800.0n 0.4177 20099.9n 0.4177 20100.0n 0.4177 20399.9n 0.4177 20400.0n 0.4177 20699.9n 0.4177 20700.0n 0.4177 20999.9n 0.4177 21000.0n 0.7005 21299.9n 0.7005 21300.0n 0.4177 21599.9n 0.4177 21600.0n 0.4177 21899.9n 0.4177 21900.0n 0.6440 22199.9n 0.6440 22200.0n 0.6440 22499.9n 0.6440 22500.0n 0.6440 22799.9n 0.6440 22800.0n 0.5308 23099.9n 0.5308 23100.0n 0.6157 23399.9n 0.6157 23400.0n 0.6440 23699.9n 0.6440 23700.0n 0.5308 23999.9n 0.5308 24000.0n 0.4177 24299.9n 0.4177 24300.0n 0.4177 24599.9n 0.4177 24600.0n 0.4177 24899.9n 0.4177 24900.0n 0.4177 25199.9n 0.4177 25200.0n 0.4177 25499.9n 0.4177 25500.0n 0.4177 25799.9n 0.4177 25800.0n 0.4177 26099.9n 0.4177 26100.0n 0.4177 26399.9n 0.4177 26400.0n 0.7005 26699.9n 0.7005 26700.0n 0.4177 26999.9n 0.4177 27000.0n 0.4177 27299.9n 0.4177 27300.0n 0.6440 27599.9n 0.6440 27600.0n 0.6440 27899.9n 0.6440 27900.0n 0.6440 28199.9n 0.6440 28200.0n 0.5308 28499.9n 0.5308 28500.0n 0.6157 28799.9n 0.6157 28800.0n 0.6440 29099.9n 0.6440 29100.0n 0.5308 29399.9n 0.5308 29400.0n 0.4177 29699.9n 0.4177 29700.0n 0.4177 29999.9n 0.4177 30000.0n 0.4177 30299.9n 0.4177 30300.0n 0.4177 30599.9n 0.4177 30600.0n 0.4177 30899.9n 0.4177 30900.0n 0.4177 31199.9n 0.4177 31200.0n 0.4177 31499.9n 0.4177 31500.0n 0.4177 31799.9n 0.4177 31800.0n 0.7005 32099.9n 0.7005 32100.0n 0.4177 32399.9n 0.4177 32400.0n 0.4177 32699.9n 0.4177 32700.0n 0.6440 32999.9n 0.6440 33000.0n 0.6440 33299.9n 0.6440 33300.0n 0.6440 33599.9n 0.6440 33600.0n 0.5308 33899.9n 0.5308 33900.0n 0.6157 34199.9n 0.6157 34200.0n 0.6440 34499.9n 0.6440 34500.0n 0.5308 34799.9n 0.5308 34800.0n 0.4177 35099.9n 0.4177 35100.0n 0.4177 35399.9n 0.4177 35400.0n 0.4177 35699.9n 0.4177 35700.0n 0.4177 35999.9n 0.4177 36000.0n 0.4177 36299.9n 0.4177 36300.0n 0.4177 36599.9n 0.4177 36600.0n 0.4177 36899.9n 0.4177 36900.0n 0.4177 37199.9n 0.4177 37200.0n 0.7005 37499.9n 0.7005 37500.0n 0.4177 37799.9n 0.4177 37800.0n 0.4177 38099.9n 0.4177 38100.0n 0.6440 38399.9n 0.6440 38400.0n 0.6440 38699.9n 0.6440 38700.0n 0.6440 38999.9n 0.6440 39000.0n 0.5308 39299.9n 0.5308 39300.0n 0.6157 39599.9n 0.6157 39600.0n 0.6440 39899.9n 0.6440 39900.0n 0.5308 40199.9n 0.5308 40200.0n 0.4177 40499.9n 0.4177 40500.0n 0.4177 40799.9n 0.4177 40800.0n 0.4177 41099.9n 0.4177 41100.0n 0.4177 41399.9n 0.4177 41400.0n 0.4177 41699.9n 0.4177 41700.0n 0.4177 41999.9n 0.4177 42000.0n 0.4177 42299.9n 0.4177 42300.0n 0.4177 42599.9n 0.4177 42600.0n 0.7005 42899.9n 0.7005 42900.0n 0.4177 43199.9n 0.4177 43200.0n 0.4177 43499.9n 0.4177 43500.0n 0.6440 43799.9n 0.6440 43800.0n 0.6440 44099.9n 0.6440 44100.0n 0.6440 44399.9n 0.6440 44400.0n 0.5308 44699.9n 0.5308 44700.0n 0.6157 44999.9n 0.6157 45000.0n 0.6440 45299.9n 0.6440 45300.0n 0.5308 45599.9n 0.5308 45600.0n 0.4177 45899.9n 0.4177 45900.0n 0.4177 46199.9n 0.4177 46200.0n 0.4177 46499.9n 0.4177 46500.0n 0.4177 46799.9n 0.4177 46800.0n 0.4177 47099.9n 0.4177 47100.0n 0.4177 47399.9n 0.4177 47400.0n 0.4177 47699.9n 0.4177 47700.0n 0.4177 47999.9n 0.4177 48000.0n 0.7005 48299.9n 0.7005 48300.0n 0.4177 48599.9n 0.4177 48600.0n 0.4177 48899.9n 0.4177 48900.0n 0.6440 49199.9n 0.6440 49200.0n 0.6440 49499.9n 0.6440 49500.0n 0.6440 49799.9n 0.6440 49800.0n 0.5308 50099.9n 0.5308 50100.0n 0.6157 50399.9n 0.6157 50400.0n 0.6440 50699.9n 0.6440 50700.0n 0.5308 50999.9n 0.5308 51000.0n 0.4177 51299.9n 0.4177 51300.0n 0.4177 51599.9n 0.4177 51600.0n 0.4177 51899.9n 0.4177 51900.0n 0.4177 52199.9n 0.4177 52200.0n 0.4177 52499.9n 0.4177 52500.0n 0.4177 52799.9n 0.4177 52800.0n 0.4177 53099.9n 0.4177 53100.0n 0.4177 53399.9n 0.4177 53400.0n 0.7005 53699.9n 0.7005 53700.0n 0.4177 53999.9n 0.4177 54000.0n 0.6722 54299.9n 0.6722 54300.0n 0.6440 54599.9n 0.6440 54600.0n 0.7571 54899.9n 0.7571 54900.0n 0.5308 55199.9n 0.5308 55200.0n 0.6440 55499.9n 0.6440 55500.0n 0.6157 55799.9n 0.6157 55800.0n 0.4177 56099.9n 0.4177 56100.0n 0.4177 56399.9n 0.4177 56400.0n 0.4177 56699.9n 0.4177 56700.0n 0.4177 56999.9n 0.4177 57000.0n 0.4177 57299.9n 0.4177 57300.0n 0.4177 57599.9n 0.4177 57600.0n 0.4177 57899.9n 0.4177 57900.0n 0.4177 58199.9n 0.4177 58200.0n 0.4177 58499.9n 0.4177 58500.0n 0.4177 58799.9n 0.4177 58800.0n 0.4177 59099.9n 0.4177 59100.0n 0.4177)
Vxn38 a_xn38 0 PWL(0.0n 0.5823 299.9n 0.5823 300.0n 0.3560 599.9n 0.3560 600.0n 0.3560 899.9n 0.3560 900.0n 0.3560 1199.9n 0.3560 1200.0n 0.4692 1499.9n 0.4692 1500.0n 0.3843 1799.9n 0.3843 1800.0n 0.3560 2099.9n 0.3560 2100.0n 0.4692 2399.9n 0.4692 2400.0n 0.5823 2699.9n 0.5823 2700.0n 0.5823 2999.9n 0.5823 3000.0n 0.5823 3299.9n 0.5823 3300.0n 0.5823 3599.9n 0.5823 3600.0n 0.5823 3899.9n 0.5823 3900.0n 0.5823 4199.9n 0.5823 4200.0n 0.5823 4499.9n 0.5823 4500.0n 0.5823 4799.9n 0.5823 4800.0n 0.2995 5099.9n 0.2995 5100.0n 0.5823 5399.9n 0.5823 5400.0n 0.5823 5699.9n 0.5823 5700.0n 0.3560 5999.9n 0.3560 6000.0n 0.3560 6299.9n 0.3560 6300.0n 0.3560 6599.9n 0.3560 6600.0n 0.4692 6899.9n 0.4692 6900.0n 0.3843 7199.9n 0.3843 7200.0n 0.3560 7499.9n 0.3560 7500.0n 0.4692 7799.9n 0.4692 7800.0n 0.5823 8099.9n 0.5823 8100.0n 0.5823 8399.9n 0.5823 8400.0n 0.5823 8699.9n 0.5823 8700.0n 0.5823 8999.9n 0.5823 9000.0n 0.5823 9299.9n 0.5823 9300.0n 0.5823 9599.9n 0.5823 9600.0n 0.5823 9899.9n 0.5823 9900.0n 0.5823 10199.9n 0.5823 10200.0n 0.2995 10499.9n 0.2995 10500.0n 0.5823 10799.9n 0.5823 10800.0n 0.5823 11099.9n 0.5823 11100.0n 0.3560 11399.9n 0.3560 11400.0n 0.3560 11699.9n 0.3560 11700.0n 0.3560 11999.9n 0.3560 12000.0n 0.4692 12299.9n 0.4692 12300.0n 0.3843 12599.9n 0.3843 12600.0n 0.3560 12899.9n 0.3560 12900.0n 0.4692 13199.9n 0.4692 13200.0n 0.5823 13499.9n 0.5823 13500.0n 0.5823 13799.9n 0.5823 13800.0n 0.5823 14099.9n 0.5823 14100.0n 0.5823 14399.9n 0.5823 14400.0n 0.5823 14699.9n 0.5823 14700.0n 0.5823 14999.9n 0.5823 15000.0n 0.5823 15299.9n 0.5823 15300.0n 0.5823 15599.9n 0.5823 15600.0n 0.2995 15899.9n 0.2995 15900.0n 0.5823 16199.9n 0.5823 16200.0n 0.5823 16499.9n 0.5823 16500.0n 0.3560 16799.9n 0.3560 16800.0n 0.3560 17099.9n 0.3560 17100.0n 0.3560 17399.9n 0.3560 17400.0n 0.4692 17699.9n 0.4692 17700.0n 0.3843 17999.9n 0.3843 18000.0n 0.3560 18299.9n 0.3560 18300.0n 0.4692 18599.9n 0.4692 18600.0n 0.5823 18899.9n 0.5823 18900.0n 0.5823 19199.9n 0.5823 19200.0n 0.5823 19499.9n 0.5823 19500.0n 0.5823 19799.9n 0.5823 19800.0n 0.5823 20099.9n 0.5823 20100.0n 0.5823 20399.9n 0.5823 20400.0n 0.5823 20699.9n 0.5823 20700.0n 0.5823 20999.9n 0.5823 21000.0n 0.2995 21299.9n 0.2995 21300.0n 0.5823 21599.9n 0.5823 21600.0n 0.5823 21899.9n 0.5823 21900.0n 0.3560 22199.9n 0.3560 22200.0n 0.3560 22499.9n 0.3560 22500.0n 0.3560 22799.9n 0.3560 22800.0n 0.4692 23099.9n 0.4692 23100.0n 0.3843 23399.9n 0.3843 23400.0n 0.3560 23699.9n 0.3560 23700.0n 0.4692 23999.9n 0.4692 24000.0n 0.5823 24299.9n 0.5823 24300.0n 0.5823 24599.9n 0.5823 24600.0n 0.5823 24899.9n 0.5823 24900.0n 0.5823 25199.9n 0.5823 25200.0n 0.5823 25499.9n 0.5823 25500.0n 0.5823 25799.9n 0.5823 25800.0n 0.5823 26099.9n 0.5823 26100.0n 0.5823 26399.9n 0.5823 26400.0n 0.2995 26699.9n 0.2995 26700.0n 0.5823 26999.9n 0.5823 27000.0n 0.5823 27299.9n 0.5823 27300.0n 0.3560 27599.9n 0.3560 27600.0n 0.3560 27899.9n 0.3560 27900.0n 0.3560 28199.9n 0.3560 28200.0n 0.4692 28499.9n 0.4692 28500.0n 0.3843 28799.9n 0.3843 28800.0n 0.3560 29099.9n 0.3560 29100.0n 0.4692 29399.9n 0.4692 29400.0n 0.5823 29699.9n 0.5823 29700.0n 0.5823 29999.9n 0.5823 30000.0n 0.5823 30299.9n 0.5823 30300.0n 0.5823 30599.9n 0.5823 30600.0n 0.5823 30899.9n 0.5823 30900.0n 0.5823 31199.9n 0.5823 31200.0n 0.5823 31499.9n 0.5823 31500.0n 0.5823 31799.9n 0.5823 31800.0n 0.2995 32099.9n 0.2995 32100.0n 0.5823 32399.9n 0.5823 32400.0n 0.5823 32699.9n 0.5823 32700.0n 0.3560 32999.9n 0.3560 33000.0n 0.3560 33299.9n 0.3560 33300.0n 0.3560 33599.9n 0.3560 33600.0n 0.4692 33899.9n 0.4692 33900.0n 0.3843 34199.9n 0.3843 34200.0n 0.3560 34499.9n 0.3560 34500.0n 0.4692 34799.9n 0.4692 34800.0n 0.5823 35099.9n 0.5823 35100.0n 0.5823 35399.9n 0.5823 35400.0n 0.5823 35699.9n 0.5823 35700.0n 0.5823 35999.9n 0.5823 36000.0n 0.5823 36299.9n 0.5823 36300.0n 0.5823 36599.9n 0.5823 36600.0n 0.5823 36899.9n 0.5823 36900.0n 0.5823 37199.9n 0.5823 37200.0n 0.2995 37499.9n 0.2995 37500.0n 0.5823 37799.9n 0.5823 37800.0n 0.5823 38099.9n 0.5823 38100.0n 0.3560 38399.9n 0.3560 38400.0n 0.3560 38699.9n 0.3560 38700.0n 0.3560 38999.9n 0.3560 39000.0n 0.4692 39299.9n 0.4692 39300.0n 0.3843 39599.9n 0.3843 39600.0n 0.3560 39899.9n 0.3560 39900.0n 0.4692 40199.9n 0.4692 40200.0n 0.5823 40499.9n 0.5823 40500.0n 0.5823 40799.9n 0.5823 40800.0n 0.5823 41099.9n 0.5823 41100.0n 0.5823 41399.9n 0.5823 41400.0n 0.5823 41699.9n 0.5823 41700.0n 0.5823 41999.9n 0.5823 42000.0n 0.5823 42299.9n 0.5823 42300.0n 0.5823 42599.9n 0.5823 42600.0n 0.2995 42899.9n 0.2995 42900.0n 0.5823 43199.9n 0.5823 43200.0n 0.5823 43499.9n 0.5823 43500.0n 0.3560 43799.9n 0.3560 43800.0n 0.3560 44099.9n 0.3560 44100.0n 0.3560 44399.9n 0.3560 44400.0n 0.4692 44699.9n 0.4692 44700.0n 0.3843 44999.9n 0.3843 45000.0n 0.3560 45299.9n 0.3560 45300.0n 0.4692 45599.9n 0.4692 45600.0n 0.5823 45899.9n 0.5823 45900.0n 0.5823 46199.9n 0.5823 46200.0n 0.5823 46499.9n 0.5823 46500.0n 0.5823 46799.9n 0.5823 46800.0n 0.5823 47099.9n 0.5823 47100.0n 0.5823 47399.9n 0.5823 47400.0n 0.5823 47699.9n 0.5823 47700.0n 0.5823 47999.9n 0.5823 48000.0n 0.2995 48299.9n 0.2995 48300.0n 0.5823 48599.9n 0.5823 48600.0n 0.5823 48899.9n 0.5823 48900.0n 0.3560 49199.9n 0.3560 49200.0n 0.3560 49499.9n 0.3560 49500.0n 0.3560 49799.9n 0.3560 49800.0n 0.4692 50099.9n 0.4692 50100.0n 0.3843 50399.9n 0.3843 50400.0n 0.3560 50699.9n 0.3560 50700.0n 0.4692 50999.9n 0.4692 51000.0n 0.5823 51299.9n 0.5823 51300.0n 0.5823 51599.9n 0.5823 51600.0n 0.5823 51899.9n 0.5823 51900.0n 0.5823 52199.9n 0.5823 52200.0n 0.5823 52499.9n 0.5823 52500.0n 0.5823 52799.9n 0.5823 52800.0n 0.5823 53099.9n 0.5823 53100.0n 0.5823 53399.9n 0.5823 53400.0n 0.2995 53699.9n 0.2995 53700.0n 0.5823 53999.9n 0.5823 54000.0n 0.3278 54299.9n 0.3278 54300.0n 0.3560 54599.9n 0.3560 54600.0n 0.2429 54899.9n 0.2429 54900.0n 0.4692 55199.9n 0.4692 55200.0n 0.3560 55499.9n 0.3560 55500.0n 0.3843 55799.9n 0.3843 55800.0n 0.5823 56099.9n 0.5823 56100.0n 0.5823 56399.9n 0.5823 56400.0n 0.5823 56699.9n 0.5823 56700.0n 0.5823 56999.9n 0.5823 57000.0n 0.5823 57299.9n 0.5823 57300.0n 0.5823 57599.9n 0.5823 57600.0n 0.5823 57899.9n 0.5823 57900.0n 0.5823 58199.9n 0.5823 58200.0n 0.5823 58499.9n 0.5823 58500.0n 0.5823 58799.9n 0.5823 58800.0n 0.5823 59099.9n 0.5823 59100.0n 0.5823)
Vxp39 a_xp39 0 PWL(0.0n 0.5000 299.9n 0.5000 300.0n 0.5000 599.9n 0.5000 600.0n 0.5000 899.9n 0.5000 900.0n 0.5000 1199.9n 0.5000 1200.0n 0.5000 1499.9n 0.5000 1500.0n 0.5000 1799.9n 0.5000 1800.0n 0.5000 2099.9n 0.5000 2100.0n 0.5000 2399.9n 0.5000 2400.0n 0.5000 2699.9n 0.5000 2700.0n 0.5000 2999.9n 0.5000 3000.0n 0.5000 3299.9n 0.5000 3300.0n 0.5000 3599.9n 0.5000 3600.0n 0.5000 3899.9n 0.5000 3900.0n 0.5000 4199.9n 0.5000 4200.0n 0.5000 4499.9n 0.5000 4500.0n 0.5000 4799.9n 0.5000 4800.0n 0.5000 5099.9n 0.5000 5100.0n 0.5000 5399.9n 0.5000 5400.0n 0.5000 5699.9n 0.5000 5700.0n 0.5000 5999.9n 0.5000 6000.0n 0.5000 6299.9n 0.5000 6300.0n 0.5000 6599.9n 0.5000 6600.0n 0.5000 6899.9n 0.5000 6900.0n 0.5000 7199.9n 0.5000 7200.0n 0.5000 7499.9n 0.5000 7500.0n 0.5000 7799.9n 0.5000 7800.0n 0.5000 8099.9n 0.5000 8100.0n 0.5000 8399.9n 0.5000 8400.0n 0.5000 8699.9n 0.5000 8700.0n 0.5000 8999.9n 0.5000 9000.0n 0.5000 9299.9n 0.5000 9300.0n 0.5000 9599.9n 0.5000 9600.0n 0.5000 9899.9n 0.5000 9900.0n 0.5000 10199.9n 0.5000 10200.0n 0.5000 10499.9n 0.5000 10500.0n 0.5000 10799.9n 0.5000 10800.0n 0.5000 11099.9n 0.5000 11100.0n 0.5000 11399.9n 0.5000 11400.0n 0.5000 11699.9n 0.5000 11700.0n 0.5000 11999.9n 0.5000 12000.0n 0.5000 12299.9n 0.5000 12300.0n 0.5000 12599.9n 0.5000 12600.0n 0.5000 12899.9n 0.5000 12900.0n 0.5000 13199.9n 0.5000 13200.0n 0.5000 13499.9n 0.5000 13500.0n 0.5000 13799.9n 0.5000 13800.0n 0.5000 14099.9n 0.5000 14100.0n 0.5000 14399.9n 0.5000 14400.0n 0.5000 14699.9n 0.5000 14700.0n 0.5000 14999.9n 0.5000 15000.0n 0.5000 15299.9n 0.5000 15300.0n 0.5000 15599.9n 0.5000 15600.0n 0.5000 15899.9n 0.5000 15900.0n 0.5000 16199.9n 0.5000 16200.0n 0.5000 16499.9n 0.5000 16500.0n 0.5000 16799.9n 0.5000 16800.0n 0.5000 17099.9n 0.5000 17100.0n 0.5000 17399.9n 0.5000 17400.0n 0.5000 17699.9n 0.5000 17700.0n 0.5000 17999.9n 0.5000 18000.0n 0.5000 18299.9n 0.5000 18300.0n 0.5000 18599.9n 0.5000 18600.0n 0.5000 18899.9n 0.5000 18900.0n 0.5000 19199.9n 0.5000 19200.0n 0.5000 19499.9n 0.5000 19500.0n 0.5000 19799.9n 0.5000 19800.0n 0.5000 20099.9n 0.5000 20100.0n 0.5000 20399.9n 0.5000 20400.0n 0.5000 20699.9n 0.5000 20700.0n 0.5000 20999.9n 0.5000 21000.0n 0.5000 21299.9n 0.5000 21300.0n 0.5000 21599.9n 0.5000 21600.0n 0.5000 21899.9n 0.5000 21900.0n 0.5000 22199.9n 0.5000 22200.0n 0.5000 22499.9n 0.5000 22500.0n 0.5000 22799.9n 0.5000 22800.0n 0.5000 23099.9n 0.5000 23100.0n 0.5000 23399.9n 0.5000 23400.0n 0.5000 23699.9n 0.5000 23700.0n 0.5000 23999.9n 0.5000 24000.0n 0.5000 24299.9n 0.5000 24300.0n 0.5000 24599.9n 0.5000 24600.0n 0.5000 24899.9n 0.5000 24900.0n 0.5000 25199.9n 0.5000 25200.0n 0.5000 25499.9n 0.5000 25500.0n 0.5000 25799.9n 0.5000 25800.0n 0.5000 26099.9n 0.5000 26100.0n 0.5000 26399.9n 0.5000 26400.0n 0.5000 26699.9n 0.5000 26700.0n 0.5000 26999.9n 0.5000 27000.0n 0.5000 27299.9n 0.5000 27300.0n 0.5000 27599.9n 0.5000 27600.0n 0.5000 27899.9n 0.5000 27900.0n 0.5000 28199.9n 0.5000 28200.0n 0.5000 28499.9n 0.5000 28500.0n 0.5000 28799.9n 0.5000 28800.0n 0.5000 29099.9n 0.5000 29100.0n 0.5000 29399.9n 0.5000 29400.0n 0.5000 29699.9n 0.5000 29700.0n 0.5000 29999.9n 0.5000 30000.0n 0.5000 30299.9n 0.5000 30300.0n 0.5000 30599.9n 0.5000 30600.0n 0.5000 30899.9n 0.5000 30900.0n 0.5000 31199.9n 0.5000 31200.0n 0.5000 31499.9n 0.5000 31500.0n 0.5000 31799.9n 0.5000 31800.0n 0.5000 32099.9n 0.5000 32100.0n 0.5000 32399.9n 0.5000 32400.0n 0.5000 32699.9n 0.5000 32700.0n 0.5000 32999.9n 0.5000 33000.0n 0.5000 33299.9n 0.5000 33300.0n 0.5000 33599.9n 0.5000 33600.0n 0.5000 33899.9n 0.5000 33900.0n 0.5000 34199.9n 0.5000 34200.0n 0.5000 34499.9n 0.5000 34500.0n 0.5000 34799.9n 0.5000 34800.0n 0.5000 35099.9n 0.5000 35100.0n 0.5000 35399.9n 0.5000 35400.0n 0.5000 35699.9n 0.5000 35700.0n 0.5000 35999.9n 0.5000 36000.0n 0.5000 36299.9n 0.5000 36300.0n 0.5000 36599.9n 0.5000 36600.0n 0.5000 36899.9n 0.5000 36900.0n 0.5000 37199.9n 0.5000 37200.0n 0.5000 37499.9n 0.5000 37500.0n 0.5000 37799.9n 0.5000 37800.0n 0.5000 38099.9n 0.5000 38100.0n 0.5000 38399.9n 0.5000 38400.0n 0.5000 38699.9n 0.5000 38700.0n 0.5000 38999.9n 0.5000 39000.0n 0.5000 39299.9n 0.5000 39300.0n 0.5000 39599.9n 0.5000 39600.0n 0.5000 39899.9n 0.5000 39900.0n 0.5000 40199.9n 0.5000 40200.0n 0.5000 40499.9n 0.5000 40500.0n 0.5000 40799.9n 0.5000 40800.0n 0.5000 41099.9n 0.5000 41100.0n 0.5000 41399.9n 0.5000 41400.0n 0.5000 41699.9n 0.5000 41700.0n 0.5000 41999.9n 0.5000 42000.0n 0.5000 42299.9n 0.5000 42300.0n 0.5000 42599.9n 0.5000 42600.0n 0.5000 42899.9n 0.5000 42900.0n 0.5000 43199.9n 0.5000 43200.0n 0.5000 43499.9n 0.5000 43500.0n 0.5000 43799.9n 0.5000 43800.0n 0.5000 44099.9n 0.5000 44100.0n 0.5000 44399.9n 0.5000 44400.0n 0.5000 44699.9n 0.5000 44700.0n 0.5000 44999.9n 0.5000 45000.0n 0.5000 45299.9n 0.5000 45300.0n 0.5000 45599.9n 0.5000 45600.0n 0.5000 45899.9n 0.5000 45900.0n 0.5000 46199.9n 0.5000 46200.0n 0.5000 46499.9n 0.5000 46500.0n 0.5000 46799.9n 0.5000 46800.0n 0.5000 47099.9n 0.5000 47100.0n 0.5000 47399.9n 0.5000 47400.0n 0.5000 47699.9n 0.5000 47700.0n 0.5000 47999.9n 0.5000 48000.0n 0.5000 48299.9n 0.5000 48300.0n 0.5000 48599.9n 0.5000 48600.0n 0.5000 48899.9n 0.5000 48900.0n 0.5000 49199.9n 0.5000 49200.0n 0.5000 49499.9n 0.5000 49500.0n 0.5000 49799.9n 0.5000 49800.0n 0.5000 50099.9n 0.5000 50100.0n 0.5000 50399.9n 0.5000 50400.0n 0.5000 50699.9n 0.5000 50700.0n 0.5000 50999.9n 0.5000 51000.0n 0.5000 51299.9n 0.5000 51300.0n 0.5000 51599.9n 0.5000 51600.0n 0.5000 51899.9n 0.5000 51900.0n 0.5000 52199.9n 0.5000 52200.0n 0.5000 52499.9n 0.5000 52500.0n 0.5000 52799.9n 0.5000 52800.0n 0.5000 53099.9n 0.5000 53100.0n 0.5000 53399.9n 0.5000 53400.0n 0.5000 53699.9n 0.5000 53700.0n 0.5000 53999.9n 0.5000 54000.0n 0.5000 54299.9n 0.5000 54300.0n 0.5000 54599.9n 0.5000 54600.0n 0.5000 54899.9n 0.5000 54900.0n 0.5000 55199.9n 0.5000 55200.0n 0.5000 55499.9n 0.5000 55500.0n 0.5000 55799.9n 0.5000 55800.0n 0.5000 56099.9n 0.5000 56100.0n 0.5000 56399.9n 0.5000 56400.0n 0.5000 56699.9n 0.5000 56700.0n 0.5000 56999.9n 0.5000 57000.0n 0.5000 57299.9n 0.5000 57300.0n 0.5000 57599.9n 0.5000 57600.0n 0.5000 57899.9n 0.5000 57900.0n 0.5000 58199.9n 0.5000 58200.0n 0.5000 58499.9n 0.5000 58500.0n 0.5000 58799.9n 0.5000 58800.0n 0.5000 59099.9n 0.5000 59100.0n 0.5000)
Vxn39 a_xn39 0 PWL(0.0n 0.5000 299.9n 0.5000 300.0n 0.5000 599.9n 0.5000 600.0n 0.5000 899.9n 0.5000 900.0n 0.5000 1199.9n 0.5000 1200.0n 0.5000 1499.9n 0.5000 1500.0n 0.5000 1799.9n 0.5000 1800.0n 0.5000 2099.9n 0.5000 2100.0n 0.5000 2399.9n 0.5000 2400.0n 0.5000 2699.9n 0.5000 2700.0n 0.5000 2999.9n 0.5000 3000.0n 0.5000 3299.9n 0.5000 3300.0n 0.5000 3599.9n 0.5000 3600.0n 0.5000 3899.9n 0.5000 3900.0n 0.5000 4199.9n 0.5000 4200.0n 0.5000 4499.9n 0.5000 4500.0n 0.5000 4799.9n 0.5000 4800.0n 0.5000 5099.9n 0.5000 5100.0n 0.5000 5399.9n 0.5000 5400.0n 0.5000 5699.9n 0.5000 5700.0n 0.5000 5999.9n 0.5000 6000.0n 0.5000 6299.9n 0.5000 6300.0n 0.5000 6599.9n 0.5000 6600.0n 0.5000 6899.9n 0.5000 6900.0n 0.5000 7199.9n 0.5000 7200.0n 0.5000 7499.9n 0.5000 7500.0n 0.5000 7799.9n 0.5000 7800.0n 0.5000 8099.9n 0.5000 8100.0n 0.5000 8399.9n 0.5000 8400.0n 0.5000 8699.9n 0.5000 8700.0n 0.5000 8999.9n 0.5000 9000.0n 0.5000 9299.9n 0.5000 9300.0n 0.5000 9599.9n 0.5000 9600.0n 0.5000 9899.9n 0.5000 9900.0n 0.5000 10199.9n 0.5000 10200.0n 0.5000 10499.9n 0.5000 10500.0n 0.5000 10799.9n 0.5000 10800.0n 0.5000 11099.9n 0.5000 11100.0n 0.5000 11399.9n 0.5000 11400.0n 0.5000 11699.9n 0.5000 11700.0n 0.5000 11999.9n 0.5000 12000.0n 0.5000 12299.9n 0.5000 12300.0n 0.5000 12599.9n 0.5000 12600.0n 0.5000 12899.9n 0.5000 12900.0n 0.5000 13199.9n 0.5000 13200.0n 0.5000 13499.9n 0.5000 13500.0n 0.5000 13799.9n 0.5000 13800.0n 0.5000 14099.9n 0.5000 14100.0n 0.5000 14399.9n 0.5000 14400.0n 0.5000 14699.9n 0.5000 14700.0n 0.5000 14999.9n 0.5000 15000.0n 0.5000 15299.9n 0.5000 15300.0n 0.5000 15599.9n 0.5000 15600.0n 0.5000 15899.9n 0.5000 15900.0n 0.5000 16199.9n 0.5000 16200.0n 0.5000 16499.9n 0.5000 16500.0n 0.5000 16799.9n 0.5000 16800.0n 0.5000 17099.9n 0.5000 17100.0n 0.5000 17399.9n 0.5000 17400.0n 0.5000 17699.9n 0.5000 17700.0n 0.5000 17999.9n 0.5000 18000.0n 0.5000 18299.9n 0.5000 18300.0n 0.5000 18599.9n 0.5000 18600.0n 0.5000 18899.9n 0.5000 18900.0n 0.5000 19199.9n 0.5000 19200.0n 0.5000 19499.9n 0.5000 19500.0n 0.5000 19799.9n 0.5000 19800.0n 0.5000 20099.9n 0.5000 20100.0n 0.5000 20399.9n 0.5000 20400.0n 0.5000 20699.9n 0.5000 20700.0n 0.5000 20999.9n 0.5000 21000.0n 0.5000 21299.9n 0.5000 21300.0n 0.5000 21599.9n 0.5000 21600.0n 0.5000 21899.9n 0.5000 21900.0n 0.5000 22199.9n 0.5000 22200.0n 0.5000 22499.9n 0.5000 22500.0n 0.5000 22799.9n 0.5000 22800.0n 0.5000 23099.9n 0.5000 23100.0n 0.5000 23399.9n 0.5000 23400.0n 0.5000 23699.9n 0.5000 23700.0n 0.5000 23999.9n 0.5000 24000.0n 0.5000 24299.9n 0.5000 24300.0n 0.5000 24599.9n 0.5000 24600.0n 0.5000 24899.9n 0.5000 24900.0n 0.5000 25199.9n 0.5000 25200.0n 0.5000 25499.9n 0.5000 25500.0n 0.5000 25799.9n 0.5000 25800.0n 0.5000 26099.9n 0.5000 26100.0n 0.5000 26399.9n 0.5000 26400.0n 0.5000 26699.9n 0.5000 26700.0n 0.5000 26999.9n 0.5000 27000.0n 0.5000 27299.9n 0.5000 27300.0n 0.5000 27599.9n 0.5000 27600.0n 0.5000 27899.9n 0.5000 27900.0n 0.5000 28199.9n 0.5000 28200.0n 0.5000 28499.9n 0.5000 28500.0n 0.5000 28799.9n 0.5000 28800.0n 0.5000 29099.9n 0.5000 29100.0n 0.5000 29399.9n 0.5000 29400.0n 0.5000 29699.9n 0.5000 29700.0n 0.5000 29999.9n 0.5000 30000.0n 0.5000 30299.9n 0.5000 30300.0n 0.5000 30599.9n 0.5000 30600.0n 0.5000 30899.9n 0.5000 30900.0n 0.5000 31199.9n 0.5000 31200.0n 0.5000 31499.9n 0.5000 31500.0n 0.5000 31799.9n 0.5000 31800.0n 0.5000 32099.9n 0.5000 32100.0n 0.5000 32399.9n 0.5000 32400.0n 0.5000 32699.9n 0.5000 32700.0n 0.5000 32999.9n 0.5000 33000.0n 0.5000 33299.9n 0.5000 33300.0n 0.5000 33599.9n 0.5000 33600.0n 0.5000 33899.9n 0.5000 33900.0n 0.5000 34199.9n 0.5000 34200.0n 0.5000 34499.9n 0.5000 34500.0n 0.5000 34799.9n 0.5000 34800.0n 0.5000 35099.9n 0.5000 35100.0n 0.5000 35399.9n 0.5000 35400.0n 0.5000 35699.9n 0.5000 35700.0n 0.5000 35999.9n 0.5000 36000.0n 0.5000 36299.9n 0.5000 36300.0n 0.5000 36599.9n 0.5000 36600.0n 0.5000 36899.9n 0.5000 36900.0n 0.5000 37199.9n 0.5000 37200.0n 0.5000 37499.9n 0.5000 37500.0n 0.5000 37799.9n 0.5000 37800.0n 0.5000 38099.9n 0.5000 38100.0n 0.5000 38399.9n 0.5000 38400.0n 0.5000 38699.9n 0.5000 38700.0n 0.5000 38999.9n 0.5000 39000.0n 0.5000 39299.9n 0.5000 39300.0n 0.5000 39599.9n 0.5000 39600.0n 0.5000 39899.9n 0.5000 39900.0n 0.5000 40199.9n 0.5000 40200.0n 0.5000 40499.9n 0.5000 40500.0n 0.5000 40799.9n 0.5000 40800.0n 0.5000 41099.9n 0.5000 41100.0n 0.5000 41399.9n 0.5000 41400.0n 0.5000 41699.9n 0.5000 41700.0n 0.5000 41999.9n 0.5000 42000.0n 0.5000 42299.9n 0.5000 42300.0n 0.5000 42599.9n 0.5000 42600.0n 0.5000 42899.9n 0.5000 42900.0n 0.5000 43199.9n 0.5000 43200.0n 0.5000 43499.9n 0.5000 43500.0n 0.5000 43799.9n 0.5000 43800.0n 0.5000 44099.9n 0.5000 44100.0n 0.5000 44399.9n 0.5000 44400.0n 0.5000 44699.9n 0.5000 44700.0n 0.5000 44999.9n 0.5000 45000.0n 0.5000 45299.9n 0.5000 45300.0n 0.5000 45599.9n 0.5000 45600.0n 0.5000 45899.9n 0.5000 45900.0n 0.5000 46199.9n 0.5000 46200.0n 0.5000 46499.9n 0.5000 46500.0n 0.5000 46799.9n 0.5000 46800.0n 0.5000 47099.9n 0.5000 47100.0n 0.5000 47399.9n 0.5000 47400.0n 0.5000 47699.9n 0.5000 47700.0n 0.5000 47999.9n 0.5000 48000.0n 0.5000 48299.9n 0.5000 48300.0n 0.5000 48599.9n 0.5000 48600.0n 0.5000 48899.9n 0.5000 48900.0n 0.5000 49199.9n 0.5000 49200.0n 0.5000 49499.9n 0.5000 49500.0n 0.5000 49799.9n 0.5000 49800.0n 0.5000 50099.9n 0.5000 50100.0n 0.5000 50399.9n 0.5000 50400.0n 0.5000 50699.9n 0.5000 50700.0n 0.5000 50999.9n 0.5000 51000.0n 0.5000 51299.9n 0.5000 51300.0n 0.5000 51599.9n 0.5000 51600.0n 0.5000 51899.9n 0.5000 51900.0n 0.5000 52199.9n 0.5000 52200.0n 0.5000 52499.9n 0.5000 52500.0n 0.5000 52799.9n 0.5000 52800.0n 0.5000 53099.9n 0.5000 53100.0n 0.5000 53399.9n 0.5000 53400.0n 0.5000 53699.9n 0.5000 53700.0n 0.5000 53999.9n 0.5000 54000.0n 0.5000 54299.9n 0.5000 54300.0n 0.5000 54599.9n 0.5000 54600.0n 0.5000 54899.9n 0.5000 54900.0n 0.5000 55199.9n 0.5000 55200.0n 0.5000 55499.9n 0.5000 55500.0n 0.5000 55799.9n 0.5000 55800.0n 0.5000 56099.9n 0.5000 56100.0n 0.5000 56399.9n 0.5000 56400.0n 0.5000 56699.9n 0.5000 56700.0n 0.5000 56999.9n 0.5000 57000.0n 0.5000 57299.9n 0.5000 57300.0n 0.5000 57599.9n 0.5000 57600.0n 0.5000 57899.9n 0.5000 57900.0n 0.5000 58199.9n 0.5000 58200.0n 0.5000 58499.9n 0.5000 58500.0n 0.5000 58799.9n 0.5000 58800.0n 0.5000 59099.9n 0.5000 59100.0n 0.5000)
Vxp40 a_xp40 0 PWL(0.0n 0.4939 299.9n 0.4939 300.0n 0.4939 599.9n 0.4939 600.0n 0.4939 899.9n 0.4939 900.0n 0.4939 1199.9n 0.4939 1200.0n 0.4939 1499.9n 0.4939 1500.0n 0.4939 1799.9n 0.4939 1800.0n 0.4939 2099.9n 0.4939 2100.0n 0.4939 2399.9n 0.4939 2400.0n 0.4939 2699.9n 0.4939 2700.0n 0.4939 2999.9n 0.4939 3000.0n 0.4939 3299.9n 0.4939 3300.0n 0.4939 3599.9n 0.4939 3600.0n 0.4939 3899.9n 0.4939 3900.0n 0.4939 4199.9n 0.4939 4200.0n 0.4939 4499.9n 0.4939 4500.0n 0.4939 4799.9n 0.4939 4800.0n 0.4939 5099.9n 0.4939 5100.0n 0.4939 5399.9n 0.4939 5400.0n 0.4939 5699.9n 0.4939 5700.0n 0.4939 5999.9n 0.4939 6000.0n 0.4939 6299.9n 0.4939 6300.0n 0.4939 6599.9n 0.4939 6600.0n 0.4939 6899.9n 0.4939 6900.0n 0.4939 7199.9n 0.4939 7200.0n 0.4939 7499.9n 0.4939 7500.0n 0.4939 7799.9n 0.4939 7800.0n 0.4939 8099.9n 0.4939 8100.0n 0.4939 8399.9n 0.4939 8400.0n 0.4939 8699.9n 0.4939 8700.0n 0.4939 8999.9n 0.4939 9000.0n 0.4939 9299.9n 0.4939 9300.0n 0.4939 9599.9n 0.4939 9600.0n 0.4939 9899.9n 0.4939 9900.0n 0.4939 10199.9n 0.4939 10200.0n 0.4939 10499.9n 0.4939 10500.0n 0.4939 10799.9n 0.4939 10800.0n 0.4939 11099.9n 0.4939 11100.0n 0.4939 11399.9n 0.4939 11400.0n 0.4939 11699.9n 0.4939 11700.0n 0.4939 11999.9n 0.4939 12000.0n 0.4939 12299.9n 0.4939 12300.0n 0.4939 12599.9n 0.4939 12600.0n 0.4939 12899.9n 0.4939 12900.0n 0.4939 13199.9n 0.4939 13200.0n 0.4939 13499.9n 0.4939 13500.0n 0.4939 13799.9n 0.4939 13800.0n 0.4939 14099.9n 0.4939 14100.0n 0.4939 14399.9n 0.4939 14400.0n 0.4939 14699.9n 0.4939 14700.0n 0.4939 14999.9n 0.4939 15000.0n 0.4939 15299.9n 0.4939 15300.0n 0.4939 15599.9n 0.4939 15600.0n 0.4939 15899.9n 0.4939 15900.0n 0.4939 16199.9n 0.4939 16200.0n 0.4939 16499.9n 0.4939 16500.0n 0.4939 16799.9n 0.4939 16800.0n 0.4939 17099.9n 0.4939 17100.0n 0.4939 17399.9n 0.4939 17400.0n 0.4939 17699.9n 0.4939 17700.0n 0.4939 17999.9n 0.4939 18000.0n 0.4939 18299.9n 0.4939 18300.0n 0.4939 18599.9n 0.4939 18600.0n 0.4939 18899.9n 0.4939 18900.0n 0.4939 19199.9n 0.4939 19200.0n 0.4939 19499.9n 0.4939 19500.0n 0.4939 19799.9n 0.4939 19800.0n 0.4939 20099.9n 0.4939 20100.0n 0.4939 20399.9n 0.4939 20400.0n 0.4939 20699.9n 0.4939 20700.0n 0.4939 20999.9n 0.4939 21000.0n 0.4939 21299.9n 0.4939 21300.0n 0.4939 21599.9n 0.4939 21600.0n 0.4939 21899.9n 0.4939 21900.0n 0.4939 22199.9n 0.4939 22200.0n 0.4939 22499.9n 0.4939 22500.0n 0.4939 22799.9n 0.4939 22800.0n 0.4939 23099.9n 0.4939 23100.0n 0.4939 23399.9n 0.4939 23400.0n 0.4939 23699.9n 0.4939 23700.0n 0.4939 23999.9n 0.4939 24000.0n 0.4939 24299.9n 0.4939 24300.0n 0.4939 24599.9n 0.4939 24600.0n 0.4939 24899.9n 0.4939 24900.0n 0.4939 25199.9n 0.4939 25200.0n 0.4939 25499.9n 0.4939 25500.0n 0.4939 25799.9n 0.4939 25800.0n 0.4939 26099.9n 0.4939 26100.0n 0.4939 26399.9n 0.4939 26400.0n 0.4939 26699.9n 0.4939 26700.0n 0.4939 26999.9n 0.4939 27000.0n 0.4939 27299.9n 0.4939 27300.0n 0.4939 27599.9n 0.4939 27600.0n 0.4939 27899.9n 0.4939 27900.0n 0.4939 28199.9n 0.4939 28200.0n 0.4939 28499.9n 0.4939 28500.0n 0.4939 28799.9n 0.4939 28800.0n 0.4939 29099.9n 0.4939 29100.0n 0.4939 29399.9n 0.4939 29400.0n 0.4939 29699.9n 0.4939 29700.0n 0.4939 29999.9n 0.4939 30000.0n 0.4939 30299.9n 0.4939 30300.0n 0.4939 30599.9n 0.4939 30600.0n 0.4939 30899.9n 0.4939 30900.0n 0.4939 31199.9n 0.4939 31200.0n 0.4939 31499.9n 0.4939 31500.0n 0.4939 31799.9n 0.4939 31800.0n 0.4939 32099.9n 0.4939 32100.0n 0.4939 32399.9n 0.4939 32400.0n 0.4939 32699.9n 0.4939 32700.0n 0.4939 32999.9n 0.4939 33000.0n 0.4939 33299.9n 0.4939 33300.0n 0.4939 33599.9n 0.4939 33600.0n 0.4939 33899.9n 0.4939 33900.0n 0.4939 34199.9n 0.4939 34200.0n 0.4939 34499.9n 0.4939 34500.0n 0.4939 34799.9n 0.4939 34800.0n 0.4939 35099.9n 0.4939 35100.0n 0.4939 35399.9n 0.4939 35400.0n 0.4939 35699.9n 0.4939 35700.0n 0.4939 35999.9n 0.4939 36000.0n 0.4939 36299.9n 0.4939 36300.0n 0.4939 36599.9n 0.4939 36600.0n 0.4939 36899.9n 0.4939 36900.0n 0.4939 37199.9n 0.4939 37200.0n 0.4939 37499.9n 0.4939 37500.0n 0.4939 37799.9n 0.4939 37800.0n 0.4939 38099.9n 0.4939 38100.0n 0.4939 38399.9n 0.4939 38400.0n 0.4939 38699.9n 0.4939 38700.0n 0.4939 38999.9n 0.4939 39000.0n 0.4939 39299.9n 0.4939 39300.0n 0.4939 39599.9n 0.4939 39600.0n 0.4939 39899.9n 0.4939 39900.0n 0.4939 40199.9n 0.4939 40200.0n 0.4939 40499.9n 0.4939 40500.0n 0.4939 40799.9n 0.4939 40800.0n 0.4939 41099.9n 0.4939 41100.0n 0.4939 41399.9n 0.4939 41400.0n 0.4939 41699.9n 0.4939 41700.0n 0.4939 41999.9n 0.4939 42000.0n 0.4939 42299.9n 0.4939 42300.0n 0.4939 42599.9n 0.4939 42600.0n 0.4939 42899.9n 0.4939 42900.0n 0.4939 43199.9n 0.4939 43200.0n 0.4939 43499.9n 0.4939 43500.0n 0.4939 43799.9n 0.4939 43800.0n 0.4939 44099.9n 0.4939 44100.0n 0.4939 44399.9n 0.4939 44400.0n 0.4939 44699.9n 0.4939 44700.0n 0.4939 44999.9n 0.4939 45000.0n 0.4939 45299.9n 0.4939 45300.0n 0.4939 45599.9n 0.4939 45600.0n 0.4939 45899.9n 0.4939 45900.0n 0.4939 46199.9n 0.4939 46200.0n 0.4939 46499.9n 0.4939 46500.0n 0.4939 46799.9n 0.4939 46800.0n 0.4939 47099.9n 0.4939 47100.0n 0.4939 47399.9n 0.4939 47400.0n 0.4939 47699.9n 0.4939 47700.0n 0.4939 47999.9n 0.4939 48000.0n 0.4939 48299.9n 0.4939 48300.0n 0.4939 48599.9n 0.4939 48600.0n 0.4939 48899.9n 0.4939 48900.0n 0.4939 49199.9n 0.4939 49200.0n 0.4939 49499.9n 0.4939 49500.0n 0.4939 49799.9n 0.4939 49800.0n 0.4939 50099.9n 0.4939 50100.0n 0.4939 50399.9n 0.4939 50400.0n 0.4939 50699.9n 0.4939 50700.0n 0.4939 50999.9n 0.4939 51000.0n 0.4939 51299.9n 0.4939 51300.0n 0.4939 51599.9n 0.4939 51600.0n 0.4939 51899.9n 0.4939 51900.0n 0.4939 52199.9n 0.4939 52200.0n 0.4939 52499.9n 0.4939 52500.0n 0.4939 52799.9n 0.4939 52800.0n 0.4939 53099.9n 0.4939 53100.0n 0.4939 53399.9n 0.4939 53400.0n 0.4939 53699.9n 0.4939 53700.0n 0.4939 53999.9n 0.4939 54000.0n 0.4939 54299.9n 0.4939 54300.0n 0.4939 54599.9n 0.4939 54600.0n 0.4939 54899.9n 0.4939 54900.0n 0.4939 55199.9n 0.4939 55200.0n 0.4939 55499.9n 0.4939 55500.0n 0.4939 55799.9n 0.4939 55800.0n 0.4939 56099.9n 0.4939 56100.0n 0.4939 56399.9n 0.4939 56400.0n 0.4939 56699.9n 0.4939 56700.0n 0.4939 56999.9n 0.4939 57000.0n 0.4939 57299.9n 0.4939 57300.0n 0.4939 57599.9n 0.4939 57600.0n 0.4939 57899.9n 0.4939 57900.0n 0.4939 58199.9n 0.4939 58200.0n 0.4939 58499.9n 0.4939 58500.0n 0.4939 58799.9n 0.4939 58800.0n 0.4939 59099.9n 0.4939 59100.0n 0.4939)
Vxn40 a_xn40 0 PWL(0.0n 0.5061 299.9n 0.5061 300.0n 0.5061 599.9n 0.5061 600.0n 0.5061 899.9n 0.5061 900.0n 0.5061 1199.9n 0.5061 1200.0n 0.5061 1499.9n 0.5061 1500.0n 0.5061 1799.9n 0.5061 1800.0n 0.5061 2099.9n 0.5061 2100.0n 0.5061 2399.9n 0.5061 2400.0n 0.5061 2699.9n 0.5061 2700.0n 0.5061 2999.9n 0.5061 3000.0n 0.5061 3299.9n 0.5061 3300.0n 0.5061 3599.9n 0.5061 3600.0n 0.5061 3899.9n 0.5061 3900.0n 0.5061 4199.9n 0.5061 4200.0n 0.5061 4499.9n 0.5061 4500.0n 0.5061 4799.9n 0.5061 4800.0n 0.5061 5099.9n 0.5061 5100.0n 0.5061 5399.9n 0.5061 5400.0n 0.5061 5699.9n 0.5061 5700.0n 0.5061 5999.9n 0.5061 6000.0n 0.5061 6299.9n 0.5061 6300.0n 0.5061 6599.9n 0.5061 6600.0n 0.5061 6899.9n 0.5061 6900.0n 0.5061 7199.9n 0.5061 7200.0n 0.5061 7499.9n 0.5061 7500.0n 0.5061 7799.9n 0.5061 7800.0n 0.5061 8099.9n 0.5061 8100.0n 0.5061 8399.9n 0.5061 8400.0n 0.5061 8699.9n 0.5061 8700.0n 0.5061 8999.9n 0.5061 9000.0n 0.5061 9299.9n 0.5061 9300.0n 0.5061 9599.9n 0.5061 9600.0n 0.5061 9899.9n 0.5061 9900.0n 0.5061 10199.9n 0.5061 10200.0n 0.5061 10499.9n 0.5061 10500.0n 0.5061 10799.9n 0.5061 10800.0n 0.5061 11099.9n 0.5061 11100.0n 0.5061 11399.9n 0.5061 11400.0n 0.5061 11699.9n 0.5061 11700.0n 0.5061 11999.9n 0.5061 12000.0n 0.5061 12299.9n 0.5061 12300.0n 0.5061 12599.9n 0.5061 12600.0n 0.5061 12899.9n 0.5061 12900.0n 0.5061 13199.9n 0.5061 13200.0n 0.5061 13499.9n 0.5061 13500.0n 0.5061 13799.9n 0.5061 13800.0n 0.5061 14099.9n 0.5061 14100.0n 0.5061 14399.9n 0.5061 14400.0n 0.5061 14699.9n 0.5061 14700.0n 0.5061 14999.9n 0.5061 15000.0n 0.5061 15299.9n 0.5061 15300.0n 0.5061 15599.9n 0.5061 15600.0n 0.5061 15899.9n 0.5061 15900.0n 0.5061 16199.9n 0.5061 16200.0n 0.5061 16499.9n 0.5061 16500.0n 0.5061 16799.9n 0.5061 16800.0n 0.5061 17099.9n 0.5061 17100.0n 0.5061 17399.9n 0.5061 17400.0n 0.5061 17699.9n 0.5061 17700.0n 0.5061 17999.9n 0.5061 18000.0n 0.5061 18299.9n 0.5061 18300.0n 0.5061 18599.9n 0.5061 18600.0n 0.5061 18899.9n 0.5061 18900.0n 0.5061 19199.9n 0.5061 19200.0n 0.5061 19499.9n 0.5061 19500.0n 0.5061 19799.9n 0.5061 19800.0n 0.5061 20099.9n 0.5061 20100.0n 0.5061 20399.9n 0.5061 20400.0n 0.5061 20699.9n 0.5061 20700.0n 0.5061 20999.9n 0.5061 21000.0n 0.5061 21299.9n 0.5061 21300.0n 0.5061 21599.9n 0.5061 21600.0n 0.5061 21899.9n 0.5061 21900.0n 0.5061 22199.9n 0.5061 22200.0n 0.5061 22499.9n 0.5061 22500.0n 0.5061 22799.9n 0.5061 22800.0n 0.5061 23099.9n 0.5061 23100.0n 0.5061 23399.9n 0.5061 23400.0n 0.5061 23699.9n 0.5061 23700.0n 0.5061 23999.9n 0.5061 24000.0n 0.5061 24299.9n 0.5061 24300.0n 0.5061 24599.9n 0.5061 24600.0n 0.5061 24899.9n 0.5061 24900.0n 0.5061 25199.9n 0.5061 25200.0n 0.5061 25499.9n 0.5061 25500.0n 0.5061 25799.9n 0.5061 25800.0n 0.5061 26099.9n 0.5061 26100.0n 0.5061 26399.9n 0.5061 26400.0n 0.5061 26699.9n 0.5061 26700.0n 0.5061 26999.9n 0.5061 27000.0n 0.5061 27299.9n 0.5061 27300.0n 0.5061 27599.9n 0.5061 27600.0n 0.5061 27899.9n 0.5061 27900.0n 0.5061 28199.9n 0.5061 28200.0n 0.5061 28499.9n 0.5061 28500.0n 0.5061 28799.9n 0.5061 28800.0n 0.5061 29099.9n 0.5061 29100.0n 0.5061 29399.9n 0.5061 29400.0n 0.5061 29699.9n 0.5061 29700.0n 0.5061 29999.9n 0.5061 30000.0n 0.5061 30299.9n 0.5061 30300.0n 0.5061 30599.9n 0.5061 30600.0n 0.5061 30899.9n 0.5061 30900.0n 0.5061 31199.9n 0.5061 31200.0n 0.5061 31499.9n 0.5061 31500.0n 0.5061 31799.9n 0.5061 31800.0n 0.5061 32099.9n 0.5061 32100.0n 0.5061 32399.9n 0.5061 32400.0n 0.5061 32699.9n 0.5061 32700.0n 0.5061 32999.9n 0.5061 33000.0n 0.5061 33299.9n 0.5061 33300.0n 0.5061 33599.9n 0.5061 33600.0n 0.5061 33899.9n 0.5061 33900.0n 0.5061 34199.9n 0.5061 34200.0n 0.5061 34499.9n 0.5061 34500.0n 0.5061 34799.9n 0.5061 34800.0n 0.5061 35099.9n 0.5061 35100.0n 0.5061 35399.9n 0.5061 35400.0n 0.5061 35699.9n 0.5061 35700.0n 0.5061 35999.9n 0.5061 36000.0n 0.5061 36299.9n 0.5061 36300.0n 0.5061 36599.9n 0.5061 36600.0n 0.5061 36899.9n 0.5061 36900.0n 0.5061 37199.9n 0.5061 37200.0n 0.5061 37499.9n 0.5061 37500.0n 0.5061 37799.9n 0.5061 37800.0n 0.5061 38099.9n 0.5061 38100.0n 0.5061 38399.9n 0.5061 38400.0n 0.5061 38699.9n 0.5061 38700.0n 0.5061 38999.9n 0.5061 39000.0n 0.5061 39299.9n 0.5061 39300.0n 0.5061 39599.9n 0.5061 39600.0n 0.5061 39899.9n 0.5061 39900.0n 0.5061 40199.9n 0.5061 40200.0n 0.5061 40499.9n 0.5061 40500.0n 0.5061 40799.9n 0.5061 40800.0n 0.5061 41099.9n 0.5061 41100.0n 0.5061 41399.9n 0.5061 41400.0n 0.5061 41699.9n 0.5061 41700.0n 0.5061 41999.9n 0.5061 42000.0n 0.5061 42299.9n 0.5061 42300.0n 0.5061 42599.9n 0.5061 42600.0n 0.5061 42899.9n 0.5061 42900.0n 0.5061 43199.9n 0.5061 43200.0n 0.5061 43499.9n 0.5061 43500.0n 0.5061 43799.9n 0.5061 43800.0n 0.5061 44099.9n 0.5061 44100.0n 0.5061 44399.9n 0.5061 44400.0n 0.5061 44699.9n 0.5061 44700.0n 0.5061 44999.9n 0.5061 45000.0n 0.5061 45299.9n 0.5061 45300.0n 0.5061 45599.9n 0.5061 45600.0n 0.5061 45899.9n 0.5061 45900.0n 0.5061 46199.9n 0.5061 46200.0n 0.5061 46499.9n 0.5061 46500.0n 0.5061 46799.9n 0.5061 46800.0n 0.5061 47099.9n 0.5061 47100.0n 0.5061 47399.9n 0.5061 47400.0n 0.5061 47699.9n 0.5061 47700.0n 0.5061 47999.9n 0.5061 48000.0n 0.5061 48299.9n 0.5061 48300.0n 0.5061 48599.9n 0.5061 48600.0n 0.5061 48899.9n 0.5061 48900.0n 0.5061 49199.9n 0.5061 49200.0n 0.5061 49499.9n 0.5061 49500.0n 0.5061 49799.9n 0.5061 49800.0n 0.5061 50099.9n 0.5061 50100.0n 0.5061 50399.9n 0.5061 50400.0n 0.5061 50699.9n 0.5061 50700.0n 0.5061 50999.9n 0.5061 51000.0n 0.5061 51299.9n 0.5061 51300.0n 0.5061 51599.9n 0.5061 51600.0n 0.5061 51899.9n 0.5061 51900.0n 0.5061 52199.9n 0.5061 52200.0n 0.5061 52499.9n 0.5061 52500.0n 0.5061 52799.9n 0.5061 52800.0n 0.5061 53099.9n 0.5061 53100.0n 0.5061 53399.9n 0.5061 53400.0n 0.5061 53699.9n 0.5061 53700.0n 0.5061 53999.9n 0.5061 54000.0n 0.5061 54299.9n 0.5061 54300.0n 0.5061 54599.9n 0.5061 54600.0n 0.5061 54899.9n 0.5061 54900.0n 0.5061 55199.9n 0.5061 55200.0n 0.5061 55499.9n 0.5061 55500.0n 0.5061 55799.9n 0.5061 55800.0n 0.5061 56099.9n 0.5061 56100.0n 0.5061 56399.9n 0.5061 56400.0n 0.5061 56699.9n 0.5061 56700.0n 0.5061 56999.9n 0.5061 57000.0n 0.5061 57299.9n 0.5061 57300.0n 0.5061 57599.9n 0.5061 57600.0n 0.5061 57899.9n 0.5061 57900.0n 0.5061 58199.9n 0.5061 58200.0n 0.5061 58499.9n 0.5061 58500.0n 0.5061 58799.9n 0.5061 58800.0n 0.5061 59099.9n 0.5061 59100.0n 0.5061)
Vxp41 a_xp41 0 PWL(0.0n 0.4469 299.9n 0.4469 300.0n 0.6481 599.9n 0.6481 600.0n 0.5811 899.9n 0.5811 900.0n 0.6481 1199.9n 0.6481 1200.0n 0.4469 1499.9n 0.4469 1500.0n 0.5140 1799.9n 0.5140 1800.0n 0.5140 2099.9n 0.5140 2100.0n 0.4469 2399.9n 0.4469 2400.0n 0.4469 2699.9n 0.4469 2700.0n 0.4469 2999.9n 0.4469 3000.0n 0.4469 3299.9n 0.4469 3300.0n 0.4804 3599.9n 0.4804 3600.0n 0.4469 3899.9n 0.4469 3900.0n 0.4469 4199.9n 0.4469 4200.0n 0.4469 4499.9n 0.4469 4500.0n 0.4469 4799.9n 0.4469 4800.0n 0.4469 5099.9n 0.4469 5100.0n 0.6146 5399.9n 0.6146 5400.0n 0.4469 5699.9n 0.4469 5700.0n 0.6481 5999.9n 0.6481 6000.0n 0.5811 6299.9n 0.5811 6300.0n 0.6481 6599.9n 0.6481 6600.0n 0.4469 6899.9n 0.4469 6900.0n 0.5140 7199.9n 0.5140 7200.0n 0.5140 7499.9n 0.5140 7500.0n 0.4469 7799.9n 0.4469 7800.0n 0.4469 8099.9n 0.4469 8100.0n 0.4469 8399.9n 0.4469 8400.0n 0.4469 8699.9n 0.4469 8700.0n 0.4804 8999.9n 0.4804 9000.0n 0.4469 9299.9n 0.4469 9300.0n 0.4469 9599.9n 0.4469 9600.0n 0.4469 9899.9n 0.4469 9900.0n 0.4469 10199.9n 0.4469 10200.0n 0.4469 10499.9n 0.4469 10500.0n 0.6146 10799.9n 0.6146 10800.0n 0.4469 11099.9n 0.4469 11100.0n 0.6481 11399.9n 0.6481 11400.0n 0.5811 11699.9n 0.5811 11700.0n 0.6481 11999.9n 0.6481 12000.0n 0.4469 12299.9n 0.4469 12300.0n 0.5140 12599.9n 0.5140 12600.0n 0.5140 12899.9n 0.5140 12900.0n 0.4469 13199.9n 0.4469 13200.0n 0.4469 13499.9n 0.4469 13500.0n 0.4469 13799.9n 0.4469 13800.0n 0.4469 14099.9n 0.4469 14100.0n 0.4804 14399.9n 0.4804 14400.0n 0.4469 14699.9n 0.4469 14700.0n 0.4469 14999.9n 0.4469 15000.0n 0.4469 15299.9n 0.4469 15300.0n 0.4469 15599.9n 0.4469 15600.0n 0.4469 15899.9n 0.4469 15900.0n 0.6146 16199.9n 0.6146 16200.0n 0.4469 16499.9n 0.4469 16500.0n 0.6481 16799.9n 0.6481 16800.0n 0.5811 17099.9n 0.5811 17100.0n 0.6481 17399.9n 0.6481 17400.0n 0.4469 17699.9n 0.4469 17700.0n 0.5140 17999.9n 0.5140 18000.0n 0.5140 18299.9n 0.5140 18300.0n 0.4469 18599.9n 0.4469 18600.0n 0.4469 18899.9n 0.4469 18900.0n 0.4469 19199.9n 0.4469 19200.0n 0.4469 19499.9n 0.4469 19500.0n 0.4804 19799.9n 0.4804 19800.0n 0.4469 20099.9n 0.4469 20100.0n 0.4469 20399.9n 0.4469 20400.0n 0.4469 20699.9n 0.4469 20700.0n 0.4469 20999.9n 0.4469 21000.0n 0.4469 21299.9n 0.4469 21300.0n 0.6146 21599.9n 0.6146 21600.0n 0.4469 21899.9n 0.4469 21900.0n 0.6481 22199.9n 0.6481 22200.0n 0.5811 22499.9n 0.5811 22500.0n 0.6481 22799.9n 0.6481 22800.0n 0.4469 23099.9n 0.4469 23100.0n 0.5140 23399.9n 0.5140 23400.0n 0.5140 23699.9n 0.5140 23700.0n 0.4469 23999.9n 0.4469 24000.0n 0.4469 24299.9n 0.4469 24300.0n 0.4469 24599.9n 0.4469 24600.0n 0.4469 24899.9n 0.4469 24900.0n 0.4804 25199.9n 0.4804 25200.0n 0.4469 25499.9n 0.4469 25500.0n 0.4469 25799.9n 0.4469 25800.0n 0.4469 26099.9n 0.4469 26100.0n 0.4469 26399.9n 0.4469 26400.0n 0.4469 26699.9n 0.4469 26700.0n 0.6146 26999.9n 0.6146 27000.0n 0.4469 27299.9n 0.4469 27300.0n 0.6481 27599.9n 0.6481 27600.0n 0.5811 27899.9n 0.5811 27900.0n 0.6481 28199.9n 0.6481 28200.0n 0.4469 28499.9n 0.4469 28500.0n 0.5140 28799.9n 0.5140 28800.0n 0.5140 29099.9n 0.5140 29100.0n 0.4469 29399.9n 0.4469 29400.0n 0.4469 29699.9n 0.4469 29700.0n 0.4469 29999.9n 0.4469 30000.0n 0.4469 30299.9n 0.4469 30300.0n 0.4804 30599.9n 0.4804 30600.0n 0.4469 30899.9n 0.4469 30900.0n 0.4469 31199.9n 0.4469 31200.0n 0.4469 31499.9n 0.4469 31500.0n 0.4469 31799.9n 0.4469 31800.0n 0.4469 32099.9n 0.4469 32100.0n 0.6146 32399.9n 0.6146 32400.0n 0.4469 32699.9n 0.4469 32700.0n 0.6481 32999.9n 0.6481 33000.0n 0.5811 33299.9n 0.5811 33300.0n 0.6481 33599.9n 0.6481 33600.0n 0.4469 33899.9n 0.4469 33900.0n 0.5140 34199.9n 0.5140 34200.0n 0.5140 34499.9n 0.5140 34500.0n 0.4469 34799.9n 0.4469 34800.0n 0.4469 35099.9n 0.4469 35100.0n 0.4469 35399.9n 0.4469 35400.0n 0.4469 35699.9n 0.4469 35700.0n 0.4804 35999.9n 0.4804 36000.0n 0.4469 36299.9n 0.4469 36300.0n 0.4469 36599.9n 0.4469 36600.0n 0.4469 36899.9n 0.4469 36900.0n 0.4469 37199.9n 0.4469 37200.0n 0.4469 37499.9n 0.4469 37500.0n 0.6146 37799.9n 0.6146 37800.0n 0.4469 38099.9n 0.4469 38100.0n 0.6481 38399.9n 0.6481 38400.0n 0.5811 38699.9n 0.5811 38700.0n 0.6481 38999.9n 0.6481 39000.0n 0.4469 39299.9n 0.4469 39300.0n 0.5140 39599.9n 0.5140 39600.0n 0.5140 39899.9n 0.5140 39900.0n 0.4469 40199.9n 0.4469 40200.0n 0.4469 40499.9n 0.4469 40500.0n 0.4469 40799.9n 0.4469 40800.0n 0.4469 41099.9n 0.4469 41100.0n 0.4804 41399.9n 0.4804 41400.0n 0.4469 41699.9n 0.4469 41700.0n 0.4469 41999.9n 0.4469 42000.0n 0.4469 42299.9n 0.4469 42300.0n 0.4469 42599.9n 0.4469 42600.0n 0.4469 42899.9n 0.4469 42900.0n 0.6146 43199.9n 0.6146 43200.0n 0.4469 43499.9n 0.4469 43500.0n 0.6481 43799.9n 0.6481 43800.0n 0.5811 44099.9n 0.5811 44100.0n 0.6481 44399.9n 0.6481 44400.0n 0.4469 44699.9n 0.4469 44700.0n 0.5140 44999.9n 0.5140 45000.0n 0.5140 45299.9n 0.5140 45300.0n 0.4469 45599.9n 0.4469 45600.0n 0.4469 45899.9n 0.4469 45900.0n 0.4469 46199.9n 0.4469 46200.0n 0.4469 46499.9n 0.4469 46500.0n 0.4804 46799.9n 0.4804 46800.0n 0.4469 47099.9n 0.4469 47100.0n 0.4469 47399.9n 0.4469 47400.0n 0.4469 47699.9n 0.4469 47700.0n 0.4469 47999.9n 0.4469 48000.0n 0.4469 48299.9n 0.4469 48300.0n 0.6146 48599.9n 0.6146 48600.0n 0.4469 48899.9n 0.4469 48900.0n 0.6481 49199.9n 0.6481 49200.0n 0.5811 49499.9n 0.5811 49500.0n 0.6481 49799.9n 0.6481 49800.0n 0.4469 50099.9n 0.4469 50100.0n 0.5140 50399.9n 0.5140 50400.0n 0.5140 50699.9n 0.5140 50700.0n 0.4469 50999.9n 0.4469 51000.0n 0.4469 51299.9n 0.4469 51300.0n 0.4469 51599.9n 0.4469 51600.0n 0.4469 51899.9n 0.4469 51900.0n 0.4804 52199.9n 0.4804 52200.0n 0.4469 52499.9n 0.4469 52500.0n 0.4469 52799.9n 0.4469 52800.0n 0.4469 53099.9n 0.4469 53100.0n 0.4469 53399.9n 0.4469 53400.0n 0.4469 53699.9n 0.4469 53700.0n 0.6146 53999.9n 0.6146 54000.0n 0.4469 54299.9n 0.4469 54300.0n 0.5475 54599.9n 0.5475 54600.0n 0.6817 54899.9n 0.6817 54900.0n 0.5811 55199.9n 0.5811 55200.0n 0.4804 55499.9n 0.4804 55500.0n 0.5811 55799.9n 0.5811 55800.0n 0.4469 56099.9n 0.4469 56100.0n 0.4469 56399.9n 0.4469 56400.0n 0.5475 56699.9n 0.5475 56700.0n 0.4469 56999.9n 0.4469 57000.0n 0.4469 57299.9n 0.4469 57300.0n 0.5811 57599.9n 0.5811 57600.0n 0.4469 57899.9n 0.4469 57900.0n 0.4469 58199.9n 0.4469 58200.0n 0.4469 58499.9n 0.4469 58500.0n 0.4804 58799.9n 0.4804 58800.0n 0.4469 59099.9n 0.4469 59100.0n 0.4469)
Vxn41 a_xn41 0 PWL(0.0n 0.5531 299.9n 0.5531 300.0n 0.3519 599.9n 0.3519 600.0n 0.4189 899.9n 0.4189 900.0n 0.3519 1199.9n 0.3519 1200.0n 0.5531 1499.9n 0.5531 1500.0n 0.4860 1799.9n 0.4860 1800.0n 0.4860 2099.9n 0.4860 2100.0n 0.5531 2399.9n 0.5531 2400.0n 0.5531 2699.9n 0.5531 2700.0n 0.5531 2999.9n 0.5531 3000.0n 0.5531 3299.9n 0.5531 3300.0n 0.5196 3599.9n 0.5196 3600.0n 0.5531 3899.9n 0.5531 3900.0n 0.5531 4199.9n 0.5531 4200.0n 0.5531 4499.9n 0.5531 4500.0n 0.5531 4799.9n 0.5531 4800.0n 0.5531 5099.9n 0.5531 5100.0n 0.3854 5399.9n 0.3854 5400.0n 0.5531 5699.9n 0.5531 5700.0n 0.3519 5999.9n 0.3519 6000.0n 0.4189 6299.9n 0.4189 6300.0n 0.3519 6599.9n 0.3519 6600.0n 0.5531 6899.9n 0.5531 6900.0n 0.4860 7199.9n 0.4860 7200.0n 0.4860 7499.9n 0.4860 7500.0n 0.5531 7799.9n 0.5531 7800.0n 0.5531 8099.9n 0.5531 8100.0n 0.5531 8399.9n 0.5531 8400.0n 0.5531 8699.9n 0.5531 8700.0n 0.5196 8999.9n 0.5196 9000.0n 0.5531 9299.9n 0.5531 9300.0n 0.5531 9599.9n 0.5531 9600.0n 0.5531 9899.9n 0.5531 9900.0n 0.5531 10199.9n 0.5531 10200.0n 0.5531 10499.9n 0.5531 10500.0n 0.3854 10799.9n 0.3854 10800.0n 0.5531 11099.9n 0.5531 11100.0n 0.3519 11399.9n 0.3519 11400.0n 0.4189 11699.9n 0.4189 11700.0n 0.3519 11999.9n 0.3519 12000.0n 0.5531 12299.9n 0.5531 12300.0n 0.4860 12599.9n 0.4860 12600.0n 0.4860 12899.9n 0.4860 12900.0n 0.5531 13199.9n 0.5531 13200.0n 0.5531 13499.9n 0.5531 13500.0n 0.5531 13799.9n 0.5531 13800.0n 0.5531 14099.9n 0.5531 14100.0n 0.5196 14399.9n 0.5196 14400.0n 0.5531 14699.9n 0.5531 14700.0n 0.5531 14999.9n 0.5531 15000.0n 0.5531 15299.9n 0.5531 15300.0n 0.5531 15599.9n 0.5531 15600.0n 0.5531 15899.9n 0.5531 15900.0n 0.3854 16199.9n 0.3854 16200.0n 0.5531 16499.9n 0.5531 16500.0n 0.3519 16799.9n 0.3519 16800.0n 0.4189 17099.9n 0.4189 17100.0n 0.3519 17399.9n 0.3519 17400.0n 0.5531 17699.9n 0.5531 17700.0n 0.4860 17999.9n 0.4860 18000.0n 0.4860 18299.9n 0.4860 18300.0n 0.5531 18599.9n 0.5531 18600.0n 0.5531 18899.9n 0.5531 18900.0n 0.5531 19199.9n 0.5531 19200.0n 0.5531 19499.9n 0.5531 19500.0n 0.5196 19799.9n 0.5196 19800.0n 0.5531 20099.9n 0.5531 20100.0n 0.5531 20399.9n 0.5531 20400.0n 0.5531 20699.9n 0.5531 20700.0n 0.5531 20999.9n 0.5531 21000.0n 0.5531 21299.9n 0.5531 21300.0n 0.3854 21599.9n 0.3854 21600.0n 0.5531 21899.9n 0.5531 21900.0n 0.3519 22199.9n 0.3519 22200.0n 0.4189 22499.9n 0.4189 22500.0n 0.3519 22799.9n 0.3519 22800.0n 0.5531 23099.9n 0.5531 23100.0n 0.4860 23399.9n 0.4860 23400.0n 0.4860 23699.9n 0.4860 23700.0n 0.5531 23999.9n 0.5531 24000.0n 0.5531 24299.9n 0.5531 24300.0n 0.5531 24599.9n 0.5531 24600.0n 0.5531 24899.9n 0.5531 24900.0n 0.5196 25199.9n 0.5196 25200.0n 0.5531 25499.9n 0.5531 25500.0n 0.5531 25799.9n 0.5531 25800.0n 0.5531 26099.9n 0.5531 26100.0n 0.5531 26399.9n 0.5531 26400.0n 0.5531 26699.9n 0.5531 26700.0n 0.3854 26999.9n 0.3854 27000.0n 0.5531 27299.9n 0.5531 27300.0n 0.3519 27599.9n 0.3519 27600.0n 0.4189 27899.9n 0.4189 27900.0n 0.3519 28199.9n 0.3519 28200.0n 0.5531 28499.9n 0.5531 28500.0n 0.4860 28799.9n 0.4860 28800.0n 0.4860 29099.9n 0.4860 29100.0n 0.5531 29399.9n 0.5531 29400.0n 0.5531 29699.9n 0.5531 29700.0n 0.5531 29999.9n 0.5531 30000.0n 0.5531 30299.9n 0.5531 30300.0n 0.5196 30599.9n 0.5196 30600.0n 0.5531 30899.9n 0.5531 30900.0n 0.5531 31199.9n 0.5531 31200.0n 0.5531 31499.9n 0.5531 31500.0n 0.5531 31799.9n 0.5531 31800.0n 0.5531 32099.9n 0.5531 32100.0n 0.3854 32399.9n 0.3854 32400.0n 0.5531 32699.9n 0.5531 32700.0n 0.3519 32999.9n 0.3519 33000.0n 0.4189 33299.9n 0.4189 33300.0n 0.3519 33599.9n 0.3519 33600.0n 0.5531 33899.9n 0.5531 33900.0n 0.4860 34199.9n 0.4860 34200.0n 0.4860 34499.9n 0.4860 34500.0n 0.5531 34799.9n 0.5531 34800.0n 0.5531 35099.9n 0.5531 35100.0n 0.5531 35399.9n 0.5531 35400.0n 0.5531 35699.9n 0.5531 35700.0n 0.5196 35999.9n 0.5196 36000.0n 0.5531 36299.9n 0.5531 36300.0n 0.5531 36599.9n 0.5531 36600.0n 0.5531 36899.9n 0.5531 36900.0n 0.5531 37199.9n 0.5531 37200.0n 0.5531 37499.9n 0.5531 37500.0n 0.3854 37799.9n 0.3854 37800.0n 0.5531 38099.9n 0.5531 38100.0n 0.3519 38399.9n 0.3519 38400.0n 0.4189 38699.9n 0.4189 38700.0n 0.3519 38999.9n 0.3519 39000.0n 0.5531 39299.9n 0.5531 39300.0n 0.4860 39599.9n 0.4860 39600.0n 0.4860 39899.9n 0.4860 39900.0n 0.5531 40199.9n 0.5531 40200.0n 0.5531 40499.9n 0.5531 40500.0n 0.5531 40799.9n 0.5531 40800.0n 0.5531 41099.9n 0.5531 41100.0n 0.5196 41399.9n 0.5196 41400.0n 0.5531 41699.9n 0.5531 41700.0n 0.5531 41999.9n 0.5531 42000.0n 0.5531 42299.9n 0.5531 42300.0n 0.5531 42599.9n 0.5531 42600.0n 0.5531 42899.9n 0.5531 42900.0n 0.3854 43199.9n 0.3854 43200.0n 0.5531 43499.9n 0.5531 43500.0n 0.3519 43799.9n 0.3519 43800.0n 0.4189 44099.9n 0.4189 44100.0n 0.3519 44399.9n 0.3519 44400.0n 0.5531 44699.9n 0.5531 44700.0n 0.4860 44999.9n 0.4860 45000.0n 0.4860 45299.9n 0.4860 45300.0n 0.5531 45599.9n 0.5531 45600.0n 0.5531 45899.9n 0.5531 45900.0n 0.5531 46199.9n 0.5531 46200.0n 0.5531 46499.9n 0.5531 46500.0n 0.5196 46799.9n 0.5196 46800.0n 0.5531 47099.9n 0.5531 47100.0n 0.5531 47399.9n 0.5531 47400.0n 0.5531 47699.9n 0.5531 47700.0n 0.5531 47999.9n 0.5531 48000.0n 0.5531 48299.9n 0.5531 48300.0n 0.3854 48599.9n 0.3854 48600.0n 0.5531 48899.9n 0.5531 48900.0n 0.3519 49199.9n 0.3519 49200.0n 0.4189 49499.9n 0.4189 49500.0n 0.3519 49799.9n 0.3519 49800.0n 0.5531 50099.9n 0.5531 50100.0n 0.4860 50399.9n 0.4860 50400.0n 0.4860 50699.9n 0.4860 50700.0n 0.5531 50999.9n 0.5531 51000.0n 0.5531 51299.9n 0.5531 51300.0n 0.5531 51599.9n 0.5531 51600.0n 0.5531 51899.9n 0.5531 51900.0n 0.5196 52199.9n 0.5196 52200.0n 0.5531 52499.9n 0.5531 52500.0n 0.5531 52799.9n 0.5531 52800.0n 0.5531 53099.9n 0.5531 53100.0n 0.5531 53399.9n 0.5531 53400.0n 0.5531 53699.9n 0.5531 53700.0n 0.3854 53999.9n 0.3854 54000.0n 0.5531 54299.9n 0.5531 54300.0n 0.4525 54599.9n 0.4525 54600.0n 0.3183 54899.9n 0.3183 54900.0n 0.4189 55199.9n 0.4189 55200.0n 0.5196 55499.9n 0.5196 55500.0n 0.4189 55799.9n 0.4189 55800.0n 0.5531 56099.9n 0.5531 56100.0n 0.5531 56399.9n 0.5531 56400.0n 0.4525 56699.9n 0.4525 56700.0n 0.5531 56999.9n 0.5531 57000.0n 0.5531 57299.9n 0.5531 57300.0n 0.4189 57599.9n 0.4189 57600.0n 0.5531 57899.9n 0.5531 57900.0n 0.5531 58199.9n 0.5531 58200.0n 0.5531 58499.9n 0.5531 58500.0n 0.5196 58799.9n 0.5196 58800.0n 0.5531 59099.9n 0.5531 59100.0n 0.5531)
Vxp42 a_xp42 0 PWL(0.0n 0.3947 299.9n 0.3947 300.0n 0.5783 599.9n 0.5783 600.0n 0.5783 899.9n 0.5783 900.0n 0.5936 1199.9n 0.5936 1200.0n 0.3947 1499.9n 0.3947 1500.0n 0.6242 1799.9n 0.6242 1800.0n 0.5783 2099.9n 0.5783 2100.0n 0.3947 2399.9n 0.3947 2400.0n 0.5018 2699.9n 0.5018 2700.0n 0.3947 2999.9n 0.3947 3000.0n 0.4100 3299.9n 0.4100 3300.0n 0.6395 3599.9n 0.6395 3600.0n 0.3947 3899.9n 0.3947 3900.0n 0.3947 4199.9n 0.3947 4200.0n 0.4100 4499.9n 0.4100 4500.0n 0.3947 4799.9n 0.3947 4800.0n 0.6242 5099.9n 0.6242 5100.0n 0.6395 5399.9n 0.6395 5400.0n 0.3947 5699.9n 0.3947 5700.0n 0.5783 5999.9n 0.5783 6000.0n 0.5783 6299.9n 0.5783 6300.0n 0.5936 6599.9n 0.5936 6600.0n 0.3947 6899.9n 0.3947 6900.0n 0.6242 7199.9n 0.6242 7200.0n 0.5783 7499.9n 0.5783 7500.0n 0.3947 7799.9n 0.3947 7800.0n 0.5018 8099.9n 0.5018 8100.0n 0.3947 8399.9n 0.3947 8400.0n 0.4100 8699.9n 0.4100 8700.0n 0.6395 8999.9n 0.6395 9000.0n 0.3947 9299.9n 0.3947 9300.0n 0.3947 9599.9n 0.3947 9600.0n 0.4100 9899.9n 0.4100 9900.0n 0.3947 10199.9n 0.3947 10200.0n 0.6242 10499.9n 0.6242 10500.0n 0.6395 10799.9n 0.6395 10800.0n 0.3947 11099.9n 0.3947 11100.0n 0.5783 11399.9n 0.5783 11400.0n 0.5783 11699.9n 0.5783 11700.0n 0.5936 11999.9n 0.5936 12000.0n 0.3947 12299.9n 0.3947 12300.0n 0.6242 12599.9n 0.6242 12600.0n 0.5783 12899.9n 0.5783 12900.0n 0.3947 13199.9n 0.3947 13200.0n 0.5018 13499.9n 0.5018 13500.0n 0.3947 13799.9n 0.3947 13800.0n 0.4100 14099.9n 0.4100 14100.0n 0.6395 14399.9n 0.6395 14400.0n 0.3947 14699.9n 0.3947 14700.0n 0.3947 14999.9n 0.3947 15000.0n 0.4100 15299.9n 0.4100 15300.0n 0.3947 15599.9n 0.3947 15600.0n 0.6242 15899.9n 0.6242 15900.0n 0.6395 16199.9n 0.6395 16200.0n 0.3947 16499.9n 0.3947 16500.0n 0.5783 16799.9n 0.5783 16800.0n 0.5783 17099.9n 0.5783 17100.0n 0.5936 17399.9n 0.5936 17400.0n 0.3947 17699.9n 0.3947 17700.0n 0.6242 17999.9n 0.6242 18000.0n 0.5783 18299.9n 0.5783 18300.0n 0.3947 18599.9n 0.3947 18600.0n 0.5018 18899.9n 0.5018 18900.0n 0.3947 19199.9n 0.3947 19200.0n 0.4100 19499.9n 0.4100 19500.0n 0.6395 19799.9n 0.6395 19800.0n 0.3947 20099.9n 0.3947 20100.0n 0.3947 20399.9n 0.3947 20400.0n 0.4100 20699.9n 0.4100 20700.0n 0.3947 20999.9n 0.3947 21000.0n 0.6242 21299.9n 0.6242 21300.0n 0.6395 21599.9n 0.6395 21600.0n 0.3947 21899.9n 0.3947 21900.0n 0.5783 22199.9n 0.5783 22200.0n 0.5783 22499.9n 0.5783 22500.0n 0.5936 22799.9n 0.5936 22800.0n 0.3947 23099.9n 0.3947 23100.0n 0.6242 23399.9n 0.6242 23400.0n 0.5783 23699.9n 0.5783 23700.0n 0.3947 23999.9n 0.3947 24000.0n 0.5018 24299.9n 0.5018 24300.0n 0.3947 24599.9n 0.3947 24600.0n 0.4100 24899.9n 0.4100 24900.0n 0.6395 25199.9n 0.6395 25200.0n 0.3947 25499.9n 0.3947 25500.0n 0.3947 25799.9n 0.3947 25800.0n 0.4100 26099.9n 0.4100 26100.0n 0.3947 26399.9n 0.3947 26400.0n 0.6242 26699.9n 0.6242 26700.0n 0.6395 26999.9n 0.6395 27000.0n 0.3947 27299.9n 0.3947 27300.0n 0.5783 27599.9n 0.5783 27600.0n 0.5783 27899.9n 0.5783 27900.0n 0.5936 28199.9n 0.5936 28200.0n 0.3947 28499.9n 0.3947 28500.0n 0.6242 28799.9n 0.6242 28800.0n 0.5783 29099.9n 0.5783 29100.0n 0.3947 29399.9n 0.3947 29400.0n 0.5018 29699.9n 0.5018 29700.0n 0.3947 29999.9n 0.3947 30000.0n 0.4100 30299.9n 0.4100 30300.0n 0.6395 30599.9n 0.6395 30600.0n 0.3947 30899.9n 0.3947 30900.0n 0.3947 31199.9n 0.3947 31200.0n 0.4100 31499.9n 0.4100 31500.0n 0.3947 31799.9n 0.3947 31800.0n 0.6242 32099.9n 0.6242 32100.0n 0.6395 32399.9n 0.6395 32400.0n 0.3947 32699.9n 0.3947 32700.0n 0.5783 32999.9n 0.5783 33000.0n 0.5783 33299.9n 0.5783 33300.0n 0.5936 33599.9n 0.5936 33600.0n 0.3947 33899.9n 0.3947 33900.0n 0.6242 34199.9n 0.6242 34200.0n 0.5783 34499.9n 0.5783 34500.0n 0.3947 34799.9n 0.3947 34800.0n 0.5018 35099.9n 0.5018 35100.0n 0.3947 35399.9n 0.3947 35400.0n 0.4100 35699.9n 0.4100 35700.0n 0.6395 35999.9n 0.6395 36000.0n 0.3947 36299.9n 0.3947 36300.0n 0.3947 36599.9n 0.3947 36600.0n 0.4100 36899.9n 0.4100 36900.0n 0.3947 37199.9n 0.3947 37200.0n 0.6242 37499.9n 0.6242 37500.0n 0.6395 37799.9n 0.6395 37800.0n 0.3947 38099.9n 0.3947 38100.0n 0.5783 38399.9n 0.5783 38400.0n 0.5783 38699.9n 0.5783 38700.0n 0.5936 38999.9n 0.5936 39000.0n 0.3947 39299.9n 0.3947 39300.0n 0.6242 39599.9n 0.6242 39600.0n 0.5783 39899.9n 0.5783 39900.0n 0.3947 40199.9n 0.3947 40200.0n 0.5018 40499.9n 0.5018 40500.0n 0.3947 40799.9n 0.3947 40800.0n 0.4100 41099.9n 0.4100 41100.0n 0.6395 41399.9n 0.6395 41400.0n 0.3947 41699.9n 0.3947 41700.0n 0.3947 41999.9n 0.3947 42000.0n 0.4100 42299.9n 0.4100 42300.0n 0.3947 42599.9n 0.3947 42600.0n 0.6242 42899.9n 0.6242 42900.0n 0.6395 43199.9n 0.6395 43200.0n 0.3947 43499.9n 0.3947 43500.0n 0.5783 43799.9n 0.5783 43800.0n 0.5783 44099.9n 0.5783 44100.0n 0.5936 44399.9n 0.5936 44400.0n 0.3947 44699.9n 0.3947 44700.0n 0.6242 44999.9n 0.6242 45000.0n 0.5783 45299.9n 0.5783 45300.0n 0.3947 45599.9n 0.3947 45600.0n 0.5018 45899.9n 0.5018 45900.0n 0.3947 46199.9n 0.3947 46200.0n 0.4100 46499.9n 0.4100 46500.0n 0.6395 46799.9n 0.6395 46800.0n 0.3947 47099.9n 0.3947 47100.0n 0.3947 47399.9n 0.3947 47400.0n 0.4100 47699.9n 0.4100 47700.0n 0.3947 47999.9n 0.3947 48000.0n 0.6242 48299.9n 0.6242 48300.0n 0.6395 48599.9n 0.6395 48600.0n 0.3947 48899.9n 0.3947 48900.0n 0.5783 49199.9n 0.5783 49200.0n 0.5783 49499.9n 0.5783 49500.0n 0.5936 49799.9n 0.5936 49800.0n 0.3947 50099.9n 0.3947 50100.0n 0.6242 50399.9n 0.6242 50400.0n 0.5783 50699.9n 0.5783 50700.0n 0.3947 50999.9n 0.3947 51000.0n 0.5018 51299.9n 0.5018 51300.0n 0.3947 51599.9n 0.3947 51600.0n 0.4100 51899.9n 0.4100 51900.0n 0.6395 52199.9n 0.6395 52200.0n 0.3947 52499.9n 0.3947 52500.0n 0.3947 52799.9n 0.3947 52800.0n 0.4100 53099.9n 0.4100 53100.0n 0.3947 53399.9n 0.3947 53400.0n 0.6242 53699.9n 0.6242 53700.0n 0.6395 53999.9n 0.6395 54000.0n 0.6395 54299.9n 0.6395 54300.0n 0.6242 54599.9n 0.6242 54600.0n 0.6395 54899.9n 0.6395 54900.0n 0.6395 55199.9n 0.6395 55200.0n 0.5783 55499.9n 0.5783 55500.0n 0.6395 55799.9n 0.6395 55800.0n 0.4559 56099.9n 0.4559 56100.0n 0.6242 56399.9n 0.6242 56400.0n 0.5477 56699.9n 0.5477 56700.0n 0.5018 56999.9n 0.5018 57000.0n 0.3947 57299.9n 0.3947 57300.0n 0.6395 57599.9n 0.6395 57600.0n 0.3947 57899.9n 0.3947 57900.0n 0.5018 58199.9n 0.5018 58200.0n 0.5018 58499.9n 0.5018 58500.0n 0.6242 58799.9n 0.6242 58800.0n 0.4100 59099.9n 0.4100 59100.0n 0.4865)
Vxn42 a_xn42 0 PWL(0.0n 0.6053 299.9n 0.6053 300.0n 0.4217 599.9n 0.4217 600.0n 0.4217 899.9n 0.4217 900.0n 0.4064 1199.9n 0.4064 1200.0n 0.6053 1499.9n 0.6053 1500.0n 0.3758 1799.9n 0.3758 1800.0n 0.4217 2099.9n 0.4217 2100.0n 0.6053 2399.9n 0.6053 2400.0n 0.4982 2699.9n 0.4982 2700.0n 0.6053 2999.9n 0.6053 3000.0n 0.5900 3299.9n 0.5900 3300.0n 0.3605 3599.9n 0.3605 3600.0n 0.6053 3899.9n 0.6053 3900.0n 0.6053 4199.9n 0.6053 4200.0n 0.5900 4499.9n 0.5900 4500.0n 0.6053 4799.9n 0.6053 4800.0n 0.3758 5099.9n 0.3758 5100.0n 0.3605 5399.9n 0.3605 5400.0n 0.6053 5699.9n 0.6053 5700.0n 0.4217 5999.9n 0.4217 6000.0n 0.4217 6299.9n 0.4217 6300.0n 0.4064 6599.9n 0.4064 6600.0n 0.6053 6899.9n 0.6053 6900.0n 0.3758 7199.9n 0.3758 7200.0n 0.4217 7499.9n 0.4217 7500.0n 0.6053 7799.9n 0.6053 7800.0n 0.4982 8099.9n 0.4982 8100.0n 0.6053 8399.9n 0.6053 8400.0n 0.5900 8699.9n 0.5900 8700.0n 0.3605 8999.9n 0.3605 9000.0n 0.6053 9299.9n 0.6053 9300.0n 0.6053 9599.9n 0.6053 9600.0n 0.5900 9899.9n 0.5900 9900.0n 0.6053 10199.9n 0.6053 10200.0n 0.3758 10499.9n 0.3758 10500.0n 0.3605 10799.9n 0.3605 10800.0n 0.6053 11099.9n 0.6053 11100.0n 0.4217 11399.9n 0.4217 11400.0n 0.4217 11699.9n 0.4217 11700.0n 0.4064 11999.9n 0.4064 12000.0n 0.6053 12299.9n 0.6053 12300.0n 0.3758 12599.9n 0.3758 12600.0n 0.4217 12899.9n 0.4217 12900.0n 0.6053 13199.9n 0.6053 13200.0n 0.4982 13499.9n 0.4982 13500.0n 0.6053 13799.9n 0.6053 13800.0n 0.5900 14099.9n 0.5900 14100.0n 0.3605 14399.9n 0.3605 14400.0n 0.6053 14699.9n 0.6053 14700.0n 0.6053 14999.9n 0.6053 15000.0n 0.5900 15299.9n 0.5900 15300.0n 0.6053 15599.9n 0.6053 15600.0n 0.3758 15899.9n 0.3758 15900.0n 0.3605 16199.9n 0.3605 16200.0n 0.6053 16499.9n 0.6053 16500.0n 0.4217 16799.9n 0.4217 16800.0n 0.4217 17099.9n 0.4217 17100.0n 0.4064 17399.9n 0.4064 17400.0n 0.6053 17699.9n 0.6053 17700.0n 0.3758 17999.9n 0.3758 18000.0n 0.4217 18299.9n 0.4217 18300.0n 0.6053 18599.9n 0.6053 18600.0n 0.4982 18899.9n 0.4982 18900.0n 0.6053 19199.9n 0.6053 19200.0n 0.5900 19499.9n 0.5900 19500.0n 0.3605 19799.9n 0.3605 19800.0n 0.6053 20099.9n 0.6053 20100.0n 0.6053 20399.9n 0.6053 20400.0n 0.5900 20699.9n 0.5900 20700.0n 0.6053 20999.9n 0.6053 21000.0n 0.3758 21299.9n 0.3758 21300.0n 0.3605 21599.9n 0.3605 21600.0n 0.6053 21899.9n 0.6053 21900.0n 0.4217 22199.9n 0.4217 22200.0n 0.4217 22499.9n 0.4217 22500.0n 0.4064 22799.9n 0.4064 22800.0n 0.6053 23099.9n 0.6053 23100.0n 0.3758 23399.9n 0.3758 23400.0n 0.4217 23699.9n 0.4217 23700.0n 0.6053 23999.9n 0.6053 24000.0n 0.4982 24299.9n 0.4982 24300.0n 0.6053 24599.9n 0.6053 24600.0n 0.5900 24899.9n 0.5900 24900.0n 0.3605 25199.9n 0.3605 25200.0n 0.6053 25499.9n 0.6053 25500.0n 0.6053 25799.9n 0.6053 25800.0n 0.5900 26099.9n 0.5900 26100.0n 0.6053 26399.9n 0.6053 26400.0n 0.3758 26699.9n 0.3758 26700.0n 0.3605 26999.9n 0.3605 27000.0n 0.6053 27299.9n 0.6053 27300.0n 0.4217 27599.9n 0.4217 27600.0n 0.4217 27899.9n 0.4217 27900.0n 0.4064 28199.9n 0.4064 28200.0n 0.6053 28499.9n 0.6053 28500.0n 0.3758 28799.9n 0.3758 28800.0n 0.4217 29099.9n 0.4217 29100.0n 0.6053 29399.9n 0.6053 29400.0n 0.4982 29699.9n 0.4982 29700.0n 0.6053 29999.9n 0.6053 30000.0n 0.5900 30299.9n 0.5900 30300.0n 0.3605 30599.9n 0.3605 30600.0n 0.6053 30899.9n 0.6053 30900.0n 0.6053 31199.9n 0.6053 31200.0n 0.5900 31499.9n 0.5900 31500.0n 0.6053 31799.9n 0.6053 31800.0n 0.3758 32099.9n 0.3758 32100.0n 0.3605 32399.9n 0.3605 32400.0n 0.6053 32699.9n 0.6053 32700.0n 0.4217 32999.9n 0.4217 33000.0n 0.4217 33299.9n 0.4217 33300.0n 0.4064 33599.9n 0.4064 33600.0n 0.6053 33899.9n 0.6053 33900.0n 0.3758 34199.9n 0.3758 34200.0n 0.4217 34499.9n 0.4217 34500.0n 0.6053 34799.9n 0.6053 34800.0n 0.4982 35099.9n 0.4982 35100.0n 0.6053 35399.9n 0.6053 35400.0n 0.5900 35699.9n 0.5900 35700.0n 0.3605 35999.9n 0.3605 36000.0n 0.6053 36299.9n 0.6053 36300.0n 0.6053 36599.9n 0.6053 36600.0n 0.5900 36899.9n 0.5900 36900.0n 0.6053 37199.9n 0.6053 37200.0n 0.3758 37499.9n 0.3758 37500.0n 0.3605 37799.9n 0.3605 37800.0n 0.6053 38099.9n 0.6053 38100.0n 0.4217 38399.9n 0.4217 38400.0n 0.4217 38699.9n 0.4217 38700.0n 0.4064 38999.9n 0.4064 39000.0n 0.6053 39299.9n 0.6053 39300.0n 0.3758 39599.9n 0.3758 39600.0n 0.4217 39899.9n 0.4217 39900.0n 0.6053 40199.9n 0.6053 40200.0n 0.4982 40499.9n 0.4982 40500.0n 0.6053 40799.9n 0.6053 40800.0n 0.5900 41099.9n 0.5900 41100.0n 0.3605 41399.9n 0.3605 41400.0n 0.6053 41699.9n 0.6053 41700.0n 0.6053 41999.9n 0.6053 42000.0n 0.5900 42299.9n 0.5900 42300.0n 0.6053 42599.9n 0.6053 42600.0n 0.3758 42899.9n 0.3758 42900.0n 0.3605 43199.9n 0.3605 43200.0n 0.6053 43499.9n 0.6053 43500.0n 0.4217 43799.9n 0.4217 43800.0n 0.4217 44099.9n 0.4217 44100.0n 0.4064 44399.9n 0.4064 44400.0n 0.6053 44699.9n 0.6053 44700.0n 0.3758 44999.9n 0.3758 45000.0n 0.4217 45299.9n 0.4217 45300.0n 0.6053 45599.9n 0.6053 45600.0n 0.4982 45899.9n 0.4982 45900.0n 0.6053 46199.9n 0.6053 46200.0n 0.5900 46499.9n 0.5900 46500.0n 0.3605 46799.9n 0.3605 46800.0n 0.6053 47099.9n 0.6053 47100.0n 0.6053 47399.9n 0.6053 47400.0n 0.5900 47699.9n 0.5900 47700.0n 0.6053 47999.9n 0.6053 48000.0n 0.3758 48299.9n 0.3758 48300.0n 0.3605 48599.9n 0.3605 48600.0n 0.6053 48899.9n 0.6053 48900.0n 0.4217 49199.9n 0.4217 49200.0n 0.4217 49499.9n 0.4217 49500.0n 0.4064 49799.9n 0.4064 49800.0n 0.6053 50099.9n 0.6053 50100.0n 0.3758 50399.9n 0.3758 50400.0n 0.4217 50699.9n 0.4217 50700.0n 0.6053 50999.9n 0.6053 51000.0n 0.4982 51299.9n 0.4982 51300.0n 0.6053 51599.9n 0.6053 51600.0n 0.5900 51899.9n 0.5900 51900.0n 0.3605 52199.9n 0.3605 52200.0n 0.6053 52499.9n 0.6053 52500.0n 0.6053 52799.9n 0.6053 52800.0n 0.5900 53099.9n 0.5900 53100.0n 0.6053 53399.9n 0.6053 53400.0n 0.3758 53699.9n 0.3758 53700.0n 0.3605 53999.9n 0.3605 54000.0n 0.3605 54299.9n 0.3605 54300.0n 0.3758 54599.9n 0.3758 54600.0n 0.3605 54899.9n 0.3605 54900.0n 0.3605 55199.9n 0.3605 55200.0n 0.4217 55499.9n 0.4217 55500.0n 0.3605 55799.9n 0.3605 55800.0n 0.5441 56099.9n 0.5441 56100.0n 0.3758 56399.9n 0.3758 56400.0n 0.4523 56699.9n 0.4523 56700.0n 0.4982 56999.9n 0.4982 57000.0n 0.6053 57299.9n 0.6053 57300.0n 0.3605 57599.9n 0.3605 57600.0n 0.6053 57899.9n 0.6053 57900.0n 0.4982 58199.9n 0.4982 58200.0n 0.4982 58499.9n 0.4982 58500.0n 0.3758 58799.9n 0.3758 58800.0n 0.5900 59099.9n 0.5900 59100.0n 0.5135)
Vxp43 a_xp43 0 PWL(0.0n 0.4343 299.9n 0.4343 300.0n 0.3878 599.9n 0.3878 600.0n 0.3878 899.9n 0.3878 900.0n 0.3878 1199.9n 0.3878 1200.0n 0.3878 1499.9n 0.3878 1500.0n 0.4033 1799.9n 0.4033 1800.0n 0.3878 2099.9n 0.3878 2100.0n 0.3878 2399.9n 0.3878 2400.0n 0.6207 2699.9n 0.6207 2700.0n 0.4654 2999.9n 0.4654 3000.0n 0.5741 3299.9n 0.5741 3300.0n 0.5896 3599.9n 0.5896 3600.0n 0.5275 3899.9n 0.5275 3900.0n 0.5896 4199.9n 0.5896 4200.0n 0.6362 4499.9n 0.6362 4500.0n 0.5586 4799.9n 0.5586 4800.0n 0.4343 5099.9n 0.4343 5100.0n 0.4809 5399.9n 0.4809 5400.0n 0.4343 5699.9n 0.4343 5700.0n 0.3878 5999.9n 0.3878 6000.0n 0.3878 6299.9n 0.3878 6300.0n 0.3878 6599.9n 0.3878 6600.0n 0.3878 6899.9n 0.3878 6900.0n 0.4033 7199.9n 0.4033 7200.0n 0.3878 7499.9n 0.3878 7500.0n 0.3878 7799.9n 0.3878 7800.0n 0.6207 8099.9n 0.6207 8100.0n 0.4654 8399.9n 0.4654 8400.0n 0.5741 8699.9n 0.5741 8700.0n 0.5896 8999.9n 0.5896 9000.0n 0.5275 9299.9n 0.5275 9300.0n 0.5896 9599.9n 0.5896 9600.0n 0.6362 9899.9n 0.6362 9900.0n 0.5586 10199.9n 0.5586 10200.0n 0.4343 10499.9n 0.4343 10500.0n 0.4809 10799.9n 0.4809 10800.0n 0.4343 11099.9n 0.4343 11100.0n 0.3878 11399.9n 0.3878 11400.0n 0.3878 11699.9n 0.3878 11700.0n 0.3878 11999.9n 0.3878 12000.0n 0.3878 12299.9n 0.3878 12300.0n 0.4033 12599.9n 0.4033 12600.0n 0.3878 12899.9n 0.3878 12900.0n 0.3878 13199.9n 0.3878 13200.0n 0.6207 13499.9n 0.6207 13500.0n 0.4654 13799.9n 0.4654 13800.0n 0.5741 14099.9n 0.5741 14100.0n 0.5896 14399.9n 0.5896 14400.0n 0.5275 14699.9n 0.5275 14700.0n 0.5896 14999.9n 0.5896 15000.0n 0.6362 15299.9n 0.6362 15300.0n 0.5586 15599.9n 0.5586 15600.0n 0.4343 15899.9n 0.4343 15900.0n 0.4809 16199.9n 0.4809 16200.0n 0.4343 16499.9n 0.4343 16500.0n 0.3878 16799.9n 0.3878 16800.0n 0.3878 17099.9n 0.3878 17100.0n 0.3878 17399.9n 0.3878 17400.0n 0.3878 17699.9n 0.3878 17700.0n 0.4033 17999.9n 0.4033 18000.0n 0.3878 18299.9n 0.3878 18300.0n 0.3878 18599.9n 0.3878 18600.0n 0.6207 18899.9n 0.6207 18900.0n 0.4654 19199.9n 0.4654 19200.0n 0.5741 19499.9n 0.5741 19500.0n 0.5896 19799.9n 0.5896 19800.0n 0.5275 20099.9n 0.5275 20100.0n 0.5896 20399.9n 0.5896 20400.0n 0.6362 20699.9n 0.6362 20700.0n 0.5586 20999.9n 0.5586 21000.0n 0.4343 21299.9n 0.4343 21300.0n 0.4809 21599.9n 0.4809 21600.0n 0.4343 21899.9n 0.4343 21900.0n 0.3878 22199.9n 0.3878 22200.0n 0.3878 22499.9n 0.3878 22500.0n 0.3878 22799.9n 0.3878 22800.0n 0.3878 23099.9n 0.3878 23100.0n 0.4033 23399.9n 0.4033 23400.0n 0.3878 23699.9n 0.3878 23700.0n 0.3878 23999.9n 0.3878 24000.0n 0.6207 24299.9n 0.6207 24300.0n 0.4654 24599.9n 0.4654 24600.0n 0.5741 24899.9n 0.5741 24900.0n 0.5896 25199.9n 0.5896 25200.0n 0.5275 25499.9n 0.5275 25500.0n 0.5896 25799.9n 0.5896 25800.0n 0.6362 26099.9n 0.6362 26100.0n 0.5586 26399.9n 0.5586 26400.0n 0.4343 26699.9n 0.4343 26700.0n 0.4809 26999.9n 0.4809 27000.0n 0.4343 27299.9n 0.4343 27300.0n 0.3878 27599.9n 0.3878 27600.0n 0.3878 27899.9n 0.3878 27900.0n 0.3878 28199.9n 0.3878 28200.0n 0.3878 28499.9n 0.3878 28500.0n 0.4033 28799.9n 0.4033 28800.0n 0.3878 29099.9n 0.3878 29100.0n 0.3878 29399.9n 0.3878 29400.0n 0.6207 29699.9n 0.6207 29700.0n 0.4654 29999.9n 0.4654 30000.0n 0.5741 30299.9n 0.5741 30300.0n 0.5896 30599.9n 0.5896 30600.0n 0.5275 30899.9n 0.5275 30900.0n 0.5896 31199.9n 0.5896 31200.0n 0.6362 31499.9n 0.6362 31500.0n 0.5586 31799.9n 0.5586 31800.0n 0.4343 32099.9n 0.4343 32100.0n 0.4809 32399.9n 0.4809 32400.0n 0.4343 32699.9n 0.4343 32700.0n 0.3878 32999.9n 0.3878 33000.0n 0.3878 33299.9n 0.3878 33300.0n 0.3878 33599.9n 0.3878 33600.0n 0.3878 33899.9n 0.3878 33900.0n 0.4033 34199.9n 0.4033 34200.0n 0.3878 34499.9n 0.3878 34500.0n 0.3878 34799.9n 0.3878 34800.0n 0.6207 35099.9n 0.6207 35100.0n 0.4654 35399.9n 0.4654 35400.0n 0.5741 35699.9n 0.5741 35700.0n 0.5896 35999.9n 0.5896 36000.0n 0.5275 36299.9n 0.5275 36300.0n 0.5896 36599.9n 0.5896 36600.0n 0.6362 36899.9n 0.6362 36900.0n 0.5586 37199.9n 0.5586 37200.0n 0.4343 37499.9n 0.4343 37500.0n 0.4809 37799.9n 0.4809 37800.0n 0.4343 38099.9n 0.4343 38100.0n 0.3878 38399.9n 0.3878 38400.0n 0.3878 38699.9n 0.3878 38700.0n 0.3878 38999.9n 0.3878 39000.0n 0.3878 39299.9n 0.3878 39300.0n 0.4033 39599.9n 0.4033 39600.0n 0.3878 39899.9n 0.3878 39900.0n 0.3878 40199.9n 0.3878 40200.0n 0.6207 40499.9n 0.6207 40500.0n 0.4654 40799.9n 0.4654 40800.0n 0.5741 41099.9n 0.5741 41100.0n 0.5896 41399.9n 0.5896 41400.0n 0.5275 41699.9n 0.5275 41700.0n 0.5896 41999.9n 0.5896 42000.0n 0.6362 42299.9n 0.6362 42300.0n 0.5586 42599.9n 0.5586 42600.0n 0.4343 42899.9n 0.4343 42900.0n 0.4809 43199.9n 0.4809 43200.0n 0.4343 43499.9n 0.4343 43500.0n 0.3878 43799.9n 0.3878 43800.0n 0.3878 44099.9n 0.3878 44100.0n 0.3878 44399.9n 0.3878 44400.0n 0.3878 44699.9n 0.3878 44700.0n 0.4033 44999.9n 0.4033 45000.0n 0.3878 45299.9n 0.3878 45300.0n 0.3878 45599.9n 0.3878 45600.0n 0.6207 45899.9n 0.6207 45900.0n 0.4654 46199.9n 0.4654 46200.0n 0.5741 46499.9n 0.5741 46500.0n 0.5896 46799.9n 0.5896 46800.0n 0.5275 47099.9n 0.5275 47100.0n 0.5896 47399.9n 0.5896 47400.0n 0.6362 47699.9n 0.6362 47700.0n 0.5586 47999.9n 0.5586 48000.0n 0.4343 48299.9n 0.4343 48300.0n 0.4809 48599.9n 0.4809 48600.0n 0.4343 48899.9n 0.4343 48900.0n 0.3878 49199.9n 0.3878 49200.0n 0.3878 49499.9n 0.3878 49500.0n 0.3878 49799.9n 0.3878 49800.0n 0.3878 50099.9n 0.3878 50100.0n 0.4033 50399.9n 0.4033 50400.0n 0.3878 50699.9n 0.3878 50700.0n 0.3878 50999.9n 0.3878 51000.0n 0.6207 51299.9n 0.6207 51300.0n 0.4654 51599.9n 0.4654 51600.0n 0.5741 51899.9n 0.5741 51900.0n 0.5896 52199.9n 0.5896 52200.0n 0.5275 52499.9n 0.5275 52500.0n 0.5896 52799.9n 0.5896 52800.0n 0.6362 53099.9n 0.6362 53100.0n 0.5586 53399.9n 0.5586 53400.0n 0.4343 53699.9n 0.4343 53700.0n 0.4809 53999.9n 0.4809 54000.0n 0.3878 54299.9n 0.3878 54300.0n 0.4033 54599.9n 0.4033 54600.0n 0.4033 54899.9n 0.4033 54900.0n 0.4654 55199.9n 0.4654 55200.0n 0.3878 55499.9n 0.3878 55500.0n 0.4033 55799.9n 0.4033 55800.0n 0.6362 56099.9n 0.6362 56100.0n 0.6362 56399.9n 0.6362 56400.0n 0.4343 56699.9n 0.4343 56700.0n 0.5120 56999.9n 0.5120 57000.0n 0.5430 57299.9n 0.5430 57300.0n 0.6362 57599.9n 0.6362 57600.0n 0.5586 57899.9n 0.5586 57900.0n 0.6362 58199.9n 0.6362 58200.0n 0.6052 58499.9n 0.6052 58500.0n 0.4965 58799.9n 0.4965 58800.0n 0.6362 59099.9n 0.6362 59100.0n 0.5741)
Vxn43 a_xn43 0 PWL(0.0n 0.5657 299.9n 0.5657 300.0n 0.6122 599.9n 0.6122 600.0n 0.6122 899.9n 0.6122 900.0n 0.6122 1199.9n 0.6122 1200.0n 0.6122 1499.9n 0.6122 1500.0n 0.5967 1799.9n 0.5967 1800.0n 0.6122 2099.9n 0.6122 2100.0n 0.6122 2399.9n 0.6122 2400.0n 0.3793 2699.9n 0.3793 2700.0n 0.5346 2999.9n 0.5346 3000.0n 0.4259 3299.9n 0.4259 3300.0n 0.4104 3599.9n 0.4104 3600.0n 0.4725 3899.9n 0.4725 3900.0n 0.4104 4199.9n 0.4104 4200.0n 0.3638 4499.9n 0.3638 4500.0n 0.4414 4799.9n 0.4414 4800.0n 0.5657 5099.9n 0.5657 5100.0n 0.5191 5399.9n 0.5191 5400.0n 0.5657 5699.9n 0.5657 5700.0n 0.6122 5999.9n 0.6122 6000.0n 0.6122 6299.9n 0.6122 6300.0n 0.6122 6599.9n 0.6122 6600.0n 0.6122 6899.9n 0.6122 6900.0n 0.5967 7199.9n 0.5967 7200.0n 0.6122 7499.9n 0.6122 7500.0n 0.6122 7799.9n 0.6122 7800.0n 0.3793 8099.9n 0.3793 8100.0n 0.5346 8399.9n 0.5346 8400.0n 0.4259 8699.9n 0.4259 8700.0n 0.4104 8999.9n 0.4104 9000.0n 0.4725 9299.9n 0.4725 9300.0n 0.4104 9599.9n 0.4104 9600.0n 0.3638 9899.9n 0.3638 9900.0n 0.4414 10199.9n 0.4414 10200.0n 0.5657 10499.9n 0.5657 10500.0n 0.5191 10799.9n 0.5191 10800.0n 0.5657 11099.9n 0.5657 11100.0n 0.6122 11399.9n 0.6122 11400.0n 0.6122 11699.9n 0.6122 11700.0n 0.6122 11999.9n 0.6122 12000.0n 0.6122 12299.9n 0.6122 12300.0n 0.5967 12599.9n 0.5967 12600.0n 0.6122 12899.9n 0.6122 12900.0n 0.6122 13199.9n 0.6122 13200.0n 0.3793 13499.9n 0.3793 13500.0n 0.5346 13799.9n 0.5346 13800.0n 0.4259 14099.9n 0.4259 14100.0n 0.4104 14399.9n 0.4104 14400.0n 0.4725 14699.9n 0.4725 14700.0n 0.4104 14999.9n 0.4104 15000.0n 0.3638 15299.9n 0.3638 15300.0n 0.4414 15599.9n 0.4414 15600.0n 0.5657 15899.9n 0.5657 15900.0n 0.5191 16199.9n 0.5191 16200.0n 0.5657 16499.9n 0.5657 16500.0n 0.6122 16799.9n 0.6122 16800.0n 0.6122 17099.9n 0.6122 17100.0n 0.6122 17399.9n 0.6122 17400.0n 0.6122 17699.9n 0.6122 17700.0n 0.5967 17999.9n 0.5967 18000.0n 0.6122 18299.9n 0.6122 18300.0n 0.6122 18599.9n 0.6122 18600.0n 0.3793 18899.9n 0.3793 18900.0n 0.5346 19199.9n 0.5346 19200.0n 0.4259 19499.9n 0.4259 19500.0n 0.4104 19799.9n 0.4104 19800.0n 0.4725 20099.9n 0.4725 20100.0n 0.4104 20399.9n 0.4104 20400.0n 0.3638 20699.9n 0.3638 20700.0n 0.4414 20999.9n 0.4414 21000.0n 0.5657 21299.9n 0.5657 21300.0n 0.5191 21599.9n 0.5191 21600.0n 0.5657 21899.9n 0.5657 21900.0n 0.6122 22199.9n 0.6122 22200.0n 0.6122 22499.9n 0.6122 22500.0n 0.6122 22799.9n 0.6122 22800.0n 0.6122 23099.9n 0.6122 23100.0n 0.5967 23399.9n 0.5967 23400.0n 0.6122 23699.9n 0.6122 23700.0n 0.6122 23999.9n 0.6122 24000.0n 0.3793 24299.9n 0.3793 24300.0n 0.5346 24599.9n 0.5346 24600.0n 0.4259 24899.9n 0.4259 24900.0n 0.4104 25199.9n 0.4104 25200.0n 0.4725 25499.9n 0.4725 25500.0n 0.4104 25799.9n 0.4104 25800.0n 0.3638 26099.9n 0.3638 26100.0n 0.4414 26399.9n 0.4414 26400.0n 0.5657 26699.9n 0.5657 26700.0n 0.5191 26999.9n 0.5191 27000.0n 0.5657 27299.9n 0.5657 27300.0n 0.6122 27599.9n 0.6122 27600.0n 0.6122 27899.9n 0.6122 27900.0n 0.6122 28199.9n 0.6122 28200.0n 0.6122 28499.9n 0.6122 28500.0n 0.5967 28799.9n 0.5967 28800.0n 0.6122 29099.9n 0.6122 29100.0n 0.6122 29399.9n 0.6122 29400.0n 0.3793 29699.9n 0.3793 29700.0n 0.5346 29999.9n 0.5346 30000.0n 0.4259 30299.9n 0.4259 30300.0n 0.4104 30599.9n 0.4104 30600.0n 0.4725 30899.9n 0.4725 30900.0n 0.4104 31199.9n 0.4104 31200.0n 0.3638 31499.9n 0.3638 31500.0n 0.4414 31799.9n 0.4414 31800.0n 0.5657 32099.9n 0.5657 32100.0n 0.5191 32399.9n 0.5191 32400.0n 0.5657 32699.9n 0.5657 32700.0n 0.6122 32999.9n 0.6122 33000.0n 0.6122 33299.9n 0.6122 33300.0n 0.6122 33599.9n 0.6122 33600.0n 0.6122 33899.9n 0.6122 33900.0n 0.5967 34199.9n 0.5967 34200.0n 0.6122 34499.9n 0.6122 34500.0n 0.6122 34799.9n 0.6122 34800.0n 0.3793 35099.9n 0.3793 35100.0n 0.5346 35399.9n 0.5346 35400.0n 0.4259 35699.9n 0.4259 35700.0n 0.4104 35999.9n 0.4104 36000.0n 0.4725 36299.9n 0.4725 36300.0n 0.4104 36599.9n 0.4104 36600.0n 0.3638 36899.9n 0.3638 36900.0n 0.4414 37199.9n 0.4414 37200.0n 0.5657 37499.9n 0.5657 37500.0n 0.5191 37799.9n 0.5191 37800.0n 0.5657 38099.9n 0.5657 38100.0n 0.6122 38399.9n 0.6122 38400.0n 0.6122 38699.9n 0.6122 38700.0n 0.6122 38999.9n 0.6122 39000.0n 0.6122 39299.9n 0.6122 39300.0n 0.5967 39599.9n 0.5967 39600.0n 0.6122 39899.9n 0.6122 39900.0n 0.6122 40199.9n 0.6122 40200.0n 0.3793 40499.9n 0.3793 40500.0n 0.5346 40799.9n 0.5346 40800.0n 0.4259 41099.9n 0.4259 41100.0n 0.4104 41399.9n 0.4104 41400.0n 0.4725 41699.9n 0.4725 41700.0n 0.4104 41999.9n 0.4104 42000.0n 0.3638 42299.9n 0.3638 42300.0n 0.4414 42599.9n 0.4414 42600.0n 0.5657 42899.9n 0.5657 42900.0n 0.5191 43199.9n 0.5191 43200.0n 0.5657 43499.9n 0.5657 43500.0n 0.6122 43799.9n 0.6122 43800.0n 0.6122 44099.9n 0.6122 44100.0n 0.6122 44399.9n 0.6122 44400.0n 0.6122 44699.9n 0.6122 44700.0n 0.5967 44999.9n 0.5967 45000.0n 0.6122 45299.9n 0.6122 45300.0n 0.6122 45599.9n 0.6122 45600.0n 0.3793 45899.9n 0.3793 45900.0n 0.5346 46199.9n 0.5346 46200.0n 0.4259 46499.9n 0.4259 46500.0n 0.4104 46799.9n 0.4104 46800.0n 0.4725 47099.9n 0.4725 47100.0n 0.4104 47399.9n 0.4104 47400.0n 0.3638 47699.9n 0.3638 47700.0n 0.4414 47999.9n 0.4414 48000.0n 0.5657 48299.9n 0.5657 48300.0n 0.5191 48599.9n 0.5191 48600.0n 0.5657 48899.9n 0.5657 48900.0n 0.6122 49199.9n 0.6122 49200.0n 0.6122 49499.9n 0.6122 49500.0n 0.6122 49799.9n 0.6122 49800.0n 0.6122 50099.9n 0.6122 50100.0n 0.5967 50399.9n 0.5967 50400.0n 0.6122 50699.9n 0.6122 50700.0n 0.6122 50999.9n 0.6122 51000.0n 0.3793 51299.9n 0.3793 51300.0n 0.5346 51599.9n 0.5346 51600.0n 0.4259 51899.9n 0.4259 51900.0n 0.4104 52199.9n 0.4104 52200.0n 0.4725 52499.9n 0.4725 52500.0n 0.4104 52799.9n 0.4104 52800.0n 0.3638 53099.9n 0.3638 53100.0n 0.4414 53399.9n 0.4414 53400.0n 0.5657 53699.9n 0.5657 53700.0n 0.5191 53999.9n 0.5191 54000.0n 0.6122 54299.9n 0.6122 54300.0n 0.5967 54599.9n 0.5967 54600.0n 0.5967 54899.9n 0.5967 54900.0n 0.5346 55199.9n 0.5346 55200.0n 0.6122 55499.9n 0.6122 55500.0n 0.5967 55799.9n 0.5967 55800.0n 0.3638 56099.9n 0.3638 56100.0n 0.3638 56399.9n 0.3638 56400.0n 0.5657 56699.9n 0.5657 56700.0n 0.4880 56999.9n 0.4880 57000.0n 0.4570 57299.9n 0.4570 57300.0n 0.3638 57599.9n 0.3638 57600.0n 0.4414 57899.9n 0.4414 57900.0n 0.3638 58199.9n 0.3638 58200.0n 0.3948 58499.9n 0.3948 58500.0n 0.5035 58799.9n 0.5035 58800.0n 0.3638 59099.9n 0.3638 59100.0n 0.4259)
Vxp44 a_xp44 0 PWL(0.0n 0.6331 299.9n 0.6331 300.0n 0.3774 599.9n 0.3774 600.0n 0.3774 899.9n 0.3774 900.0n 0.3774 1199.9n 0.3774 1200.0n 0.5692 1499.9n 0.5692 1500.0n 0.3934 1799.9n 0.3934 1800.0n 0.3774 2099.9n 0.3774 2100.0n 0.4253 2399.9n 0.4253 2400.0n 0.3774 2699.9n 0.3774 2700.0n 0.6171 2999.9n 0.6171 3000.0n 0.5212 3299.9n 0.5212 3300.0n 0.3774 3599.9n 0.3774 3600.0n 0.6331 3899.9n 0.6331 3900.0n 0.6331 4199.9n 0.6331 4200.0n 0.4893 4499.9n 0.4893 4500.0n 0.5692 4799.9n 0.5692 4800.0n 0.3774 5099.9n 0.3774 5100.0n 0.6171 5399.9n 0.6171 5400.0n 0.6331 5699.9n 0.6331 5700.0n 0.3774 5999.9n 0.3774 6000.0n 0.3774 6299.9n 0.3774 6300.0n 0.3774 6599.9n 0.3774 6600.0n 0.5692 6899.9n 0.5692 6900.0n 0.3934 7199.9n 0.3934 7200.0n 0.3774 7499.9n 0.3774 7500.0n 0.4253 7799.9n 0.4253 7800.0n 0.3774 8099.9n 0.3774 8100.0n 0.6171 8399.9n 0.6171 8400.0n 0.5212 8699.9n 0.5212 8700.0n 0.3774 8999.9n 0.3774 9000.0n 0.6331 9299.9n 0.6331 9300.0n 0.6331 9599.9n 0.6331 9600.0n 0.4893 9899.9n 0.4893 9900.0n 0.5692 10199.9n 0.5692 10200.0n 0.3774 10499.9n 0.3774 10500.0n 0.6171 10799.9n 0.6171 10800.0n 0.6331 11099.9n 0.6331 11100.0n 0.3774 11399.9n 0.3774 11400.0n 0.3774 11699.9n 0.3774 11700.0n 0.3774 11999.9n 0.3774 12000.0n 0.5692 12299.9n 0.5692 12300.0n 0.3934 12599.9n 0.3934 12600.0n 0.3774 12899.9n 0.3774 12900.0n 0.4253 13199.9n 0.4253 13200.0n 0.3774 13499.9n 0.3774 13500.0n 0.6171 13799.9n 0.6171 13800.0n 0.5212 14099.9n 0.5212 14100.0n 0.3774 14399.9n 0.3774 14400.0n 0.6331 14699.9n 0.6331 14700.0n 0.6331 14999.9n 0.6331 15000.0n 0.4893 15299.9n 0.4893 15300.0n 0.5692 15599.9n 0.5692 15600.0n 0.3774 15899.9n 0.3774 15900.0n 0.6171 16199.9n 0.6171 16200.0n 0.6331 16499.9n 0.6331 16500.0n 0.3774 16799.9n 0.3774 16800.0n 0.3774 17099.9n 0.3774 17100.0n 0.3774 17399.9n 0.3774 17400.0n 0.5692 17699.9n 0.5692 17700.0n 0.3934 17999.9n 0.3934 18000.0n 0.3774 18299.9n 0.3774 18300.0n 0.4253 18599.9n 0.4253 18600.0n 0.3774 18899.9n 0.3774 18900.0n 0.6171 19199.9n 0.6171 19200.0n 0.5212 19499.9n 0.5212 19500.0n 0.3774 19799.9n 0.3774 19800.0n 0.6331 20099.9n 0.6331 20100.0n 0.6331 20399.9n 0.6331 20400.0n 0.4893 20699.9n 0.4893 20700.0n 0.5692 20999.9n 0.5692 21000.0n 0.3774 21299.9n 0.3774 21300.0n 0.6171 21599.9n 0.6171 21600.0n 0.6331 21899.9n 0.6331 21900.0n 0.3774 22199.9n 0.3774 22200.0n 0.3774 22499.9n 0.3774 22500.0n 0.3774 22799.9n 0.3774 22800.0n 0.5692 23099.9n 0.5692 23100.0n 0.3934 23399.9n 0.3934 23400.0n 0.3774 23699.9n 0.3774 23700.0n 0.4253 23999.9n 0.4253 24000.0n 0.3774 24299.9n 0.3774 24300.0n 0.6171 24599.9n 0.6171 24600.0n 0.5212 24899.9n 0.5212 24900.0n 0.3774 25199.9n 0.3774 25200.0n 0.6331 25499.9n 0.6331 25500.0n 0.6331 25799.9n 0.6331 25800.0n 0.4893 26099.9n 0.4893 26100.0n 0.5692 26399.9n 0.5692 26400.0n 0.3774 26699.9n 0.3774 26700.0n 0.6171 26999.9n 0.6171 27000.0n 0.6331 27299.9n 0.6331 27300.0n 0.3774 27599.9n 0.3774 27600.0n 0.3774 27899.9n 0.3774 27900.0n 0.3774 28199.9n 0.3774 28200.0n 0.5692 28499.9n 0.5692 28500.0n 0.3934 28799.9n 0.3934 28800.0n 0.3774 29099.9n 0.3774 29100.0n 0.4253 29399.9n 0.4253 29400.0n 0.3774 29699.9n 0.3774 29700.0n 0.6171 29999.9n 0.6171 30000.0n 0.5212 30299.9n 0.5212 30300.0n 0.3774 30599.9n 0.3774 30600.0n 0.6331 30899.9n 0.6331 30900.0n 0.6331 31199.9n 0.6331 31200.0n 0.4893 31499.9n 0.4893 31500.0n 0.5692 31799.9n 0.5692 31800.0n 0.3774 32099.9n 0.3774 32100.0n 0.6171 32399.9n 0.6171 32400.0n 0.6331 32699.9n 0.6331 32700.0n 0.3774 32999.9n 0.3774 33000.0n 0.3774 33299.9n 0.3774 33300.0n 0.3774 33599.9n 0.3774 33600.0n 0.5692 33899.9n 0.5692 33900.0n 0.3934 34199.9n 0.3934 34200.0n 0.3774 34499.9n 0.3774 34500.0n 0.4253 34799.9n 0.4253 34800.0n 0.3774 35099.9n 0.3774 35100.0n 0.6171 35399.9n 0.6171 35400.0n 0.5212 35699.9n 0.5212 35700.0n 0.3774 35999.9n 0.3774 36000.0n 0.6331 36299.9n 0.6331 36300.0n 0.6331 36599.9n 0.6331 36600.0n 0.4893 36899.9n 0.4893 36900.0n 0.5692 37199.9n 0.5692 37200.0n 0.3774 37499.9n 0.3774 37500.0n 0.6171 37799.9n 0.6171 37800.0n 0.6331 38099.9n 0.6331 38100.0n 0.3774 38399.9n 0.3774 38400.0n 0.3774 38699.9n 0.3774 38700.0n 0.3774 38999.9n 0.3774 39000.0n 0.5692 39299.9n 0.5692 39300.0n 0.3934 39599.9n 0.3934 39600.0n 0.3774 39899.9n 0.3774 39900.0n 0.4253 40199.9n 0.4253 40200.0n 0.3774 40499.9n 0.3774 40500.0n 0.6171 40799.9n 0.6171 40800.0n 0.5212 41099.9n 0.5212 41100.0n 0.3774 41399.9n 0.3774 41400.0n 0.6331 41699.9n 0.6331 41700.0n 0.6331 41999.9n 0.6331 42000.0n 0.4893 42299.9n 0.4893 42300.0n 0.5692 42599.9n 0.5692 42600.0n 0.3774 42899.9n 0.3774 42900.0n 0.6171 43199.9n 0.6171 43200.0n 0.6331 43499.9n 0.6331 43500.0n 0.3774 43799.9n 0.3774 43800.0n 0.3774 44099.9n 0.3774 44100.0n 0.3774 44399.9n 0.3774 44400.0n 0.5692 44699.9n 0.5692 44700.0n 0.3934 44999.9n 0.3934 45000.0n 0.3774 45299.9n 0.3774 45300.0n 0.4253 45599.9n 0.4253 45600.0n 0.3774 45899.9n 0.3774 45900.0n 0.6171 46199.9n 0.6171 46200.0n 0.5212 46499.9n 0.5212 46500.0n 0.3774 46799.9n 0.3774 46800.0n 0.6331 47099.9n 0.6331 47100.0n 0.6331 47399.9n 0.6331 47400.0n 0.4893 47699.9n 0.4893 47700.0n 0.5692 47999.9n 0.5692 48000.0n 0.3774 48299.9n 0.3774 48300.0n 0.6171 48599.9n 0.6171 48600.0n 0.6331 48899.9n 0.6331 48900.0n 0.3774 49199.9n 0.3774 49200.0n 0.3774 49499.9n 0.3774 49500.0n 0.3774 49799.9n 0.3774 49800.0n 0.5692 50099.9n 0.5692 50100.0n 0.3934 50399.9n 0.3934 50400.0n 0.3774 50699.9n 0.3774 50700.0n 0.4253 50999.9n 0.4253 51000.0n 0.3774 51299.9n 0.3774 51300.0n 0.6171 51599.9n 0.6171 51600.0n 0.5212 51899.9n 0.5212 51900.0n 0.3774 52199.9n 0.3774 52200.0n 0.6331 52499.9n 0.6331 52500.0n 0.6331 52799.9n 0.6331 52800.0n 0.4893 53099.9n 0.4893 53100.0n 0.5692 53399.9n 0.5692 53400.0n 0.3774 53699.9n 0.3774 53700.0n 0.6171 53999.9n 0.6171 54000.0n 0.3774 54299.9n 0.3774 54300.0n 0.3774 54599.9n 0.3774 54600.0n 0.3774 54899.9n 0.3774 54900.0n 0.5372 55199.9n 0.5372 55200.0n 0.3774 55499.9n 0.3774 55500.0n 0.3774 55799.9n 0.3774 55800.0n 0.6171 56099.9n 0.6171 56100.0n 0.6171 56399.9n 0.6171 56400.0n 0.6331 56699.9n 0.6331 56700.0n 0.6011 56999.9n 0.6011 57000.0n 0.6331 57299.9n 0.6331 57300.0n 0.5052 57599.9n 0.5052 57600.0n 0.4733 57899.9n 0.4733 57900.0n 0.4413 58199.9n 0.4413 58200.0n 0.3774 58499.9n 0.3774 58500.0n 0.3774 58799.9n 0.3774 58800.0n 0.5052 59099.9n 0.5052 59100.0n 0.3934)
Vxn44 a_xn44 0 PWL(0.0n 0.3669 299.9n 0.3669 300.0n 0.6226 599.9n 0.6226 600.0n 0.6226 899.9n 0.6226 900.0n 0.6226 1199.9n 0.6226 1200.0n 0.4308 1499.9n 0.4308 1500.0n 0.6066 1799.9n 0.6066 1800.0n 0.6226 2099.9n 0.6226 2100.0n 0.5747 2399.9n 0.5747 2400.0n 0.6226 2699.9n 0.6226 2700.0n 0.3829 2999.9n 0.3829 3000.0n 0.4788 3299.9n 0.4788 3300.0n 0.6226 3599.9n 0.6226 3600.0n 0.3669 3899.9n 0.3669 3900.0n 0.3669 4199.9n 0.3669 4200.0n 0.5107 4499.9n 0.5107 4500.0n 0.4308 4799.9n 0.4308 4800.0n 0.6226 5099.9n 0.6226 5100.0n 0.3829 5399.9n 0.3829 5400.0n 0.3669 5699.9n 0.3669 5700.0n 0.6226 5999.9n 0.6226 6000.0n 0.6226 6299.9n 0.6226 6300.0n 0.6226 6599.9n 0.6226 6600.0n 0.4308 6899.9n 0.4308 6900.0n 0.6066 7199.9n 0.6066 7200.0n 0.6226 7499.9n 0.6226 7500.0n 0.5747 7799.9n 0.5747 7800.0n 0.6226 8099.9n 0.6226 8100.0n 0.3829 8399.9n 0.3829 8400.0n 0.4788 8699.9n 0.4788 8700.0n 0.6226 8999.9n 0.6226 9000.0n 0.3669 9299.9n 0.3669 9300.0n 0.3669 9599.9n 0.3669 9600.0n 0.5107 9899.9n 0.5107 9900.0n 0.4308 10199.9n 0.4308 10200.0n 0.6226 10499.9n 0.6226 10500.0n 0.3829 10799.9n 0.3829 10800.0n 0.3669 11099.9n 0.3669 11100.0n 0.6226 11399.9n 0.6226 11400.0n 0.6226 11699.9n 0.6226 11700.0n 0.6226 11999.9n 0.6226 12000.0n 0.4308 12299.9n 0.4308 12300.0n 0.6066 12599.9n 0.6066 12600.0n 0.6226 12899.9n 0.6226 12900.0n 0.5747 13199.9n 0.5747 13200.0n 0.6226 13499.9n 0.6226 13500.0n 0.3829 13799.9n 0.3829 13800.0n 0.4788 14099.9n 0.4788 14100.0n 0.6226 14399.9n 0.6226 14400.0n 0.3669 14699.9n 0.3669 14700.0n 0.3669 14999.9n 0.3669 15000.0n 0.5107 15299.9n 0.5107 15300.0n 0.4308 15599.9n 0.4308 15600.0n 0.6226 15899.9n 0.6226 15900.0n 0.3829 16199.9n 0.3829 16200.0n 0.3669 16499.9n 0.3669 16500.0n 0.6226 16799.9n 0.6226 16800.0n 0.6226 17099.9n 0.6226 17100.0n 0.6226 17399.9n 0.6226 17400.0n 0.4308 17699.9n 0.4308 17700.0n 0.6066 17999.9n 0.6066 18000.0n 0.6226 18299.9n 0.6226 18300.0n 0.5747 18599.9n 0.5747 18600.0n 0.6226 18899.9n 0.6226 18900.0n 0.3829 19199.9n 0.3829 19200.0n 0.4788 19499.9n 0.4788 19500.0n 0.6226 19799.9n 0.6226 19800.0n 0.3669 20099.9n 0.3669 20100.0n 0.3669 20399.9n 0.3669 20400.0n 0.5107 20699.9n 0.5107 20700.0n 0.4308 20999.9n 0.4308 21000.0n 0.6226 21299.9n 0.6226 21300.0n 0.3829 21599.9n 0.3829 21600.0n 0.3669 21899.9n 0.3669 21900.0n 0.6226 22199.9n 0.6226 22200.0n 0.6226 22499.9n 0.6226 22500.0n 0.6226 22799.9n 0.6226 22800.0n 0.4308 23099.9n 0.4308 23100.0n 0.6066 23399.9n 0.6066 23400.0n 0.6226 23699.9n 0.6226 23700.0n 0.5747 23999.9n 0.5747 24000.0n 0.6226 24299.9n 0.6226 24300.0n 0.3829 24599.9n 0.3829 24600.0n 0.4788 24899.9n 0.4788 24900.0n 0.6226 25199.9n 0.6226 25200.0n 0.3669 25499.9n 0.3669 25500.0n 0.3669 25799.9n 0.3669 25800.0n 0.5107 26099.9n 0.5107 26100.0n 0.4308 26399.9n 0.4308 26400.0n 0.6226 26699.9n 0.6226 26700.0n 0.3829 26999.9n 0.3829 27000.0n 0.3669 27299.9n 0.3669 27300.0n 0.6226 27599.9n 0.6226 27600.0n 0.6226 27899.9n 0.6226 27900.0n 0.6226 28199.9n 0.6226 28200.0n 0.4308 28499.9n 0.4308 28500.0n 0.6066 28799.9n 0.6066 28800.0n 0.6226 29099.9n 0.6226 29100.0n 0.5747 29399.9n 0.5747 29400.0n 0.6226 29699.9n 0.6226 29700.0n 0.3829 29999.9n 0.3829 30000.0n 0.4788 30299.9n 0.4788 30300.0n 0.6226 30599.9n 0.6226 30600.0n 0.3669 30899.9n 0.3669 30900.0n 0.3669 31199.9n 0.3669 31200.0n 0.5107 31499.9n 0.5107 31500.0n 0.4308 31799.9n 0.4308 31800.0n 0.6226 32099.9n 0.6226 32100.0n 0.3829 32399.9n 0.3829 32400.0n 0.3669 32699.9n 0.3669 32700.0n 0.6226 32999.9n 0.6226 33000.0n 0.6226 33299.9n 0.6226 33300.0n 0.6226 33599.9n 0.6226 33600.0n 0.4308 33899.9n 0.4308 33900.0n 0.6066 34199.9n 0.6066 34200.0n 0.6226 34499.9n 0.6226 34500.0n 0.5747 34799.9n 0.5747 34800.0n 0.6226 35099.9n 0.6226 35100.0n 0.3829 35399.9n 0.3829 35400.0n 0.4788 35699.9n 0.4788 35700.0n 0.6226 35999.9n 0.6226 36000.0n 0.3669 36299.9n 0.3669 36300.0n 0.3669 36599.9n 0.3669 36600.0n 0.5107 36899.9n 0.5107 36900.0n 0.4308 37199.9n 0.4308 37200.0n 0.6226 37499.9n 0.6226 37500.0n 0.3829 37799.9n 0.3829 37800.0n 0.3669 38099.9n 0.3669 38100.0n 0.6226 38399.9n 0.6226 38400.0n 0.6226 38699.9n 0.6226 38700.0n 0.6226 38999.9n 0.6226 39000.0n 0.4308 39299.9n 0.4308 39300.0n 0.6066 39599.9n 0.6066 39600.0n 0.6226 39899.9n 0.6226 39900.0n 0.5747 40199.9n 0.5747 40200.0n 0.6226 40499.9n 0.6226 40500.0n 0.3829 40799.9n 0.3829 40800.0n 0.4788 41099.9n 0.4788 41100.0n 0.6226 41399.9n 0.6226 41400.0n 0.3669 41699.9n 0.3669 41700.0n 0.3669 41999.9n 0.3669 42000.0n 0.5107 42299.9n 0.5107 42300.0n 0.4308 42599.9n 0.4308 42600.0n 0.6226 42899.9n 0.6226 42900.0n 0.3829 43199.9n 0.3829 43200.0n 0.3669 43499.9n 0.3669 43500.0n 0.6226 43799.9n 0.6226 43800.0n 0.6226 44099.9n 0.6226 44100.0n 0.6226 44399.9n 0.6226 44400.0n 0.4308 44699.9n 0.4308 44700.0n 0.6066 44999.9n 0.6066 45000.0n 0.6226 45299.9n 0.6226 45300.0n 0.5747 45599.9n 0.5747 45600.0n 0.6226 45899.9n 0.6226 45900.0n 0.3829 46199.9n 0.3829 46200.0n 0.4788 46499.9n 0.4788 46500.0n 0.6226 46799.9n 0.6226 46800.0n 0.3669 47099.9n 0.3669 47100.0n 0.3669 47399.9n 0.3669 47400.0n 0.5107 47699.9n 0.5107 47700.0n 0.4308 47999.9n 0.4308 48000.0n 0.6226 48299.9n 0.6226 48300.0n 0.3829 48599.9n 0.3829 48600.0n 0.3669 48899.9n 0.3669 48900.0n 0.6226 49199.9n 0.6226 49200.0n 0.6226 49499.9n 0.6226 49500.0n 0.6226 49799.9n 0.6226 49800.0n 0.4308 50099.9n 0.4308 50100.0n 0.6066 50399.9n 0.6066 50400.0n 0.6226 50699.9n 0.6226 50700.0n 0.5747 50999.9n 0.5747 51000.0n 0.6226 51299.9n 0.6226 51300.0n 0.3829 51599.9n 0.3829 51600.0n 0.4788 51899.9n 0.4788 51900.0n 0.6226 52199.9n 0.6226 52200.0n 0.3669 52499.9n 0.3669 52500.0n 0.3669 52799.9n 0.3669 52800.0n 0.5107 53099.9n 0.5107 53100.0n 0.4308 53399.9n 0.4308 53400.0n 0.6226 53699.9n 0.6226 53700.0n 0.3829 53999.9n 0.3829 54000.0n 0.6226 54299.9n 0.6226 54300.0n 0.6226 54599.9n 0.6226 54600.0n 0.6226 54899.9n 0.6226 54900.0n 0.4628 55199.9n 0.4628 55200.0n 0.6226 55499.9n 0.6226 55500.0n 0.6226 55799.9n 0.6226 55800.0n 0.3829 56099.9n 0.3829 56100.0n 0.3829 56399.9n 0.3829 56400.0n 0.3669 56699.9n 0.3669 56700.0n 0.3989 56999.9n 0.3989 57000.0n 0.3669 57299.9n 0.3669 57300.0n 0.4948 57599.9n 0.4948 57600.0n 0.5267 57899.9n 0.5267 57900.0n 0.5587 58199.9n 0.5587 58200.0n 0.6226 58499.9n 0.6226 58500.0n 0.6226 58799.9n 0.6226 58800.0n 0.4948 59099.9n 0.4948 59100.0n 0.6066)
Vxp45 a_xp45 0 PWL(0.0n 0.6363 299.9n 0.6363 300.0n 0.4958 599.9n 0.4958 600.0n 0.5134 899.9n 0.5134 900.0n 0.5661 1199.9n 0.5661 1200.0n 0.6363 1499.9n 0.6363 1500.0n 0.5661 1799.9n 0.5661 1800.0n 0.4607 2099.9n 0.4607 2100.0n 0.6363 2399.9n 0.6363 2400.0n 0.3553 2699.9n 0.3553 2700.0n 0.4783 2999.9n 0.4783 3000.0n 0.3553 3299.9n 0.3553 3300.0n 0.3553 3599.9n 0.3553 3600.0n 0.3905 3899.9n 0.3905 3900.0n 0.3553 4199.9n 0.3553 4200.0n 0.3905 4499.9n 0.3905 4500.0n 0.3553 4799.9n 0.3553 4800.0n 0.4080 5099.9n 0.4080 5100.0n 0.5661 5399.9n 0.5661 5400.0n 0.6363 5699.9n 0.6363 5700.0n 0.4958 5999.9n 0.4958 6000.0n 0.5134 6299.9n 0.5134 6300.0n 0.5661 6599.9n 0.5661 6600.0n 0.6363 6899.9n 0.6363 6900.0n 0.5661 7199.9n 0.5661 7200.0n 0.4607 7499.9n 0.4607 7500.0n 0.6363 7799.9n 0.6363 7800.0n 0.3553 8099.9n 0.3553 8100.0n 0.4783 8399.9n 0.4783 8400.0n 0.3553 8699.9n 0.3553 8700.0n 0.3553 8999.9n 0.3553 9000.0n 0.3905 9299.9n 0.3905 9300.0n 0.3553 9599.9n 0.3553 9600.0n 0.3905 9899.9n 0.3905 9900.0n 0.3553 10199.9n 0.3553 10200.0n 0.4080 10499.9n 0.4080 10500.0n 0.5661 10799.9n 0.5661 10800.0n 0.6363 11099.9n 0.6363 11100.0n 0.4958 11399.9n 0.4958 11400.0n 0.5134 11699.9n 0.5134 11700.0n 0.5661 11999.9n 0.5661 12000.0n 0.6363 12299.9n 0.6363 12300.0n 0.5661 12599.9n 0.5661 12600.0n 0.4607 12899.9n 0.4607 12900.0n 0.6363 13199.9n 0.6363 13200.0n 0.3553 13499.9n 0.3553 13500.0n 0.4783 13799.9n 0.4783 13800.0n 0.3553 14099.9n 0.3553 14100.0n 0.3553 14399.9n 0.3553 14400.0n 0.3905 14699.9n 0.3905 14700.0n 0.3553 14999.9n 0.3553 15000.0n 0.3905 15299.9n 0.3905 15300.0n 0.3553 15599.9n 0.3553 15600.0n 0.4080 15899.9n 0.4080 15900.0n 0.5661 16199.9n 0.5661 16200.0n 0.6363 16499.9n 0.6363 16500.0n 0.4958 16799.9n 0.4958 16800.0n 0.5134 17099.9n 0.5134 17100.0n 0.5661 17399.9n 0.5661 17400.0n 0.6363 17699.9n 0.6363 17700.0n 0.5661 17999.9n 0.5661 18000.0n 0.4607 18299.9n 0.4607 18300.0n 0.6363 18599.9n 0.6363 18600.0n 0.3553 18899.9n 0.3553 18900.0n 0.4783 19199.9n 0.4783 19200.0n 0.3553 19499.9n 0.3553 19500.0n 0.3553 19799.9n 0.3553 19800.0n 0.3905 20099.9n 0.3905 20100.0n 0.3553 20399.9n 0.3553 20400.0n 0.3905 20699.9n 0.3905 20700.0n 0.3553 20999.9n 0.3553 21000.0n 0.4080 21299.9n 0.4080 21300.0n 0.5661 21599.9n 0.5661 21600.0n 0.6363 21899.9n 0.6363 21900.0n 0.4958 22199.9n 0.4958 22200.0n 0.5134 22499.9n 0.5134 22500.0n 0.5661 22799.9n 0.5661 22800.0n 0.6363 23099.9n 0.6363 23100.0n 0.5661 23399.9n 0.5661 23400.0n 0.4607 23699.9n 0.4607 23700.0n 0.6363 23999.9n 0.6363 24000.0n 0.3553 24299.9n 0.3553 24300.0n 0.4783 24599.9n 0.4783 24600.0n 0.3553 24899.9n 0.3553 24900.0n 0.3553 25199.9n 0.3553 25200.0n 0.3905 25499.9n 0.3905 25500.0n 0.3553 25799.9n 0.3553 25800.0n 0.3905 26099.9n 0.3905 26100.0n 0.3553 26399.9n 0.3553 26400.0n 0.4080 26699.9n 0.4080 26700.0n 0.5661 26999.9n 0.5661 27000.0n 0.6363 27299.9n 0.6363 27300.0n 0.4958 27599.9n 0.4958 27600.0n 0.5134 27899.9n 0.5134 27900.0n 0.5661 28199.9n 0.5661 28200.0n 0.6363 28499.9n 0.6363 28500.0n 0.5661 28799.9n 0.5661 28800.0n 0.4607 29099.9n 0.4607 29100.0n 0.6363 29399.9n 0.6363 29400.0n 0.3553 29699.9n 0.3553 29700.0n 0.4783 29999.9n 0.4783 30000.0n 0.3553 30299.9n 0.3553 30300.0n 0.3553 30599.9n 0.3553 30600.0n 0.3905 30899.9n 0.3905 30900.0n 0.3553 31199.9n 0.3553 31200.0n 0.3905 31499.9n 0.3905 31500.0n 0.3553 31799.9n 0.3553 31800.0n 0.4080 32099.9n 0.4080 32100.0n 0.5661 32399.9n 0.5661 32400.0n 0.6363 32699.9n 0.6363 32700.0n 0.4958 32999.9n 0.4958 33000.0n 0.5134 33299.9n 0.5134 33300.0n 0.5661 33599.9n 0.5661 33600.0n 0.6363 33899.9n 0.6363 33900.0n 0.5661 34199.9n 0.5661 34200.0n 0.4607 34499.9n 0.4607 34500.0n 0.6363 34799.9n 0.6363 34800.0n 0.3553 35099.9n 0.3553 35100.0n 0.4783 35399.9n 0.4783 35400.0n 0.3553 35699.9n 0.3553 35700.0n 0.3553 35999.9n 0.3553 36000.0n 0.3905 36299.9n 0.3905 36300.0n 0.3553 36599.9n 0.3553 36600.0n 0.3905 36899.9n 0.3905 36900.0n 0.3553 37199.9n 0.3553 37200.0n 0.4080 37499.9n 0.4080 37500.0n 0.5661 37799.9n 0.5661 37800.0n 0.6363 38099.9n 0.6363 38100.0n 0.4958 38399.9n 0.4958 38400.0n 0.5134 38699.9n 0.5134 38700.0n 0.5661 38999.9n 0.5661 39000.0n 0.6363 39299.9n 0.6363 39300.0n 0.5661 39599.9n 0.5661 39600.0n 0.4607 39899.9n 0.4607 39900.0n 0.6363 40199.9n 0.6363 40200.0n 0.3553 40499.9n 0.3553 40500.0n 0.4783 40799.9n 0.4783 40800.0n 0.3553 41099.9n 0.3553 41100.0n 0.3553 41399.9n 0.3553 41400.0n 0.3905 41699.9n 0.3905 41700.0n 0.3553 41999.9n 0.3553 42000.0n 0.3905 42299.9n 0.3905 42300.0n 0.3553 42599.9n 0.3553 42600.0n 0.4080 42899.9n 0.4080 42900.0n 0.5661 43199.9n 0.5661 43200.0n 0.6363 43499.9n 0.6363 43500.0n 0.4958 43799.9n 0.4958 43800.0n 0.5134 44099.9n 0.5134 44100.0n 0.5661 44399.9n 0.5661 44400.0n 0.6363 44699.9n 0.6363 44700.0n 0.5661 44999.9n 0.5661 45000.0n 0.4607 45299.9n 0.4607 45300.0n 0.6363 45599.9n 0.6363 45600.0n 0.3553 45899.9n 0.3553 45900.0n 0.4783 46199.9n 0.4783 46200.0n 0.3553 46499.9n 0.3553 46500.0n 0.3553 46799.9n 0.3553 46800.0n 0.3905 47099.9n 0.3905 47100.0n 0.3553 47399.9n 0.3553 47400.0n 0.3905 47699.9n 0.3905 47700.0n 0.3553 47999.9n 0.3553 48000.0n 0.4080 48299.9n 0.4080 48300.0n 0.5661 48599.9n 0.5661 48600.0n 0.6363 48899.9n 0.6363 48900.0n 0.4958 49199.9n 0.4958 49200.0n 0.5134 49499.9n 0.5134 49500.0n 0.5661 49799.9n 0.5661 49800.0n 0.6363 50099.9n 0.6363 50100.0n 0.5661 50399.9n 0.5661 50400.0n 0.4607 50699.9n 0.4607 50700.0n 0.6363 50999.9n 0.6363 51000.0n 0.3553 51299.9n 0.3553 51300.0n 0.4783 51599.9n 0.4783 51600.0n 0.3553 51899.9n 0.3553 51900.0n 0.3553 52199.9n 0.3553 52200.0n 0.3905 52499.9n 0.3905 52500.0n 0.3553 52799.9n 0.3553 52800.0n 0.3905 53099.9n 0.3905 53100.0n 0.3553 53399.9n 0.3553 53400.0n 0.4080 53699.9n 0.4080 53700.0n 0.5661 53999.9n 0.5661 54000.0n 0.5485 54299.9n 0.5485 54300.0n 0.4080 54599.9n 0.4080 54600.0n 0.5485 54899.9n 0.5485 54900.0n 0.6012 55199.9n 0.6012 55200.0n 0.5485 55499.9n 0.5485 55500.0n 0.5661 55799.9n 0.5661 55800.0n 0.3553 56099.9n 0.3553 56100.0n 0.3905 56399.9n 0.3905 56400.0n 0.5485 56699.9n 0.5485 56700.0n 0.5310 56999.9n 0.5310 57000.0n 0.4080 57299.9n 0.4080 57300.0n 0.3553 57599.9n 0.3553 57600.0n 0.3553 57899.9n 0.3553 57900.0n 0.4080 58199.9n 0.4080 58200.0n 0.3553 58499.9n 0.3553 58500.0n 0.3553 58799.9n 0.3553 58800.0n 0.3553 59099.9n 0.3553 59100.0n 0.3553)
Vxn45 a_xn45 0 PWL(0.0n 0.3637 299.9n 0.3637 300.0n 0.5042 599.9n 0.5042 600.0n 0.4866 899.9n 0.4866 900.0n 0.4339 1199.9n 0.4339 1200.0n 0.3637 1499.9n 0.3637 1500.0n 0.4339 1799.9n 0.4339 1800.0n 0.5393 2099.9n 0.5393 2100.0n 0.3637 2399.9n 0.3637 2400.0n 0.6447 2699.9n 0.6447 2700.0n 0.5217 2999.9n 0.5217 3000.0n 0.6447 3299.9n 0.6447 3300.0n 0.6447 3599.9n 0.6447 3600.0n 0.6095 3899.9n 0.6095 3900.0n 0.6447 4199.9n 0.6447 4200.0n 0.6095 4499.9n 0.6095 4500.0n 0.6447 4799.9n 0.6447 4800.0n 0.5920 5099.9n 0.5920 5100.0n 0.4339 5399.9n 0.4339 5400.0n 0.3637 5699.9n 0.3637 5700.0n 0.5042 5999.9n 0.5042 6000.0n 0.4866 6299.9n 0.4866 6300.0n 0.4339 6599.9n 0.4339 6600.0n 0.3637 6899.9n 0.3637 6900.0n 0.4339 7199.9n 0.4339 7200.0n 0.5393 7499.9n 0.5393 7500.0n 0.3637 7799.9n 0.3637 7800.0n 0.6447 8099.9n 0.6447 8100.0n 0.5217 8399.9n 0.5217 8400.0n 0.6447 8699.9n 0.6447 8700.0n 0.6447 8999.9n 0.6447 9000.0n 0.6095 9299.9n 0.6095 9300.0n 0.6447 9599.9n 0.6447 9600.0n 0.6095 9899.9n 0.6095 9900.0n 0.6447 10199.9n 0.6447 10200.0n 0.5920 10499.9n 0.5920 10500.0n 0.4339 10799.9n 0.4339 10800.0n 0.3637 11099.9n 0.3637 11100.0n 0.5042 11399.9n 0.5042 11400.0n 0.4866 11699.9n 0.4866 11700.0n 0.4339 11999.9n 0.4339 12000.0n 0.3637 12299.9n 0.3637 12300.0n 0.4339 12599.9n 0.4339 12600.0n 0.5393 12899.9n 0.5393 12900.0n 0.3637 13199.9n 0.3637 13200.0n 0.6447 13499.9n 0.6447 13500.0n 0.5217 13799.9n 0.5217 13800.0n 0.6447 14099.9n 0.6447 14100.0n 0.6447 14399.9n 0.6447 14400.0n 0.6095 14699.9n 0.6095 14700.0n 0.6447 14999.9n 0.6447 15000.0n 0.6095 15299.9n 0.6095 15300.0n 0.6447 15599.9n 0.6447 15600.0n 0.5920 15899.9n 0.5920 15900.0n 0.4339 16199.9n 0.4339 16200.0n 0.3637 16499.9n 0.3637 16500.0n 0.5042 16799.9n 0.5042 16800.0n 0.4866 17099.9n 0.4866 17100.0n 0.4339 17399.9n 0.4339 17400.0n 0.3637 17699.9n 0.3637 17700.0n 0.4339 17999.9n 0.4339 18000.0n 0.5393 18299.9n 0.5393 18300.0n 0.3637 18599.9n 0.3637 18600.0n 0.6447 18899.9n 0.6447 18900.0n 0.5217 19199.9n 0.5217 19200.0n 0.6447 19499.9n 0.6447 19500.0n 0.6447 19799.9n 0.6447 19800.0n 0.6095 20099.9n 0.6095 20100.0n 0.6447 20399.9n 0.6447 20400.0n 0.6095 20699.9n 0.6095 20700.0n 0.6447 20999.9n 0.6447 21000.0n 0.5920 21299.9n 0.5920 21300.0n 0.4339 21599.9n 0.4339 21600.0n 0.3637 21899.9n 0.3637 21900.0n 0.5042 22199.9n 0.5042 22200.0n 0.4866 22499.9n 0.4866 22500.0n 0.4339 22799.9n 0.4339 22800.0n 0.3637 23099.9n 0.3637 23100.0n 0.4339 23399.9n 0.4339 23400.0n 0.5393 23699.9n 0.5393 23700.0n 0.3637 23999.9n 0.3637 24000.0n 0.6447 24299.9n 0.6447 24300.0n 0.5217 24599.9n 0.5217 24600.0n 0.6447 24899.9n 0.6447 24900.0n 0.6447 25199.9n 0.6447 25200.0n 0.6095 25499.9n 0.6095 25500.0n 0.6447 25799.9n 0.6447 25800.0n 0.6095 26099.9n 0.6095 26100.0n 0.6447 26399.9n 0.6447 26400.0n 0.5920 26699.9n 0.5920 26700.0n 0.4339 26999.9n 0.4339 27000.0n 0.3637 27299.9n 0.3637 27300.0n 0.5042 27599.9n 0.5042 27600.0n 0.4866 27899.9n 0.4866 27900.0n 0.4339 28199.9n 0.4339 28200.0n 0.3637 28499.9n 0.3637 28500.0n 0.4339 28799.9n 0.4339 28800.0n 0.5393 29099.9n 0.5393 29100.0n 0.3637 29399.9n 0.3637 29400.0n 0.6447 29699.9n 0.6447 29700.0n 0.5217 29999.9n 0.5217 30000.0n 0.6447 30299.9n 0.6447 30300.0n 0.6447 30599.9n 0.6447 30600.0n 0.6095 30899.9n 0.6095 30900.0n 0.6447 31199.9n 0.6447 31200.0n 0.6095 31499.9n 0.6095 31500.0n 0.6447 31799.9n 0.6447 31800.0n 0.5920 32099.9n 0.5920 32100.0n 0.4339 32399.9n 0.4339 32400.0n 0.3637 32699.9n 0.3637 32700.0n 0.5042 32999.9n 0.5042 33000.0n 0.4866 33299.9n 0.4866 33300.0n 0.4339 33599.9n 0.4339 33600.0n 0.3637 33899.9n 0.3637 33900.0n 0.4339 34199.9n 0.4339 34200.0n 0.5393 34499.9n 0.5393 34500.0n 0.3637 34799.9n 0.3637 34800.0n 0.6447 35099.9n 0.6447 35100.0n 0.5217 35399.9n 0.5217 35400.0n 0.6447 35699.9n 0.6447 35700.0n 0.6447 35999.9n 0.6447 36000.0n 0.6095 36299.9n 0.6095 36300.0n 0.6447 36599.9n 0.6447 36600.0n 0.6095 36899.9n 0.6095 36900.0n 0.6447 37199.9n 0.6447 37200.0n 0.5920 37499.9n 0.5920 37500.0n 0.4339 37799.9n 0.4339 37800.0n 0.3637 38099.9n 0.3637 38100.0n 0.5042 38399.9n 0.5042 38400.0n 0.4866 38699.9n 0.4866 38700.0n 0.4339 38999.9n 0.4339 39000.0n 0.3637 39299.9n 0.3637 39300.0n 0.4339 39599.9n 0.4339 39600.0n 0.5393 39899.9n 0.5393 39900.0n 0.3637 40199.9n 0.3637 40200.0n 0.6447 40499.9n 0.6447 40500.0n 0.5217 40799.9n 0.5217 40800.0n 0.6447 41099.9n 0.6447 41100.0n 0.6447 41399.9n 0.6447 41400.0n 0.6095 41699.9n 0.6095 41700.0n 0.6447 41999.9n 0.6447 42000.0n 0.6095 42299.9n 0.6095 42300.0n 0.6447 42599.9n 0.6447 42600.0n 0.5920 42899.9n 0.5920 42900.0n 0.4339 43199.9n 0.4339 43200.0n 0.3637 43499.9n 0.3637 43500.0n 0.5042 43799.9n 0.5042 43800.0n 0.4866 44099.9n 0.4866 44100.0n 0.4339 44399.9n 0.4339 44400.0n 0.3637 44699.9n 0.3637 44700.0n 0.4339 44999.9n 0.4339 45000.0n 0.5393 45299.9n 0.5393 45300.0n 0.3637 45599.9n 0.3637 45600.0n 0.6447 45899.9n 0.6447 45900.0n 0.5217 46199.9n 0.5217 46200.0n 0.6447 46499.9n 0.6447 46500.0n 0.6447 46799.9n 0.6447 46800.0n 0.6095 47099.9n 0.6095 47100.0n 0.6447 47399.9n 0.6447 47400.0n 0.6095 47699.9n 0.6095 47700.0n 0.6447 47999.9n 0.6447 48000.0n 0.5920 48299.9n 0.5920 48300.0n 0.4339 48599.9n 0.4339 48600.0n 0.3637 48899.9n 0.3637 48900.0n 0.5042 49199.9n 0.5042 49200.0n 0.4866 49499.9n 0.4866 49500.0n 0.4339 49799.9n 0.4339 49800.0n 0.3637 50099.9n 0.3637 50100.0n 0.4339 50399.9n 0.4339 50400.0n 0.5393 50699.9n 0.5393 50700.0n 0.3637 50999.9n 0.3637 51000.0n 0.6447 51299.9n 0.6447 51300.0n 0.5217 51599.9n 0.5217 51600.0n 0.6447 51899.9n 0.6447 51900.0n 0.6447 52199.9n 0.6447 52200.0n 0.6095 52499.9n 0.6095 52500.0n 0.6447 52799.9n 0.6447 52800.0n 0.6095 53099.9n 0.6095 53100.0n 0.6447 53399.9n 0.6447 53400.0n 0.5920 53699.9n 0.5920 53700.0n 0.4339 53999.9n 0.4339 54000.0n 0.4515 54299.9n 0.4515 54300.0n 0.5920 54599.9n 0.5920 54600.0n 0.4515 54899.9n 0.4515 54900.0n 0.3988 55199.9n 0.3988 55200.0n 0.4515 55499.9n 0.4515 55500.0n 0.4339 55799.9n 0.4339 55800.0n 0.6447 56099.9n 0.6447 56100.0n 0.6095 56399.9n 0.6095 56400.0n 0.4515 56699.9n 0.4515 56700.0n 0.4690 56999.9n 0.4690 57000.0n 0.5920 57299.9n 0.5920 57300.0n 0.6447 57599.9n 0.6447 57600.0n 0.6447 57899.9n 0.6447 57900.0n 0.5920 58199.9n 0.5920 58200.0n 0.6447 58499.9n 0.6447 58500.0n 0.6447 58799.9n 0.6447 58800.0n 0.6447 59099.9n 0.6447 59100.0n 0.6447)
Vxp46 a_xp46 0 PWL(0.0n 0.4895 299.9n 0.4895 300.0n 0.5126 599.9n 0.5126 600.0n 0.5818 899.9n 0.5818 900.0n 0.4895 1199.9n 0.4895 1200.0n 0.5126 1499.9n 0.5126 1500.0n 0.5357 1799.9n 0.5357 1800.0n 0.5587 2099.9n 0.5587 2100.0n 0.4895 2399.9n 0.4895 2400.0n 0.4202 2699.9n 0.4202 2700.0n 0.4202 2999.9n 0.4202 3000.0n 0.4202 3299.9n 0.4202 3300.0n 0.4202 3599.9n 0.4202 3600.0n 0.4202 3899.9n 0.4202 3900.0n 0.4202 4199.9n 0.4202 4200.0n 0.4664 4499.9n 0.4664 4500.0n 0.4202 4799.9n 0.4202 4800.0n 0.7435 5099.9n 0.7435 5100.0n 0.4202 5399.9n 0.4202 5400.0n 0.4895 5699.9n 0.4895 5700.0n 0.5126 5999.9n 0.5126 6000.0n 0.5818 6299.9n 0.5818 6300.0n 0.4895 6599.9n 0.4895 6600.0n 0.5126 6899.9n 0.5126 6900.0n 0.5357 7199.9n 0.5357 7200.0n 0.5587 7499.9n 0.5587 7500.0n 0.4895 7799.9n 0.4895 7800.0n 0.4202 8099.9n 0.4202 8100.0n 0.4202 8399.9n 0.4202 8400.0n 0.4202 8699.9n 0.4202 8700.0n 0.4202 8999.9n 0.4202 9000.0n 0.4202 9299.9n 0.4202 9300.0n 0.4202 9599.9n 0.4202 9600.0n 0.4664 9899.9n 0.4664 9900.0n 0.4202 10199.9n 0.4202 10200.0n 0.7435 10499.9n 0.7435 10500.0n 0.4202 10799.9n 0.4202 10800.0n 0.4895 11099.9n 0.4895 11100.0n 0.5126 11399.9n 0.5126 11400.0n 0.5818 11699.9n 0.5818 11700.0n 0.4895 11999.9n 0.4895 12000.0n 0.5126 12299.9n 0.5126 12300.0n 0.5357 12599.9n 0.5357 12600.0n 0.5587 12899.9n 0.5587 12900.0n 0.4895 13199.9n 0.4895 13200.0n 0.4202 13499.9n 0.4202 13500.0n 0.4202 13799.9n 0.4202 13800.0n 0.4202 14099.9n 0.4202 14100.0n 0.4202 14399.9n 0.4202 14400.0n 0.4202 14699.9n 0.4202 14700.0n 0.4202 14999.9n 0.4202 15000.0n 0.4664 15299.9n 0.4664 15300.0n 0.4202 15599.9n 0.4202 15600.0n 0.7435 15899.9n 0.7435 15900.0n 0.4202 16199.9n 0.4202 16200.0n 0.4895 16499.9n 0.4895 16500.0n 0.5126 16799.9n 0.5126 16800.0n 0.5818 17099.9n 0.5818 17100.0n 0.4895 17399.9n 0.4895 17400.0n 0.5126 17699.9n 0.5126 17700.0n 0.5357 17999.9n 0.5357 18000.0n 0.5587 18299.9n 0.5587 18300.0n 0.4895 18599.9n 0.4895 18600.0n 0.4202 18899.9n 0.4202 18900.0n 0.4202 19199.9n 0.4202 19200.0n 0.4202 19499.9n 0.4202 19500.0n 0.4202 19799.9n 0.4202 19800.0n 0.4202 20099.9n 0.4202 20100.0n 0.4202 20399.9n 0.4202 20400.0n 0.4664 20699.9n 0.4664 20700.0n 0.4202 20999.9n 0.4202 21000.0n 0.7435 21299.9n 0.7435 21300.0n 0.4202 21599.9n 0.4202 21600.0n 0.4895 21899.9n 0.4895 21900.0n 0.5126 22199.9n 0.5126 22200.0n 0.5818 22499.9n 0.5818 22500.0n 0.4895 22799.9n 0.4895 22800.0n 0.5126 23099.9n 0.5126 23100.0n 0.5357 23399.9n 0.5357 23400.0n 0.5587 23699.9n 0.5587 23700.0n 0.4895 23999.9n 0.4895 24000.0n 0.4202 24299.9n 0.4202 24300.0n 0.4202 24599.9n 0.4202 24600.0n 0.4202 24899.9n 0.4202 24900.0n 0.4202 25199.9n 0.4202 25200.0n 0.4202 25499.9n 0.4202 25500.0n 0.4202 25799.9n 0.4202 25800.0n 0.4664 26099.9n 0.4664 26100.0n 0.4202 26399.9n 0.4202 26400.0n 0.7435 26699.9n 0.7435 26700.0n 0.4202 26999.9n 0.4202 27000.0n 0.4895 27299.9n 0.4895 27300.0n 0.5126 27599.9n 0.5126 27600.0n 0.5818 27899.9n 0.5818 27900.0n 0.4895 28199.9n 0.4895 28200.0n 0.5126 28499.9n 0.5126 28500.0n 0.5357 28799.9n 0.5357 28800.0n 0.5587 29099.9n 0.5587 29100.0n 0.4895 29399.9n 0.4895 29400.0n 0.4202 29699.9n 0.4202 29700.0n 0.4202 29999.9n 0.4202 30000.0n 0.4202 30299.9n 0.4202 30300.0n 0.4202 30599.9n 0.4202 30600.0n 0.4202 30899.9n 0.4202 30900.0n 0.4202 31199.9n 0.4202 31200.0n 0.4664 31499.9n 0.4664 31500.0n 0.4202 31799.9n 0.4202 31800.0n 0.7435 32099.9n 0.7435 32100.0n 0.4202 32399.9n 0.4202 32400.0n 0.4895 32699.9n 0.4895 32700.0n 0.5126 32999.9n 0.5126 33000.0n 0.5818 33299.9n 0.5818 33300.0n 0.4895 33599.9n 0.4895 33600.0n 0.5126 33899.9n 0.5126 33900.0n 0.5357 34199.9n 0.5357 34200.0n 0.5587 34499.9n 0.5587 34500.0n 0.4895 34799.9n 0.4895 34800.0n 0.4202 35099.9n 0.4202 35100.0n 0.4202 35399.9n 0.4202 35400.0n 0.4202 35699.9n 0.4202 35700.0n 0.4202 35999.9n 0.4202 36000.0n 0.4202 36299.9n 0.4202 36300.0n 0.4202 36599.9n 0.4202 36600.0n 0.4664 36899.9n 0.4664 36900.0n 0.4202 37199.9n 0.4202 37200.0n 0.7435 37499.9n 0.7435 37500.0n 0.4202 37799.9n 0.4202 37800.0n 0.4895 38099.9n 0.4895 38100.0n 0.5126 38399.9n 0.5126 38400.0n 0.5818 38699.9n 0.5818 38700.0n 0.4895 38999.9n 0.4895 39000.0n 0.5126 39299.9n 0.5126 39300.0n 0.5357 39599.9n 0.5357 39600.0n 0.5587 39899.9n 0.5587 39900.0n 0.4895 40199.9n 0.4895 40200.0n 0.4202 40499.9n 0.4202 40500.0n 0.4202 40799.9n 0.4202 40800.0n 0.4202 41099.9n 0.4202 41100.0n 0.4202 41399.9n 0.4202 41400.0n 0.4202 41699.9n 0.4202 41700.0n 0.4202 41999.9n 0.4202 42000.0n 0.4664 42299.9n 0.4664 42300.0n 0.4202 42599.9n 0.4202 42600.0n 0.7435 42899.9n 0.7435 42900.0n 0.4202 43199.9n 0.4202 43200.0n 0.4895 43499.9n 0.4895 43500.0n 0.5126 43799.9n 0.5126 43800.0n 0.5818 44099.9n 0.5818 44100.0n 0.4895 44399.9n 0.4895 44400.0n 0.5126 44699.9n 0.5126 44700.0n 0.5357 44999.9n 0.5357 45000.0n 0.5587 45299.9n 0.5587 45300.0n 0.4895 45599.9n 0.4895 45600.0n 0.4202 45899.9n 0.4202 45900.0n 0.4202 46199.9n 0.4202 46200.0n 0.4202 46499.9n 0.4202 46500.0n 0.4202 46799.9n 0.4202 46800.0n 0.4202 47099.9n 0.4202 47100.0n 0.4202 47399.9n 0.4202 47400.0n 0.4664 47699.9n 0.4664 47700.0n 0.4202 47999.9n 0.4202 48000.0n 0.7435 48299.9n 0.7435 48300.0n 0.4202 48599.9n 0.4202 48600.0n 0.4895 48899.9n 0.4895 48900.0n 0.5126 49199.9n 0.5126 49200.0n 0.5818 49499.9n 0.5818 49500.0n 0.4895 49799.9n 0.4895 49800.0n 0.5126 50099.9n 0.5126 50100.0n 0.5357 50399.9n 0.5357 50400.0n 0.5587 50699.9n 0.5587 50700.0n 0.4895 50999.9n 0.4895 51000.0n 0.4202 51299.9n 0.4202 51300.0n 0.4202 51599.9n 0.4202 51600.0n 0.4202 51899.9n 0.4202 51900.0n 0.4202 52199.9n 0.4202 52200.0n 0.4202 52499.9n 0.4202 52500.0n 0.4202 52799.9n 0.4202 52800.0n 0.4664 53099.9n 0.4664 53100.0n 0.4202 53399.9n 0.4202 53400.0n 0.7435 53699.9n 0.7435 53700.0n 0.4202 53999.9n 0.4202 54000.0n 0.6280 54299.9n 0.6280 54300.0n 0.5818 54599.9n 0.5818 54600.0n 0.7204 54899.9n 0.7204 54900.0n 0.4202 55199.9n 0.4202 55200.0n 0.6280 55499.9n 0.6280 55500.0n 0.5126 55799.9n 0.5126 55800.0n 0.4202 56099.9n 0.4202 56100.0n 0.4202 56399.9n 0.4202 56400.0n 0.4202 56699.9n 0.4202 56700.0n 0.4202 56999.9n 0.4202 57000.0n 0.4202 57299.9n 0.4202 57300.0n 0.4202 57599.9n 0.4202 57600.0n 0.4202 57899.9n 0.4202 57900.0n 0.4895 58199.9n 0.4895 58200.0n 0.4202 58499.9n 0.4202 58500.0n 0.4202 58799.9n 0.4202 58800.0n 0.4664 59099.9n 0.4664 59100.0n 0.4202)
Vxn46 a_xn46 0 PWL(0.0n 0.5105 299.9n 0.5105 300.0n 0.4874 599.9n 0.4874 600.0n 0.4182 899.9n 0.4182 900.0n 0.5105 1199.9n 0.5105 1200.0n 0.4874 1499.9n 0.4874 1500.0n 0.4643 1799.9n 0.4643 1800.0n 0.4413 2099.9n 0.4413 2100.0n 0.5105 2399.9n 0.5105 2400.0n 0.5798 2699.9n 0.5798 2700.0n 0.5798 2999.9n 0.5798 3000.0n 0.5798 3299.9n 0.5798 3300.0n 0.5798 3599.9n 0.5798 3600.0n 0.5798 3899.9n 0.5798 3900.0n 0.5798 4199.9n 0.5798 4200.0n 0.5336 4499.9n 0.5336 4500.0n 0.5798 4799.9n 0.5798 4800.0n 0.2565 5099.9n 0.2565 5100.0n 0.5798 5399.9n 0.5798 5400.0n 0.5105 5699.9n 0.5105 5700.0n 0.4874 5999.9n 0.4874 6000.0n 0.4182 6299.9n 0.4182 6300.0n 0.5105 6599.9n 0.5105 6600.0n 0.4874 6899.9n 0.4874 6900.0n 0.4643 7199.9n 0.4643 7200.0n 0.4413 7499.9n 0.4413 7500.0n 0.5105 7799.9n 0.5105 7800.0n 0.5798 8099.9n 0.5798 8100.0n 0.5798 8399.9n 0.5798 8400.0n 0.5798 8699.9n 0.5798 8700.0n 0.5798 8999.9n 0.5798 9000.0n 0.5798 9299.9n 0.5798 9300.0n 0.5798 9599.9n 0.5798 9600.0n 0.5336 9899.9n 0.5336 9900.0n 0.5798 10199.9n 0.5798 10200.0n 0.2565 10499.9n 0.2565 10500.0n 0.5798 10799.9n 0.5798 10800.0n 0.5105 11099.9n 0.5105 11100.0n 0.4874 11399.9n 0.4874 11400.0n 0.4182 11699.9n 0.4182 11700.0n 0.5105 11999.9n 0.5105 12000.0n 0.4874 12299.9n 0.4874 12300.0n 0.4643 12599.9n 0.4643 12600.0n 0.4413 12899.9n 0.4413 12900.0n 0.5105 13199.9n 0.5105 13200.0n 0.5798 13499.9n 0.5798 13500.0n 0.5798 13799.9n 0.5798 13800.0n 0.5798 14099.9n 0.5798 14100.0n 0.5798 14399.9n 0.5798 14400.0n 0.5798 14699.9n 0.5798 14700.0n 0.5798 14999.9n 0.5798 15000.0n 0.5336 15299.9n 0.5336 15300.0n 0.5798 15599.9n 0.5798 15600.0n 0.2565 15899.9n 0.2565 15900.0n 0.5798 16199.9n 0.5798 16200.0n 0.5105 16499.9n 0.5105 16500.0n 0.4874 16799.9n 0.4874 16800.0n 0.4182 17099.9n 0.4182 17100.0n 0.5105 17399.9n 0.5105 17400.0n 0.4874 17699.9n 0.4874 17700.0n 0.4643 17999.9n 0.4643 18000.0n 0.4413 18299.9n 0.4413 18300.0n 0.5105 18599.9n 0.5105 18600.0n 0.5798 18899.9n 0.5798 18900.0n 0.5798 19199.9n 0.5798 19200.0n 0.5798 19499.9n 0.5798 19500.0n 0.5798 19799.9n 0.5798 19800.0n 0.5798 20099.9n 0.5798 20100.0n 0.5798 20399.9n 0.5798 20400.0n 0.5336 20699.9n 0.5336 20700.0n 0.5798 20999.9n 0.5798 21000.0n 0.2565 21299.9n 0.2565 21300.0n 0.5798 21599.9n 0.5798 21600.0n 0.5105 21899.9n 0.5105 21900.0n 0.4874 22199.9n 0.4874 22200.0n 0.4182 22499.9n 0.4182 22500.0n 0.5105 22799.9n 0.5105 22800.0n 0.4874 23099.9n 0.4874 23100.0n 0.4643 23399.9n 0.4643 23400.0n 0.4413 23699.9n 0.4413 23700.0n 0.5105 23999.9n 0.5105 24000.0n 0.5798 24299.9n 0.5798 24300.0n 0.5798 24599.9n 0.5798 24600.0n 0.5798 24899.9n 0.5798 24900.0n 0.5798 25199.9n 0.5798 25200.0n 0.5798 25499.9n 0.5798 25500.0n 0.5798 25799.9n 0.5798 25800.0n 0.5336 26099.9n 0.5336 26100.0n 0.5798 26399.9n 0.5798 26400.0n 0.2565 26699.9n 0.2565 26700.0n 0.5798 26999.9n 0.5798 27000.0n 0.5105 27299.9n 0.5105 27300.0n 0.4874 27599.9n 0.4874 27600.0n 0.4182 27899.9n 0.4182 27900.0n 0.5105 28199.9n 0.5105 28200.0n 0.4874 28499.9n 0.4874 28500.0n 0.4643 28799.9n 0.4643 28800.0n 0.4413 29099.9n 0.4413 29100.0n 0.5105 29399.9n 0.5105 29400.0n 0.5798 29699.9n 0.5798 29700.0n 0.5798 29999.9n 0.5798 30000.0n 0.5798 30299.9n 0.5798 30300.0n 0.5798 30599.9n 0.5798 30600.0n 0.5798 30899.9n 0.5798 30900.0n 0.5798 31199.9n 0.5798 31200.0n 0.5336 31499.9n 0.5336 31500.0n 0.5798 31799.9n 0.5798 31800.0n 0.2565 32099.9n 0.2565 32100.0n 0.5798 32399.9n 0.5798 32400.0n 0.5105 32699.9n 0.5105 32700.0n 0.4874 32999.9n 0.4874 33000.0n 0.4182 33299.9n 0.4182 33300.0n 0.5105 33599.9n 0.5105 33600.0n 0.4874 33899.9n 0.4874 33900.0n 0.4643 34199.9n 0.4643 34200.0n 0.4413 34499.9n 0.4413 34500.0n 0.5105 34799.9n 0.5105 34800.0n 0.5798 35099.9n 0.5798 35100.0n 0.5798 35399.9n 0.5798 35400.0n 0.5798 35699.9n 0.5798 35700.0n 0.5798 35999.9n 0.5798 36000.0n 0.5798 36299.9n 0.5798 36300.0n 0.5798 36599.9n 0.5798 36600.0n 0.5336 36899.9n 0.5336 36900.0n 0.5798 37199.9n 0.5798 37200.0n 0.2565 37499.9n 0.2565 37500.0n 0.5798 37799.9n 0.5798 37800.0n 0.5105 38099.9n 0.5105 38100.0n 0.4874 38399.9n 0.4874 38400.0n 0.4182 38699.9n 0.4182 38700.0n 0.5105 38999.9n 0.5105 39000.0n 0.4874 39299.9n 0.4874 39300.0n 0.4643 39599.9n 0.4643 39600.0n 0.4413 39899.9n 0.4413 39900.0n 0.5105 40199.9n 0.5105 40200.0n 0.5798 40499.9n 0.5798 40500.0n 0.5798 40799.9n 0.5798 40800.0n 0.5798 41099.9n 0.5798 41100.0n 0.5798 41399.9n 0.5798 41400.0n 0.5798 41699.9n 0.5798 41700.0n 0.5798 41999.9n 0.5798 42000.0n 0.5336 42299.9n 0.5336 42300.0n 0.5798 42599.9n 0.5798 42600.0n 0.2565 42899.9n 0.2565 42900.0n 0.5798 43199.9n 0.5798 43200.0n 0.5105 43499.9n 0.5105 43500.0n 0.4874 43799.9n 0.4874 43800.0n 0.4182 44099.9n 0.4182 44100.0n 0.5105 44399.9n 0.5105 44400.0n 0.4874 44699.9n 0.4874 44700.0n 0.4643 44999.9n 0.4643 45000.0n 0.4413 45299.9n 0.4413 45300.0n 0.5105 45599.9n 0.5105 45600.0n 0.5798 45899.9n 0.5798 45900.0n 0.5798 46199.9n 0.5798 46200.0n 0.5798 46499.9n 0.5798 46500.0n 0.5798 46799.9n 0.5798 46800.0n 0.5798 47099.9n 0.5798 47100.0n 0.5798 47399.9n 0.5798 47400.0n 0.5336 47699.9n 0.5336 47700.0n 0.5798 47999.9n 0.5798 48000.0n 0.2565 48299.9n 0.2565 48300.0n 0.5798 48599.9n 0.5798 48600.0n 0.5105 48899.9n 0.5105 48900.0n 0.4874 49199.9n 0.4874 49200.0n 0.4182 49499.9n 0.4182 49500.0n 0.5105 49799.9n 0.5105 49800.0n 0.4874 50099.9n 0.4874 50100.0n 0.4643 50399.9n 0.4643 50400.0n 0.4413 50699.9n 0.4413 50700.0n 0.5105 50999.9n 0.5105 51000.0n 0.5798 51299.9n 0.5798 51300.0n 0.5798 51599.9n 0.5798 51600.0n 0.5798 51899.9n 0.5798 51900.0n 0.5798 52199.9n 0.5798 52200.0n 0.5798 52499.9n 0.5798 52500.0n 0.5798 52799.9n 0.5798 52800.0n 0.5336 53099.9n 0.5336 53100.0n 0.5798 53399.9n 0.5798 53400.0n 0.2565 53699.9n 0.2565 53700.0n 0.5798 53999.9n 0.5798 54000.0n 0.3720 54299.9n 0.3720 54300.0n 0.4182 54599.9n 0.4182 54600.0n 0.2796 54899.9n 0.2796 54900.0n 0.5798 55199.9n 0.5798 55200.0n 0.3720 55499.9n 0.3720 55500.0n 0.4874 55799.9n 0.4874 55800.0n 0.5798 56099.9n 0.5798 56100.0n 0.5798 56399.9n 0.5798 56400.0n 0.5798 56699.9n 0.5798 56700.0n 0.5798 56999.9n 0.5798 57000.0n 0.5798 57299.9n 0.5798 57300.0n 0.5798 57599.9n 0.5798 57600.0n 0.5798 57899.9n 0.5798 57900.0n 0.5105 58199.9n 0.5105 58200.0n 0.5798 58499.9n 0.5798 58500.0n 0.5798 58799.9n 0.5798 58800.0n 0.5336 59099.9n 0.5336 59100.0n 0.5798)
Vxp47 a_xp47 0 PWL(0.0n 0.4911 299.9n 0.4911 300.0n 0.4911 599.9n 0.4911 600.0n 0.4911 899.9n 0.4911 900.0n 0.4911 1199.9n 0.4911 1200.0n 0.4911 1499.9n 0.4911 1500.0n 0.4911 1799.9n 0.4911 1800.0n 0.4911 2099.9n 0.4911 2100.0n 0.4911 2399.9n 0.4911 2400.0n 0.4911 2699.9n 0.4911 2700.0n 0.4911 2999.9n 0.4911 3000.0n 0.4911 3299.9n 0.4911 3300.0n 0.4911 3599.9n 0.4911 3600.0n 0.4911 3899.9n 0.4911 3900.0n 0.4911 4199.9n 0.4911 4200.0n 0.4911 4499.9n 0.4911 4500.0n 0.4911 4799.9n 0.4911 4800.0n 0.4911 5099.9n 0.4911 5100.0n 0.4911 5399.9n 0.4911 5400.0n 0.4911 5699.9n 0.4911 5700.0n 0.4911 5999.9n 0.4911 6000.0n 0.4911 6299.9n 0.4911 6300.0n 0.4911 6599.9n 0.4911 6600.0n 0.4911 6899.9n 0.4911 6900.0n 0.4911 7199.9n 0.4911 7200.0n 0.4911 7499.9n 0.4911 7500.0n 0.4911 7799.9n 0.4911 7800.0n 0.4911 8099.9n 0.4911 8100.0n 0.4911 8399.9n 0.4911 8400.0n 0.4911 8699.9n 0.4911 8700.0n 0.4911 8999.9n 0.4911 9000.0n 0.4911 9299.9n 0.4911 9300.0n 0.4911 9599.9n 0.4911 9600.0n 0.4911 9899.9n 0.4911 9900.0n 0.4911 10199.9n 0.4911 10200.0n 0.4911 10499.9n 0.4911 10500.0n 0.4911 10799.9n 0.4911 10800.0n 0.4911 11099.9n 0.4911 11100.0n 0.4911 11399.9n 0.4911 11400.0n 0.4911 11699.9n 0.4911 11700.0n 0.4911 11999.9n 0.4911 12000.0n 0.4911 12299.9n 0.4911 12300.0n 0.4911 12599.9n 0.4911 12600.0n 0.4911 12899.9n 0.4911 12900.0n 0.4911 13199.9n 0.4911 13200.0n 0.4911 13499.9n 0.4911 13500.0n 0.4911 13799.9n 0.4911 13800.0n 0.4911 14099.9n 0.4911 14100.0n 0.4911 14399.9n 0.4911 14400.0n 0.4911 14699.9n 0.4911 14700.0n 0.4911 14999.9n 0.4911 15000.0n 0.4911 15299.9n 0.4911 15300.0n 0.4911 15599.9n 0.4911 15600.0n 0.4911 15899.9n 0.4911 15900.0n 0.4911 16199.9n 0.4911 16200.0n 0.4911 16499.9n 0.4911 16500.0n 0.4911 16799.9n 0.4911 16800.0n 0.4911 17099.9n 0.4911 17100.0n 0.4911 17399.9n 0.4911 17400.0n 0.4911 17699.9n 0.4911 17700.0n 0.4911 17999.9n 0.4911 18000.0n 0.4911 18299.9n 0.4911 18300.0n 0.4911 18599.9n 0.4911 18600.0n 0.4911 18899.9n 0.4911 18900.0n 0.4911 19199.9n 0.4911 19200.0n 0.4911 19499.9n 0.4911 19500.0n 0.4911 19799.9n 0.4911 19800.0n 0.4911 20099.9n 0.4911 20100.0n 0.4911 20399.9n 0.4911 20400.0n 0.4911 20699.9n 0.4911 20700.0n 0.4911 20999.9n 0.4911 21000.0n 0.4911 21299.9n 0.4911 21300.0n 0.4911 21599.9n 0.4911 21600.0n 0.4911 21899.9n 0.4911 21900.0n 0.4911 22199.9n 0.4911 22200.0n 0.4911 22499.9n 0.4911 22500.0n 0.4911 22799.9n 0.4911 22800.0n 0.4911 23099.9n 0.4911 23100.0n 0.4911 23399.9n 0.4911 23400.0n 0.4911 23699.9n 0.4911 23700.0n 0.4911 23999.9n 0.4911 24000.0n 0.4911 24299.9n 0.4911 24300.0n 0.4911 24599.9n 0.4911 24600.0n 0.4911 24899.9n 0.4911 24900.0n 0.4911 25199.9n 0.4911 25200.0n 0.4911 25499.9n 0.4911 25500.0n 0.4911 25799.9n 0.4911 25800.0n 0.4911 26099.9n 0.4911 26100.0n 0.4911 26399.9n 0.4911 26400.0n 0.4911 26699.9n 0.4911 26700.0n 0.4911 26999.9n 0.4911 27000.0n 0.4911 27299.9n 0.4911 27300.0n 0.4911 27599.9n 0.4911 27600.0n 0.4911 27899.9n 0.4911 27900.0n 0.4911 28199.9n 0.4911 28200.0n 0.4911 28499.9n 0.4911 28500.0n 0.4911 28799.9n 0.4911 28800.0n 0.4911 29099.9n 0.4911 29100.0n 0.4911 29399.9n 0.4911 29400.0n 0.4911 29699.9n 0.4911 29700.0n 0.4911 29999.9n 0.4911 30000.0n 0.4911 30299.9n 0.4911 30300.0n 0.4911 30599.9n 0.4911 30600.0n 0.4911 30899.9n 0.4911 30900.0n 0.4911 31199.9n 0.4911 31200.0n 0.4911 31499.9n 0.4911 31500.0n 0.4911 31799.9n 0.4911 31800.0n 0.4911 32099.9n 0.4911 32100.0n 0.4911 32399.9n 0.4911 32400.0n 0.4911 32699.9n 0.4911 32700.0n 0.4911 32999.9n 0.4911 33000.0n 0.4911 33299.9n 0.4911 33300.0n 0.4911 33599.9n 0.4911 33600.0n 0.4911 33899.9n 0.4911 33900.0n 0.4911 34199.9n 0.4911 34200.0n 0.4911 34499.9n 0.4911 34500.0n 0.4911 34799.9n 0.4911 34800.0n 0.4911 35099.9n 0.4911 35100.0n 0.4911 35399.9n 0.4911 35400.0n 0.4911 35699.9n 0.4911 35700.0n 0.4911 35999.9n 0.4911 36000.0n 0.4911 36299.9n 0.4911 36300.0n 0.4911 36599.9n 0.4911 36600.0n 0.4911 36899.9n 0.4911 36900.0n 0.4911 37199.9n 0.4911 37200.0n 0.4911 37499.9n 0.4911 37500.0n 0.4911 37799.9n 0.4911 37800.0n 0.4911 38099.9n 0.4911 38100.0n 0.4911 38399.9n 0.4911 38400.0n 0.4911 38699.9n 0.4911 38700.0n 0.4911 38999.9n 0.4911 39000.0n 0.4911 39299.9n 0.4911 39300.0n 0.4911 39599.9n 0.4911 39600.0n 0.4911 39899.9n 0.4911 39900.0n 0.4911 40199.9n 0.4911 40200.0n 0.4911 40499.9n 0.4911 40500.0n 0.4911 40799.9n 0.4911 40800.0n 0.4911 41099.9n 0.4911 41100.0n 0.4911 41399.9n 0.4911 41400.0n 0.4911 41699.9n 0.4911 41700.0n 0.4911 41999.9n 0.4911 42000.0n 0.4911 42299.9n 0.4911 42300.0n 0.4911 42599.9n 0.4911 42600.0n 0.4911 42899.9n 0.4911 42900.0n 0.4911 43199.9n 0.4911 43200.0n 0.4911 43499.9n 0.4911 43500.0n 0.4911 43799.9n 0.4911 43800.0n 0.4911 44099.9n 0.4911 44100.0n 0.4911 44399.9n 0.4911 44400.0n 0.4911 44699.9n 0.4911 44700.0n 0.4911 44999.9n 0.4911 45000.0n 0.4911 45299.9n 0.4911 45300.0n 0.4911 45599.9n 0.4911 45600.0n 0.4911 45899.9n 0.4911 45900.0n 0.4911 46199.9n 0.4911 46200.0n 0.4911 46499.9n 0.4911 46500.0n 0.4911 46799.9n 0.4911 46800.0n 0.4911 47099.9n 0.4911 47100.0n 0.4911 47399.9n 0.4911 47400.0n 0.4911 47699.9n 0.4911 47700.0n 0.4911 47999.9n 0.4911 48000.0n 0.4911 48299.9n 0.4911 48300.0n 0.4911 48599.9n 0.4911 48600.0n 0.4911 48899.9n 0.4911 48900.0n 0.4911 49199.9n 0.4911 49200.0n 0.4911 49499.9n 0.4911 49500.0n 0.4911 49799.9n 0.4911 49800.0n 0.4911 50099.9n 0.4911 50100.0n 0.4911 50399.9n 0.4911 50400.0n 0.4911 50699.9n 0.4911 50700.0n 0.4911 50999.9n 0.4911 51000.0n 0.4911 51299.9n 0.4911 51300.0n 0.4911 51599.9n 0.4911 51600.0n 0.4911 51899.9n 0.4911 51900.0n 0.4911 52199.9n 0.4911 52200.0n 0.4911 52499.9n 0.4911 52500.0n 0.4911 52799.9n 0.4911 52800.0n 0.4911 53099.9n 0.4911 53100.0n 0.4911 53399.9n 0.4911 53400.0n 0.4911 53699.9n 0.4911 53700.0n 0.4911 53999.9n 0.4911 54000.0n 0.4911 54299.9n 0.4911 54300.0n 0.4911 54599.9n 0.4911 54600.0n 0.4911 54899.9n 0.4911 54900.0n 0.4911 55199.9n 0.4911 55200.0n 0.4911 55499.9n 0.4911 55500.0n 0.4911 55799.9n 0.4911 55800.0n 0.4911 56099.9n 0.4911 56100.0n 0.4911 56399.9n 0.4911 56400.0n 0.4911 56699.9n 0.4911 56700.0n 0.4911 56999.9n 0.4911 57000.0n 0.4911 57299.9n 0.4911 57300.0n 0.4911 57599.9n 0.4911 57600.0n 0.4911 57899.9n 0.4911 57900.0n 0.4911 58199.9n 0.4911 58200.0n 0.4911 58499.9n 0.4911 58500.0n 0.4911 58799.9n 0.4911 58800.0n 0.4911 59099.9n 0.4911 59100.0n 0.4911)
Vxn47 a_xn47 0 PWL(0.0n 0.5089 299.9n 0.5089 300.0n 0.5089 599.9n 0.5089 600.0n 0.5089 899.9n 0.5089 900.0n 0.5089 1199.9n 0.5089 1200.0n 0.5089 1499.9n 0.5089 1500.0n 0.5089 1799.9n 0.5089 1800.0n 0.5089 2099.9n 0.5089 2100.0n 0.5089 2399.9n 0.5089 2400.0n 0.5089 2699.9n 0.5089 2700.0n 0.5089 2999.9n 0.5089 3000.0n 0.5089 3299.9n 0.5089 3300.0n 0.5089 3599.9n 0.5089 3600.0n 0.5089 3899.9n 0.5089 3900.0n 0.5089 4199.9n 0.5089 4200.0n 0.5089 4499.9n 0.5089 4500.0n 0.5089 4799.9n 0.5089 4800.0n 0.5089 5099.9n 0.5089 5100.0n 0.5089 5399.9n 0.5089 5400.0n 0.5089 5699.9n 0.5089 5700.0n 0.5089 5999.9n 0.5089 6000.0n 0.5089 6299.9n 0.5089 6300.0n 0.5089 6599.9n 0.5089 6600.0n 0.5089 6899.9n 0.5089 6900.0n 0.5089 7199.9n 0.5089 7200.0n 0.5089 7499.9n 0.5089 7500.0n 0.5089 7799.9n 0.5089 7800.0n 0.5089 8099.9n 0.5089 8100.0n 0.5089 8399.9n 0.5089 8400.0n 0.5089 8699.9n 0.5089 8700.0n 0.5089 8999.9n 0.5089 9000.0n 0.5089 9299.9n 0.5089 9300.0n 0.5089 9599.9n 0.5089 9600.0n 0.5089 9899.9n 0.5089 9900.0n 0.5089 10199.9n 0.5089 10200.0n 0.5089 10499.9n 0.5089 10500.0n 0.5089 10799.9n 0.5089 10800.0n 0.5089 11099.9n 0.5089 11100.0n 0.5089 11399.9n 0.5089 11400.0n 0.5089 11699.9n 0.5089 11700.0n 0.5089 11999.9n 0.5089 12000.0n 0.5089 12299.9n 0.5089 12300.0n 0.5089 12599.9n 0.5089 12600.0n 0.5089 12899.9n 0.5089 12900.0n 0.5089 13199.9n 0.5089 13200.0n 0.5089 13499.9n 0.5089 13500.0n 0.5089 13799.9n 0.5089 13800.0n 0.5089 14099.9n 0.5089 14100.0n 0.5089 14399.9n 0.5089 14400.0n 0.5089 14699.9n 0.5089 14700.0n 0.5089 14999.9n 0.5089 15000.0n 0.5089 15299.9n 0.5089 15300.0n 0.5089 15599.9n 0.5089 15600.0n 0.5089 15899.9n 0.5089 15900.0n 0.5089 16199.9n 0.5089 16200.0n 0.5089 16499.9n 0.5089 16500.0n 0.5089 16799.9n 0.5089 16800.0n 0.5089 17099.9n 0.5089 17100.0n 0.5089 17399.9n 0.5089 17400.0n 0.5089 17699.9n 0.5089 17700.0n 0.5089 17999.9n 0.5089 18000.0n 0.5089 18299.9n 0.5089 18300.0n 0.5089 18599.9n 0.5089 18600.0n 0.5089 18899.9n 0.5089 18900.0n 0.5089 19199.9n 0.5089 19200.0n 0.5089 19499.9n 0.5089 19500.0n 0.5089 19799.9n 0.5089 19800.0n 0.5089 20099.9n 0.5089 20100.0n 0.5089 20399.9n 0.5089 20400.0n 0.5089 20699.9n 0.5089 20700.0n 0.5089 20999.9n 0.5089 21000.0n 0.5089 21299.9n 0.5089 21300.0n 0.5089 21599.9n 0.5089 21600.0n 0.5089 21899.9n 0.5089 21900.0n 0.5089 22199.9n 0.5089 22200.0n 0.5089 22499.9n 0.5089 22500.0n 0.5089 22799.9n 0.5089 22800.0n 0.5089 23099.9n 0.5089 23100.0n 0.5089 23399.9n 0.5089 23400.0n 0.5089 23699.9n 0.5089 23700.0n 0.5089 23999.9n 0.5089 24000.0n 0.5089 24299.9n 0.5089 24300.0n 0.5089 24599.9n 0.5089 24600.0n 0.5089 24899.9n 0.5089 24900.0n 0.5089 25199.9n 0.5089 25200.0n 0.5089 25499.9n 0.5089 25500.0n 0.5089 25799.9n 0.5089 25800.0n 0.5089 26099.9n 0.5089 26100.0n 0.5089 26399.9n 0.5089 26400.0n 0.5089 26699.9n 0.5089 26700.0n 0.5089 26999.9n 0.5089 27000.0n 0.5089 27299.9n 0.5089 27300.0n 0.5089 27599.9n 0.5089 27600.0n 0.5089 27899.9n 0.5089 27900.0n 0.5089 28199.9n 0.5089 28200.0n 0.5089 28499.9n 0.5089 28500.0n 0.5089 28799.9n 0.5089 28800.0n 0.5089 29099.9n 0.5089 29100.0n 0.5089 29399.9n 0.5089 29400.0n 0.5089 29699.9n 0.5089 29700.0n 0.5089 29999.9n 0.5089 30000.0n 0.5089 30299.9n 0.5089 30300.0n 0.5089 30599.9n 0.5089 30600.0n 0.5089 30899.9n 0.5089 30900.0n 0.5089 31199.9n 0.5089 31200.0n 0.5089 31499.9n 0.5089 31500.0n 0.5089 31799.9n 0.5089 31800.0n 0.5089 32099.9n 0.5089 32100.0n 0.5089 32399.9n 0.5089 32400.0n 0.5089 32699.9n 0.5089 32700.0n 0.5089 32999.9n 0.5089 33000.0n 0.5089 33299.9n 0.5089 33300.0n 0.5089 33599.9n 0.5089 33600.0n 0.5089 33899.9n 0.5089 33900.0n 0.5089 34199.9n 0.5089 34200.0n 0.5089 34499.9n 0.5089 34500.0n 0.5089 34799.9n 0.5089 34800.0n 0.5089 35099.9n 0.5089 35100.0n 0.5089 35399.9n 0.5089 35400.0n 0.5089 35699.9n 0.5089 35700.0n 0.5089 35999.9n 0.5089 36000.0n 0.5089 36299.9n 0.5089 36300.0n 0.5089 36599.9n 0.5089 36600.0n 0.5089 36899.9n 0.5089 36900.0n 0.5089 37199.9n 0.5089 37200.0n 0.5089 37499.9n 0.5089 37500.0n 0.5089 37799.9n 0.5089 37800.0n 0.5089 38099.9n 0.5089 38100.0n 0.5089 38399.9n 0.5089 38400.0n 0.5089 38699.9n 0.5089 38700.0n 0.5089 38999.9n 0.5089 39000.0n 0.5089 39299.9n 0.5089 39300.0n 0.5089 39599.9n 0.5089 39600.0n 0.5089 39899.9n 0.5089 39900.0n 0.5089 40199.9n 0.5089 40200.0n 0.5089 40499.9n 0.5089 40500.0n 0.5089 40799.9n 0.5089 40800.0n 0.5089 41099.9n 0.5089 41100.0n 0.5089 41399.9n 0.5089 41400.0n 0.5089 41699.9n 0.5089 41700.0n 0.5089 41999.9n 0.5089 42000.0n 0.5089 42299.9n 0.5089 42300.0n 0.5089 42599.9n 0.5089 42600.0n 0.5089 42899.9n 0.5089 42900.0n 0.5089 43199.9n 0.5089 43200.0n 0.5089 43499.9n 0.5089 43500.0n 0.5089 43799.9n 0.5089 43800.0n 0.5089 44099.9n 0.5089 44100.0n 0.5089 44399.9n 0.5089 44400.0n 0.5089 44699.9n 0.5089 44700.0n 0.5089 44999.9n 0.5089 45000.0n 0.5089 45299.9n 0.5089 45300.0n 0.5089 45599.9n 0.5089 45600.0n 0.5089 45899.9n 0.5089 45900.0n 0.5089 46199.9n 0.5089 46200.0n 0.5089 46499.9n 0.5089 46500.0n 0.5089 46799.9n 0.5089 46800.0n 0.5089 47099.9n 0.5089 47100.0n 0.5089 47399.9n 0.5089 47400.0n 0.5089 47699.9n 0.5089 47700.0n 0.5089 47999.9n 0.5089 48000.0n 0.5089 48299.9n 0.5089 48300.0n 0.5089 48599.9n 0.5089 48600.0n 0.5089 48899.9n 0.5089 48900.0n 0.5089 49199.9n 0.5089 49200.0n 0.5089 49499.9n 0.5089 49500.0n 0.5089 49799.9n 0.5089 49800.0n 0.5089 50099.9n 0.5089 50100.0n 0.5089 50399.9n 0.5089 50400.0n 0.5089 50699.9n 0.5089 50700.0n 0.5089 50999.9n 0.5089 51000.0n 0.5089 51299.9n 0.5089 51300.0n 0.5089 51599.9n 0.5089 51600.0n 0.5089 51899.9n 0.5089 51900.0n 0.5089 52199.9n 0.5089 52200.0n 0.5089 52499.9n 0.5089 52500.0n 0.5089 52799.9n 0.5089 52800.0n 0.5089 53099.9n 0.5089 53100.0n 0.5089 53399.9n 0.5089 53400.0n 0.5089 53699.9n 0.5089 53700.0n 0.5089 53999.9n 0.5089 54000.0n 0.5089 54299.9n 0.5089 54300.0n 0.5089 54599.9n 0.5089 54600.0n 0.5089 54899.9n 0.5089 54900.0n 0.5089 55199.9n 0.5089 55200.0n 0.5089 55499.9n 0.5089 55500.0n 0.5089 55799.9n 0.5089 55800.0n 0.5089 56099.9n 0.5089 56100.0n 0.5089 56399.9n 0.5089 56400.0n 0.5089 56699.9n 0.5089 56700.0n 0.5089 56999.9n 0.5089 57000.0n 0.5089 57299.9n 0.5089 57300.0n 0.5089 57599.9n 0.5089 57600.0n 0.5089 57899.9n 0.5089 57900.0n 0.5089 58199.9n 0.5089 58200.0n 0.5089 58499.9n 0.5089 58500.0n 0.5089 58799.9n 0.5089 58800.0n 0.5089 59099.9n 0.5089 59100.0n 0.5089)
Vxp48 a_xp48 0 PWL(0.0n 0.4965 299.9n 0.4965 300.0n 0.4965 599.9n 0.4965 600.0n 0.4965 899.9n 0.4965 900.0n 0.4965 1199.9n 0.4965 1200.0n 0.4965 1499.9n 0.4965 1500.0n 0.4965 1799.9n 0.4965 1800.0n 0.4965 2099.9n 0.4965 2100.0n 0.4965 2399.9n 0.4965 2400.0n 0.4965 2699.9n 0.4965 2700.0n 0.4965 2999.9n 0.4965 3000.0n 0.4965 3299.9n 0.4965 3300.0n 0.4965 3599.9n 0.4965 3600.0n 0.4965 3899.9n 0.4965 3900.0n 0.4965 4199.9n 0.4965 4200.0n 0.4965 4499.9n 0.4965 4500.0n 0.4965 4799.9n 0.4965 4800.0n 0.4965 5099.9n 0.4965 5100.0n 0.4965 5399.9n 0.4965 5400.0n 0.4965 5699.9n 0.4965 5700.0n 0.4965 5999.9n 0.4965 6000.0n 0.4965 6299.9n 0.4965 6300.0n 0.4965 6599.9n 0.4965 6600.0n 0.4965 6899.9n 0.4965 6900.0n 0.4965 7199.9n 0.4965 7200.0n 0.4965 7499.9n 0.4965 7500.0n 0.4965 7799.9n 0.4965 7800.0n 0.4965 8099.9n 0.4965 8100.0n 0.4965 8399.9n 0.4965 8400.0n 0.4965 8699.9n 0.4965 8700.0n 0.4965 8999.9n 0.4965 9000.0n 0.4965 9299.9n 0.4965 9300.0n 0.4965 9599.9n 0.4965 9600.0n 0.4965 9899.9n 0.4965 9900.0n 0.4965 10199.9n 0.4965 10200.0n 0.4965 10499.9n 0.4965 10500.0n 0.4965 10799.9n 0.4965 10800.0n 0.4965 11099.9n 0.4965 11100.0n 0.4965 11399.9n 0.4965 11400.0n 0.4965 11699.9n 0.4965 11700.0n 0.4965 11999.9n 0.4965 12000.0n 0.4965 12299.9n 0.4965 12300.0n 0.4965 12599.9n 0.4965 12600.0n 0.4965 12899.9n 0.4965 12900.0n 0.4965 13199.9n 0.4965 13200.0n 0.4965 13499.9n 0.4965 13500.0n 0.4965 13799.9n 0.4965 13800.0n 0.4965 14099.9n 0.4965 14100.0n 0.4965 14399.9n 0.4965 14400.0n 0.4965 14699.9n 0.4965 14700.0n 0.4965 14999.9n 0.4965 15000.0n 0.4965 15299.9n 0.4965 15300.0n 0.4965 15599.9n 0.4965 15600.0n 0.4965 15899.9n 0.4965 15900.0n 0.4965 16199.9n 0.4965 16200.0n 0.4965 16499.9n 0.4965 16500.0n 0.4965 16799.9n 0.4965 16800.0n 0.4965 17099.9n 0.4965 17100.0n 0.4965 17399.9n 0.4965 17400.0n 0.4965 17699.9n 0.4965 17700.0n 0.4965 17999.9n 0.4965 18000.0n 0.4965 18299.9n 0.4965 18300.0n 0.4965 18599.9n 0.4965 18600.0n 0.4965 18899.9n 0.4965 18900.0n 0.4965 19199.9n 0.4965 19200.0n 0.4965 19499.9n 0.4965 19500.0n 0.4965 19799.9n 0.4965 19800.0n 0.4965 20099.9n 0.4965 20100.0n 0.4965 20399.9n 0.4965 20400.0n 0.4965 20699.9n 0.4965 20700.0n 0.4965 20999.9n 0.4965 21000.0n 0.4965 21299.9n 0.4965 21300.0n 0.4965 21599.9n 0.4965 21600.0n 0.4965 21899.9n 0.4965 21900.0n 0.4965 22199.9n 0.4965 22200.0n 0.4965 22499.9n 0.4965 22500.0n 0.4965 22799.9n 0.4965 22800.0n 0.4965 23099.9n 0.4965 23100.0n 0.4965 23399.9n 0.4965 23400.0n 0.4965 23699.9n 0.4965 23700.0n 0.4965 23999.9n 0.4965 24000.0n 0.4965 24299.9n 0.4965 24300.0n 0.4965 24599.9n 0.4965 24600.0n 0.4965 24899.9n 0.4965 24900.0n 0.4965 25199.9n 0.4965 25200.0n 0.4965 25499.9n 0.4965 25500.0n 0.4965 25799.9n 0.4965 25800.0n 0.4965 26099.9n 0.4965 26100.0n 0.4965 26399.9n 0.4965 26400.0n 0.4965 26699.9n 0.4965 26700.0n 0.4965 26999.9n 0.4965 27000.0n 0.4965 27299.9n 0.4965 27300.0n 0.4965 27599.9n 0.4965 27600.0n 0.4965 27899.9n 0.4965 27900.0n 0.4965 28199.9n 0.4965 28200.0n 0.4965 28499.9n 0.4965 28500.0n 0.4965 28799.9n 0.4965 28800.0n 0.4965 29099.9n 0.4965 29100.0n 0.4965 29399.9n 0.4965 29400.0n 0.4965 29699.9n 0.4965 29700.0n 0.4965 29999.9n 0.4965 30000.0n 0.4965 30299.9n 0.4965 30300.0n 0.4965 30599.9n 0.4965 30600.0n 0.4965 30899.9n 0.4965 30900.0n 0.4965 31199.9n 0.4965 31200.0n 0.4965 31499.9n 0.4965 31500.0n 0.4965 31799.9n 0.4965 31800.0n 0.4965 32099.9n 0.4965 32100.0n 0.4965 32399.9n 0.4965 32400.0n 0.4965 32699.9n 0.4965 32700.0n 0.4965 32999.9n 0.4965 33000.0n 0.4965 33299.9n 0.4965 33300.0n 0.4965 33599.9n 0.4965 33600.0n 0.4965 33899.9n 0.4965 33900.0n 0.4965 34199.9n 0.4965 34200.0n 0.4965 34499.9n 0.4965 34500.0n 0.4965 34799.9n 0.4965 34800.0n 0.4965 35099.9n 0.4965 35100.0n 0.4965 35399.9n 0.4965 35400.0n 0.4965 35699.9n 0.4965 35700.0n 0.4965 35999.9n 0.4965 36000.0n 0.4965 36299.9n 0.4965 36300.0n 0.4965 36599.9n 0.4965 36600.0n 0.4965 36899.9n 0.4965 36900.0n 0.4965 37199.9n 0.4965 37200.0n 0.4965 37499.9n 0.4965 37500.0n 0.4965 37799.9n 0.4965 37800.0n 0.4965 38099.9n 0.4965 38100.0n 0.4965 38399.9n 0.4965 38400.0n 0.4965 38699.9n 0.4965 38700.0n 0.4965 38999.9n 0.4965 39000.0n 0.4965 39299.9n 0.4965 39300.0n 0.4965 39599.9n 0.4965 39600.0n 0.4965 39899.9n 0.4965 39900.0n 0.4965 40199.9n 0.4965 40200.0n 0.4965 40499.9n 0.4965 40500.0n 0.4965 40799.9n 0.4965 40800.0n 0.4965 41099.9n 0.4965 41100.0n 0.4965 41399.9n 0.4965 41400.0n 0.4965 41699.9n 0.4965 41700.0n 0.4965 41999.9n 0.4965 42000.0n 0.4965 42299.9n 0.4965 42300.0n 0.4965 42599.9n 0.4965 42600.0n 0.4965 42899.9n 0.4965 42900.0n 0.4965 43199.9n 0.4965 43200.0n 0.4965 43499.9n 0.4965 43500.0n 0.4965 43799.9n 0.4965 43800.0n 0.4965 44099.9n 0.4965 44100.0n 0.4965 44399.9n 0.4965 44400.0n 0.4965 44699.9n 0.4965 44700.0n 0.4965 44999.9n 0.4965 45000.0n 0.4965 45299.9n 0.4965 45300.0n 0.4965 45599.9n 0.4965 45600.0n 0.4965 45899.9n 0.4965 45900.0n 0.4965 46199.9n 0.4965 46200.0n 0.4965 46499.9n 0.4965 46500.0n 0.4965 46799.9n 0.4965 46800.0n 0.4965 47099.9n 0.4965 47100.0n 0.4965 47399.9n 0.4965 47400.0n 0.4965 47699.9n 0.4965 47700.0n 0.4965 47999.9n 0.4965 48000.0n 0.4965 48299.9n 0.4965 48300.0n 0.4965 48599.9n 0.4965 48600.0n 0.4965 48899.9n 0.4965 48900.0n 0.4965 49199.9n 0.4965 49200.0n 0.4965 49499.9n 0.4965 49500.0n 0.4965 49799.9n 0.4965 49800.0n 0.4965 50099.9n 0.4965 50100.0n 0.4965 50399.9n 0.4965 50400.0n 0.4965 50699.9n 0.4965 50700.0n 0.4965 50999.9n 0.4965 51000.0n 0.4965 51299.9n 0.4965 51300.0n 0.4965 51599.9n 0.4965 51600.0n 0.4965 51899.9n 0.4965 51900.0n 0.4965 52199.9n 0.4965 52200.0n 0.4965 52499.9n 0.4965 52500.0n 0.4965 52799.9n 0.4965 52800.0n 0.4965 53099.9n 0.4965 53100.0n 0.4965 53399.9n 0.4965 53400.0n 0.4965 53699.9n 0.4965 53700.0n 0.4965 53999.9n 0.4965 54000.0n 0.4965 54299.9n 0.4965 54300.0n 0.4965 54599.9n 0.4965 54600.0n 0.4965 54899.9n 0.4965 54900.0n 0.4965 55199.9n 0.4965 55200.0n 0.4965 55499.9n 0.4965 55500.0n 0.4965 55799.9n 0.4965 55800.0n 0.4965 56099.9n 0.4965 56100.0n 0.4965 56399.9n 0.4965 56400.0n 0.4965 56699.9n 0.4965 56700.0n 0.4965 56999.9n 0.4965 57000.0n 0.4965 57299.9n 0.4965 57300.0n 0.4965 57599.9n 0.4965 57600.0n 0.4965 57899.9n 0.4965 57900.0n 0.4965 58199.9n 0.4965 58200.0n 0.4965 58499.9n 0.4965 58500.0n 0.4965 58799.9n 0.4965 58800.0n 0.4965 59099.9n 0.4965 59100.0n 0.4965)
Vxn48 a_xn48 0 PWL(0.0n 0.5035 299.9n 0.5035 300.0n 0.5035 599.9n 0.5035 600.0n 0.5035 899.9n 0.5035 900.0n 0.5035 1199.9n 0.5035 1200.0n 0.5035 1499.9n 0.5035 1500.0n 0.5035 1799.9n 0.5035 1800.0n 0.5035 2099.9n 0.5035 2100.0n 0.5035 2399.9n 0.5035 2400.0n 0.5035 2699.9n 0.5035 2700.0n 0.5035 2999.9n 0.5035 3000.0n 0.5035 3299.9n 0.5035 3300.0n 0.5035 3599.9n 0.5035 3600.0n 0.5035 3899.9n 0.5035 3900.0n 0.5035 4199.9n 0.5035 4200.0n 0.5035 4499.9n 0.5035 4500.0n 0.5035 4799.9n 0.5035 4800.0n 0.5035 5099.9n 0.5035 5100.0n 0.5035 5399.9n 0.5035 5400.0n 0.5035 5699.9n 0.5035 5700.0n 0.5035 5999.9n 0.5035 6000.0n 0.5035 6299.9n 0.5035 6300.0n 0.5035 6599.9n 0.5035 6600.0n 0.5035 6899.9n 0.5035 6900.0n 0.5035 7199.9n 0.5035 7200.0n 0.5035 7499.9n 0.5035 7500.0n 0.5035 7799.9n 0.5035 7800.0n 0.5035 8099.9n 0.5035 8100.0n 0.5035 8399.9n 0.5035 8400.0n 0.5035 8699.9n 0.5035 8700.0n 0.5035 8999.9n 0.5035 9000.0n 0.5035 9299.9n 0.5035 9300.0n 0.5035 9599.9n 0.5035 9600.0n 0.5035 9899.9n 0.5035 9900.0n 0.5035 10199.9n 0.5035 10200.0n 0.5035 10499.9n 0.5035 10500.0n 0.5035 10799.9n 0.5035 10800.0n 0.5035 11099.9n 0.5035 11100.0n 0.5035 11399.9n 0.5035 11400.0n 0.5035 11699.9n 0.5035 11700.0n 0.5035 11999.9n 0.5035 12000.0n 0.5035 12299.9n 0.5035 12300.0n 0.5035 12599.9n 0.5035 12600.0n 0.5035 12899.9n 0.5035 12900.0n 0.5035 13199.9n 0.5035 13200.0n 0.5035 13499.9n 0.5035 13500.0n 0.5035 13799.9n 0.5035 13800.0n 0.5035 14099.9n 0.5035 14100.0n 0.5035 14399.9n 0.5035 14400.0n 0.5035 14699.9n 0.5035 14700.0n 0.5035 14999.9n 0.5035 15000.0n 0.5035 15299.9n 0.5035 15300.0n 0.5035 15599.9n 0.5035 15600.0n 0.5035 15899.9n 0.5035 15900.0n 0.5035 16199.9n 0.5035 16200.0n 0.5035 16499.9n 0.5035 16500.0n 0.5035 16799.9n 0.5035 16800.0n 0.5035 17099.9n 0.5035 17100.0n 0.5035 17399.9n 0.5035 17400.0n 0.5035 17699.9n 0.5035 17700.0n 0.5035 17999.9n 0.5035 18000.0n 0.5035 18299.9n 0.5035 18300.0n 0.5035 18599.9n 0.5035 18600.0n 0.5035 18899.9n 0.5035 18900.0n 0.5035 19199.9n 0.5035 19200.0n 0.5035 19499.9n 0.5035 19500.0n 0.5035 19799.9n 0.5035 19800.0n 0.5035 20099.9n 0.5035 20100.0n 0.5035 20399.9n 0.5035 20400.0n 0.5035 20699.9n 0.5035 20700.0n 0.5035 20999.9n 0.5035 21000.0n 0.5035 21299.9n 0.5035 21300.0n 0.5035 21599.9n 0.5035 21600.0n 0.5035 21899.9n 0.5035 21900.0n 0.5035 22199.9n 0.5035 22200.0n 0.5035 22499.9n 0.5035 22500.0n 0.5035 22799.9n 0.5035 22800.0n 0.5035 23099.9n 0.5035 23100.0n 0.5035 23399.9n 0.5035 23400.0n 0.5035 23699.9n 0.5035 23700.0n 0.5035 23999.9n 0.5035 24000.0n 0.5035 24299.9n 0.5035 24300.0n 0.5035 24599.9n 0.5035 24600.0n 0.5035 24899.9n 0.5035 24900.0n 0.5035 25199.9n 0.5035 25200.0n 0.5035 25499.9n 0.5035 25500.0n 0.5035 25799.9n 0.5035 25800.0n 0.5035 26099.9n 0.5035 26100.0n 0.5035 26399.9n 0.5035 26400.0n 0.5035 26699.9n 0.5035 26700.0n 0.5035 26999.9n 0.5035 27000.0n 0.5035 27299.9n 0.5035 27300.0n 0.5035 27599.9n 0.5035 27600.0n 0.5035 27899.9n 0.5035 27900.0n 0.5035 28199.9n 0.5035 28200.0n 0.5035 28499.9n 0.5035 28500.0n 0.5035 28799.9n 0.5035 28800.0n 0.5035 29099.9n 0.5035 29100.0n 0.5035 29399.9n 0.5035 29400.0n 0.5035 29699.9n 0.5035 29700.0n 0.5035 29999.9n 0.5035 30000.0n 0.5035 30299.9n 0.5035 30300.0n 0.5035 30599.9n 0.5035 30600.0n 0.5035 30899.9n 0.5035 30900.0n 0.5035 31199.9n 0.5035 31200.0n 0.5035 31499.9n 0.5035 31500.0n 0.5035 31799.9n 0.5035 31800.0n 0.5035 32099.9n 0.5035 32100.0n 0.5035 32399.9n 0.5035 32400.0n 0.5035 32699.9n 0.5035 32700.0n 0.5035 32999.9n 0.5035 33000.0n 0.5035 33299.9n 0.5035 33300.0n 0.5035 33599.9n 0.5035 33600.0n 0.5035 33899.9n 0.5035 33900.0n 0.5035 34199.9n 0.5035 34200.0n 0.5035 34499.9n 0.5035 34500.0n 0.5035 34799.9n 0.5035 34800.0n 0.5035 35099.9n 0.5035 35100.0n 0.5035 35399.9n 0.5035 35400.0n 0.5035 35699.9n 0.5035 35700.0n 0.5035 35999.9n 0.5035 36000.0n 0.5035 36299.9n 0.5035 36300.0n 0.5035 36599.9n 0.5035 36600.0n 0.5035 36899.9n 0.5035 36900.0n 0.5035 37199.9n 0.5035 37200.0n 0.5035 37499.9n 0.5035 37500.0n 0.5035 37799.9n 0.5035 37800.0n 0.5035 38099.9n 0.5035 38100.0n 0.5035 38399.9n 0.5035 38400.0n 0.5035 38699.9n 0.5035 38700.0n 0.5035 38999.9n 0.5035 39000.0n 0.5035 39299.9n 0.5035 39300.0n 0.5035 39599.9n 0.5035 39600.0n 0.5035 39899.9n 0.5035 39900.0n 0.5035 40199.9n 0.5035 40200.0n 0.5035 40499.9n 0.5035 40500.0n 0.5035 40799.9n 0.5035 40800.0n 0.5035 41099.9n 0.5035 41100.0n 0.5035 41399.9n 0.5035 41400.0n 0.5035 41699.9n 0.5035 41700.0n 0.5035 41999.9n 0.5035 42000.0n 0.5035 42299.9n 0.5035 42300.0n 0.5035 42599.9n 0.5035 42600.0n 0.5035 42899.9n 0.5035 42900.0n 0.5035 43199.9n 0.5035 43200.0n 0.5035 43499.9n 0.5035 43500.0n 0.5035 43799.9n 0.5035 43800.0n 0.5035 44099.9n 0.5035 44100.0n 0.5035 44399.9n 0.5035 44400.0n 0.5035 44699.9n 0.5035 44700.0n 0.5035 44999.9n 0.5035 45000.0n 0.5035 45299.9n 0.5035 45300.0n 0.5035 45599.9n 0.5035 45600.0n 0.5035 45899.9n 0.5035 45900.0n 0.5035 46199.9n 0.5035 46200.0n 0.5035 46499.9n 0.5035 46500.0n 0.5035 46799.9n 0.5035 46800.0n 0.5035 47099.9n 0.5035 47100.0n 0.5035 47399.9n 0.5035 47400.0n 0.5035 47699.9n 0.5035 47700.0n 0.5035 47999.9n 0.5035 48000.0n 0.5035 48299.9n 0.5035 48300.0n 0.5035 48599.9n 0.5035 48600.0n 0.5035 48899.9n 0.5035 48900.0n 0.5035 49199.9n 0.5035 49200.0n 0.5035 49499.9n 0.5035 49500.0n 0.5035 49799.9n 0.5035 49800.0n 0.5035 50099.9n 0.5035 50100.0n 0.5035 50399.9n 0.5035 50400.0n 0.5035 50699.9n 0.5035 50700.0n 0.5035 50999.9n 0.5035 51000.0n 0.5035 51299.9n 0.5035 51300.0n 0.5035 51599.9n 0.5035 51600.0n 0.5035 51899.9n 0.5035 51900.0n 0.5035 52199.9n 0.5035 52200.0n 0.5035 52499.9n 0.5035 52500.0n 0.5035 52799.9n 0.5035 52800.0n 0.5035 53099.9n 0.5035 53100.0n 0.5035 53399.9n 0.5035 53400.0n 0.5035 53699.9n 0.5035 53700.0n 0.5035 53999.9n 0.5035 54000.0n 0.5035 54299.9n 0.5035 54300.0n 0.5035 54599.9n 0.5035 54600.0n 0.5035 54899.9n 0.5035 54900.0n 0.5035 55199.9n 0.5035 55200.0n 0.5035 55499.9n 0.5035 55500.0n 0.5035 55799.9n 0.5035 55800.0n 0.5035 56099.9n 0.5035 56100.0n 0.5035 56399.9n 0.5035 56400.0n 0.5035 56699.9n 0.5035 56700.0n 0.5035 56999.9n 0.5035 57000.0n 0.5035 57299.9n 0.5035 57300.0n 0.5035 57599.9n 0.5035 57600.0n 0.5035 57899.9n 0.5035 57900.0n 0.5035 58199.9n 0.5035 58200.0n 0.5035 58499.9n 0.5035 58500.0n 0.5035 58799.9n 0.5035 58800.0n 0.5035 59099.9n 0.5035 59100.0n 0.5035)
Vxp49 a_xp49 0 PWL(0.0n 0.4596 299.9n 0.4596 300.0n 0.4596 599.9n 0.4596 600.0n 0.6315 899.9n 0.6315 900.0n 0.5742 1199.9n 0.5742 1200.0n 0.4596 1499.9n 0.4596 1500.0n 0.4596 1799.9n 0.4596 1800.0n 0.4596 2099.9n 0.4596 2100.0n 0.4596 2399.9n 0.4596 2400.0n 0.4596 2699.9n 0.4596 2700.0n 0.4596 2999.9n 0.4596 3000.0n 0.4596 3299.9n 0.4596 3300.0n 0.7461 3599.9n 0.7461 3600.0n 0.4596 3899.9n 0.4596 3900.0n 0.4596 4199.9n 0.4596 4200.0n 0.5169 4499.9n 0.5169 4500.0n 0.4596 4799.9n 0.4596 4800.0n 0.4596 5099.9n 0.4596 5100.0n 0.4596 5399.9n 0.4596 5400.0n 0.4596 5699.9n 0.4596 5700.0n 0.4596 5999.9n 0.4596 6000.0n 0.6315 6299.9n 0.6315 6300.0n 0.5742 6599.9n 0.5742 6600.0n 0.4596 6899.9n 0.4596 6900.0n 0.4596 7199.9n 0.4596 7200.0n 0.4596 7499.9n 0.4596 7500.0n 0.4596 7799.9n 0.4596 7800.0n 0.4596 8099.9n 0.4596 8100.0n 0.4596 8399.9n 0.4596 8400.0n 0.4596 8699.9n 0.4596 8700.0n 0.7461 8999.9n 0.7461 9000.0n 0.4596 9299.9n 0.4596 9300.0n 0.4596 9599.9n 0.4596 9600.0n 0.5169 9899.9n 0.5169 9900.0n 0.4596 10199.9n 0.4596 10200.0n 0.4596 10499.9n 0.4596 10500.0n 0.4596 10799.9n 0.4596 10800.0n 0.4596 11099.9n 0.4596 11100.0n 0.4596 11399.9n 0.4596 11400.0n 0.6315 11699.9n 0.6315 11700.0n 0.5742 11999.9n 0.5742 12000.0n 0.4596 12299.9n 0.4596 12300.0n 0.4596 12599.9n 0.4596 12600.0n 0.4596 12899.9n 0.4596 12900.0n 0.4596 13199.9n 0.4596 13200.0n 0.4596 13499.9n 0.4596 13500.0n 0.4596 13799.9n 0.4596 13800.0n 0.4596 14099.9n 0.4596 14100.0n 0.7461 14399.9n 0.7461 14400.0n 0.4596 14699.9n 0.4596 14700.0n 0.4596 14999.9n 0.4596 15000.0n 0.5169 15299.9n 0.5169 15300.0n 0.4596 15599.9n 0.4596 15600.0n 0.4596 15899.9n 0.4596 15900.0n 0.4596 16199.9n 0.4596 16200.0n 0.4596 16499.9n 0.4596 16500.0n 0.4596 16799.9n 0.4596 16800.0n 0.6315 17099.9n 0.6315 17100.0n 0.5742 17399.9n 0.5742 17400.0n 0.4596 17699.9n 0.4596 17700.0n 0.4596 17999.9n 0.4596 18000.0n 0.4596 18299.9n 0.4596 18300.0n 0.4596 18599.9n 0.4596 18600.0n 0.4596 18899.9n 0.4596 18900.0n 0.4596 19199.9n 0.4596 19200.0n 0.4596 19499.9n 0.4596 19500.0n 0.7461 19799.9n 0.7461 19800.0n 0.4596 20099.9n 0.4596 20100.0n 0.4596 20399.9n 0.4596 20400.0n 0.5169 20699.9n 0.5169 20700.0n 0.4596 20999.9n 0.4596 21000.0n 0.4596 21299.9n 0.4596 21300.0n 0.4596 21599.9n 0.4596 21600.0n 0.4596 21899.9n 0.4596 21900.0n 0.4596 22199.9n 0.4596 22200.0n 0.6315 22499.9n 0.6315 22500.0n 0.5742 22799.9n 0.5742 22800.0n 0.4596 23099.9n 0.4596 23100.0n 0.4596 23399.9n 0.4596 23400.0n 0.4596 23699.9n 0.4596 23700.0n 0.4596 23999.9n 0.4596 24000.0n 0.4596 24299.9n 0.4596 24300.0n 0.4596 24599.9n 0.4596 24600.0n 0.4596 24899.9n 0.4596 24900.0n 0.7461 25199.9n 0.7461 25200.0n 0.4596 25499.9n 0.4596 25500.0n 0.4596 25799.9n 0.4596 25800.0n 0.5169 26099.9n 0.5169 26100.0n 0.4596 26399.9n 0.4596 26400.0n 0.4596 26699.9n 0.4596 26700.0n 0.4596 26999.9n 0.4596 27000.0n 0.4596 27299.9n 0.4596 27300.0n 0.4596 27599.9n 0.4596 27600.0n 0.6315 27899.9n 0.6315 27900.0n 0.5742 28199.9n 0.5742 28200.0n 0.4596 28499.9n 0.4596 28500.0n 0.4596 28799.9n 0.4596 28800.0n 0.4596 29099.9n 0.4596 29100.0n 0.4596 29399.9n 0.4596 29400.0n 0.4596 29699.9n 0.4596 29700.0n 0.4596 29999.9n 0.4596 30000.0n 0.4596 30299.9n 0.4596 30300.0n 0.7461 30599.9n 0.7461 30600.0n 0.4596 30899.9n 0.4596 30900.0n 0.4596 31199.9n 0.4596 31200.0n 0.5169 31499.9n 0.5169 31500.0n 0.4596 31799.9n 0.4596 31800.0n 0.4596 32099.9n 0.4596 32100.0n 0.4596 32399.9n 0.4596 32400.0n 0.4596 32699.9n 0.4596 32700.0n 0.4596 32999.9n 0.4596 33000.0n 0.6315 33299.9n 0.6315 33300.0n 0.5742 33599.9n 0.5742 33600.0n 0.4596 33899.9n 0.4596 33900.0n 0.4596 34199.9n 0.4596 34200.0n 0.4596 34499.9n 0.4596 34500.0n 0.4596 34799.9n 0.4596 34800.0n 0.4596 35099.9n 0.4596 35100.0n 0.4596 35399.9n 0.4596 35400.0n 0.4596 35699.9n 0.4596 35700.0n 0.7461 35999.9n 0.7461 36000.0n 0.4596 36299.9n 0.4596 36300.0n 0.4596 36599.9n 0.4596 36600.0n 0.5169 36899.9n 0.5169 36900.0n 0.4596 37199.9n 0.4596 37200.0n 0.4596 37499.9n 0.4596 37500.0n 0.4596 37799.9n 0.4596 37800.0n 0.4596 38099.9n 0.4596 38100.0n 0.4596 38399.9n 0.4596 38400.0n 0.6315 38699.9n 0.6315 38700.0n 0.5742 38999.9n 0.5742 39000.0n 0.4596 39299.9n 0.4596 39300.0n 0.4596 39599.9n 0.4596 39600.0n 0.4596 39899.9n 0.4596 39900.0n 0.4596 40199.9n 0.4596 40200.0n 0.4596 40499.9n 0.4596 40500.0n 0.4596 40799.9n 0.4596 40800.0n 0.4596 41099.9n 0.4596 41100.0n 0.7461 41399.9n 0.7461 41400.0n 0.4596 41699.9n 0.4596 41700.0n 0.4596 41999.9n 0.4596 42000.0n 0.5169 42299.9n 0.5169 42300.0n 0.4596 42599.9n 0.4596 42600.0n 0.4596 42899.9n 0.4596 42900.0n 0.4596 43199.9n 0.4596 43200.0n 0.4596 43499.9n 0.4596 43500.0n 0.4596 43799.9n 0.4596 43800.0n 0.6315 44099.9n 0.6315 44100.0n 0.5742 44399.9n 0.5742 44400.0n 0.4596 44699.9n 0.4596 44700.0n 0.4596 44999.9n 0.4596 45000.0n 0.4596 45299.9n 0.4596 45300.0n 0.4596 45599.9n 0.4596 45600.0n 0.4596 45899.9n 0.4596 45900.0n 0.4596 46199.9n 0.4596 46200.0n 0.4596 46499.9n 0.4596 46500.0n 0.7461 46799.9n 0.7461 46800.0n 0.4596 47099.9n 0.4596 47100.0n 0.4596 47399.9n 0.4596 47400.0n 0.5169 47699.9n 0.5169 47700.0n 0.4596 47999.9n 0.4596 48000.0n 0.4596 48299.9n 0.4596 48300.0n 0.4596 48599.9n 0.4596 48600.0n 0.4596 48899.9n 0.4596 48900.0n 0.4596 49199.9n 0.4596 49200.0n 0.6315 49499.9n 0.6315 49500.0n 0.5742 49799.9n 0.5742 49800.0n 0.4596 50099.9n 0.4596 50100.0n 0.4596 50399.9n 0.4596 50400.0n 0.4596 50699.9n 0.4596 50700.0n 0.4596 50999.9n 0.4596 51000.0n 0.4596 51299.9n 0.4596 51300.0n 0.4596 51599.9n 0.4596 51600.0n 0.4596 51899.9n 0.4596 51900.0n 0.7461 52199.9n 0.7461 52200.0n 0.4596 52499.9n 0.4596 52500.0n 0.4596 52799.9n 0.4596 52800.0n 0.5169 53099.9n 0.5169 53100.0n 0.4596 53399.9n 0.4596 53400.0n 0.4596 53699.9n 0.4596 53700.0n 0.4596 53999.9n 0.4596 54000.0n 0.4596 54299.9n 0.4596 54300.0n 0.4596 54599.9n 0.4596 54600.0n 0.4596 54899.9n 0.4596 54900.0n 0.4596 55199.9n 0.4596 55200.0n 0.4596 55499.9n 0.4596 55500.0n 0.5169 55799.9n 0.5169 55800.0n 0.4596 56099.9n 0.4596 56100.0n 0.4596 56399.9n 0.4596 56400.0n 0.4596 56699.9n 0.4596 56700.0n 0.4596 56999.9n 0.4596 57000.0n 0.4596 57299.9n 0.4596 57300.0n 0.6315 57599.9n 0.6315 57600.0n 0.4596 57899.9n 0.4596 57900.0n 0.6315 58199.9n 0.6315 58200.0n 0.4596 58499.9n 0.4596 58500.0n 0.6888 58799.9n 0.6888 58800.0n 0.4596 59099.9n 0.4596 59100.0n 0.4596)
Vxn49 a_xn49 0 PWL(0.0n 0.5404 299.9n 0.5404 300.0n 0.5404 599.9n 0.5404 600.0n 0.3685 899.9n 0.3685 900.0n 0.4258 1199.9n 0.4258 1200.0n 0.5404 1499.9n 0.5404 1500.0n 0.5404 1799.9n 0.5404 1800.0n 0.5404 2099.9n 0.5404 2100.0n 0.5404 2399.9n 0.5404 2400.0n 0.5404 2699.9n 0.5404 2700.0n 0.5404 2999.9n 0.5404 3000.0n 0.5404 3299.9n 0.5404 3300.0n 0.2539 3599.9n 0.2539 3600.0n 0.5404 3899.9n 0.5404 3900.0n 0.5404 4199.9n 0.5404 4200.0n 0.4831 4499.9n 0.4831 4500.0n 0.5404 4799.9n 0.5404 4800.0n 0.5404 5099.9n 0.5404 5100.0n 0.5404 5399.9n 0.5404 5400.0n 0.5404 5699.9n 0.5404 5700.0n 0.5404 5999.9n 0.5404 6000.0n 0.3685 6299.9n 0.3685 6300.0n 0.4258 6599.9n 0.4258 6600.0n 0.5404 6899.9n 0.5404 6900.0n 0.5404 7199.9n 0.5404 7200.0n 0.5404 7499.9n 0.5404 7500.0n 0.5404 7799.9n 0.5404 7800.0n 0.5404 8099.9n 0.5404 8100.0n 0.5404 8399.9n 0.5404 8400.0n 0.5404 8699.9n 0.5404 8700.0n 0.2539 8999.9n 0.2539 9000.0n 0.5404 9299.9n 0.5404 9300.0n 0.5404 9599.9n 0.5404 9600.0n 0.4831 9899.9n 0.4831 9900.0n 0.5404 10199.9n 0.5404 10200.0n 0.5404 10499.9n 0.5404 10500.0n 0.5404 10799.9n 0.5404 10800.0n 0.5404 11099.9n 0.5404 11100.0n 0.5404 11399.9n 0.5404 11400.0n 0.3685 11699.9n 0.3685 11700.0n 0.4258 11999.9n 0.4258 12000.0n 0.5404 12299.9n 0.5404 12300.0n 0.5404 12599.9n 0.5404 12600.0n 0.5404 12899.9n 0.5404 12900.0n 0.5404 13199.9n 0.5404 13200.0n 0.5404 13499.9n 0.5404 13500.0n 0.5404 13799.9n 0.5404 13800.0n 0.5404 14099.9n 0.5404 14100.0n 0.2539 14399.9n 0.2539 14400.0n 0.5404 14699.9n 0.5404 14700.0n 0.5404 14999.9n 0.5404 15000.0n 0.4831 15299.9n 0.4831 15300.0n 0.5404 15599.9n 0.5404 15600.0n 0.5404 15899.9n 0.5404 15900.0n 0.5404 16199.9n 0.5404 16200.0n 0.5404 16499.9n 0.5404 16500.0n 0.5404 16799.9n 0.5404 16800.0n 0.3685 17099.9n 0.3685 17100.0n 0.4258 17399.9n 0.4258 17400.0n 0.5404 17699.9n 0.5404 17700.0n 0.5404 17999.9n 0.5404 18000.0n 0.5404 18299.9n 0.5404 18300.0n 0.5404 18599.9n 0.5404 18600.0n 0.5404 18899.9n 0.5404 18900.0n 0.5404 19199.9n 0.5404 19200.0n 0.5404 19499.9n 0.5404 19500.0n 0.2539 19799.9n 0.2539 19800.0n 0.5404 20099.9n 0.5404 20100.0n 0.5404 20399.9n 0.5404 20400.0n 0.4831 20699.9n 0.4831 20700.0n 0.5404 20999.9n 0.5404 21000.0n 0.5404 21299.9n 0.5404 21300.0n 0.5404 21599.9n 0.5404 21600.0n 0.5404 21899.9n 0.5404 21900.0n 0.5404 22199.9n 0.5404 22200.0n 0.3685 22499.9n 0.3685 22500.0n 0.4258 22799.9n 0.4258 22800.0n 0.5404 23099.9n 0.5404 23100.0n 0.5404 23399.9n 0.5404 23400.0n 0.5404 23699.9n 0.5404 23700.0n 0.5404 23999.9n 0.5404 24000.0n 0.5404 24299.9n 0.5404 24300.0n 0.5404 24599.9n 0.5404 24600.0n 0.5404 24899.9n 0.5404 24900.0n 0.2539 25199.9n 0.2539 25200.0n 0.5404 25499.9n 0.5404 25500.0n 0.5404 25799.9n 0.5404 25800.0n 0.4831 26099.9n 0.4831 26100.0n 0.5404 26399.9n 0.5404 26400.0n 0.5404 26699.9n 0.5404 26700.0n 0.5404 26999.9n 0.5404 27000.0n 0.5404 27299.9n 0.5404 27300.0n 0.5404 27599.9n 0.5404 27600.0n 0.3685 27899.9n 0.3685 27900.0n 0.4258 28199.9n 0.4258 28200.0n 0.5404 28499.9n 0.5404 28500.0n 0.5404 28799.9n 0.5404 28800.0n 0.5404 29099.9n 0.5404 29100.0n 0.5404 29399.9n 0.5404 29400.0n 0.5404 29699.9n 0.5404 29700.0n 0.5404 29999.9n 0.5404 30000.0n 0.5404 30299.9n 0.5404 30300.0n 0.2539 30599.9n 0.2539 30600.0n 0.5404 30899.9n 0.5404 30900.0n 0.5404 31199.9n 0.5404 31200.0n 0.4831 31499.9n 0.4831 31500.0n 0.5404 31799.9n 0.5404 31800.0n 0.5404 32099.9n 0.5404 32100.0n 0.5404 32399.9n 0.5404 32400.0n 0.5404 32699.9n 0.5404 32700.0n 0.5404 32999.9n 0.5404 33000.0n 0.3685 33299.9n 0.3685 33300.0n 0.4258 33599.9n 0.4258 33600.0n 0.5404 33899.9n 0.5404 33900.0n 0.5404 34199.9n 0.5404 34200.0n 0.5404 34499.9n 0.5404 34500.0n 0.5404 34799.9n 0.5404 34800.0n 0.5404 35099.9n 0.5404 35100.0n 0.5404 35399.9n 0.5404 35400.0n 0.5404 35699.9n 0.5404 35700.0n 0.2539 35999.9n 0.2539 36000.0n 0.5404 36299.9n 0.5404 36300.0n 0.5404 36599.9n 0.5404 36600.0n 0.4831 36899.9n 0.4831 36900.0n 0.5404 37199.9n 0.5404 37200.0n 0.5404 37499.9n 0.5404 37500.0n 0.5404 37799.9n 0.5404 37800.0n 0.5404 38099.9n 0.5404 38100.0n 0.5404 38399.9n 0.5404 38400.0n 0.3685 38699.9n 0.3685 38700.0n 0.4258 38999.9n 0.4258 39000.0n 0.5404 39299.9n 0.5404 39300.0n 0.5404 39599.9n 0.5404 39600.0n 0.5404 39899.9n 0.5404 39900.0n 0.5404 40199.9n 0.5404 40200.0n 0.5404 40499.9n 0.5404 40500.0n 0.5404 40799.9n 0.5404 40800.0n 0.5404 41099.9n 0.5404 41100.0n 0.2539 41399.9n 0.2539 41400.0n 0.5404 41699.9n 0.5404 41700.0n 0.5404 41999.9n 0.5404 42000.0n 0.4831 42299.9n 0.4831 42300.0n 0.5404 42599.9n 0.5404 42600.0n 0.5404 42899.9n 0.5404 42900.0n 0.5404 43199.9n 0.5404 43200.0n 0.5404 43499.9n 0.5404 43500.0n 0.5404 43799.9n 0.5404 43800.0n 0.3685 44099.9n 0.3685 44100.0n 0.4258 44399.9n 0.4258 44400.0n 0.5404 44699.9n 0.5404 44700.0n 0.5404 44999.9n 0.5404 45000.0n 0.5404 45299.9n 0.5404 45300.0n 0.5404 45599.9n 0.5404 45600.0n 0.5404 45899.9n 0.5404 45900.0n 0.5404 46199.9n 0.5404 46200.0n 0.5404 46499.9n 0.5404 46500.0n 0.2539 46799.9n 0.2539 46800.0n 0.5404 47099.9n 0.5404 47100.0n 0.5404 47399.9n 0.5404 47400.0n 0.4831 47699.9n 0.4831 47700.0n 0.5404 47999.9n 0.5404 48000.0n 0.5404 48299.9n 0.5404 48300.0n 0.5404 48599.9n 0.5404 48600.0n 0.5404 48899.9n 0.5404 48900.0n 0.5404 49199.9n 0.5404 49200.0n 0.3685 49499.9n 0.3685 49500.0n 0.4258 49799.9n 0.4258 49800.0n 0.5404 50099.9n 0.5404 50100.0n 0.5404 50399.9n 0.5404 50400.0n 0.5404 50699.9n 0.5404 50700.0n 0.5404 50999.9n 0.5404 51000.0n 0.5404 51299.9n 0.5404 51300.0n 0.5404 51599.9n 0.5404 51600.0n 0.5404 51899.9n 0.5404 51900.0n 0.2539 52199.9n 0.2539 52200.0n 0.5404 52499.9n 0.5404 52500.0n 0.5404 52799.9n 0.5404 52800.0n 0.4831 53099.9n 0.4831 53100.0n 0.5404 53399.9n 0.5404 53400.0n 0.5404 53699.9n 0.5404 53700.0n 0.5404 53999.9n 0.5404 54000.0n 0.5404 54299.9n 0.5404 54300.0n 0.5404 54599.9n 0.5404 54600.0n 0.5404 54899.9n 0.5404 54900.0n 0.5404 55199.9n 0.5404 55200.0n 0.5404 55499.9n 0.5404 55500.0n 0.4831 55799.9n 0.4831 55800.0n 0.5404 56099.9n 0.5404 56100.0n 0.5404 56399.9n 0.5404 56400.0n 0.5404 56699.9n 0.5404 56700.0n 0.5404 56999.9n 0.5404 57000.0n 0.5404 57299.9n 0.5404 57300.0n 0.3685 57599.9n 0.3685 57600.0n 0.5404 57899.9n 0.5404 57900.0n 0.3685 58199.9n 0.3685 58200.0n 0.5404 58499.9n 0.5404 58500.0n 0.3112 58799.9n 0.3112 58800.0n 0.5404 59099.9n 0.5404 59100.0n 0.5404)
Vxp50 a_xp50 0 PWL(0.0n 0.3670 299.9n 0.3670 300.0n 0.6151 599.9n 0.6151 600.0n 0.6505 899.9n 0.6505 900.0n 0.6505 1199.9n 0.6505 1200.0n 0.3670 1499.9n 0.3670 1500.0n 0.6505 1799.9n 0.6505 1800.0n 0.5796 2099.9n 0.5796 2100.0n 0.3670 2399.9n 0.3670 2400.0n 0.6151 2699.9n 0.6151 2700.0n 0.5265 2999.9n 0.5265 3000.0n 0.6151 3299.9n 0.6151 3300.0n 0.6505 3599.9n 0.6505 3600.0n 0.3670 3899.9n 0.3670 3900.0n 0.3670 4199.9n 0.3670 4200.0n 0.5796 4499.9n 0.5796 4500.0n 0.5619 4799.9n 0.5619 4800.0n 0.4910 5099.9n 0.4910 5100.0n 0.3847 5399.9n 0.3847 5400.0n 0.3670 5699.9n 0.3670 5700.0n 0.6151 5999.9n 0.6151 6000.0n 0.6505 6299.9n 0.6505 6300.0n 0.6505 6599.9n 0.6505 6600.0n 0.3670 6899.9n 0.3670 6900.0n 0.6505 7199.9n 0.6505 7200.0n 0.5796 7499.9n 0.5796 7500.0n 0.3670 7799.9n 0.3670 7800.0n 0.6151 8099.9n 0.6151 8100.0n 0.5265 8399.9n 0.5265 8400.0n 0.6151 8699.9n 0.6151 8700.0n 0.6505 8999.9n 0.6505 9000.0n 0.3670 9299.9n 0.3670 9300.0n 0.3670 9599.9n 0.3670 9600.0n 0.5796 9899.9n 0.5796 9900.0n 0.5619 10199.9n 0.5619 10200.0n 0.4910 10499.9n 0.4910 10500.0n 0.3847 10799.9n 0.3847 10800.0n 0.3670 11099.9n 0.3670 11100.0n 0.6151 11399.9n 0.6151 11400.0n 0.6505 11699.9n 0.6505 11700.0n 0.6505 11999.9n 0.6505 12000.0n 0.3670 12299.9n 0.3670 12300.0n 0.6505 12599.9n 0.6505 12600.0n 0.5796 12899.9n 0.5796 12900.0n 0.3670 13199.9n 0.3670 13200.0n 0.6151 13499.9n 0.6151 13500.0n 0.5265 13799.9n 0.5265 13800.0n 0.6151 14099.9n 0.6151 14100.0n 0.6505 14399.9n 0.6505 14400.0n 0.3670 14699.9n 0.3670 14700.0n 0.3670 14999.9n 0.3670 15000.0n 0.5796 15299.9n 0.5796 15300.0n 0.5619 15599.9n 0.5619 15600.0n 0.4910 15899.9n 0.4910 15900.0n 0.3847 16199.9n 0.3847 16200.0n 0.3670 16499.9n 0.3670 16500.0n 0.6151 16799.9n 0.6151 16800.0n 0.6505 17099.9n 0.6505 17100.0n 0.6505 17399.9n 0.6505 17400.0n 0.3670 17699.9n 0.3670 17700.0n 0.6505 17999.9n 0.6505 18000.0n 0.5796 18299.9n 0.5796 18300.0n 0.3670 18599.9n 0.3670 18600.0n 0.6151 18899.9n 0.6151 18900.0n 0.5265 19199.9n 0.5265 19200.0n 0.6151 19499.9n 0.6151 19500.0n 0.6505 19799.9n 0.6505 19800.0n 0.3670 20099.9n 0.3670 20100.0n 0.3670 20399.9n 0.3670 20400.0n 0.5796 20699.9n 0.5796 20700.0n 0.5619 20999.9n 0.5619 21000.0n 0.4910 21299.9n 0.4910 21300.0n 0.3847 21599.9n 0.3847 21600.0n 0.3670 21899.9n 0.3670 21900.0n 0.6151 22199.9n 0.6151 22200.0n 0.6505 22499.9n 0.6505 22500.0n 0.6505 22799.9n 0.6505 22800.0n 0.3670 23099.9n 0.3670 23100.0n 0.6505 23399.9n 0.6505 23400.0n 0.5796 23699.9n 0.5796 23700.0n 0.3670 23999.9n 0.3670 24000.0n 0.6151 24299.9n 0.6151 24300.0n 0.5265 24599.9n 0.5265 24600.0n 0.6151 24899.9n 0.6151 24900.0n 0.6505 25199.9n 0.6505 25200.0n 0.3670 25499.9n 0.3670 25500.0n 0.3670 25799.9n 0.3670 25800.0n 0.5796 26099.9n 0.5796 26100.0n 0.5619 26399.9n 0.5619 26400.0n 0.4910 26699.9n 0.4910 26700.0n 0.3847 26999.9n 0.3847 27000.0n 0.3670 27299.9n 0.3670 27300.0n 0.6151 27599.9n 0.6151 27600.0n 0.6505 27899.9n 0.6505 27900.0n 0.6505 28199.9n 0.6505 28200.0n 0.3670 28499.9n 0.3670 28500.0n 0.6505 28799.9n 0.6505 28800.0n 0.5796 29099.9n 0.5796 29100.0n 0.3670 29399.9n 0.3670 29400.0n 0.6151 29699.9n 0.6151 29700.0n 0.5265 29999.9n 0.5265 30000.0n 0.6151 30299.9n 0.6151 30300.0n 0.6505 30599.9n 0.6505 30600.0n 0.3670 30899.9n 0.3670 30900.0n 0.3670 31199.9n 0.3670 31200.0n 0.5796 31499.9n 0.5796 31500.0n 0.5619 31799.9n 0.5619 31800.0n 0.4910 32099.9n 0.4910 32100.0n 0.3847 32399.9n 0.3847 32400.0n 0.3670 32699.9n 0.3670 32700.0n 0.6151 32999.9n 0.6151 33000.0n 0.6505 33299.9n 0.6505 33300.0n 0.6505 33599.9n 0.6505 33600.0n 0.3670 33899.9n 0.3670 33900.0n 0.6505 34199.9n 0.6505 34200.0n 0.5796 34499.9n 0.5796 34500.0n 0.3670 34799.9n 0.3670 34800.0n 0.6151 35099.9n 0.6151 35100.0n 0.5265 35399.9n 0.5265 35400.0n 0.6151 35699.9n 0.6151 35700.0n 0.6505 35999.9n 0.6505 36000.0n 0.3670 36299.9n 0.3670 36300.0n 0.3670 36599.9n 0.3670 36600.0n 0.5796 36899.9n 0.5796 36900.0n 0.5619 37199.9n 0.5619 37200.0n 0.4910 37499.9n 0.4910 37500.0n 0.3847 37799.9n 0.3847 37800.0n 0.3670 38099.9n 0.3670 38100.0n 0.6151 38399.9n 0.6151 38400.0n 0.6505 38699.9n 0.6505 38700.0n 0.6505 38999.9n 0.6505 39000.0n 0.3670 39299.9n 0.3670 39300.0n 0.6505 39599.9n 0.6505 39600.0n 0.5796 39899.9n 0.5796 39900.0n 0.3670 40199.9n 0.3670 40200.0n 0.6151 40499.9n 0.6151 40500.0n 0.5265 40799.9n 0.5265 40800.0n 0.6151 41099.9n 0.6151 41100.0n 0.6505 41399.9n 0.6505 41400.0n 0.3670 41699.9n 0.3670 41700.0n 0.3670 41999.9n 0.3670 42000.0n 0.5796 42299.9n 0.5796 42300.0n 0.5619 42599.9n 0.5619 42600.0n 0.4910 42899.9n 0.4910 42900.0n 0.3847 43199.9n 0.3847 43200.0n 0.3670 43499.9n 0.3670 43500.0n 0.6151 43799.9n 0.6151 43800.0n 0.6505 44099.9n 0.6505 44100.0n 0.6505 44399.9n 0.6505 44400.0n 0.3670 44699.9n 0.3670 44700.0n 0.6505 44999.9n 0.6505 45000.0n 0.5796 45299.9n 0.5796 45300.0n 0.3670 45599.9n 0.3670 45600.0n 0.6151 45899.9n 0.6151 45900.0n 0.5265 46199.9n 0.5265 46200.0n 0.6151 46499.9n 0.6151 46500.0n 0.6505 46799.9n 0.6505 46800.0n 0.3670 47099.9n 0.3670 47100.0n 0.3670 47399.9n 0.3670 47400.0n 0.5796 47699.9n 0.5796 47700.0n 0.5619 47999.9n 0.5619 48000.0n 0.4910 48299.9n 0.4910 48300.0n 0.3847 48599.9n 0.3847 48600.0n 0.3670 48899.9n 0.3670 48900.0n 0.6151 49199.9n 0.6151 49200.0n 0.6505 49499.9n 0.6505 49500.0n 0.6505 49799.9n 0.6505 49800.0n 0.3670 50099.9n 0.3670 50100.0n 0.6505 50399.9n 0.6505 50400.0n 0.5796 50699.9n 0.5796 50700.0n 0.3670 50999.9n 0.3670 51000.0n 0.6151 51299.9n 0.6151 51300.0n 0.5265 51599.9n 0.5265 51600.0n 0.6151 51899.9n 0.6151 51900.0n 0.6505 52199.9n 0.6505 52200.0n 0.3670 52499.9n 0.3670 52500.0n 0.3670 52799.9n 0.3670 52800.0n 0.5796 53099.9n 0.5796 53100.0n 0.5619 53399.9n 0.5619 53400.0n 0.4910 53699.9n 0.4910 53700.0n 0.3847 53999.9n 0.3847 54000.0n 0.5973 54299.9n 0.5973 54300.0n 0.6151 54599.9n 0.6151 54600.0n 0.6328 54899.9n 0.6328 54900.0n 0.6151 55199.9n 0.6151 55200.0n 0.6328 55499.9n 0.6328 55500.0n 0.6151 55799.9n 0.6151 55800.0n 0.3847 56099.9n 0.3847 56100.0n 0.5619 56399.9n 0.5619 56400.0n 0.3670 56699.9n 0.3670 56700.0n 0.5796 56999.9n 0.5796 57000.0n 0.3670 57299.9n 0.3670 57300.0n 0.6328 57599.9n 0.6328 57600.0n 0.4910 57899.9n 0.4910 57900.0n 0.6328 58199.9n 0.6328 58200.0n 0.5796 58499.9n 0.5796 58500.0n 0.6505 58799.9n 0.6505 58800.0n 0.5087 59099.9n 0.5087 59100.0n 0.6505)
Vxn50 a_xn50 0 PWL(0.0n 0.6330 299.9n 0.6330 300.0n 0.3849 599.9n 0.3849 600.0n 0.3495 899.9n 0.3495 900.0n 0.3495 1199.9n 0.3495 1200.0n 0.6330 1499.9n 0.6330 1500.0n 0.3495 1799.9n 0.3495 1800.0n 0.4204 2099.9n 0.4204 2100.0n 0.6330 2399.9n 0.6330 2400.0n 0.3849 2699.9n 0.3849 2700.0n 0.4735 2999.9n 0.4735 3000.0n 0.3849 3299.9n 0.3849 3300.0n 0.3495 3599.9n 0.3495 3600.0n 0.6330 3899.9n 0.6330 3900.0n 0.6330 4199.9n 0.6330 4200.0n 0.4204 4499.9n 0.4204 4500.0n 0.4381 4799.9n 0.4381 4800.0n 0.5090 5099.9n 0.5090 5100.0n 0.6153 5399.9n 0.6153 5400.0n 0.6330 5699.9n 0.6330 5700.0n 0.3849 5999.9n 0.3849 6000.0n 0.3495 6299.9n 0.3495 6300.0n 0.3495 6599.9n 0.3495 6600.0n 0.6330 6899.9n 0.6330 6900.0n 0.3495 7199.9n 0.3495 7200.0n 0.4204 7499.9n 0.4204 7500.0n 0.6330 7799.9n 0.6330 7800.0n 0.3849 8099.9n 0.3849 8100.0n 0.4735 8399.9n 0.4735 8400.0n 0.3849 8699.9n 0.3849 8700.0n 0.3495 8999.9n 0.3495 9000.0n 0.6330 9299.9n 0.6330 9300.0n 0.6330 9599.9n 0.6330 9600.0n 0.4204 9899.9n 0.4204 9900.0n 0.4381 10199.9n 0.4381 10200.0n 0.5090 10499.9n 0.5090 10500.0n 0.6153 10799.9n 0.6153 10800.0n 0.6330 11099.9n 0.6330 11100.0n 0.3849 11399.9n 0.3849 11400.0n 0.3495 11699.9n 0.3495 11700.0n 0.3495 11999.9n 0.3495 12000.0n 0.6330 12299.9n 0.6330 12300.0n 0.3495 12599.9n 0.3495 12600.0n 0.4204 12899.9n 0.4204 12900.0n 0.6330 13199.9n 0.6330 13200.0n 0.3849 13499.9n 0.3849 13500.0n 0.4735 13799.9n 0.4735 13800.0n 0.3849 14099.9n 0.3849 14100.0n 0.3495 14399.9n 0.3495 14400.0n 0.6330 14699.9n 0.6330 14700.0n 0.6330 14999.9n 0.6330 15000.0n 0.4204 15299.9n 0.4204 15300.0n 0.4381 15599.9n 0.4381 15600.0n 0.5090 15899.9n 0.5090 15900.0n 0.6153 16199.9n 0.6153 16200.0n 0.6330 16499.9n 0.6330 16500.0n 0.3849 16799.9n 0.3849 16800.0n 0.3495 17099.9n 0.3495 17100.0n 0.3495 17399.9n 0.3495 17400.0n 0.6330 17699.9n 0.6330 17700.0n 0.3495 17999.9n 0.3495 18000.0n 0.4204 18299.9n 0.4204 18300.0n 0.6330 18599.9n 0.6330 18600.0n 0.3849 18899.9n 0.3849 18900.0n 0.4735 19199.9n 0.4735 19200.0n 0.3849 19499.9n 0.3849 19500.0n 0.3495 19799.9n 0.3495 19800.0n 0.6330 20099.9n 0.6330 20100.0n 0.6330 20399.9n 0.6330 20400.0n 0.4204 20699.9n 0.4204 20700.0n 0.4381 20999.9n 0.4381 21000.0n 0.5090 21299.9n 0.5090 21300.0n 0.6153 21599.9n 0.6153 21600.0n 0.6330 21899.9n 0.6330 21900.0n 0.3849 22199.9n 0.3849 22200.0n 0.3495 22499.9n 0.3495 22500.0n 0.3495 22799.9n 0.3495 22800.0n 0.6330 23099.9n 0.6330 23100.0n 0.3495 23399.9n 0.3495 23400.0n 0.4204 23699.9n 0.4204 23700.0n 0.6330 23999.9n 0.6330 24000.0n 0.3849 24299.9n 0.3849 24300.0n 0.4735 24599.9n 0.4735 24600.0n 0.3849 24899.9n 0.3849 24900.0n 0.3495 25199.9n 0.3495 25200.0n 0.6330 25499.9n 0.6330 25500.0n 0.6330 25799.9n 0.6330 25800.0n 0.4204 26099.9n 0.4204 26100.0n 0.4381 26399.9n 0.4381 26400.0n 0.5090 26699.9n 0.5090 26700.0n 0.6153 26999.9n 0.6153 27000.0n 0.6330 27299.9n 0.6330 27300.0n 0.3849 27599.9n 0.3849 27600.0n 0.3495 27899.9n 0.3495 27900.0n 0.3495 28199.9n 0.3495 28200.0n 0.6330 28499.9n 0.6330 28500.0n 0.3495 28799.9n 0.3495 28800.0n 0.4204 29099.9n 0.4204 29100.0n 0.6330 29399.9n 0.6330 29400.0n 0.3849 29699.9n 0.3849 29700.0n 0.4735 29999.9n 0.4735 30000.0n 0.3849 30299.9n 0.3849 30300.0n 0.3495 30599.9n 0.3495 30600.0n 0.6330 30899.9n 0.6330 30900.0n 0.6330 31199.9n 0.6330 31200.0n 0.4204 31499.9n 0.4204 31500.0n 0.4381 31799.9n 0.4381 31800.0n 0.5090 32099.9n 0.5090 32100.0n 0.6153 32399.9n 0.6153 32400.0n 0.6330 32699.9n 0.6330 32700.0n 0.3849 32999.9n 0.3849 33000.0n 0.3495 33299.9n 0.3495 33300.0n 0.3495 33599.9n 0.3495 33600.0n 0.6330 33899.9n 0.6330 33900.0n 0.3495 34199.9n 0.3495 34200.0n 0.4204 34499.9n 0.4204 34500.0n 0.6330 34799.9n 0.6330 34800.0n 0.3849 35099.9n 0.3849 35100.0n 0.4735 35399.9n 0.4735 35400.0n 0.3849 35699.9n 0.3849 35700.0n 0.3495 35999.9n 0.3495 36000.0n 0.6330 36299.9n 0.6330 36300.0n 0.6330 36599.9n 0.6330 36600.0n 0.4204 36899.9n 0.4204 36900.0n 0.4381 37199.9n 0.4381 37200.0n 0.5090 37499.9n 0.5090 37500.0n 0.6153 37799.9n 0.6153 37800.0n 0.6330 38099.9n 0.6330 38100.0n 0.3849 38399.9n 0.3849 38400.0n 0.3495 38699.9n 0.3495 38700.0n 0.3495 38999.9n 0.3495 39000.0n 0.6330 39299.9n 0.6330 39300.0n 0.3495 39599.9n 0.3495 39600.0n 0.4204 39899.9n 0.4204 39900.0n 0.6330 40199.9n 0.6330 40200.0n 0.3849 40499.9n 0.3849 40500.0n 0.4735 40799.9n 0.4735 40800.0n 0.3849 41099.9n 0.3849 41100.0n 0.3495 41399.9n 0.3495 41400.0n 0.6330 41699.9n 0.6330 41700.0n 0.6330 41999.9n 0.6330 42000.0n 0.4204 42299.9n 0.4204 42300.0n 0.4381 42599.9n 0.4381 42600.0n 0.5090 42899.9n 0.5090 42900.0n 0.6153 43199.9n 0.6153 43200.0n 0.6330 43499.9n 0.6330 43500.0n 0.3849 43799.9n 0.3849 43800.0n 0.3495 44099.9n 0.3495 44100.0n 0.3495 44399.9n 0.3495 44400.0n 0.6330 44699.9n 0.6330 44700.0n 0.3495 44999.9n 0.3495 45000.0n 0.4204 45299.9n 0.4204 45300.0n 0.6330 45599.9n 0.6330 45600.0n 0.3849 45899.9n 0.3849 45900.0n 0.4735 46199.9n 0.4735 46200.0n 0.3849 46499.9n 0.3849 46500.0n 0.3495 46799.9n 0.3495 46800.0n 0.6330 47099.9n 0.6330 47100.0n 0.6330 47399.9n 0.6330 47400.0n 0.4204 47699.9n 0.4204 47700.0n 0.4381 47999.9n 0.4381 48000.0n 0.5090 48299.9n 0.5090 48300.0n 0.6153 48599.9n 0.6153 48600.0n 0.6330 48899.9n 0.6330 48900.0n 0.3849 49199.9n 0.3849 49200.0n 0.3495 49499.9n 0.3495 49500.0n 0.3495 49799.9n 0.3495 49800.0n 0.6330 50099.9n 0.6330 50100.0n 0.3495 50399.9n 0.3495 50400.0n 0.4204 50699.9n 0.4204 50700.0n 0.6330 50999.9n 0.6330 51000.0n 0.3849 51299.9n 0.3849 51300.0n 0.4735 51599.9n 0.4735 51600.0n 0.3849 51899.9n 0.3849 51900.0n 0.3495 52199.9n 0.3495 52200.0n 0.6330 52499.9n 0.6330 52500.0n 0.6330 52799.9n 0.6330 52800.0n 0.4204 53099.9n 0.4204 53100.0n 0.4381 53399.9n 0.4381 53400.0n 0.5090 53699.9n 0.5090 53700.0n 0.6153 53999.9n 0.6153 54000.0n 0.4027 54299.9n 0.4027 54300.0n 0.3849 54599.9n 0.3849 54600.0n 0.3672 54899.9n 0.3672 54900.0n 0.3849 55199.9n 0.3849 55200.0n 0.3672 55499.9n 0.3672 55500.0n 0.3849 55799.9n 0.3849 55800.0n 0.6153 56099.9n 0.6153 56100.0n 0.4381 56399.9n 0.4381 56400.0n 0.6330 56699.9n 0.6330 56700.0n 0.4204 56999.9n 0.4204 57000.0n 0.6330 57299.9n 0.6330 57300.0n 0.3672 57599.9n 0.3672 57600.0n 0.5090 57899.9n 0.5090 57900.0n 0.3672 58199.9n 0.3672 58200.0n 0.4204 58499.9n 0.4204 58500.0n 0.3495 58799.9n 0.3495 58800.0n 0.4913 59099.9n 0.4913 59100.0n 0.3495)
Vxp51 a_xp51 0 PWL(0.0n 0.3366 299.9n 0.3366 300.0n 0.5280 599.9n 0.5280 600.0n 0.4131 899.9n 0.4131 900.0n 0.4323 1199.9n 0.4323 1200.0n 0.3557 1499.9n 0.3557 1500.0n 0.5280 1799.9n 0.5280 1800.0n 0.4705 2099.9n 0.4705 2100.0n 0.3174 2399.9n 0.3174 2400.0n 0.5280 2699.9n 0.5280 2700.0n 0.6236 2999.9n 0.6236 3000.0n 0.6236 3299.9n 0.6236 3300.0n 0.5280 3599.9n 0.5280 3600.0n 0.4897 3899.9n 0.4897 3900.0n 0.5854 4199.9n 0.5854 4200.0n 0.6236 4499.9n 0.6236 4500.0n 0.6236 4799.9n 0.6236 4800.0n 0.5471 5099.9n 0.5471 5100.0n 0.3174 5399.9n 0.3174 5400.0n 0.3366 5699.9n 0.3366 5700.0n 0.5280 5999.9n 0.5280 6000.0n 0.4131 6299.9n 0.4131 6300.0n 0.4323 6599.9n 0.4323 6600.0n 0.3557 6899.9n 0.3557 6900.0n 0.5280 7199.9n 0.5280 7200.0n 0.4705 7499.9n 0.4705 7500.0n 0.3174 7799.9n 0.3174 7800.0n 0.5280 8099.9n 0.5280 8100.0n 0.6236 8399.9n 0.6236 8400.0n 0.6236 8699.9n 0.6236 8700.0n 0.5280 8999.9n 0.5280 9000.0n 0.4897 9299.9n 0.4897 9300.0n 0.5854 9599.9n 0.5854 9600.0n 0.6236 9899.9n 0.6236 9900.0n 0.6236 10199.9n 0.6236 10200.0n 0.5471 10499.9n 0.5471 10500.0n 0.3174 10799.9n 0.3174 10800.0n 0.3366 11099.9n 0.3366 11100.0n 0.5280 11399.9n 0.5280 11400.0n 0.4131 11699.9n 0.4131 11700.0n 0.4323 11999.9n 0.4323 12000.0n 0.3557 12299.9n 0.3557 12300.0n 0.5280 12599.9n 0.5280 12600.0n 0.4705 12899.9n 0.4705 12900.0n 0.3174 13199.9n 0.3174 13200.0n 0.5280 13499.9n 0.5280 13500.0n 0.6236 13799.9n 0.6236 13800.0n 0.6236 14099.9n 0.6236 14100.0n 0.5280 14399.9n 0.5280 14400.0n 0.4897 14699.9n 0.4897 14700.0n 0.5854 14999.9n 0.5854 15000.0n 0.6236 15299.9n 0.6236 15300.0n 0.6236 15599.9n 0.6236 15600.0n 0.5471 15899.9n 0.5471 15900.0n 0.3174 16199.9n 0.3174 16200.0n 0.3366 16499.9n 0.3366 16500.0n 0.5280 16799.9n 0.5280 16800.0n 0.4131 17099.9n 0.4131 17100.0n 0.4323 17399.9n 0.4323 17400.0n 0.3557 17699.9n 0.3557 17700.0n 0.5280 17999.9n 0.5280 18000.0n 0.4705 18299.9n 0.4705 18300.0n 0.3174 18599.9n 0.3174 18600.0n 0.5280 18899.9n 0.5280 18900.0n 0.6236 19199.9n 0.6236 19200.0n 0.6236 19499.9n 0.6236 19500.0n 0.5280 19799.9n 0.5280 19800.0n 0.4897 20099.9n 0.4897 20100.0n 0.5854 20399.9n 0.5854 20400.0n 0.6236 20699.9n 0.6236 20700.0n 0.6236 20999.9n 0.6236 21000.0n 0.5471 21299.9n 0.5471 21300.0n 0.3174 21599.9n 0.3174 21600.0n 0.3366 21899.9n 0.3366 21900.0n 0.5280 22199.9n 0.5280 22200.0n 0.4131 22499.9n 0.4131 22500.0n 0.4323 22799.9n 0.4323 22800.0n 0.3557 23099.9n 0.3557 23100.0n 0.5280 23399.9n 0.5280 23400.0n 0.4705 23699.9n 0.4705 23700.0n 0.3174 23999.9n 0.3174 24000.0n 0.5280 24299.9n 0.5280 24300.0n 0.6236 24599.9n 0.6236 24600.0n 0.6236 24899.9n 0.6236 24900.0n 0.5280 25199.9n 0.5280 25200.0n 0.4897 25499.9n 0.4897 25500.0n 0.5854 25799.9n 0.5854 25800.0n 0.6236 26099.9n 0.6236 26100.0n 0.6236 26399.9n 0.6236 26400.0n 0.5471 26699.9n 0.5471 26700.0n 0.3174 26999.9n 0.3174 27000.0n 0.3366 27299.9n 0.3366 27300.0n 0.5280 27599.9n 0.5280 27600.0n 0.4131 27899.9n 0.4131 27900.0n 0.4323 28199.9n 0.4323 28200.0n 0.3557 28499.9n 0.3557 28500.0n 0.5280 28799.9n 0.5280 28800.0n 0.4705 29099.9n 0.4705 29100.0n 0.3174 29399.9n 0.3174 29400.0n 0.5280 29699.9n 0.5280 29700.0n 0.6236 29999.9n 0.6236 30000.0n 0.6236 30299.9n 0.6236 30300.0n 0.5280 30599.9n 0.5280 30600.0n 0.4897 30899.9n 0.4897 30900.0n 0.5854 31199.9n 0.5854 31200.0n 0.6236 31499.9n 0.6236 31500.0n 0.6236 31799.9n 0.6236 31800.0n 0.5471 32099.9n 0.5471 32100.0n 0.3174 32399.9n 0.3174 32400.0n 0.3366 32699.9n 0.3366 32700.0n 0.5280 32999.9n 0.5280 33000.0n 0.4131 33299.9n 0.4131 33300.0n 0.4323 33599.9n 0.4323 33600.0n 0.3557 33899.9n 0.3557 33900.0n 0.5280 34199.9n 0.5280 34200.0n 0.4705 34499.9n 0.4705 34500.0n 0.3174 34799.9n 0.3174 34800.0n 0.5280 35099.9n 0.5280 35100.0n 0.6236 35399.9n 0.6236 35400.0n 0.6236 35699.9n 0.6236 35700.0n 0.5280 35999.9n 0.5280 36000.0n 0.4897 36299.9n 0.4897 36300.0n 0.5854 36599.9n 0.5854 36600.0n 0.6236 36899.9n 0.6236 36900.0n 0.6236 37199.9n 0.6236 37200.0n 0.5471 37499.9n 0.5471 37500.0n 0.3174 37799.9n 0.3174 37800.0n 0.3366 38099.9n 0.3366 38100.0n 0.5280 38399.9n 0.5280 38400.0n 0.4131 38699.9n 0.4131 38700.0n 0.4323 38999.9n 0.4323 39000.0n 0.3557 39299.9n 0.3557 39300.0n 0.5280 39599.9n 0.5280 39600.0n 0.4705 39899.9n 0.4705 39900.0n 0.3174 40199.9n 0.3174 40200.0n 0.5280 40499.9n 0.5280 40500.0n 0.6236 40799.9n 0.6236 40800.0n 0.6236 41099.9n 0.6236 41100.0n 0.5280 41399.9n 0.5280 41400.0n 0.4897 41699.9n 0.4897 41700.0n 0.5854 41999.9n 0.5854 42000.0n 0.6236 42299.9n 0.6236 42300.0n 0.6236 42599.9n 0.6236 42600.0n 0.5471 42899.9n 0.5471 42900.0n 0.3174 43199.9n 0.3174 43200.0n 0.3366 43499.9n 0.3366 43500.0n 0.5280 43799.9n 0.5280 43800.0n 0.4131 44099.9n 0.4131 44100.0n 0.4323 44399.9n 0.4323 44400.0n 0.3557 44699.9n 0.3557 44700.0n 0.5280 44999.9n 0.5280 45000.0n 0.4705 45299.9n 0.4705 45300.0n 0.3174 45599.9n 0.3174 45600.0n 0.5280 45899.9n 0.5280 45900.0n 0.6236 46199.9n 0.6236 46200.0n 0.6236 46499.9n 0.6236 46500.0n 0.5280 46799.9n 0.5280 46800.0n 0.4897 47099.9n 0.4897 47100.0n 0.5854 47399.9n 0.5854 47400.0n 0.6236 47699.9n 0.6236 47700.0n 0.6236 47999.9n 0.6236 48000.0n 0.5471 48299.9n 0.5471 48300.0n 0.3174 48599.9n 0.3174 48600.0n 0.3366 48899.9n 0.3366 48900.0n 0.5280 49199.9n 0.5280 49200.0n 0.4131 49499.9n 0.4131 49500.0n 0.4323 49799.9n 0.4323 49800.0n 0.3557 50099.9n 0.3557 50100.0n 0.5280 50399.9n 0.5280 50400.0n 0.4705 50699.9n 0.4705 50700.0n 0.3174 50999.9n 0.3174 51000.0n 0.5280 51299.9n 0.5280 51300.0n 0.6236 51599.9n 0.6236 51600.0n 0.6236 51899.9n 0.6236 51900.0n 0.5280 52199.9n 0.5280 52200.0n 0.4897 52499.9n 0.4897 52500.0n 0.5854 52799.9n 0.5854 52800.0n 0.6236 53099.9n 0.6236 53100.0n 0.6236 53399.9n 0.6236 53400.0n 0.5471 53699.9n 0.5471 53700.0n 0.3174 53999.9n 0.3174 54000.0n 0.5280 54299.9n 0.5280 54300.0n 0.5280 54599.9n 0.5280 54600.0n 0.5854 54899.9n 0.5854 54900.0n 0.6236 55199.9n 0.6236 55200.0n 0.4897 55499.9n 0.4897 55500.0n 0.5471 55799.9n 0.5471 55800.0n 0.6236 56099.9n 0.6236 56100.0n 0.6236 56399.9n 0.6236 56400.0n 0.3174 56699.9n 0.3174 56700.0n 0.6045 56999.9n 0.6045 57000.0n 0.4705 57299.9n 0.4705 57300.0n 0.6236 57599.9n 0.6236 57600.0n 0.6236 57899.9n 0.6236 57900.0n 0.6236 58199.9n 0.6236 58200.0n 0.5088 58499.9n 0.5088 58500.0n 0.4897 58799.9n 0.4897 58800.0n 0.6236 59099.9n 0.6236 59100.0n 0.3749)
Vxn51 a_xn51 0 PWL(0.0n 0.6634 299.9n 0.6634 300.0n 0.4720 599.9n 0.4720 600.0n 0.5869 899.9n 0.5869 900.0n 0.5677 1199.9n 0.5677 1200.0n 0.6443 1499.9n 0.6443 1500.0n 0.4720 1799.9n 0.4720 1800.0n 0.5295 2099.9n 0.5295 2100.0n 0.6826 2399.9n 0.6826 2400.0n 0.4720 2699.9n 0.4720 2700.0n 0.3764 2999.9n 0.3764 3000.0n 0.3764 3299.9n 0.3764 3300.0n 0.4720 3599.9n 0.4720 3600.0n 0.5103 3899.9n 0.5103 3900.0n 0.4146 4199.9n 0.4146 4200.0n 0.3764 4499.9n 0.3764 4500.0n 0.3764 4799.9n 0.3764 4800.0n 0.4529 5099.9n 0.4529 5100.0n 0.6826 5399.9n 0.6826 5400.0n 0.6634 5699.9n 0.6634 5700.0n 0.4720 5999.9n 0.4720 6000.0n 0.5869 6299.9n 0.5869 6300.0n 0.5677 6599.9n 0.5677 6600.0n 0.6443 6899.9n 0.6443 6900.0n 0.4720 7199.9n 0.4720 7200.0n 0.5295 7499.9n 0.5295 7500.0n 0.6826 7799.9n 0.6826 7800.0n 0.4720 8099.9n 0.4720 8100.0n 0.3764 8399.9n 0.3764 8400.0n 0.3764 8699.9n 0.3764 8700.0n 0.4720 8999.9n 0.4720 9000.0n 0.5103 9299.9n 0.5103 9300.0n 0.4146 9599.9n 0.4146 9600.0n 0.3764 9899.9n 0.3764 9900.0n 0.3764 10199.9n 0.3764 10200.0n 0.4529 10499.9n 0.4529 10500.0n 0.6826 10799.9n 0.6826 10800.0n 0.6634 11099.9n 0.6634 11100.0n 0.4720 11399.9n 0.4720 11400.0n 0.5869 11699.9n 0.5869 11700.0n 0.5677 11999.9n 0.5677 12000.0n 0.6443 12299.9n 0.6443 12300.0n 0.4720 12599.9n 0.4720 12600.0n 0.5295 12899.9n 0.5295 12900.0n 0.6826 13199.9n 0.6826 13200.0n 0.4720 13499.9n 0.4720 13500.0n 0.3764 13799.9n 0.3764 13800.0n 0.3764 14099.9n 0.3764 14100.0n 0.4720 14399.9n 0.4720 14400.0n 0.5103 14699.9n 0.5103 14700.0n 0.4146 14999.9n 0.4146 15000.0n 0.3764 15299.9n 0.3764 15300.0n 0.3764 15599.9n 0.3764 15600.0n 0.4529 15899.9n 0.4529 15900.0n 0.6826 16199.9n 0.6826 16200.0n 0.6634 16499.9n 0.6634 16500.0n 0.4720 16799.9n 0.4720 16800.0n 0.5869 17099.9n 0.5869 17100.0n 0.5677 17399.9n 0.5677 17400.0n 0.6443 17699.9n 0.6443 17700.0n 0.4720 17999.9n 0.4720 18000.0n 0.5295 18299.9n 0.5295 18300.0n 0.6826 18599.9n 0.6826 18600.0n 0.4720 18899.9n 0.4720 18900.0n 0.3764 19199.9n 0.3764 19200.0n 0.3764 19499.9n 0.3764 19500.0n 0.4720 19799.9n 0.4720 19800.0n 0.5103 20099.9n 0.5103 20100.0n 0.4146 20399.9n 0.4146 20400.0n 0.3764 20699.9n 0.3764 20700.0n 0.3764 20999.9n 0.3764 21000.0n 0.4529 21299.9n 0.4529 21300.0n 0.6826 21599.9n 0.6826 21600.0n 0.6634 21899.9n 0.6634 21900.0n 0.4720 22199.9n 0.4720 22200.0n 0.5869 22499.9n 0.5869 22500.0n 0.5677 22799.9n 0.5677 22800.0n 0.6443 23099.9n 0.6443 23100.0n 0.4720 23399.9n 0.4720 23400.0n 0.5295 23699.9n 0.5295 23700.0n 0.6826 23999.9n 0.6826 24000.0n 0.4720 24299.9n 0.4720 24300.0n 0.3764 24599.9n 0.3764 24600.0n 0.3764 24899.9n 0.3764 24900.0n 0.4720 25199.9n 0.4720 25200.0n 0.5103 25499.9n 0.5103 25500.0n 0.4146 25799.9n 0.4146 25800.0n 0.3764 26099.9n 0.3764 26100.0n 0.3764 26399.9n 0.3764 26400.0n 0.4529 26699.9n 0.4529 26700.0n 0.6826 26999.9n 0.6826 27000.0n 0.6634 27299.9n 0.6634 27300.0n 0.4720 27599.9n 0.4720 27600.0n 0.5869 27899.9n 0.5869 27900.0n 0.5677 28199.9n 0.5677 28200.0n 0.6443 28499.9n 0.6443 28500.0n 0.4720 28799.9n 0.4720 28800.0n 0.5295 29099.9n 0.5295 29100.0n 0.6826 29399.9n 0.6826 29400.0n 0.4720 29699.9n 0.4720 29700.0n 0.3764 29999.9n 0.3764 30000.0n 0.3764 30299.9n 0.3764 30300.0n 0.4720 30599.9n 0.4720 30600.0n 0.5103 30899.9n 0.5103 30900.0n 0.4146 31199.9n 0.4146 31200.0n 0.3764 31499.9n 0.3764 31500.0n 0.3764 31799.9n 0.3764 31800.0n 0.4529 32099.9n 0.4529 32100.0n 0.6826 32399.9n 0.6826 32400.0n 0.6634 32699.9n 0.6634 32700.0n 0.4720 32999.9n 0.4720 33000.0n 0.5869 33299.9n 0.5869 33300.0n 0.5677 33599.9n 0.5677 33600.0n 0.6443 33899.9n 0.6443 33900.0n 0.4720 34199.9n 0.4720 34200.0n 0.5295 34499.9n 0.5295 34500.0n 0.6826 34799.9n 0.6826 34800.0n 0.4720 35099.9n 0.4720 35100.0n 0.3764 35399.9n 0.3764 35400.0n 0.3764 35699.9n 0.3764 35700.0n 0.4720 35999.9n 0.4720 36000.0n 0.5103 36299.9n 0.5103 36300.0n 0.4146 36599.9n 0.4146 36600.0n 0.3764 36899.9n 0.3764 36900.0n 0.3764 37199.9n 0.3764 37200.0n 0.4529 37499.9n 0.4529 37500.0n 0.6826 37799.9n 0.6826 37800.0n 0.6634 38099.9n 0.6634 38100.0n 0.4720 38399.9n 0.4720 38400.0n 0.5869 38699.9n 0.5869 38700.0n 0.5677 38999.9n 0.5677 39000.0n 0.6443 39299.9n 0.6443 39300.0n 0.4720 39599.9n 0.4720 39600.0n 0.5295 39899.9n 0.5295 39900.0n 0.6826 40199.9n 0.6826 40200.0n 0.4720 40499.9n 0.4720 40500.0n 0.3764 40799.9n 0.3764 40800.0n 0.3764 41099.9n 0.3764 41100.0n 0.4720 41399.9n 0.4720 41400.0n 0.5103 41699.9n 0.5103 41700.0n 0.4146 41999.9n 0.4146 42000.0n 0.3764 42299.9n 0.3764 42300.0n 0.3764 42599.9n 0.3764 42600.0n 0.4529 42899.9n 0.4529 42900.0n 0.6826 43199.9n 0.6826 43200.0n 0.6634 43499.9n 0.6634 43500.0n 0.4720 43799.9n 0.4720 43800.0n 0.5869 44099.9n 0.5869 44100.0n 0.5677 44399.9n 0.5677 44400.0n 0.6443 44699.9n 0.6443 44700.0n 0.4720 44999.9n 0.4720 45000.0n 0.5295 45299.9n 0.5295 45300.0n 0.6826 45599.9n 0.6826 45600.0n 0.4720 45899.9n 0.4720 45900.0n 0.3764 46199.9n 0.3764 46200.0n 0.3764 46499.9n 0.3764 46500.0n 0.4720 46799.9n 0.4720 46800.0n 0.5103 47099.9n 0.5103 47100.0n 0.4146 47399.9n 0.4146 47400.0n 0.3764 47699.9n 0.3764 47700.0n 0.3764 47999.9n 0.3764 48000.0n 0.4529 48299.9n 0.4529 48300.0n 0.6826 48599.9n 0.6826 48600.0n 0.6634 48899.9n 0.6634 48900.0n 0.4720 49199.9n 0.4720 49200.0n 0.5869 49499.9n 0.5869 49500.0n 0.5677 49799.9n 0.5677 49800.0n 0.6443 50099.9n 0.6443 50100.0n 0.4720 50399.9n 0.4720 50400.0n 0.5295 50699.9n 0.5295 50700.0n 0.6826 50999.9n 0.6826 51000.0n 0.4720 51299.9n 0.4720 51300.0n 0.3764 51599.9n 0.3764 51600.0n 0.3764 51899.9n 0.3764 51900.0n 0.4720 52199.9n 0.4720 52200.0n 0.5103 52499.9n 0.5103 52500.0n 0.4146 52799.9n 0.4146 52800.0n 0.3764 53099.9n 0.3764 53100.0n 0.3764 53399.9n 0.3764 53400.0n 0.4529 53699.9n 0.4529 53700.0n 0.6826 53999.9n 0.6826 54000.0n 0.4720 54299.9n 0.4720 54300.0n 0.4720 54599.9n 0.4720 54600.0n 0.4146 54899.9n 0.4146 54900.0n 0.3764 55199.9n 0.3764 55200.0n 0.5103 55499.9n 0.5103 55500.0n 0.4529 55799.9n 0.4529 55800.0n 0.3764 56099.9n 0.3764 56100.0n 0.3764 56399.9n 0.3764 56400.0n 0.6826 56699.9n 0.6826 56700.0n 0.3955 56999.9n 0.3955 57000.0n 0.5295 57299.9n 0.5295 57300.0n 0.3764 57599.9n 0.3764 57600.0n 0.3764 57899.9n 0.3764 57900.0n 0.3764 58199.9n 0.3764 58200.0n 0.4912 58499.9n 0.4912 58500.0n 0.5103 58799.9n 0.5103 58800.0n 0.3764 59099.9n 0.3764 59100.0n 0.6251)
Vxp52 a_xp52 0 PWL(0.0n 0.5676 299.9n 0.5676 300.0n 0.4167 599.9n 0.4167 600.0n 0.4544 899.9n 0.4544 900.0n 0.4921 1199.9n 0.4921 1200.0n 0.6242 1499.9n 0.6242 1500.0n 0.5487 1799.9n 0.5487 1800.0n 0.3601 2099.9n 0.3601 2100.0n 0.4167 2399.9n 0.4167 2400.0n 0.4355 2699.9n 0.4355 2700.0n 0.6242 2999.9n 0.6242 3000.0n 0.5676 3299.9n 0.5676 3300.0n 0.3978 3599.9n 0.3978 3600.0n 0.6242 3899.9n 0.6242 3900.0n 0.5487 4199.9n 0.5487 4200.0n 0.6053 4499.9n 0.6053 4500.0n 0.5865 4799.9n 0.5865 4800.0n 0.4733 5099.9n 0.4733 5100.0n 0.5487 5399.9n 0.5487 5400.0n 0.5676 5699.9n 0.5676 5700.0n 0.4167 5999.9n 0.4167 6000.0n 0.4544 6299.9n 0.4544 6300.0n 0.4921 6599.9n 0.4921 6600.0n 0.6242 6899.9n 0.6242 6900.0n 0.5487 7199.9n 0.5487 7200.0n 0.3601 7499.9n 0.3601 7500.0n 0.4167 7799.9n 0.4167 7800.0n 0.4355 8099.9n 0.4355 8100.0n 0.6242 8399.9n 0.6242 8400.0n 0.5676 8699.9n 0.5676 8700.0n 0.3978 8999.9n 0.3978 9000.0n 0.6242 9299.9n 0.6242 9300.0n 0.5487 9599.9n 0.5487 9600.0n 0.6053 9899.9n 0.6053 9900.0n 0.5865 10199.9n 0.5865 10200.0n 0.4733 10499.9n 0.4733 10500.0n 0.5487 10799.9n 0.5487 10800.0n 0.5676 11099.9n 0.5676 11100.0n 0.4167 11399.9n 0.4167 11400.0n 0.4544 11699.9n 0.4544 11700.0n 0.4921 11999.9n 0.4921 12000.0n 0.6242 12299.9n 0.6242 12300.0n 0.5487 12599.9n 0.5487 12600.0n 0.3601 12899.9n 0.3601 12900.0n 0.4167 13199.9n 0.4167 13200.0n 0.4355 13499.9n 0.4355 13500.0n 0.6242 13799.9n 0.6242 13800.0n 0.5676 14099.9n 0.5676 14100.0n 0.3978 14399.9n 0.3978 14400.0n 0.6242 14699.9n 0.6242 14700.0n 0.5487 14999.9n 0.5487 15000.0n 0.6053 15299.9n 0.6053 15300.0n 0.5865 15599.9n 0.5865 15600.0n 0.4733 15899.9n 0.4733 15900.0n 0.5487 16199.9n 0.5487 16200.0n 0.5676 16499.9n 0.5676 16500.0n 0.4167 16799.9n 0.4167 16800.0n 0.4544 17099.9n 0.4544 17100.0n 0.4921 17399.9n 0.4921 17400.0n 0.6242 17699.9n 0.6242 17700.0n 0.5487 17999.9n 0.5487 18000.0n 0.3601 18299.9n 0.3601 18300.0n 0.4167 18599.9n 0.4167 18600.0n 0.4355 18899.9n 0.4355 18900.0n 0.6242 19199.9n 0.6242 19200.0n 0.5676 19499.9n 0.5676 19500.0n 0.3978 19799.9n 0.3978 19800.0n 0.6242 20099.9n 0.6242 20100.0n 0.5487 20399.9n 0.5487 20400.0n 0.6053 20699.9n 0.6053 20700.0n 0.5865 20999.9n 0.5865 21000.0n 0.4733 21299.9n 0.4733 21300.0n 0.5487 21599.9n 0.5487 21600.0n 0.5676 21899.9n 0.5676 21900.0n 0.4167 22199.9n 0.4167 22200.0n 0.4544 22499.9n 0.4544 22500.0n 0.4921 22799.9n 0.4921 22800.0n 0.6242 23099.9n 0.6242 23100.0n 0.5487 23399.9n 0.5487 23400.0n 0.3601 23699.9n 0.3601 23700.0n 0.4167 23999.9n 0.4167 24000.0n 0.4355 24299.9n 0.4355 24300.0n 0.6242 24599.9n 0.6242 24600.0n 0.5676 24899.9n 0.5676 24900.0n 0.3978 25199.9n 0.3978 25200.0n 0.6242 25499.9n 0.6242 25500.0n 0.5487 25799.9n 0.5487 25800.0n 0.6053 26099.9n 0.6053 26100.0n 0.5865 26399.9n 0.5865 26400.0n 0.4733 26699.9n 0.4733 26700.0n 0.5487 26999.9n 0.5487 27000.0n 0.5676 27299.9n 0.5676 27300.0n 0.4167 27599.9n 0.4167 27600.0n 0.4544 27899.9n 0.4544 27900.0n 0.4921 28199.9n 0.4921 28200.0n 0.6242 28499.9n 0.6242 28500.0n 0.5487 28799.9n 0.5487 28800.0n 0.3601 29099.9n 0.3601 29100.0n 0.4167 29399.9n 0.4167 29400.0n 0.4355 29699.9n 0.4355 29700.0n 0.6242 29999.9n 0.6242 30000.0n 0.5676 30299.9n 0.5676 30300.0n 0.3978 30599.9n 0.3978 30600.0n 0.6242 30899.9n 0.6242 30900.0n 0.5487 31199.9n 0.5487 31200.0n 0.6053 31499.9n 0.6053 31500.0n 0.5865 31799.9n 0.5865 31800.0n 0.4733 32099.9n 0.4733 32100.0n 0.5487 32399.9n 0.5487 32400.0n 0.5676 32699.9n 0.5676 32700.0n 0.4167 32999.9n 0.4167 33000.0n 0.4544 33299.9n 0.4544 33300.0n 0.4921 33599.9n 0.4921 33600.0n 0.6242 33899.9n 0.6242 33900.0n 0.5487 34199.9n 0.5487 34200.0n 0.3601 34499.9n 0.3601 34500.0n 0.4167 34799.9n 0.4167 34800.0n 0.4355 35099.9n 0.4355 35100.0n 0.6242 35399.9n 0.6242 35400.0n 0.5676 35699.9n 0.5676 35700.0n 0.3978 35999.9n 0.3978 36000.0n 0.6242 36299.9n 0.6242 36300.0n 0.5487 36599.9n 0.5487 36600.0n 0.6053 36899.9n 0.6053 36900.0n 0.5865 37199.9n 0.5865 37200.0n 0.4733 37499.9n 0.4733 37500.0n 0.5487 37799.9n 0.5487 37800.0n 0.5676 38099.9n 0.5676 38100.0n 0.4167 38399.9n 0.4167 38400.0n 0.4544 38699.9n 0.4544 38700.0n 0.4921 38999.9n 0.4921 39000.0n 0.6242 39299.9n 0.6242 39300.0n 0.5487 39599.9n 0.5487 39600.0n 0.3601 39899.9n 0.3601 39900.0n 0.4167 40199.9n 0.4167 40200.0n 0.4355 40499.9n 0.4355 40500.0n 0.6242 40799.9n 0.6242 40800.0n 0.5676 41099.9n 0.5676 41100.0n 0.3978 41399.9n 0.3978 41400.0n 0.6242 41699.9n 0.6242 41700.0n 0.5487 41999.9n 0.5487 42000.0n 0.6053 42299.9n 0.6053 42300.0n 0.5865 42599.9n 0.5865 42600.0n 0.4733 42899.9n 0.4733 42900.0n 0.5487 43199.9n 0.5487 43200.0n 0.5676 43499.9n 0.5676 43500.0n 0.4167 43799.9n 0.4167 43800.0n 0.4544 44099.9n 0.4544 44100.0n 0.4921 44399.9n 0.4921 44400.0n 0.6242 44699.9n 0.6242 44700.0n 0.5487 44999.9n 0.5487 45000.0n 0.3601 45299.9n 0.3601 45300.0n 0.4167 45599.9n 0.4167 45600.0n 0.4355 45899.9n 0.4355 45900.0n 0.6242 46199.9n 0.6242 46200.0n 0.5676 46499.9n 0.5676 46500.0n 0.3978 46799.9n 0.3978 46800.0n 0.6242 47099.9n 0.6242 47100.0n 0.5487 47399.9n 0.5487 47400.0n 0.6053 47699.9n 0.6053 47700.0n 0.5865 47999.9n 0.5865 48000.0n 0.4733 48299.9n 0.4733 48300.0n 0.5487 48599.9n 0.5487 48600.0n 0.5676 48899.9n 0.5676 48900.0n 0.4167 49199.9n 0.4167 49200.0n 0.4544 49499.9n 0.4544 49500.0n 0.4921 49799.9n 0.4921 49800.0n 0.6242 50099.9n 0.6242 50100.0n 0.5487 50399.9n 0.5487 50400.0n 0.3601 50699.9n 0.3601 50700.0n 0.4167 50999.9n 0.4167 51000.0n 0.4355 51299.9n 0.4355 51300.0n 0.6242 51599.9n 0.6242 51600.0n 0.5676 51899.9n 0.5676 51900.0n 0.3978 52199.9n 0.3978 52200.0n 0.6242 52499.9n 0.6242 52500.0n 0.5487 52799.9n 0.5487 52800.0n 0.6053 53099.9n 0.6053 53100.0n 0.5865 53399.9n 0.5865 53400.0n 0.4733 53699.9n 0.4733 53700.0n 0.5487 53999.9n 0.5487 54000.0n 0.5110 54299.9n 0.5110 54300.0n 0.4355 54599.9n 0.4355 54600.0n 0.5487 54899.9n 0.5487 54900.0n 0.6242 55199.9n 0.6242 55200.0n 0.5865 55499.9n 0.5865 55500.0n 0.5110 55799.9n 0.5110 55800.0n 0.6053 56099.9n 0.6053 56100.0n 0.6242 56399.9n 0.6242 56400.0n 0.6242 56699.9n 0.6242 56700.0n 0.5865 56999.9n 0.5865 57000.0n 0.6242 57299.9n 0.6242 57300.0n 0.4733 57599.9n 0.4733 57600.0n 0.6242 57899.9n 0.6242 57900.0n 0.6053 58199.9n 0.6053 58200.0n 0.4733 58499.9n 0.4733 58500.0n 0.4733 58799.9n 0.4733 58800.0n 0.5865 59099.9n 0.5865 59100.0n 0.3412)
Vxn52 a_xn52 0 PWL(0.0n 0.4324 299.9n 0.4324 300.0n 0.5833 599.9n 0.5833 600.0n 0.5456 899.9n 0.5456 900.0n 0.5079 1199.9n 0.5079 1200.0n 0.3758 1499.9n 0.3758 1500.0n 0.4513 1799.9n 0.4513 1800.0n 0.6399 2099.9n 0.6399 2100.0n 0.5833 2399.9n 0.5833 2400.0n 0.5645 2699.9n 0.5645 2700.0n 0.3758 2999.9n 0.3758 3000.0n 0.4324 3299.9n 0.4324 3300.0n 0.6022 3599.9n 0.6022 3600.0n 0.3758 3899.9n 0.3758 3900.0n 0.4513 4199.9n 0.4513 4200.0n 0.3947 4499.9n 0.3947 4500.0n 0.4135 4799.9n 0.4135 4800.0n 0.5267 5099.9n 0.5267 5100.0n 0.4513 5399.9n 0.4513 5400.0n 0.4324 5699.9n 0.4324 5700.0n 0.5833 5999.9n 0.5833 6000.0n 0.5456 6299.9n 0.5456 6300.0n 0.5079 6599.9n 0.5079 6600.0n 0.3758 6899.9n 0.3758 6900.0n 0.4513 7199.9n 0.4513 7200.0n 0.6399 7499.9n 0.6399 7500.0n 0.5833 7799.9n 0.5833 7800.0n 0.5645 8099.9n 0.5645 8100.0n 0.3758 8399.9n 0.3758 8400.0n 0.4324 8699.9n 0.4324 8700.0n 0.6022 8999.9n 0.6022 9000.0n 0.3758 9299.9n 0.3758 9300.0n 0.4513 9599.9n 0.4513 9600.0n 0.3947 9899.9n 0.3947 9900.0n 0.4135 10199.9n 0.4135 10200.0n 0.5267 10499.9n 0.5267 10500.0n 0.4513 10799.9n 0.4513 10800.0n 0.4324 11099.9n 0.4324 11100.0n 0.5833 11399.9n 0.5833 11400.0n 0.5456 11699.9n 0.5456 11700.0n 0.5079 11999.9n 0.5079 12000.0n 0.3758 12299.9n 0.3758 12300.0n 0.4513 12599.9n 0.4513 12600.0n 0.6399 12899.9n 0.6399 12900.0n 0.5833 13199.9n 0.5833 13200.0n 0.5645 13499.9n 0.5645 13500.0n 0.3758 13799.9n 0.3758 13800.0n 0.4324 14099.9n 0.4324 14100.0n 0.6022 14399.9n 0.6022 14400.0n 0.3758 14699.9n 0.3758 14700.0n 0.4513 14999.9n 0.4513 15000.0n 0.3947 15299.9n 0.3947 15300.0n 0.4135 15599.9n 0.4135 15600.0n 0.5267 15899.9n 0.5267 15900.0n 0.4513 16199.9n 0.4513 16200.0n 0.4324 16499.9n 0.4324 16500.0n 0.5833 16799.9n 0.5833 16800.0n 0.5456 17099.9n 0.5456 17100.0n 0.5079 17399.9n 0.5079 17400.0n 0.3758 17699.9n 0.3758 17700.0n 0.4513 17999.9n 0.4513 18000.0n 0.6399 18299.9n 0.6399 18300.0n 0.5833 18599.9n 0.5833 18600.0n 0.5645 18899.9n 0.5645 18900.0n 0.3758 19199.9n 0.3758 19200.0n 0.4324 19499.9n 0.4324 19500.0n 0.6022 19799.9n 0.6022 19800.0n 0.3758 20099.9n 0.3758 20100.0n 0.4513 20399.9n 0.4513 20400.0n 0.3947 20699.9n 0.3947 20700.0n 0.4135 20999.9n 0.4135 21000.0n 0.5267 21299.9n 0.5267 21300.0n 0.4513 21599.9n 0.4513 21600.0n 0.4324 21899.9n 0.4324 21900.0n 0.5833 22199.9n 0.5833 22200.0n 0.5456 22499.9n 0.5456 22500.0n 0.5079 22799.9n 0.5079 22800.0n 0.3758 23099.9n 0.3758 23100.0n 0.4513 23399.9n 0.4513 23400.0n 0.6399 23699.9n 0.6399 23700.0n 0.5833 23999.9n 0.5833 24000.0n 0.5645 24299.9n 0.5645 24300.0n 0.3758 24599.9n 0.3758 24600.0n 0.4324 24899.9n 0.4324 24900.0n 0.6022 25199.9n 0.6022 25200.0n 0.3758 25499.9n 0.3758 25500.0n 0.4513 25799.9n 0.4513 25800.0n 0.3947 26099.9n 0.3947 26100.0n 0.4135 26399.9n 0.4135 26400.0n 0.5267 26699.9n 0.5267 26700.0n 0.4513 26999.9n 0.4513 27000.0n 0.4324 27299.9n 0.4324 27300.0n 0.5833 27599.9n 0.5833 27600.0n 0.5456 27899.9n 0.5456 27900.0n 0.5079 28199.9n 0.5079 28200.0n 0.3758 28499.9n 0.3758 28500.0n 0.4513 28799.9n 0.4513 28800.0n 0.6399 29099.9n 0.6399 29100.0n 0.5833 29399.9n 0.5833 29400.0n 0.5645 29699.9n 0.5645 29700.0n 0.3758 29999.9n 0.3758 30000.0n 0.4324 30299.9n 0.4324 30300.0n 0.6022 30599.9n 0.6022 30600.0n 0.3758 30899.9n 0.3758 30900.0n 0.4513 31199.9n 0.4513 31200.0n 0.3947 31499.9n 0.3947 31500.0n 0.4135 31799.9n 0.4135 31800.0n 0.5267 32099.9n 0.5267 32100.0n 0.4513 32399.9n 0.4513 32400.0n 0.4324 32699.9n 0.4324 32700.0n 0.5833 32999.9n 0.5833 33000.0n 0.5456 33299.9n 0.5456 33300.0n 0.5079 33599.9n 0.5079 33600.0n 0.3758 33899.9n 0.3758 33900.0n 0.4513 34199.9n 0.4513 34200.0n 0.6399 34499.9n 0.6399 34500.0n 0.5833 34799.9n 0.5833 34800.0n 0.5645 35099.9n 0.5645 35100.0n 0.3758 35399.9n 0.3758 35400.0n 0.4324 35699.9n 0.4324 35700.0n 0.6022 35999.9n 0.6022 36000.0n 0.3758 36299.9n 0.3758 36300.0n 0.4513 36599.9n 0.4513 36600.0n 0.3947 36899.9n 0.3947 36900.0n 0.4135 37199.9n 0.4135 37200.0n 0.5267 37499.9n 0.5267 37500.0n 0.4513 37799.9n 0.4513 37800.0n 0.4324 38099.9n 0.4324 38100.0n 0.5833 38399.9n 0.5833 38400.0n 0.5456 38699.9n 0.5456 38700.0n 0.5079 38999.9n 0.5079 39000.0n 0.3758 39299.9n 0.3758 39300.0n 0.4513 39599.9n 0.4513 39600.0n 0.6399 39899.9n 0.6399 39900.0n 0.5833 40199.9n 0.5833 40200.0n 0.5645 40499.9n 0.5645 40500.0n 0.3758 40799.9n 0.3758 40800.0n 0.4324 41099.9n 0.4324 41100.0n 0.6022 41399.9n 0.6022 41400.0n 0.3758 41699.9n 0.3758 41700.0n 0.4513 41999.9n 0.4513 42000.0n 0.3947 42299.9n 0.3947 42300.0n 0.4135 42599.9n 0.4135 42600.0n 0.5267 42899.9n 0.5267 42900.0n 0.4513 43199.9n 0.4513 43200.0n 0.4324 43499.9n 0.4324 43500.0n 0.5833 43799.9n 0.5833 43800.0n 0.5456 44099.9n 0.5456 44100.0n 0.5079 44399.9n 0.5079 44400.0n 0.3758 44699.9n 0.3758 44700.0n 0.4513 44999.9n 0.4513 45000.0n 0.6399 45299.9n 0.6399 45300.0n 0.5833 45599.9n 0.5833 45600.0n 0.5645 45899.9n 0.5645 45900.0n 0.3758 46199.9n 0.3758 46200.0n 0.4324 46499.9n 0.4324 46500.0n 0.6022 46799.9n 0.6022 46800.0n 0.3758 47099.9n 0.3758 47100.0n 0.4513 47399.9n 0.4513 47400.0n 0.3947 47699.9n 0.3947 47700.0n 0.4135 47999.9n 0.4135 48000.0n 0.5267 48299.9n 0.5267 48300.0n 0.4513 48599.9n 0.4513 48600.0n 0.4324 48899.9n 0.4324 48900.0n 0.5833 49199.9n 0.5833 49200.0n 0.5456 49499.9n 0.5456 49500.0n 0.5079 49799.9n 0.5079 49800.0n 0.3758 50099.9n 0.3758 50100.0n 0.4513 50399.9n 0.4513 50400.0n 0.6399 50699.9n 0.6399 50700.0n 0.5833 50999.9n 0.5833 51000.0n 0.5645 51299.9n 0.5645 51300.0n 0.3758 51599.9n 0.3758 51600.0n 0.4324 51899.9n 0.4324 51900.0n 0.6022 52199.9n 0.6022 52200.0n 0.3758 52499.9n 0.3758 52500.0n 0.4513 52799.9n 0.4513 52800.0n 0.3947 53099.9n 0.3947 53100.0n 0.4135 53399.9n 0.4135 53400.0n 0.5267 53699.9n 0.5267 53700.0n 0.4513 53999.9n 0.4513 54000.0n 0.4890 54299.9n 0.4890 54300.0n 0.5645 54599.9n 0.5645 54600.0n 0.4513 54899.9n 0.4513 54900.0n 0.3758 55199.9n 0.3758 55200.0n 0.4135 55499.9n 0.4135 55500.0n 0.4890 55799.9n 0.4890 55800.0n 0.3947 56099.9n 0.3947 56100.0n 0.3758 56399.9n 0.3758 56400.0n 0.3758 56699.9n 0.3758 56700.0n 0.4135 56999.9n 0.4135 57000.0n 0.3758 57299.9n 0.3758 57300.0n 0.5267 57599.9n 0.5267 57600.0n 0.3758 57899.9n 0.3758 57900.0n 0.3947 58199.9n 0.3947 58200.0n 0.5267 58499.9n 0.5267 58500.0n 0.5267 58799.9n 0.5267 58800.0n 0.4135 59099.9n 0.4135 59100.0n 0.6588)
Vxp53 a_xp53 0 PWL(0.0n 0.6201 299.9n 0.6201 300.0n 0.5869 599.9n 0.5869 600.0n 0.5869 899.9n 0.5869 900.0n 0.5206 1199.9n 0.5206 1200.0n 0.6201 1499.9n 0.6201 1500.0n 0.6035 1799.9n 0.6035 1800.0n 0.5869 2099.9n 0.5869 2100.0n 0.6201 2399.9n 0.6201 2400.0n 0.4377 2699.9n 0.4377 2700.0n 0.6201 2999.9n 0.6201 3000.0n 0.5703 3299.9n 0.5703 3300.0n 0.4211 3599.9n 0.4211 3600.0n 0.4045 3899.9n 0.4045 3900.0n 0.3547 4199.9n 0.3547 4200.0n 0.6201 4499.9n 0.6201 4500.0n 0.5869 4799.9n 0.5869 4800.0n 0.5372 5099.9n 0.5372 5100.0n 0.6201 5399.9n 0.6201 5400.0n 0.6201 5699.9n 0.6201 5700.0n 0.5869 5999.9n 0.5869 6000.0n 0.5869 6299.9n 0.5869 6300.0n 0.5206 6599.9n 0.5206 6600.0n 0.6201 6899.9n 0.6201 6900.0n 0.6035 7199.9n 0.6035 7200.0n 0.5869 7499.9n 0.5869 7500.0n 0.6201 7799.9n 0.6201 7800.0n 0.4377 8099.9n 0.4377 8100.0n 0.6201 8399.9n 0.6201 8400.0n 0.5703 8699.9n 0.5703 8700.0n 0.4211 8999.9n 0.4211 9000.0n 0.4045 9299.9n 0.4045 9300.0n 0.3547 9599.9n 0.3547 9600.0n 0.6201 9899.9n 0.6201 9900.0n 0.5869 10199.9n 0.5869 10200.0n 0.5372 10499.9n 0.5372 10500.0n 0.6201 10799.9n 0.6201 10800.0n 0.6201 11099.9n 0.6201 11100.0n 0.5869 11399.9n 0.5869 11400.0n 0.5869 11699.9n 0.5869 11700.0n 0.5206 11999.9n 0.5206 12000.0n 0.6201 12299.9n 0.6201 12300.0n 0.6035 12599.9n 0.6035 12600.0n 0.5869 12899.9n 0.5869 12900.0n 0.6201 13199.9n 0.6201 13200.0n 0.4377 13499.9n 0.4377 13500.0n 0.6201 13799.9n 0.6201 13800.0n 0.5703 14099.9n 0.5703 14100.0n 0.4211 14399.9n 0.4211 14400.0n 0.4045 14699.9n 0.4045 14700.0n 0.3547 14999.9n 0.3547 15000.0n 0.6201 15299.9n 0.6201 15300.0n 0.5869 15599.9n 0.5869 15600.0n 0.5372 15899.9n 0.5372 15900.0n 0.6201 16199.9n 0.6201 16200.0n 0.6201 16499.9n 0.6201 16500.0n 0.5869 16799.9n 0.5869 16800.0n 0.5869 17099.9n 0.5869 17100.0n 0.5206 17399.9n 0.5206 17400.0n 0.6201 17699.9n 0.6201 17700.0n 0.6035 17999.9n 0.6035 18000.0n 0.5869 18299.9n 0.5869 18300.0n 0.6201 18599.9n 0.6201 18600.0n 0.4377 18899.9n 0.4377 18900.0n 0.6201 19199.9n 0.6201 19200.0n 0.5703 19499.9n 0.5703 19500.0n 0.4211 19799.9n 0.4211 19800.0n 0.4045 20099.9n 0.4045 20100.0n 0.3547 20399.9n 0.3547 20400.0n 0.6201 20699.9n 0.6201 20700.0n 0.5869 20999.9n 0.5869 21000.0n 0.5372 21299.9n 0.5372 21300.0n 0.6201 21599.9n 0.6201 21600.0n 0.6201 21899.9n 0.6201 21900.0n 0.5869 22199.9n 0.5869 22200.0n 0.5869 22499.9n 0.5869 22500.0n 0.5206 22799.9n 0.5206 22800.0n 0.6201 23099.9n 0.6201 23100.0n 0.6035 23399.9n 0.6035 23400.0n 0.5869 23699.9n 0.5869 23700.0n 0.6201 23999.9n 0.6201 24000.0n 0.4377 24299.9n 0.4377 24300.0n 0.6201 24599.9n 0.6201 24600.0n 0.5703 24899.9n 0.5703 24900.0n 0.4211 25199.9n 0.4211 25200.0n 0.4045 25499.9n 0.4045 25500.0n 0.3547 25799.9n 0.3547 25800.0n 0.6201 26099.9n 0.6201 26100.0n 0.5869 26399.9n 0.5869 26400.0n 0.5372 26699.9n 0.5372 26700.0n 0.6201 26999.9n 0.6201 27000.0n 0.6201 27299.9n 0.6201 27300.0n 0.5869 27599.9n 0.5869 27600.0n 0.5869 27899.9n 0.5869 27900.0n 0.5206 28199.9n 0.5206 28200.0n 0.6201 28499.9n 0.6201 28500.0n 0.6035 28799.9n 0.6035 28800.0n 0.5869 29099.9n 0.5869 29100.0n 0.6201 29399.9n 0.6201 29400.0n 0.4377 29699.9n 0.4377 29700.0n 0.6201 29999.9n 0.6201 30000.0n 0.5703 30299.9n 0.5703 30300.0n 0.4211 30599.9n 0.4211 30600.0n 0.4045 30899.9n 0.4045 30900.0n 0.3547 31199.9n 0.3547 31200.0n 0.6201 31499.9n 0.6201 31500.0n 0.5869 31799.9n 0.5869 31800.0n 0.5372 32099.9n 0.5372 32100.0n 0.6201 32399.9n 0.6201 32400.0n 0.6201 32699.9n 0.6201 32700.0n 0.5869 32999.9n 0.5869 33000.0n 0.5869 33299.9n 0.5869 33300.0n 0.5206 33599.9n 0.5206 33600.0n 0.6201 33899.9n 0.6201 33900.0n 0.6035 34199.9n 0.6035 34200.0n 0.5869 34499.9n 0.5869 34500.0n 0.6201 34799.9n 0.6201 34800.0n 0.4377 35099.9n 0.4377 35100.0n 0.6201 35399.9n 0.6201 35400.0n 0.5703 35699.9n 0.5703 35700.0n 0.4211 35999.9n 0.4211 36000.0n 0.4045 36299.9n 0.4045 36300.0n 0.3547 36599.9n 0.3547 36600.0n 0.6201 36899.9n 0.6201 36900.0n 0.5869 37199.9n 0.5869 37200.0n 0.5372 37499.9n 0.5372 37500.0n 0.6201 37799.9n 0.6201 37800.0n 0.6201 38099.9n 0.6201 38100.0n 0.5869 38399.9n 0.5869 38400.0n 0.5869 38699.9n 0.5869 38700.0n 0.5206 38999.9n 0.5206 39000.0n 0.6201 39299.9n 0.6201 39300.0n 0.6035 39599.9n 0.6035 39600.0n 0.5869 39899.9n 0.5869 39900.0n 0.6201 40199.9n 0.6201 40200.0n 0.4377 40499.9n 0.4377 40500.0n 0.6201 40799.9n 0.6201 40800.0n 0.5703 41099.9n 0.5703 41100.0n 0.4211 41399.9n 0.4211 41400.0n 0.4045 41699.9n 0.4045 41700.0n 0.3547 41999.9n 0.3547 42000.0n 0.6201 42299.9n 0.6201 42300.0n 0.5869 42599.9n 0.5869 42600.0n 0.5372 42899.9n 0.5372 42900.0n 0.6201 43199.9n 0.6201 43200.0n 0.6201 43499.9n 0.6201 43500.0n 0.5869 43799.9n 0.5869 43800.0n 0.5869 44099.9n 0.5869 44100.0n 0.5206 44399.9n 0.5206 44400.0n 0.6201 44699.9n 0.6201 44700.0n 0.6035 44999.9n 0.6035 45000.0n 0.5869 45299.9n 0.5869 45300.0n 0.6201 45599.9n 0.6201 45600.0n 0.4377 45899.9n 0.4377 45900.0n 0.6201 46199.9n 0.6201 46200.0n 0.5703 46499.9n 0.5703 46500.0n 0.4211 46799.9n 0.4211 46800.0n 0.4045 47099.9n 0.4045 47100.0n 0.3547 47399.9n 0.3547 47400.0n 0.6201 47699.9n 0.6201 47700.0n 0.5869 47999.9n 0.5869 48000.0n 0.5372 48299.9n 0.5372 48300.0n 0.6201 48599.9n 0.6201 48600.0n 0.6201 48899.9n 0.6201 48900.0n 0.5869 49199.9n 0.5869 49200.0n 0.5869 49499.9n 0.5869 49500.0n 0.5206 49799.9n 0.5206 49800.0n 0.6201 50099.9n 0.6201 50100.0n 0.6035 50399.9n 0.6035 50400.0n 0.5869 50699.9n 0.5869 50700.0n 0.6201 50999.9n 0.6201 51000.0n 0.4377 51299.9n 0.4377 51300.0n 0.6201 51599.9n 0.6201 51600.0n 0.5703 51899.9n 0.5703 51900.0n 0.4211 52199.9n 0.4211 52200.0n 0.4045 52499.9n 0.4045 52500.0n 0.3547 52799.9n 0.3547 52800.0n 0.6201 53099.9n 0.6201 53100.0n 0.5869 53399.9n 0.5869 53400.0n 0.5372 53699.9n 0.5372 53700.0n 0.6201 53999.9n 0.6201 54000.0n 0.6035 54299.9n 0.6035 54300.0n 0.5869 54599.9n 0.5869 54600.0n 0.6035 54899.9n 0.6035 54900.0n 0.5206 55199.9n 0.5206 55200.0n 0.6035 55499.9n 0.6035 55500.0n 0.6201 55799.9n 0.6201 55800.0n 0.3713 56099.9n 0.3713 56100.0n 0.4874 56399.9n 0.4874 56400.0n 0.5869 56699.9n 0.5869 56700.0n 0.6201 56999.9n 0.6201 57000.0n 0.4542 57299.9n 0.4542 57300.0n 0.3547 57599.9n 0.3547 57600.0n 0.6201 57899.9n 0.6201 57900.0n 0.6035 58199.9n 0.6035 58200.0n 0.4874 58499.9n 0.4874 58500.0n 0.4874 58799.9n 0.4874 58800.0n 0.6201 59099.9n 0.6201 59100.0n 0.4377)
Vxn53 a_xn53 0 PWL(0.0n 0.3799 299.9n 0.3799 300.0n 0.4131 599.9n 0.4131 600.0n 0.4131 899.9n 0.4131 900.0n 0.4794 1199.9n 0.4794 1200.0n 0.3799 1499.9n 0.3799 1500.0n 0.3965 1799.9n 0.3965 1800.0n 0.4131 2099.9n 0.4131 2100.0n 0.3799 2399.9n 0.3799 2400.0n 0.5623 2699.9n 0.5623 2700.0n 0.3799 2999.9n 0.3799 3000.0n 0.4297 3299.9n 0.4297 3300.0n 0.5789 3599.9n 0.5789 3600.0n 0.5955 3899.9n 0.5955 3900.0n 0.6453 4199.9n 0.6453 4200.0n 0.3799 4499.9n 0.3799 4500.0n 0.4131 4799.9n 0.4131 4800.0n 0.4628 5099.9n 0.4628 5100.0n 0.3799 5399.9n 0.3799 5400.0n 0.3799 5699.9n 0.3799 5700.0n 0.4131 5999.9n 0.4131 6000.0n 0.4131 6299.9n 0.4131 6300.0n 0.4794 6599.9n 0.4794 6600.0n 0.3799 6899.9n 0.3799 6900.0n 0.3965 7199.9n 0.3965 7200.0n 0.4131 7499.9n 0.4131 7500.0n 0.3799 7799.9n 0.3799 7800.0n 0.5623 8099.9n 0.5623 8100.0n 0.3799 8399.9n 0.3799 8400.0n 0.4297 8699.9n 0.4297 8700.0n 0.5789 8999.9n 0.5789 9000.0n 0.5955 9299.9n 0.5955 9300.0n 0.6453 9599.9n 0.6453 9600.0n 0.3799 9899.9n 0.3799 9900.0n 0.4131 10199.9n 0.4131 10200.0n 0.4628 10499.9n 0.4628 10500.0n 0.3799 10799.9n 0.3799 10800.0n 0.3799 11099.9n 0.3799 11100.0n 0.4131 11399.9n 0.4131 11400.0n 0.4131 11699.9n 0.4131 11700.0n 0.4794 11999.9n 0.4794 12000.0n 0.3799 12299.9n 0.3799 12300.0n 0.3965 12599.9n 0.3965 12600.0n 0.4131 12899.9n 0.4131 12900.0n 0.3799 13199.9n 0.3799 13200.0n 0.5623 13499.9n 0.5623 13500.0n 0.3799 13799.9n 0.3799 13800.0n 0.4297 14099.9n 0.4297 14100.0n 0.5789 14399.9n 0.5789 14400.0n 0.5955 14699.9n 0.5955 14700.0n 0.6453 14999.9n 0.6453 15000.0n 0.3799 15299.9n 0.3799 15300.0n 0.4131 15599.9n 0.4131 15600.0n 0.4628 15899.9n 0.4628 15900.0n 0.3799 16199.9n 0.3799 16200.0n 0.3799 16499.9n 0.3799 16500.0n 0.4131 16799.9n 0.4131 16800.0n 0.4131 17099.9n 0.4131 17100.0n 0.4794 17399.9n 0.4794 17400.0n 0.3799 17699.9n 0.3799 17700.0n 0.3965 17999.9n 0.3965 18000.0n 0.4131 18299.9n 0.4131 18300.0n 0.3799 18599.9n 0.3799 18600.0n 0.5623 18899.9n 0.5623 18900.0n 0.3799 19199.9n 0.3799 19200.0n 0.4297 19499.9n 0.4297 19500.0n 0.5789 19799.9n 0.5789 19800.0n 0.5955 20099.9n 0.5955 20100.0n 0.6453 20399.9n 0.6453 20400.0n 0.3799 20699.9n 0.3799 20700.0n 0.4131 20999.9n 0.4131 21000.0n 0.4628 21299.9n 0.4628 21300.0n 0.3799 21599.9n 0.3799 21600.0n 0.3799 21899.9n 0.3799 21900.0n 0.4131 22199.9n 0.4131 22200.0n 0.4131 22499.9n 0.4131 22500.0n 0.4794 22799.9n 0.4794 22800.0n 0.3799 23099.9n 0.3799 23100.0n 0.3965 23399.9n 0.3965 23400.0n 0.4131 23699.9n 0.4131 23700.0n 0.3799 23999.9n 0.3799 24000.0n 0.5623 24299.9n 0.5623 24300.0n 0.3799 24599.9n 0.3799 24600.0n 0.4297 24899.9n 0.4297 24900.0n 0.5789 25199.9n 0.5789 25200.0n 0.5955 25499.9n 0.5955 25500.0n 0.6453 25799.9n 0.6453 25800.0n 0.3799 26099.9n 0.3799 26100.0n 0.4131 26399.9n 0.4131 26400.0n 0.4628 26699.9n 0.4628 26700.0n 0.3799 26999.9n 0.3799 27000.0n 0.3799 27299.9n 0.3799 27300.0n 0.4131 27599.9n 0.4131 27600.0n 0.4131 27899.9n 0.4131 27900.0n 0.4794 28199.9n 0.4794 28200.0n 0.3799 28499.9n 0.3799 28500.0n 0.3965 28799.9n 0.3965 28800.0n 0.4131 29099.9n 0.4131 29100.0n 0.3799 29399.9n 0.3799 29400.0n 0.5623 29699.9n 0.5623 29700.0n 0.3799 29999.9n 0.3799 30000.0n 0.4297 30299.9n 0.4297 30300.0n 0.5789 30599.9n 0.5789 30600.0n 0.5955 30899.9n 0.5955 30900.0n 0.6453 31199.9n 0.6453 31200.0n 0.3799 31499.9n 0.3799 31500.0n 0.4131 31799.9n 0.4131 31800.0n 0.4628 32099.9n 0.4628 32100.0n 0.3799 32399.9n 0.3799 32400.0n 0.3799 32699.9n 0.3799 32700.0n 0.4131 32999.9n 0.4131 33000.0n 0.4131 33299.9n 0.4131 33300.0n 0.4794 33599.9n 0.4794 33600.0n 0.3799 33899.9n 0.3799 33900.0n 0.3965 34199.9n 0.3965 34200.0n 0.4131 34499.9n 0.4131 34500.0n 0.3799 34799.9n 0.3799 34800.0n 0.5623 35099.9n 0.5623 35100.0n 0.3799 35399.9n 0.3799 35400.0n 0.4297 35699.9n 0.4297 35700.0n 0.5789 35999.9n 0.5789 36000.0n 0.5955 36299.9n 0.5955 36300.0n 0.6453 36599.9n 0.6453 36600.0n 0.3799 36899.9n 0.3799 36900.0n 0.4131 37199.9n 0.4131 37200.0n 0.4628 37499.9n 0.4628 37500.0n 0.3799 37799.9n 0.3799 37800.0n 0.3799 38099.9n 0.3799 38100.0n 0.4131 38399.9n 0.4131 38400.0n 0.4131 38699.9n 0.4131 38700.0n 0.4794 38999.9n 0.4794 39000.0n 0.3799 39299.9n 0.3799 39300.0n 0.3965 39599.9n 0.3965 39600.0n 0.4131 39899.9n 0.4131 39900.0n 0.3799 40199.9n 0.3799 40200.0n 0.5623 40499.9n 0.5623 40500.0n 0.3799 40799.9n 0.3799 40800.0n 0.4297 41099.9n 0.4297 41100.0n 0.5789 41399.9n 0.5789 41400.0n 0.5955 41699.9n 0.5955 41700.0n 0.6453 41999.9n 0.6453 42000.0n 0.3799 42299.9n 0.3799 42300.0n 0.4131 42599.9n 0.4131 42600.0n 0.4628 42899.9n 0.4628 42900.0n 0.3799 43199.9n 0.3799 43200.0n 0.3799 43499.9n 0.3799 43500.0n 0.4131 43799.9n 0.4131 43800.0n 0.4131 44099.9n 0.4131 44100.0n 0.4794 44399.9n 0.4794 44400.0n 0.3799 44699.9n 0.3799 44700.0n 0.3965 44999.9n 0.3965 45000.0n 0.4131 45299.9n 0.4131 45300.0n 0.3799 45599.9n 0.3799 45600.0n 0.5623 45899.9n 0.5623 45900.0n 0.3799 46199.9n 0.3799 46200.0n 0.4297 46499.9n 0.4297 46500.0n 0.5789 46799.9n 0.5789 46800.0n 0.5955 47099.9n 0.5955 47100.0n 0.6453 47399.9n 0.6453 47400.0n 0.3799 47699.9n 0.3799 47700.0n 0.4131 47999.9n 0.4131 48000.0n 0.4628 48299.9n 0.4628 48300.0n 0.3799 48599.9n 0.3799 48600.0n 0.3799 48899.9n 0.3799 48900.0n 0.4131 49199.9n 0.4131 49200.0n 0.4131 49499.9n 0.4131 49500.0n 0.4794 49799.9n 0.4794 49800.0n 0.3799 50099.9n 0.3799 50100.0n 0.3965 50399.9n 0.3965 50400.0n 0.4131 50699.9n 0.4131 50700.0n 0.3799 50999.9n 0.3799 51000.0n 0.5623 51299.9n 0.5623 51300.0n 0.3799 51599.9n 0.3799 51600.0n 0.4297 51899.9n 0.4297 51900.0n 0.5789 52199.9n 0.5789 52200.0n 0.5955 52499.9n 0.5955 52500.0n 0.6453 52799.9n 0.6453 52800.0n 0.3799 53099.9n 0.3799 53100.0n 0.4131 53399.9n 0.4131 53400.0n 0.4628 53699.9n 0.4628 53700.0n 0.3799 53999.9n 0.3799 54000.0n 0.3965 54299.9n 0.3965 54300.0n 0.4131 54599.9n 0.4131 54600.0n 0.3965 54899.9n 0.3965 54900.0n 0.4794 55199.9n 0.4794 55200.0n 0.3965 55499.9n 0.3965 55500.0n 0.3799 55799.9n 0.3799 55800.0n 0.6287 56099.9n 0.6287 56100.0n 0.5126 56399.9n 0.5126 56400.0n 0.4131 56699.9n 0.4131 56700.0n 0.3799 56999.9n 0.3799 57000.0n 0.5458 57299.9n 0.5458 57300.0n 0.6453 57599.9n 0.6453 57600.0n 0.3799 57899.9n 0.3799 57900.0n 0.3965 58199.9n 0.3965 58200.0n 0.5126 58499.9n 0.5126 58500.0n 0.5126 58799.9n 0.5126 58800.0n 0.3799 59099.9n 0.3799 59100.0n 0.5623)
Vxp54 a_xp54 0 PWL(0.0n 0.4243 299.9n 0.4243 300.0n 0.4446 599.9n 0.4446 600.0n 0.4649 899.9n 0.4649 900.0n 0.4243 1199.9n 0.4243 1200.0n 0.5666 1499.9n 0.5666 1500.0n 0.4853 1799.9n 0.4853 1800.0n 0.4649 2099.9n 0.4649 2100.0n 0.5056 2399.9n 0.5056 2400.0n 0.4649 2699.9n 0.4649 2700.0n 0.7293 2999.9n 0.7293 3000.0n 0.7293 3299.9n 0.7293 3300.0n 0.4243 3599.9n 0.4243 3600.0n 0.4243 3899.9n 0.4243 3900.0n 0.4243 4199.9n 0.4243 4200.0n 0.7293 4499.9n 0.7293 4500.0n 0.7293 4799.9n 0.7293 4800.0n 0.6683 5099.9n 0.6683 5100.0n 0.4243 5399.9n 0.4243 5400.0n 0.4243 5699.9n 0.4243 5700.0n 0.4446 5999.9n 0.4446 6000.0n 0.4649 6299.9n 0.4649 6300.0n 0.4243 6599.9n 0.4243 6600.0n 0.5666 6899.9n 0.5666 6900.0n 0.4853 7199.9n 0.4853 7200.0n 0.4649 7499.9n 0.4649 7500.0n 0.5056 7799.9n 0.5056 7800.0n 0.4649 8099.9n 0.4649 8100.0n 0.7293 8399.9n 0.7293 8400.0n 0.7293 8699.9n 0.7293 8700.0n 0.4243 8999.9n 0.4243 9000.0n 0.4243 9299.9n 0.4243 9300.0n 0.4243 9599.9n 0.4243 9600.0n 0.7293 9899.9n 0.7293 9900.0n 0.7293 10199.9n 0.7293 10200.0n 0.6683 10499.9n 0.6683 10500.0n 0.4243 10799.9n 0.4243 10800.0n 0.4243 11099.9n 0.4243 11100.0n 0.4446 11399.9n 0.4446 11400.0n 0.4649 11699.9n 0.4649 11700.0n 0.4243 11999.9n 0.4243 12000.0n 0.5666 12299.9n 0.5666 12300.0n 0.4853 12599.9n 0.4853 12600.0n 0.4649 12899.9n 0.4649 12900.0n 0.5056 13199.9n 0.5056 13200.0n 0.4649 13499.9n 0.4649 13500.0n 0.7293 13799.9n 0.7293 13800.0n 0.7293 14099.9n 0.7293 14100.0n 0.4243 14399.9n 0.4243 14400.0n 0.4243 14699.9n 0.4243 14700.0n 0.4243 14999.9n 0.4243 15000.0n 0.7293 15299.9n 0.7293 15300.0n 0.7293 15599.9n 0.7293 15600.0n 0.6683 15899.9n 0.6683 15900.0n 0.4243 16199.9n 0.4243 16200.0n 0.4243 16499.9n 0.4243 16500.0n 0.4446 16799.9n 0.4446 16800.0n 0.4649 17099.9n 0.4649 17100.0n 0.4243 17399.9n 0.4243 17400.0n 0.5666 17699.9n 0.5666 17700.0n 0.4853 17999.9n 0.4853 18000.0n 0.4649 18299.9n 0.4649 18300.0n 0.5056 18599.9n 0.5056 18600.0n 0.4649 18899.9n 0.4649 18900.0n 0.7293 19199.9n 0.7293 19200.0n 0.7293 19499.9n 0.7293 19500.0n 0.4243 19799.9n 0.4243 19800.0n 0.4243 20099.9n 0.4243 20100.0n 0.4243 20399.9n 0.4243 20400.0n 0.7293 20699.9n 0.7293 20700.0n 0.7293 20999.9n 0.7293 21000.0n 0.6683 21299.9n 0.6683 21300.0n 0.4243 21599.9n 0.4243 21600.0n 0.4243 21899.9n 0.4243 21900.0n 0.4446 22199.9n 0.4446 22200.0n 0.4649 22499.9n 0.4649 22500.0n 0.4243 22799.9n 0.4243 22800.0n 0.5666 23099.9n 0.5666 23100.0n 0.4853 23399.9n 0.4853 23400.0n 0.4649 23699.9n 0.4649 23700.0n 0.5056 23999.9n 0.5056 24000.0n 0.4649 24299.9n 0.4649 24300.0n 0.7293 24599.9n 0.7293 24600.0n 0.7293 24899.9n 0.7293 24900.0n 0.4243 25199.9n 0.4243 25200.0n 0.4243 25499.9n 0.4243 25500.0n 0.4243 25799.9n 0.4243 25800.0n 0.7293 26099.9n 0.7293 26100.0n 0.7293 26399.9n 0.7293 26400.0n 0.6683 26699.9n 0.6683 26700.0n 0.4243 26999.9n 0.4243 27000.0n 0.4243 27299.9n 0.4243 27300.0n 0.4446 27599.9n 0.4446 27600.0n 0.4649 27899.9n 0.4649 27900.0n 0.4243 28199.9n 0.4243 28200.0n 0.5666 28499.9n 0.5666 28500.0n 0.4853 28799.9n 0.4853 28800.0n 0.4649 29099.9n 0.4649 29100.0n 0.5056 29399.9n 0.5056 29400.0n 0.4649 29699.9n 0.4649 29700.0n 0.7293 29999.9n 0.7293 30000.0n 0.7293 30299.9n 0.7293 30300.0n 0.4243 30599.9n 0.4243 30600.0n 0.4243 30899.9n 0.4243 30900.0n 0.4243 31199.9n 0.4243 31200.0n 0.7293 31499.9n 0.7293 31500.0n 0.7293 31799.9n 0.7293 31800.0n 0.6683 32099.9n 0.6683 32100.0n 0.4243 32399.9n 0.4243 32400.0n 0.4243 32699.9n 0.4243 32700.0n 0.4446 32999.9n 0.4446 33000.0n 0.4649 33299.9n 0.4649 33300.0n 0.4243 33599.9n 0.4243 33600.0n 0.5666 33899.9n 0.5666 33900.0n 0.4853 34199.9n 0.4853 34200.0n 0.4649 34499.9n 0.4649 34500.0n 0.5056 34799.9n 0.5056 34800.0n 0.4649 35099.9n 0.4649 35100.0n 0.7293 35399.9n 0.7293 35400.0n 0.7293 35699.9n 0.7293 35700.0n 0.4243 35999.9n 0.4243 36000.0n 0.4243 36299.9n 0.4243 36300.0n 0.4243 36599.9n 0.4243 36600.0n 0.7293 36899.9n 0.7293 36900.0n 0.7293 37199.9n 0.7293 37200.0n 0.6683 37499.9n 0.6683 37500.0n 0.4243 37799.9n 0.4243 37800.0n 0.4243 38099.9n 0.4243 38100.0n 0.4446 38399.9n 0.4446 38400.0n 0.4649 38699.9n 0.4649 38700.0n 0.4243 38999.9n 0.4243 39000.0n 0.5666 39299.9n 0.5666 39300.0n 0.4853 39599.9n 0.4853 39600.0n 0.4649 39899.9n 0.4649 39900.0n 0.5056 40199.9n 0.5056 40200.0n 0.4649 40499.9n 0.4649 40500.0n 0.7293 40799.9n 0.7293 40800.0n 0.7293 41099.9n 0.7293 41100.0n 0.4243 41399.9n 0.4243 41400.0n 0.4243 41699.9n 0.4243 41700.0n 0.4243 41999.9n 0.4243 42000.0n 0.7293 42299.9n 0.7293 42300.0n 0.7293 42599.9n 0.7293 42600.0n 0.6683 42899.9n 0.6683 42900.0n 0.4243 43199.9n 0.4243 43200.0n 0.4243 43499.9n 0.4243 43500.0n 0.4446 43799.9n 0.4446 43800.0n 0.4649 44099.9n 0.4649 44100.0n 0.4243 44399.9n 0.4243 44400.0n 0.5666 44699.9n 0.5666 44700.0n 0.4853 44999.9n 0.4853 45000.0n 0.4649 45299.9n 0.4649 45300.0n 0.5056 45599.9n 0.5056 45600.0n 0.4649 45899.9n 0.4649 45900.0n 0.7293 46199.9n 0.7293 46200.0n 0.7293 46499.9n 0.7293 46500.0n 0.4243 46799.9n 0.4243 46800.0n 0.4243 47099.9n 0.4243 47100.0n 0.4243 47399.9n 0.4243 47400.0n 0.7293 47699.9n 0.7293 47700.0n 0.7293 47999.9n 0.7293 48000.0n 0.6683 48299.9n 0.6683 48300.0n 0.4243 48599.9n 0.4243 48600.0n 0.4243 48899.9n 0.4243 48900.0n 0.4446 49199.9n 0.4446 49200.0n 0.4649 49499.9n 0.4649 49500.0n 0.4243 49799.9n 0.4243 49800.0n 0.5666 50099.9n 0.5666 50100.0n 0.4853 50399.9n 0.4853 50400.0n 0.4649 50699.9n 0.4649 50700.0n 0.5056 50999.9n 0.5056 51000.0n 0.4649 51299.9n 0.4649 51300.0n 0.7293 51599.9n 0.7293 51600.0n 0.7293 51899.9n 0.7293 51900.0n 0.4243 52199.9n 0.4243 52200.0n 0.4243 52499.9n 0.4243 52500.0n 0.4243 52799.9n 0.4243 52800.0n 0.7293 53099.9n 0.7293 53100.0n 0.7293 53399.9n 0.7293 53400.0n 0.6683 53699.9n 0.6683 53700.0n 0.4243 53999.9n 0.4243 54000.0n 0.5056 54299.9n 0.5056 54300.0n 0.5259 54599.9n 0.5259 54600.0n 0.6276 54899.9n 0.6276 54900.0n 0.4243 55199.9n 0.4243 55200.0n 0.4446 55499.9n 0.4446 55500.0n 0.4446 55799.9n 0.4446 55800.0n 0.4243 56099.9n 0.4243 56100.0n 0.4243 56399.9n 0.4243 56400.0n 0.4243 56699.9n 0.4243 56700.0n 0.7089 56999.9n 0.7089 57000.0n 0.4243 57299.9n 0.4243 57300.0n 0.4243 57599.9n 0.4243 57600.0n 0.5666 57899.9n 0.5666 57900.0n 0.6479 58199.9n 0.6479 58200.0n 0.5056 58499.9n 0.5056 58500.0n 0.4649 58799.9n 0.4649 58800.0n 0.7293 59099.9n 0.7293 59100.0n 0.4853)
Vxn54 a_xn54 0 PWL(0.0n 0.5757 299.9n 0.5757 300.0n 0.5554 599.9n 0.5554 600.0n 0.5351 899.9n 0.5351 900.0n 0.5757 1199.9n 0.5757 1200.0n 0.4334 1499.9n 0.4334 1500.0n 0.5147 1799.9n 0.5147 1800.0n 0.5351 2099.9n 0.5351 2100.0n 0.4944 2399.9n 0.4944 2400.0n 0.5351 2699.9n 0.5351 2700.0n 0.2707 2999.9n 0.2707 3000.0n 0.2707 3299.9n 0.2707 3300.0n 0.5757 3599.9n 0.5757 3600.0n 0.5757 3899.9n 0.5757 3900.0n 0.5757 4199.9n 0.5757 4200.0n 0.2707 4499.9n 0.2707 4500.0n 0.2707 4799.9n 0.2707 4800.0n 0.3317 5099.9n 0.3317 5100.0n 0.5757 5399.9n 0.5757 5400.0n 0.5757 5699.9n 0.5757 5700.0n 0.5554 5999.9n 0.5554 6000.0n 0.5351 6299.9n 0.5351 6300.0n 0.5757 6599.9n 0.5757 6600.0n 0.4334 6899.9n 0.4334 6900.0n 0.5147 7199.9n 0.5147 7200.0n 0.5351 7499.9n 0.5351 7500.0n 0.4944 7799.9n 0.4944 7800.0n 0.5351 8099.9n 0.5351 8100.0n 0.2707 8399.9n 0.2707 8400.0n 0.2707 8699.9n 0.2707 8700.0n 0.5757 8999.9n 0.5757 9000.0n 0.5757 9299.9n 0.5757 9300.0n 0.5757 9599.9n 0.5757 9600.0n 0.2707 9899.9n 0.2707 9900.0n 0.2707 10199.9n 0.2707 10200.0n 0.3317 10499.9n 0.3317 10500.0n 0.5757 10799.9n 0.5757 10800.0n 0.5757 11099.9n 0.5757 11100.0n 0.5554 11399.9n 0.5554 11400.0n 0.5351 11699.9n 0.5351 11700.0n 0.5757 11999.9n 0.5757 12000.0n 0.4334 12299.9n 0.4334 12300.0n 0.5147 12599.9n 0.5147 12600.0n 0.5351 12899.9n 0.5351 12900.0n 0.4944 13199.9n 0.4944 13200.0n 0.5351 13499.9n 0.5351 13500.0n 0.2707 13799.9n 0.2707 13800.0n 0.2707 14099.9n 0.2707 14100.0n 0.5757 14399.9n 0.5757 14400.0n 0.5757 14699.9n 0.5757 14700.0n 0.5757 14999.9n 0.5757 15000.0n 0.2707 15299.9n 0.2707 15300.0n 0.2707 15599.9n 0.2707 15600.0n 0.3317 15899.9n 0.3317 15900.0n 0.5757 16199.9n 0.5757 16200.0n 0.5757 16499.9n 0.5757 16500.0n 0.5554 16799.9n 0.5554 16800.0n 0.5351 17099.9n 0.5351 17100.0n 0.5757 17399.9n 0.5757 17400.0n 0.4334 17699.9n 0.4334 17700.0n 0.5147 17999.9n 0.5147 18000.0n 0.5351 18299.9n 0.5351 18300.0n 0.4944 18599.9n 0.4944 18600.0n 0.5351 18899.9n 0.5351 18900.0n 0.2707 19199.9n 0.2707 19200.0n 0.2707 19499.9n 0.2707 19500.0n 0.5757 19799.9n 0.5757 19800.0n 0.5757 20099.9n 0.5757 20100.0n 0.5757 20399.9n 0.5757 20400.0n 0.2707 20699.9n 0.2707 20700.0n 0.2707 20999.9n 0.2707 21000.0n 0.3317 21299.9n 0.3317 21300.0n 0.5757 21599.9n 0.5757 21600.0n 0.5757 21899.9n 0.5757 21900.0n 0.5554 22199.9n 0.5554 22200.0n 0.5351 22499.9n 0.5351 22500.0n 0.5757 22799.9n 0.5757 22800.0n 0.4334 23099.9n 0.4334 23100.0n 0.5147 23399.9n 0.5147 23400.0n 0.5351 23699.9n 0.5351 23700.0n 0.4944 23999.9n 0.4944 24000.0n 0.5351 24299.9n 0.5351 24300.0n 0.2707 24599.9n 0.2707 24600.0n 0.2707 24899.9n 0.2707 24900.0n 0.5757 25199.9n 0.5757 25200.0n 0.5757 25499.9n 0.5757 25500.0n 0.5757 25799.9n 0.5757 25800.0n 0.2707 26099.9n 0.2707 26100.0n 0.2707 26399.9n 0.2707 26400.0n 0.3317 26699.9n 0.3317 26700.0n 0.5757 26999.9n 0.5757 27000.0n 0.5757 27299.9n 0.5757 27300.0n 0.5554 27599.9n 0.5554 27600.0n 0.5351 27899.9n 0.5351 27900.0n 0.5757 28199.9n 0.5757 28200.0n 0.4334 28499.9n 0.4334 28500.0n 0.5147 28799.9n 0.5147 28800.0n 0.5351 29099.9n 0.5351 29100.0n 0.4944 29399.9n 0.4944 29400.0n 0.5351 29699.9n 0.5351 29700.0n 0.2707 29999.9n 0.2707 30000.0n 0.2707 30299.9n 0.2707 30300.0n 0.5757 30599.9n 0.5757 30600.0n 0.5757 30899.9n 0.5757 30900.0n 0.5757 31199.9n 0.5757 31200.0n 0.2707 31499.9n 0.2707 31500.0n 0.2707 31799.9n 0.2707 31800.0n 0.3317 32099.9n 0.3317 32100.0n 0.5757 32399.9n 0.5757 32400.0n 0.5757 32699.9n 0.5757 32700.0n 0.5554 32999.9n 0.5554 33000.0n 0.5351 33299.9n 0.5351 33300.0n 0.5757 33599.9n 0.5757 33600.0n 0.4334 33899.9n 0.4334 33900.0n 0.5147 34199.9n 0.5147 34200.0n 0.5351 34499.9n 0.5351 34500.0n 0.4944 34799.9n 0.4944 34800.0n 0.5351 35099.9n 0.5351 35100.0n 0.2707 35399.9n 0.2707 35400.0n 0.2707 35699.9n 0.2707 35700.0n 0.5757 35999.9n 0.5757 36000.0n 0.5757 36299.9n 0.5757 36300.0n 0.5757 36599.9n 0.5757 36600.0n 0.2707 36899.9n 0.2707 36900.0n 0.2707 37199.9n 0.2707 37200.0n 0.3317 37499.9n 0.3317 37500.0n 0.5757 37799.9n 0.5757 37800.0n 0.5757 38099.9n 0.5757 38100.0n 0.5554 38399.9n 0.5554 38400.0n 0.5351 38699.9n 0.5351 38700.0n 0.5757 38999.9n 0.5757 39000.0n 0.4334 39299.9n 0.4334 39300.0n 0.5147 39599.9n 0.5147 39600.0n 0.5351 39899.9n 0.5351 39900.0n 0.4944 40199.9n 0.4944 40200.0n 0.5351 40499.9n 0.5351 40500.0n 0.2707 40799.9n 0.2707 40800.0n 0.2707 41099.9n 0.2707 41100.0n 0.5757 41399.9n 0.5757 41400.0n 0.5757 41699.9n 0.5757 41700.0n 0.5757 41999.9n 0.5757 42000.0n 0.2707 42299.9n 0.2707 42300.0n 0.2707 42599.9n 0.2707 42600.0n 0.3317 42899.9n 0.3317 42900.0n 0.5757 43199.9n 0.5757 43200.0n 0.5757 43499.9n 0.5757 43500.0n 0.5554 43799.9n 0.5554 43800.0n 0.5351 44099.9n 0.5351 44100.0n 0.5757 44399.9n 0.5757 44400.0n 0.4334 44699.9n 0.4334 44700.0n 0.5147 44999.9n 0.5147 45000.0n 0.5351 45299.9n 0.5351 45300.0n 0.4944 45599.9n 0.4944 45600.0n 0.5351 45899.9n 0.5351 45900.0n 0.2707 46199.9n 0.2707 46200.0n 0.2707 46499.9n 0.2707 46500.0n 0.5757 46799.9n 0.5757 46800.0n 0.5757 47099.9n 0.5757 47100.0n 0.5757 47399.9n 0.5757 47400.0n 0.2707 47699.9n 0.2707 47700.0n 0.2707 47999.9n 0.2707 48000.0n 0.3317 48299.9n 0.3317 48300.0n 0.5757 48599.9n 0.5757 48600.0n 0.5757 48899.9n 0.5757 48900.0n 0.5554 49199.9n 0.5554 49200.0n 0.5351 49499.9n 0.5351 49500.0n 0.5757 49799.9n 0.5757 49800.0n 0.4334 50099.9n 0.4334 50100.0n 0.5147 50399.9n 0.5147 50400.0n 0.5351 50699.9n 0.5351 50700.0n 0.4944 50999.9n 0.4944 51000.0n 0.5351 51299.9n 0.5351 51300.0n 0.2707 51599.9n 0.2707 51600.0n 0.2707 51899.9n 0.2707 51900.0n 0.5757 52199.9n 0.5757 52200.0n 0.5757 52499.9n 0.5757 52500.0n 0.5757 52799.9n 0.5757 52800.0n 0.2707 53099.9n 0.2707 53100.0n 0.2707 53399.9n 0.2707 53400.0n 0.3317 53699.9n 0.3317 53700.0n 0.5757 53999.9n 0.5757 54000.0n 0.4944 54299.9n 0.4944 54300.0n 0.4741 54599.9n 0.4741 54600.0n 0.3724 54899.9n 0.3724 54900.0n 0.5757 55199.9n 0.5757 55200.0n 0.5554 55499.9n 0.5554 55500.0n 0.5554 55799.9n 0.5554 55800.0n 0.5757 56099.9n 0.5757 56100.0n 0.5757 56399.9n 0.5757 56400.0n 0.5757 56699.9n 0.5757 56700.0n 0.2911 56999.9n 0.2911 57000.0n 0.5757 57299.9n 0.5757 57300.0n 0.5757 57599.9n 0.5757 57600.0n 0.4334 57899.9n 0.4334 57900.0n 0.3521 58199.9n 0.3521 58200.0n 0.4944 58499.9n 0.4944 58500.0n 0.5351 58799.9n 0.5351 58800.0n 0.2707 59099.9n 0.2707 59100.0n 0.5147)
Vxp55 a_xp55 0 PWL(0.0n 0.4790 299.9n 0.4790 300.0n 0.4790 599.9n 0.4790 600.0n 0.4790 899.9n 0.4790 900.0n 0.4790 1199.9n 0.4790 1200.0n 0.4790 1499.9n 0.4790 1500.0n 0.4790 1799.9n 0.4790 1800.0n 0.4790 2099.9n 0.4790 2100.0n 0.4790 2399.9n 0.4790 2400.0n 0.4790 2699.9n 0.4790 2700.0n 0.4790 2999.9n 0.4790 3000.0n 0.7839 3299.9n 0.7839 3300.0n 0.4790 3599.9n 0.4790 3600.0n 0.4790 3899.9n 0.4790 3900.0n 0.4790 4199.9n 0.4790 4200.0n 0.4790 4499.9n 0.4790 4500.0n 0.7839 4799.9n 0.7839 4800.0n 0.4790 5099.9n 0.4790 5100.0n 0.4790 5399.9n 0.4790 5400.0n 0.4790 5699.9n 0.4790 5700.0n 0.4790 5999.9n 0.4790 6000.0n 0.4790 6299.9n 0.4790 6300.0n 0.4790 6599.9n 0.4790 6600.0n 0.4790 6899.9n 0.4790 6900.0n 0.4790 7199.9n 0.4790 7200.0n 0.4790 7499.9n 0.4790 7500.0n 0.4790 7799.9n 0.4790 7800.0n 0.4790 8099.9n 0.4790 8100.0n 0.4790 8399.9n 0.4790 8400.0n 0.7839 8699.9n 0.7839 8700.0n 0.4790 8999.9n 0.4790 9000.0n 0.4790 9299.9n 0.4790 9300.0n 0.4790 9599.9n 0.4790 9600.0n 0.4790 9899.9n 0.4790 9900.0n 0.7839 10199.9n 0.7839 10200.0n 0.4790 10499.9n 0.4790 10500.0n 0.4790 10799.9n 0.4790 10800.0n 0.4790 11099.9n 0.4790 11100.0n 0.4790 11399.9n 0.4790 11400.0n 0.4790 11699.9n 0.4790 11700.0n 0.4790 11999.9n 0.4790 12000.0n 0.4790 12299.9n 0.4790 12300.0n 0.4790 12599.9n 0.4790 12600.0n 0.4790 12899.9n 0.4790 12900.0n 0.4790 13199.9n 0.4790 13200.0n 0.4790 13499.9n 0.4790 13500.0n 0.4790 13799.9n 0.4790 13800.0n 0.7839 14099.9n 0.7839 14100.0n 0.4790 14399.9n 0.4790 14400.0n 0.4790 14699.9n 0.4790 14700.0n 0.4790 14999.9n 0.4790 15000.0n 0.4790 15299.9n 0.4790 15300.0n 0.7839 15599.9n 0.7839 15600.0n 0.4790 15899.9n 0.4790 15900.0n 0.4790 16199.9n 0.4790 16200.0n 0.4790 16499.9n 0.4790 16500.0n 0.4790 16799.9n 0.4790 16800.0n 0.4790 17099.9n 0.4790 17100.0n 0.4790 17399.9n 0.4790 17400.0n 0.4790 17699.9n 0.4790 17700.0n 0.4790 17999.9n 0.4790 18000.0n 0.4790 18299.9n 0.4790 18300.0n 0.4790 18599.9n 0.4790 18600.0n 0.4790 18899.9n 0.4790 18900.0n 0.4790 19199.9n 0.4790 19200.0n 0.7839 19499.9n 0.7839 19500.0n 0.4790 19799.9n 0.4790 19800.0n 0.4790 20099.9n 0.4790 20100.0n 0.4790 20399.9n 0.4790 20400.0n 0.4790 20699.9n 0.4790 20700.0n 0.7839 20999.9n 0.7839 21000.0n 0.4790 21299.9n 0.4790 21300.0n 0.4790 21599.9n 0.4790 21600.0n 0.4790 21899.9n 0.4790 21900.0n 0.4790 22199.9n 0.4790 22200.0n 0.4790 22499.9n 0.4790 22500.0n 0.4790 22799.9n 0.4790 22800.0n 0.4790 23099.9n 0.4790 23100.0n 0.4790 23399.9n 0.4790 23400.0n 0.4790 23699.9n 0.4790 23700.0n 0.4790 23999.9n 0.4790 24000.0n 0.4790 24299.9n 0.4790 24300.0n 0.4790 24599.9n 0.4790 24600.0n 0.7839 24899.9n 0.7839 24900.0n 0.4790 25199.9n 0.4790 25200.0n 0.4790 25499.9n 0.4790 25500.0n 0.4790 25799.9n 0.4790 25800.0n 0.4790 26099.9n 0.4790 26100.0n 0.7839 26399.9n 0.7839 26400.0n 0.4790 26699.9n 0.4790 26700.0n 0.4790 26999.9n 0.4790 27000.0n 0.4790 27299.9n 0.4790 27300.0n 0.4790 27599.9n 0.4790 27600.0n 0.4790 27899.9n 0.4790 27900.0n 0.4790 28199.9n 0.4790 28200.0n 0.4790 28499.9n 0.4790 28500.0n 0.4790 28799.9n 0.4790 28800.0n 0.4790 29099.9n 0.4790 29100.0n 0.4790 29399.9n 0.4790 29400.0n 0.4790 29699.9n 0.4790 29700.0n 0.4790 29999.9n 0.4790 30000.0n 0.7839 30299.9n 0.7839 30300.0n 0.4790 30599.9n 0.4790 30600.0n 0.4790 30899.9n 0.4790 30900.0n 0.4790 31199.9n 0.4790 31200.0n 0.4790 31499.9n 0.4790 31500.0n 0.7839 31799.9n 0.7839 31800.0n 0.4790 32099.9n 0.4790 32100.0n 0.4790 32399.9n 0.4790 32400.0n 0.4790 32699.9n 0.4790 32700.0n 0.4790 32999.9n 0.4790 33000.0n 0.4790 33299.9n 0.4790 33300.0n 0.4790 33599.9n 0.4790 33600.0n 0.4790 33899.9n 0.4790 33900.0n 0.4790 34199.9n 0.4790 34200.0n 0.4790 34499.9n 0.4790 34500.0n 0.4790 34799.9n 0.4790 34800.0n 0.4790 35099.9n 0.4790 35100.0n 0.4790 35399.9n 0.4790 35400.0n 0.7839 35699.9n 0.7839 35700.0n 0.4790 35999.9n 0.4790 36000.0n 0.4790 36299.9n 0.4790 36300.0n 0.4790 36599.9n 0.4790 36600.0n 0.4790 36899.9n 0.4790 36900.0n 0.7839 37199.9n 0.7839 37200.0n 0.4790 37499.9n 0.4790 37500.0n 0.4790 37799.9n 0.4790 37800.0n 0.4790 38099.9n 0.4790 38100.0n 0.4790 38399.9n 0.4790 38400.0n 0.4790 38699.9n 0.4790 38700.0n 0.4790 38999.9n 0.4790 39000.0n 0.4790 39299.9n 0.4790 39300.0n 0.4790 39599.9n 0.4790 39600.0n 0.4790 39899.9n 0.4790 39900.0n 0.4790 40199.9n 0.4790 40200.0n 0.4790 40499.9n 0.4790 40500.0n 0.4790 40799.9n 0.4790 40800.0n 0.7839 41099.9n 0.7839 41100.0n 0.4790 41399.9n 0.4790 41400.0n 0.4790 41699.9n 0.4790 41700.0n 0.4790 41999.9n 0.4790 42000.0n 0.4790 42299.9n 0.4790 42300.0n 0.7839 42599.9n 0.7839 42600.0n 0.4790 42899.9n 0.4790 42900.0n 0.4790 43199.9n 0.4790 43200.0n 0.4790 43499.9n 0.4790 43500.0n 0.4790 43799.9n 0.4790 43800.0n 0.4790 44099.9n 0.4790 44100.0n 0.4790 44399.9n 0.4790 44400.0n 0.4790 44699.9n 0.4790 44700.0n 0.4790 44999.9n 0.4790 45000.0n 0.4790 45299.9n 0.4790 45300.0n 0.4790 45599.9n 0.4790 45600.0n 0.4790 45899.9n 0.4790 45900.0n 0.4790 46199.9n 0.4790 46200.0n 0.7839 46499.9n 0.7839 46500.0n 0.4790 46799.9n 0.4790 46800.0n 0.4790 47099.9n 0.4790 47100.0n 0.4790 47399.9n 0.4790 47400.0n 0.4790 47699.9n 0.4790 47700.0n 0.7839 47999.9n 0.7839 48000.0n 0.4790 48299.9n 0.4790 48300.0n 0.4790 48599.9n 0.4790 48600.0n 0.4790 48899.9n 0.4790 48900.0n 0.4790 49199.9n 0.4790 49200.0n 0.4790 49499.9n 0.4790 49500.0n 0.4790 49799.9n 0.4790 49800.0n 0.4790 50099.9n 0.4790 50100.0n 0.4790 50399.9n 0.4790 50400.0n 0.4790 50699.9n 0.4790 50700.0n 0.4790 50999.9n 0.4790 51000.0n 0.4790 51299.9n 0.4790 51300.0n 0.4790 51599.9n 0.4790 51600.0n 0.7839 51899.9n 0.7839 51900.0n 0.4790 52199.9n 0.4790 52200.0n 0.4790 52499.9n 0.4790 52500.0n 0.4790 52799.9n 0.4790 52800.0n 0.4790 53099.9n 0.4790 53100.0n 0.7839 53399.9n 0.7839 53400.0n 0.4790 53699.9n 0.4790 53700.0n 0.4790 53999.9n 0.4790 54000.0n 0.4790 54299.9n 0.4790 54300.0n 0.4790 54599.9n 0.4790 54600.0n 0.4790 54899.9n 0.4790 54900.0n 0.4790 55199.9n 0.4790 55200.0n 0.4790 55499.9n 0.4790 55500.0n 0.4790 55799.9n 0.4790 55800.0n 0.4790 56099.9n 0.4790 56100.0n 0.4790 56399.9n 0.4790 56400.0n 0.4790 56699.9n 0.4790 56700.0n 0.8000 56999.9n 0.8000 57000.0n 0.4790 57299.9n 0.4790 57300.0n 0.4790 57599.9n 0.4790 57600.0n 0.4790 57899.9n 0.4790 57900.0n 0.4790 58199.9n 0.4790 58200.0n 0.4790 58499.9n 0.4790 58500.0n 0.4790 58799.9n 0.4790 58800.0n 0.4790 59099.9n 0.4790 59100.0n 0.4790)
Vxn55 a_xn55 0 PWL(0.0n 0.5210 299.9n 0.5210 300.0n 0.5210 599.9n 0.5210 600.0n 0.5210 899.9n 0.5210 900.0n 0.5210 1199.9n 0.5210 1200.0n 0.5210 1499.9n 0.5210 1500.0n 0.5210 1799.9n 0.5210 1800.0n 0.5210 2099.9n 0.5210 2100.0n 0.5210 2399.9n 0.5210 2400.0n 0.5210 2699.9n 0.5210 2700.0n 0.5210 2999.9n 0.5210 3000.0n 0.2161 3299.9n 0.2161 3300.0n 0.5210 3599.9n 0.5210 3600.0n 0.5210 3899.9n 0.5210 3900.0n 0.5210 4199.9n 0.5210 4200.0n 0.5210 4499.9n 0.5210 4500.0n 0.2161 4799.9n 0.2161 4800.0n 0.5210 5099.9n 0.5210 5100.0n 0.5210 5399.9n 0.5210 5400.0n 0.5210 5699.9n 0.5210 5700.0n 0.5210 5999.9n 0.5210 6000.0n 0.5210 6299.9n 0.5210 6300.0n 0.5210 6599.9n 0.5210 6600.0n 0.5210 6899.9n 0.5210 6900.0n 0.5210 7199.9n 0.5210 7200.0n 0.5210 7499.9n 0.5210 7500.0n 0.5210 7799.9n 0.5210 7800.0n 0.5210 8099.9n 0.5210 8100.0n 0.5210 8399.9n 0.5210 8400.0n 0.2161 8699.9n 0.2161 8700.0n 0.5210 8999.9n 0.5210 9000.0n 0.5210 9299.9n 0.5210 9300.0n 0.5210 9599.9n 0.5210 9600.0n 0.5210 9899.9n 0.5210 9900.0n 0.2161 10199.9n 0.2161 10200.0n 0.5210 10499.9n 0.5210 10500.0n 0.5210 10799.9n 0.5210 10800.0n 0.5210 11099.9n 0.5210 11100.0n 0.5210 11399.9n 0.5210 11400.0n 0.5210 11699.9n 0.5210 11700.0n 0.5210 11999.9n 0.5210 12000.0n 0.5210 12299.9n 0.5210 12300.0n 0.5210 12599.9n 0.5210 12600.0n 0.5210 12899.9n 0.5210 12900.0n 0.5210 13199.9n 0.5210 13200.0n 0.5210 13499.9n 0.5210 13500.0n 0.5210 13799.9n 0.5210 13800.0n 0.2161 14099.9n 0.2161 14100.0n 0.5210 14399.9n 0.5210 14400.0n 0.5210 14699.9n 0.5210 14700.0n 0.5210 14999.9n 0.5210 15000.0n 0.5210 15299.9n 0.5210 15300.0n 0.2161 15599.9n 0.2161 15600.0n 0.5210 15899.9n 0.5210 15900.0n 0.5210 16199.9n 0.5210 16200.0n 0.5210 16499.9n 0.5210 16500.0n 0.5210 16799.9n 0.5210 16800.0n 0.5210 17099.9n 0.5210 17100.0n 0.5210 17399.9n 0.5210 17400.0n 0.5210 17699.9n 0.5210 17700.0n 0.5210 17999.9n 0.5210 18000.0n 0.5210 18299.9n 0.5210 18300.0n 0.5210 18599.9n 0.5210 18600.0n 0.5210 18899.9n 0.5210 18900.0n 0.5210 19199.9n 0.5210 19200.0n 0.2161 19499.9n 0.2161 19500.0n 0.5210 19799.9n 0.5210 19800.0n 0.5210 20099.9n 0.5210 20100.0n 0.5210 20399.9n 0.5210 20400.0n 0.5210 20699.9n 0.5210 20700.0n 0.2161 20999.9n 0.2161 21000.0n 0.5210 21299.9n 0.5210 21300.0n 0.5210 21599.9n 0.5210 21600.0n 0.5210 21899.9n 0.5210 21900.0n 0.5210 22199.9n 0.5210 22200.0n 0.5210 22499.9n 0.5210 22500.0n 0.5210 22799.9n 0.5210 22800.0n 0.5210 23099.9n 0.5210 23100.0n 0.5210 23399.9n 0.5210 23400.0n 0.5210 23699.9n 0.5210 23700.0n 0.5210 23999.9n 0.5210 24000.0n 0.5210 24299.9n 0.5210 24300.0n 0.5210 24599.9n 0.5210 24600.0n 0.2161 24899.9n 0.2161 24900.0n 0.5210 25199.9n 0.5210 25200.0n 0.5210 25499.9n 0.5210 25500.0n 0.5210 25799.9n 0.5210 25800.0n 0.5210 26099.9n 0.5210 26100.0n 0.2161 26399.9n 0.2161 26400.0n 0.5210 26699.9n 0.5210 26700.0n 0.5210 26999.9n 0.5210 27000.0n 0.5210 27299.9n 0.5210 27300.0n 0.5210 27599.9n 0.5210 27600.0n 0.5210 27899.9n 0.5210 27900.0n 0.5210 28199.9n 0.5210 28200.0n 0.5210 28499.9n 0.5210 28500.0n 0.5210 28799.9n 0.5210 28800.0n 0.5210 29099.9n 0.5210 29100.0n 0.5210 29399.9n 0.5210 29400.0n 0.5210 29699.9n 0.5210 29700.0n 0.5210 29999.9n 0.5210 30000.0n 0.2161 30299.9n 0.2161 30300.0n 0.5210 30599.9n 0.5210 30600.0n 0.5210 30899.9n 0.5210 30900.0n 0.5210 31199.9n 0.5210 31200.0n 0.5210 31499.9n 0.5210 31500.0n 0.2161 31799.9n 0.2161 31800.0n 0.5210 32099.9n 0.5210 32100.0n 0.5210 32399.9n 0.5210 32400.0n 0.5210 32699.9n 0.5210 32700.0n 0.5210 32999.9n 0.5210 33000.0n 0.5210 33299.9n 0.5210 33300.0n 0.5210 33599.9n 0.5210 33600.0n 0.5210 33899.9n 0.5210 33900.0n 0.5210 34199.9n 0.5210 34200.0n 0.5210 34499.9n 0.5210 34500.0n 0.5210 34799.9n 0.5210 34800.0n 0.5210 35099.9n 0.5210 35100.0n 0.5210 35399.9n 0.5210 35400.0n 0.2161 35699.9n 0.2161 35700.0n 0.5210 35999.9n 0.5210 36000.0n 0.5210 36299.9n 0.5210 36300.0n 0.5210 36599.9n 0.5210 36600.0n 0.5210 36899.9n 0.5210 36900.0n 0.2161 37199.9n 0.2161 37200.0n 0.5210 37499.9n 0.5210 37500.0n 0.5210 37799.9n 0.5210 37800.0n 0.5210 38099.9n 0.5210 38100.0n 0.5210 38399.9n 0.5210 38400.0n 0.5210 38699.9n 0.5210 38700.0n 0.5210 38999.9n 0.5210 39000.0n 0.5210 39299.9n 0.5210 39300.0n 0.5210 39599.9n 0.5210 39600.0n 0.5210 39899.9n 0.5210 39900.0n 0.5210 40199.9n 0.5210 40200.0n 0.5210 40499.9n 0.5210 40500.0n 0.5210 40799.9n 0.5210 40800.0n 0.2161 41099.9n 0.2161 41100.0n 0.5210 41399.9n 0.5210 41400.0n 0.5210 41699.9n 0.5210 41700.0n 0.5210 41999.9n 0.5210 42000.0n 0.5210 42299.9n 0.5210 42300.0n 0.2161 42599.9n 0.2161 42600.0n 0.5210 42899.9n 0.5210 42900.0n 0.5210 43199.9n 0.5210 43200.0n 0.5210 43499.9n 0.5210 43500.0n 0.5210 43799.9n 0.5210 43800.0n 0.5210 44099.9n 0.5210 44100.0n 0.5210 44399.9n 0.5210 44400.0n 0.5210 44699.9n 0.5210 44700.0n 0.5210 44999.9n 0.5210 45000.0n 0.5210 45299.9n 0.5210 45300.0n 0.5210 45599.9n 0.5210 45600.0n 0.5210 45899.9n 0.5210 45900.0n 0.5210 46199.9n 0.5210 46200.0n 0.2161 46499.9n 0.2161 46500.0n 0.5210 46799.9n 0.5210 46800.0n 0.5210 47099.9n 0.5210 47100.0n 0.5210 47399.9n 0.5210 47400.0n 0.5210 47699.9n 0.5210 47700.0n 0.2161 47999.9n 0.2161 48000.0n 0.5210 48299.9n 0.5210 48300.0n 0.5210 48599.9n 0.5210 48600.0n 0.5210 48899.9n 0.5210 48900.0n 0.5210 49199.9n 0.5210 49200.0n 0.5210 49499.9n 0.5210 49500.0n 0.5210 49799.9n 0.5210 49800.0n 0.5210 50099.9n 0.5210 50100.0n 0.5210 50399.9n 0.5210 50400.0n 0.5210 50699.9n 0.5210 50700.0n 0.5210 50999.9n 0.5210 51000.0n 0.5210 51299.9n 0.5210 51300.0n 0.5210 51599.9n 0.5210 51600.0n 0.2161 51899.9n 0.2161 51900.0n 0.5210 52199.9n 0.5210 52200.0n 0.5210 52499.9n 0.5210 52500.0n 0.5210 52799.9n 0.5210 52800.0n 0.5210 53099.9n 0.5210 53100.0n 0.2161 53399.9n 0.2161 53400.0n 0.5210 53699.9n 0.5210 53700.0n 0.5210 53999.9n 0.5210 54000.0n 0.5210 54299.9n 0.5210 54300.0n 0.5210 54599.9n 0.5210 54600.0n 0.5210 54899.9n 0.5210 54900.0n 0.5210 55199.9n 0.5210 55200.0n 0.5210 55499.9n 0.5210 55500.0n 0.5210 55799.9n 0.5210 55800.0n 0.5210 56099.9n 0.5210 56100.0n 0.5210 56399.9n 0.5210 56400.0n 0.5210 56699.9n 0.5210 56700.0n 0.2000 56999.9n 0.2000 57000.0n 0.5210 57299.9n 0.5210 57300.0n 0.5210 57599.9n 0.5210 57600.0n 0.5210 57899.9n 0.5210 57900.0n 0.5210 58199.9n 0.5210 58200.0n 0.5210 58499.9n 0.5210 58500.0n 0.5210 58799.9n 0.5210 58800.0n 0.5210 59099.9n 0.5210 59100.0n 0.5210)
Vxp56 a_xp56 0 PWL(0.0n 0.4976 299.9n 0.4976 300.0n 0.4976 599.9n 0.4976 600.0n 0.4976 899.9n 0.4976 900.0n 0.4976 1199.9n 0.4976 1200.0n 0.4976 1499.9n 0.4976 1500.0n 0.4976 1799.9n 0.4976 1800.0n 0.4976 2099.9n 0.4976 2100.0n 0.4976 2399.9n 0.4976 2400.0n 0.4976 2699.9n 0.4976 2700.0n 0.4976 2999.9n 0.4976 3000.0n 0.4976 3299.9n 0.4976 3300.0n 0.4976 3599.9n 0.4976 3600.0n 0.4976 3899.9n 0.4976 3900.0n 0.4976 4199.9n 0.4976 4200.0n 0.4976 4499.9n 0.4976 4500.0n 0.4976 4799.9n 0.4976 4800.0n 0.4976 5099.9n 0.4976 5100.0n 0.4976 5399.9n 0.4976 5400.0n 0.4976 5699.9n 0.4976 5700.0n 0.4976 5999.9n 0.4976 6000.0n 0.4976 6299.9n 0.4976 6300.0n 0.4976 6599.9n 0.4976 6600.0n 0.4976 6899.9n 0.4976 6900.0n 0.4976 7199.9n 0.4976 7200.0n 0.4976 7499.9n 0.4976 7500.0n 0.4976 7799.9n 0.4976 7800.0n 0.4976 8099.9n 0.4976 8100.0n 0.4976 8399.9n 0.4976 8400.0n 0.4976 8699.9n 0.4976 8700.0n 0.4976 8999.9n 0.4976 9000.0n 0.4976 9299.9n 0.4976 9300.0n 0.4976 9599.9n 0.4976 9600.0n 0.4976 9899.9n 0.4976 9900.0n 0.4976 10199.9n 0.4976 10200.0n 0.4976 10499.9n 0.4976 10500.0n 0.4976 10799.9n 0.4976 10800.0n 0.4976 11099.9n 0.4976 11100.0n 0.4976 11399.9n 0.4976 11400.0n 0.4976 11699.9n 0.4976 11700.0n 0.4976 11999.9n 0.4976 12000.0n 0.4976 12299.9n 0.4976 12300.0n 0.4976 12599.9n 0.4976 12600.0n 0.4976 12899.9n 0.4976 12900.0n 0.4976 13199.9n 0.4976 13200.0n 0.4976 13499.9n 0.4976 13500.0n 0.4976 13799.9n 0.4976 13800.0n 0.4976 14099.9n 0.4976 14100.0n 0.4976 14399.9n 0.4976 14400.0n 0.4976 14699.9n 0.4976 14700.0n 0.4976 14999.9n 0.4976 15000.0n 0.4976 15299.9n 0.4976 15300.0n 0.4976 15599.9n 0.4976 15600.0n 0.4976 15899.9n 0.4976 15900.0n 0.4976 16199.9n 0.4976 16200.0n 0.4976 16499.9n 0.4976 16500.0n 0.4976 16799.9n 0.4976 16800.0n 0.4976 17099.9n 0.4976 17100.0n 0.4976 17399.9n 0.4976 17400.0n 0.4976 17699.9n 0.4976 17700.0n 0.4976 17999.9n 0.4976 18000.0n 0.4976 18299.9n 0.4976 18300.0n 0.4976 18599.9n 0.4976 18600.0n 0.4976 18899.9n 0.4976 18900.0n 0.4976 19199.9n 0.4976 19200.0n 0.4976 19499.9n 0.4976 19500.0n 0.4976 19799.9n 0.4976 19800.0n 0.4976 20099.9n 0.4976 20100.0n 0.4976 20399.9n 0.4976 20400.0n 0.4976 20699.9n 0.4976 20700.0n 0.4976 20999.9n 0.4976 21000.0n 0.4976 21299.9n 0.4976 21300.0n 0.4976 21599.9n 0.4976 21600.0n 0.4976 21899.9n 0.4976 21900.0n 0.4976 22199.9n 0.4976 22200.0n 0.4976 22499.9n 0.4976 22500.0n 0.4976 22799.9n 0.4976 22800.0n 0.4976 23099.9n 0.4976 23100.0n 0.4976 23399.9n 0.4976 23400.0n 0.4976 23699.9n 0.4976 23700.0n 0.4976 23999.9n 0.4976 24000.0n 0.4976 24299.9n 0.4976 24300.0n 0.4976 24599.9n 0.4976 24600.0n 0.4976 24899.9n 0.4976 24900.0n 0.4976 25199.9n 0.4976 25200.0n 0.4976 25499.9n 0.4976 25500.0n 0.4976 25799.9n 0.4976 25800.0n 0.4976 26099.9n 0.4976 26100.0n 0.4976 26399.9n 0.4976 26400.0n 0.4976 26699.9n 0.4976 26700.0n 0.4976 26999.9n 0.4976 27000.0n 0.4976 27299.9n 0.4976 27300.0n 0.4976 27599.9n 0.4976 27600.0n 0.4976 27899.9n 0.4976 27900.0n 0.4976 28199.9n 0.4976 28200.0n 0.4976 28499.9n 0.4976 28500.0n 0.4976 28799.9n 0.4976 28800.0n 0.4976 29099.9n 0.4976 29100.0n 0.4976 29399.9n 0.4976 29400.0n 0.4976 29699.9n 0.4976 29700.0n 0.4976 29999.9n 0.4976 30000.0n 0.4976 30299.9n 0.4976 30300.0n 0.4976 30599.9n 0.4976 30600.0n 0.4976 30899.9n 0.4976 30900.0n 0.4976 31199.9n 0.4976 31200.0n 0.4976 31499.9n 0.4976 31500.0n 0.4976 31799.9n 0.4976 31800.0n 0.4976 32099.9n 0.4976 32100.0n 0.4976 32399.9n 0.4976 32400.0n 0.4976 32699.9n 0.4976 32700.0n 0.4976 32999.9n 0.4976 33000.0n 0.4976 33299.9n 0.4976 33300.0n 0.4976 33599.9n 0.4976 33600.0n 0.4976 33899.9n 0.4976 33900.0n 0.4976 34199.9n 0.4976 34200.0n 0.4976 34499.9n 0.4976 34500.0n 0.4976 34799.9n 0.4976 34800.0n 0.4976 35099.9n 0.4976 35100.0n 0.4976 35399.9n 0.4976 35400.0n 0.4976 35699.9n 0.4976 35700.0n 0.4976 35999.9n 0.4976 36000.0n 0.4976 36299.9n 0.4976 36300.0n 0.4976 36599.9n 0.4976 36600.0n 0.4976 36899.9n 0.4976 36900.0n 0.4976 37199.9n 0.4976 37200.0n 0.4976 37499.9n 0.4976 37500.0n 0.4976 37799.9n 0.4976 37800.0n 0.4976 38099.9n 0.4976 38100.0n 0.4976 38399.9n 0.4976 38400.0n 0.4976 38699.9n 0.4976 38700.0n 0.4976 38999.9n 0.4976 39000.0n 0.4976 39299.9n 0.4976 39300.0n 0.4976 39599.9n 0.4976 39600.0n 0.4976 39899.9n 0.4976 39900.0n 0.4976 40199.9n 0.4976 40200.0n 0.4976 40499.9n 0.4976 40500.0n 0.4976 40799.9n 0.4976 40800.0n 0.4976 41099.9n 0.4976 41100.0n 0.4976 41399.9n 0.4976 41400.0n 0.4976 41699.9n 0.4976 41700.0n 0.4976 41999.9n 0.4976 42000.0n 0.4976 42299.9n 0.4976 42300.0n 0.4976 42599.9n 0.4976 42600.0n 0.4976 42899.9n 0.4976 42900.0n 0.4976 43199.9n 0.4976 43200.0n 0.4976 43499.9n 0.4976 43500.0n 0.4976 43799.9n 0.4976 43800.0n 0.4976 44099.9n 0.4976 44100.0n 0.4976 44399.9n 0.4976 44400.0n 0.4976 44699.9n 0.4976 44700.0n 0.4976 44999.9n 0.4976 45000.0n 0.4976 45299.9n 0.4976 45300.0n 0.4976 45599.9n 0.4976 45600.0n 0.4976 45899.9n 0.4976 45900.0n 0.4976 46199.9n 0.4976 46200.0n 0.4976 46499.9n 0.4976 46500.0n 0.4976 46799.9n 0.4976 46800.0n 0.4976 47099.9n 0.4976 47100.0n 0.4976 47399.9n 0.4976 47400.0n 0.4976 47699.9n 0.4976 47700.0n 0.4976 47999.9n 0.4976 48000.0n 0.4976 48299.9n 0.4976 48300.0n 0.4976 48599.9n 0.4976 48600.0n 0.4976 48899.9n 0.4976 48900.0n 0.4976 49199.9n 0.4976 49200.0n 0.4976 49499.9n 0.4976 49500.0n 0.4976 49799.9n 0.4976 49800.0n 0.4976 50099.9n 0.4976 50100.0n 0.4976 50399.9n 0.4976 50400.0n 0.4976 50699.9n 0.4976 50700.0n 0.4976 50999.9n 0.4976 51000.0n 0.4976 51299.9n 0.4976 51300.0n 0.4976 51599.9n 0.4976 51600.0n 0.4976 51899.9n 0.4976 51900.0n 0.4976 52199.9n 0.4976 52200.0n 0.4976 52499.9n 0.4976 52500.0n 0.4976 52799.9n 0.4976 52800.0n 0.4976 53099.9n 0.4976 53100.0n 0.4976 53399.9n 0.4976 53400.0n 0.4976 53699.9n 0.4976 53700.0n 0.4976 53999.9n 0.4976 54000.0n 0.4976 54299.9n 0.4976 54300.0n 0.4976 54599.9n 0.4976 54600.0n 0.4976 54899.9n 0.4976 54900.0n 0.4976 55199.9n 0.4976 55200.0n 0.4976 55499.9n 0.4976 55500.0n 0.4976 55799.9n 0.4976 55800.0n 0.4976 56099.9n 0.4976 56100.0n 0.4976 56399.9n 0.4976 56400.0n 0.4976 56699.9n 0.4976 56700.0n 0.4976 56999.9n 0.4976 57000.0n 0.4976 57299.9n 0.4976 57300.0n 0.4976 57599.9n 0.4976 57600.0n 0.4976 57899.9n 0.4976 57900.0n 0.4976 58199.9n 0.4976 58200.0n 0.4976 58499.9n 0.4976 58500.0n 0.4976 58799.9n 0.4976 58800.0n 0.4976 59099.9n 0.4976 59100.0n 0.4976)
Vxn56 a_xn56 0 PWL(0.0n 0.5024 299.9n 0.5024 300.0n 0.5024 599.9n 0.5024 600.0n 0.5024 899.9n 0.5024 900.0n 0.5024 1199.9n 0.5024 1200.0n 0.5024 1499.9n 0.5024 1500.0n 0.5024 1799.9n 0.5024 1800.0n 0.5024 2099.9n 0.5024 2100.0n 0.5024 2399.9n 0.5024 2400.0n 0.5024 2699.9n 0.5024 2700.0n 0.5024 2999.9n 0.5024 3000.0n 0.5024 3299.9n 0.5024 3300.0n 0.5024 3599.9n 0.5024 3600.0n 0.5024 3899.9n 0.5024 3900.0n 0.5024 4199.9n 0.5024 4200.0n 0.5024 4499.9n 0.5024 4500.0n 0.5024 4799.9n 0.5024 4800.0n 0.5024 5099.9n 0.5024 5100.0n 0.5024 5399.9n 0.5024 5400.0n 0.5024 5699.9n 0.5024 5700.0n 0.5024 5999.9n 0.5024 6000.0n 0.5024 6299.9n 0.5024 6300.0n 0.5024 6599.9n 0.5024 6600.0n 0.5024 6899.9n 0.5024 6900.0n 0.5024 7199.9n 0.5024 7200.0n 0.5024 7499.9n 0.5024 7500.0n 0.5024 7799.9n 0.5024 7800.0n 0.5024 8099.9n 0.5024 8100.0n 0.5024 8399.9n 0.5024 8400.0n 0.5024 8699.9n 0.5024 8700.0n 0.5024 8999.9n 0.5024 9000.0n 0.5024 9299.9n 0.5024 9300.0n 0.5024 9599.9n 0.5024 9600.0n 0.5024 9899.9n 0.5024 9900.0n 0.5024 10199.9n 0.5024 10200.0n 0.5024 10499.9n 0.5024 10500.0n 0.5024 10799.9n 0.5024 10800.0n 0.5024 11099.9n 0.5024 11100.0n 0.5024 11399.9n 0.5024 11400.0n 0.5024 11699.9n 0.5024 11700.0n 0.5024 11999.9n 0.5024 12000.0n 0.5024 12299.9n 0.5024 12300.0n 0.5024 12599.9n 0.5024 12600.0n 0.5024 12899.9n 0.5024 12900.0n 0.5024 13199.9n 0.5024 13200.0n 0.5024 13499.9n 0.5024 13500.0n 0.5024 13799.9n 0.5024 13800.0n 0.5024 14099.9n 0.5024 14100.0n 0.5024 14399.9n 0.5024 14400.0n 0.5024 14699.9n 0.5024 14700.0n 0.5024 14999.9n 0.5024 15000.0n 0.5024 15299.9n 0.5024 15300.0n 0.5024 15599.9n 0.5024 15600.0n 0.5024 15899.9n 0.5024 15900.0n 0.5024 16199.9n 0.5024 16200.0n 0.5024 16499.9n 0.5024 16500.0n 0.5024 16799.9n 0.5024 16800.0n 0.5024 17099.9n 0.5024 17100.0n 0.5024 17399.9n 0.5024 17400.0n 0.5024 17699.9n 0.5024 17700.0n 0.5024 17999.9n 0.5024 18000.0n 0.5024 18299.9n 0.5024 18300.0n 0.5024 18599.9n 0.5024 18600.0n 0.5024 18899.9n 0.5024 18900.0n 0.5024 19199.9n 0.5024 19200.0n 0.5024 19499.9n 0.5024 19500.0n 0.5024 19799.9n 0.5024 19800.0n 0.5024 20099.9n 0.5024 20100.0n 0.5024 20399.9n 0.5024 20400.0n 0.5024 20699.9n 0.5024 20700.0n 0.5024 20999.9n 0.5024 21000.0n 0.5024 21299.9n 0.5024 21300.0n 0.5024 21599.9n 0.5024 21600.0n 0.5024 21899.9n 0.5024 21900.0n 0.5024 22199.9n 0.5024 22200.0n 0.5024 22499.9n 0.5024 22500.0n 0.5024 22799.9n 0.5024 22800.0n 0.5024 23099.9n 0.5024 23100.0n 0.5024 23399.9n 0.5024 23400.0n 0.5024 23699.9n 0.5024 23700.0n 0.5024 23999.9n 0.5024 24000.0n 0.5024 24299.9n 0.5024 24300.0n 0.5024 24599.9n 0.5024 24600.0n 0.5024 24899.9n 0.5024 24900.0n 0.5024 25199.9n 0.5024 25200.0n 0.5024 25499.9n 0.5024 25500.0n 0.5024 25799.9n 0.5024 25800.0n 0.5024 26099.9n 0.5024 26100.0n 0.5024 26399.9n 0.5024 26400.0n 0.5024 26699.9n 0.5024 26700.0n 0.5024 26999.9n 0.5024 27000.0n 0.5024 27299.9n 0.5024 27300.0n 0.5024 27599.9n 0.5024 27600.0n 0.5024 27899.9n 0.5024 27900.0n 0.5024 28199.9n 0.5024 28200.0n 0.5024 28499.9n 0.5024 28500.0n 0.5024 28799.9n 0.5024 28800.0n 0.5024 29099.9n 0.5024 29100.0n 0.5024 29399.9n 0.5024 29400.0n 0.5024 29699.9n 0.5024 29700.0n 0.5024 29999.9n 0.5024 30000.0n 0.5024 30299.9n 0.5024 30300.0n 0.5024 30599.9n 0.5024 30600.0n 0.5024 30899.9n 0.5024 30900.0n 0.5024 31199.9n 0.5024 31200.0n 0.5024 31499.9n 0.5024 31500.0n 0.5024 31799.9n 0.5024 31800.0n 0.5024 32099.9n 0.5024 32100.0n 0.5024 32399.9n 0.5024 32400.0n 0.5024 32699.9n 0.5024 32700.0n 0.5024 32999.9n 0.5024 33000.0n 0.5024 33299.9n 0.5024 33300.0n 0.5024 33599.9n 0.5024 33600.0n 0.5024 33899.9n 0.5024 33900.0n 0.5024 34199.9n 0.5024 34200.0n 0.5024 34499.9n 0.5024 34500.0n 0.5024 34799.9n 0.5024 34800.0n 0.5024 35099.9n 0.5024 35100.0n 0.5024 35399.9n 0.5024 35400.0n 0.5024 35699.9n 0.5024 35700.0n 0.5024 35999.9n 0.5024 36000.0n 0.5024 36299.9n 0.5024 36300.0n 0.5024 36599.9n 0.5024 36600.0n 0.5024 36899.9n 0.5024 36900.0n 0.5024 37199.9n 0.5024 37200.0n 0.5024 37499.9n 0.5024 37500.0n 0.5024 37799.9n 0.5024 37800.0n 0.5024 38099.9n 0.5024 38100.0n 0.5024 38399.9n 0.5024 38400.0n 0.5024 38699.9n 0.5024 38700.0n 0.5024 38999.9n 0.5024 39000.0n 0.5024 39299.9n 0.5024 39300.0n 0.5024 39599.9n 0.5024 39600.0n 0.5024 39899.9n 0.5024 39900.0n 0.5024 40199.9n 0.5024 40200.0n 0.5024 40499.9n 0.5024 40500.0n 0.5024 40799.9n 0.5024 40800.0n 0.5024 41099.9n 0.5024 41100.0n 0.5024 41399.9n 0.5024 41400.0n 0.5024 41699.9n 0.5024 41700.0n 0.5024 41999.9n 0.5024 42000.0n 0.5024 42299.9n 0.5024 42300.0n 0.5024 42599.9n 0.5024 42600.0n 0.5024 42899.9n 0.5024 42900.0n 0.5024 43199.9n 0.5024 43200.0n 0.5024 43499.9n 0.5024 43500.0n 0.5024 43799.9n 0.5024 43800.0n 0.5024 44099.9n 0.5024 44100.0n 0.5024 44399.9n 0.5024 44400.0n 0.5024 44699.9n 0.5024 44700.0n 0.5024 44999.9n 0.5024 45000.0n 0.5024 45299.9n 0.5024 45300.0n 0.5024 45599.9n 0.5024 45600.0n 0.5024 45899.9n 0.5024 45900.0n 0.5024 46199.9n 0.5024 46200.0n 0.5024 46499.9n 0.5024 46500.0n 0.5024 46799.9n 0.5024 46800.0n 0.5024 47099.9n 0.5024 47100.0n 0.5024 47399.9n 0.5024 47400.0n 0.5024 47699.9n 0.5024 47700.0n 0.5024 47999.9n 0.5024 48000.0n 0.5024 48299.9n 0.5024 48300.0n 0.5024 48599.9n 0.5024 48600.0n 0.5024 48899.9n 0.5024 48900.0n 0.5024 49199.9n 0.5024 49200.0n 0.5024 49499.9n 0.5024 49500.0n 0.5024 49799.9n 0.5024 49800.0n 0.5024 50099.9n 0.5024 50100.0n 0.5024 50399.9n 0.5024 50400.0n 0.5024 50699.9n 0.5024 50700.0n 0.5024 50999.9n 0.5024 51000.0n 0.5024 51299.9n 0.5024 51300.0n 0.5024 51599.9n 0.5024 51600.0n 0.5024 51899.9n 0.5024 51900.0n 0.5024 52199.9n 0.5024 52200.0n 0.5024 52499.9n 0.5024 52500.0n 0.5024 52799.9n 0.5024 52800.0n 0.5024 53099.9n 0.5024 53100.0n 0.5024 53399.9n 0.5024 53400.0n 0.5024 53699.9n 0.5024 53700.0n 0.5024 53999.9n 0.5024 54000.0n 0.5024 54299.9n 0.5024 54300.0n 0.5024 54599.9n 0.5024 54600.0n 0.5024 54899.9n 0.5024 54900.0n 0.5024 55199.9n 0.5024 55200.0n 0.5024 55499.9n 0.5024 55500.0n 0.5024 55799.9n 0.5024 55800.0n 0.5024 56099.9n 0.5024 56100.0n 0.5024 56399.9n 0.5024 56400.0n 0.5024 56699.9n 0.5024 56700.0n 0.5024 56999.9n 0.5024 57000.0n 0.5024 57299.9n 0.5024 57300.0n 0.5024 57599.9n 0.5024 57600.0n 0.5024 57899.9n 0.5024 57900.0n 0.5024 58199.9n 0.5024 58200.0n 0.5024 58499.9n 0.5024 58500.0n 0.5024 58799.9n 0.5024 58800.0n 0.5024 59099.9n 0.5024 59100.0n 0.5024)
Vxp57 a_xp57 0 PWL(0.0n 0.4701 299.9n 0.4701 300.0n 0.4701 599.9n 0.4701 600.0n 0.4701 899.9n 0.4701 900.0n 0.4701 1199.9n 0.4701 1200.0n 0.4701 1499.9n 0.4701 1500.0n 0.4701 1799.9n 0.4701 1800.0n 0.4701 2099.9n 0.4701 2100.0n 0.4701 2399.9n 0.4701 2400.0n 0.5772 2699.9n 0.5772 2700.0n 0.4701 2999.9n 0.4701 3000.0n 0.6842 3299.9n 0.6842 3300.0n 0.5772 3599.9n 0.5772 3600.0n 0.4701 3899.9n 0.4701 3900.0n 0.4701 4199.9n 0.4701 4200.0n 0.8000 4499.9n 0.8000 4500.0n 0.5772 4799.9n 0.5772 4800.0n 0.4701 5099.9n 0.4701 5100.0n 0.4701 5399.9n 0.4701 5400.0n 0.4701 5699.9n 0.4701 5700.0n 0.4701 5999.9n 0.4701 6000.0n 0.4701 6299.9n 0.4701 6300.0n 0.4701 6599.9n 0.4701 6600.0n 0.4701 6899.9n 0.4701 6900.0n 0.4701 7199.9n 0.4701 7200.0n 0.4701 7499.9n 0.4701 7500.0n 0.4701 7799.9n 0.4701 7800.0n 0.5772 8099.9n 0.5772 8100.0n 0.4701 8399.9n 0.4701 8400.0n 0.6842 8699.9n 0.6842 8700.0n 0.5772 8999.9n 0.5772 9000.0n 0.4701 9299.9n 0.4701 9300.0n 0.4701 9599.9n 0.4701 9600.0n 0.8000 9899.9n 0.8000 9900.0n 0.5772 10199.9n 0.5772 10200.0n 0.4701 10499.9n 0.4701 10500.0n 0.4701 10799.9n 0.4701 10800.0n 0.4701 11099.9n 0.4701 11100.0n 0.4701 11399.9n 0.4701 11400.0n 0.4701 11699.9n 0.4701 11700.0n 0.4701 11999.9n 0.4701 12000.0n 0.4701 12299.9n 0.4701 12300.0n 0.4701 12599.9n 0.4701 12600.0n 0.4701 12899.9n 0.4701 12900.0n 0.4701 13199.9n 0.4701 13200.0n 0.5772 13499.9n 0.5772 13500.0n 0.4701 13799.9n 0.4701 13800.0n 0.6842 14099.9n 0.6842 14100.0n 0.5772 14399.9n 0.5772 14400.0n 0.4701 14699.9n 0.4701 14700.0n 0.4701 14999.9n 0.4701 15000.0n 0.8000 15299.9n 0.8000 15300.0n 0.5772 15599.9n 0.5772 15600.0n 0.4701 15899.9n 0.4701 15900.0n 0.4701 16199.9n 0.4701 16200.0n 0.4701 16499.9n 0.4701 16500.0n 0.4701 16799.9n 0.4701 16800.0n 0.4701 17099.9n 0.4701 17100.0n 0.4701 17399.9n 0.4701 17400.0n 0.4701 17699.9n 0.4701 17700.0n 0.4701 17999.9n 0.4701 18000.0n 0.4701 18299.9n 0.4701 18300.0n 0.4701 18599.9n 0.4701 18600.0n 0.5772 18899.9n 0.5772 18900.0n 0.4701 19199.9n 0.4701 19200.0n 0.6842 19499.9n 0.6842 19500.0n 0.5772 19799.9n 0.5772 19800.0n 0.4701 20099.9n 0.4701 20100.0n 0.4701 20399.9n 0.4701 20400.0n 0.8000 20699.9n 0.8000 20700.0n 0.5772 20999.9n 0.5772 21000.0n 0.4701 21299.9n 0.4701 21300.0n 0.4701 21599.9n 0.4701 21600.0n 0.4701 21899.9n 0.4701 21900.0n 0.4701 22199.9n 0.4701 22200.0n 0.4701 22499.9n 0.4701 22500.0n 0.4701 22799.9n 0.4701 22800.0n 0.4701 23099.9n 0.4701 23100.0n 0.4701 23399.9n 0.4701 23400.0n 0.4701 23699.9n 0.4701 23700.0n 0.4701 23999.9n 0.4701 24000.0n 0.5772 24299.9n 0.5772 24300.0n 0.4701 24599.9n 0.4701 24600.0n 0.6842 24899.9n 0.6842 24900.0n 0.5772 25199.9n 0.5772 25200.0n 0.4701 25499.9n 0.4701 25500.0n 0.4701 25799.9n 0.4701 25800.0n 0.8000 26099.9n 0.8000 26100.0n 0.5772 26399.9n 0.5772 26400.0n 0.4701 26699.9n 0.4701 26700.0n 0.4701 26999.9n 0.4701 27000.0n 0.4701 27299.9n 0.4701 27300.0n 0.4701 27599.9n 0.4701 27600.0n 0.4701 27899.9n 0.4701 27900.0n 0.4701 28199.9n 0.4701 28200.0n 0.4701 28499.9n 0.4701 28500.0n 0.4701 28799.9n 0.4701 28800.0n 0.4701 29099.9n 0.4701 29100.0n 0.4701 29399.9n 0.4701 29400.0n 0.5772 29699.9n 0.5772 29700.0n 0.4701 29999.9n 0.4701 30000.0n 0.6842 30299.9n 0.6842 30300.0n 0.5772 30599.9n 0.5772 30600.0n 0.4701 30899.9n 0.4701 30900.0n 0.4701 31199.9n 0.4701 31200.0n 0.8000 31499.9n 0.8000 31500.0n 0.5772 31799.9n 0.5772 31800.0n 0.4701 32099.9n 0.4701 32100.0n 0.4701 32399.9n 0.4701 32400.0n 0.4701 32699.9n 0.4701 32700.0n 0.4701 32999.9n 0.4701 33000.0n 0.4701 33299.9n 0.4701 33300.0n 0.4701 33599.9n 0.4701 33600.0n 0.4701 33899.9n 0.4701 33900.0n 0.4701 34199.9n 0.4701 34200.0n 0.4701 34499.9n 0.4701 34500.0n 0.4701 34799.9n 0.4701 34800.0n 0.5772 35099.9n 0.5772 35100.0n 0.4701 35399.9n 0.4701 35400.0n 0.6842 35699.9n 0.6842 35700.0n 0.5772 35999.9n 0.5772 36000.0n 0.4701 36299.9n 0.4701 36300.0n 0.4701 36599.9n 0.4701 36600.0n 0.8000 36899.9n 0.8000 36900.0n 0.5772 37199.9n 0.5772 37200.0n 0.4701 37499.9n 0.4701 37500.0n 0.4701 37799.9n 0.4701 37800.0n 0.4701 38099.9n 0.4701 38100.0n 0.4701 38399.9n 0.4701 38400.0n 0.4701 38699.9n 0.4701 38700.0n 0.4701 38999.9n 0.4701 39000.0n 0.4701 39299.9n 0.4701 39300.0n 0.4701 39599.9n 0.4701 39600.0n 0.4701 39899.9n 0.4701 39900.0n 0.4701 40199.9n 0.4701 40200.0n 0.5772 40499.9n 0.5772 40500.0n 0.4701 40799.9n 0.4701 40800.0n 0.6842 41099.9n 0.6842 41100.0n 0.5772 41399.9n 0.5772 41400.0n 0.4701 41699.9n 0.4701 41700.0n 0.4701 41999.9n 0.4701 42000.0n 0.8000 42299.9n 0.8000 42300.0n 0.5772 42599.9n 0.5772 42600.0n 0.4701 42899.9n 0.4701 42900.0n 0.4701 43199.9n 0.4701 43200.0n 0.4701 43499.9n 0.4701 43500.0n 0.4701 43799.9n 0.4701 43800.0n 0.4701 44099.9n 0.4701 44100.0n 0.4701 44399.9n 0.4701 44400.0n 0.4701 44699.9n 0.4701 44700.0n 0.4701 44999.9n 0.4701 45000.0n 0.4701 45299.9n 0.4701 45300.0n 0.4701 45599.9n 0.4701 45600.0n 0.5772 45899.9n 0.5772 45900.0n 0.4701 46199.9n 0.4701 46200.0n 0.6842 46499.9n 0.6842 46500.0n 0.5772 46799.9n 0.5772 46800.0n 0.4701 47099.9n 0.4701 47100.0n 0.4701 47399.9n 0.4701 47400.0n 0.8000 47699.9n 0.8000 47700.0n 0.5772 47999.9n 0.5772 48000.0n 0.4701 48299.9n 0.4701 48300.0n 0.4701 48599.9n 0.4701 48600.0n 0.4701 48899.9n 0.4701 48900.0n 0.4701 49199.9n 0.4701 49200.0n 0.4701 49499.9n 0.4701 49500.0n 0.4701 49799.9n 0.4701 49800.0n 0.4701 50099.9n 0.4701 50100.0n 0.4701 50399.9n 0.4701 50400.0n 0.4701 50699.9n 0.4701 50700.0n 0.4701 50999.9n 0.4701 51000.0n 0.5772 51299.9n 0.5772 51300.0n 0.4701 51599.9n 0.4701 51600.0n 0.6842 51899.9n 0.6842 51900.0n 0.5772 52199.9n 0.5772 52200.0n 0.4701 52499.9n 0.4701 52500.0n 0.4701 52799.9n 0.4701 52800.0n 0.8000 53099.9n 0.8000 53100.0n 0.5772 53399.9n 0.5772 53400.0n 0.4701 53699.9n 0.4701 53700.0n 0.4701 53999.9n 0.4701 54000.0n 0.4701 54299.9n 0.4701 54300.0n 0.4701 54599.9n 0.4701 54600.0n 0.4701 54899.9n 0.4701 54900.0n 0.4701 55199.9n 0.4701 55200.0n 0.4701 55499.9n 0.4701 55500.0n 0.4701 55799.9n 0.4701 55800.0n 0.4701 56099.9n 0.4701 56100.0n 0.4701 56399.9n 0.4701 56400.0n 0.4701 56699.9n 0.4701 56700.0n 0.4701 56999.9n 0.4701 57000.0n 0.4701 57299.9n 0.4701 57300.0n 0.4701 57599.9n 0.4701 57600.0n 0.4701 57899.9n 0.4701 57900.0n 0.6842 58199.9n 0.6842 58200.0n 0.4701 58499.9n 0.4701 58500.0n 0.6842 58799.9n 0.6842 58800.0n 0.6842 59099.9n 0.6842 59100.0n 0.5772)
Vxn57 a_xn57 0 PWL(0.0n 0.5299 299.9n 0.5299 300.0n 0.5299 599.9n 0.5299 600.0n 0.5299 899.9n 0.5299 900.0n 0.5299 1199.9n 0.5299 1200.0n 0.5299 1499.9n 0.5299 1500.0n 0.5299 1799.9n 0.5299 1800.0n 0.5299 2099.9n 0.5299 2100.0n 0.5299 2399.9n 0.5299 2400.0n 0.4228 2699.9n 0.4228 2700.0n 0.5299 2999.9n 0.5299 3000.0n 0.3158 3299.9n 0.3158 3300.0n 0.4228 3599.9n 0.4228 3600.0n 0.5299 3899.9n 0.5299 3900.0n 0.5299 4199.9n 0.5299 4200.0n 0.2000 4499.9n 0.2000 4500.0n 0.4228 4799.9n 0.4228 4800.0n 0.5299 5099.9n 0.5299 5100.0n 0.5299 5399.9n 0.5299 5400.0n 0.5299 5699.9n 0.5299 5700.0n 0.5299 5999.9n 0.5299 6000.0n 0.5299 6299.9n 0.5299 6300.0n 0.5299 6599.9n 0.5299 6600.0n 0.5299 6899.9n 0.5299 6900.0n 0.5299 7199.9n 0.5299 7200.0n 0.5299 7499.9n 0.5299 7500.0n 0.5299 7799.9n 0.5299 7800.0n 0.4228 8099.9n 0.4228 8100.0n 0.5299 8399.9n 0.5299 8400.0n 0.3158 8699.9n 0.3158 8700.0n 0.4228 8999.9n 0.4228 9000.0n 0.5299 9299.9n 0.5299 9300.0n 0.5299 9599.9n 0.5299 9600.0n 0.2000 9899.9n 0.2000 9900.0n 0.4228 10199.9n 0.4228 10200.0n 0.5299 10499.9n 0.5299 10500.0n 0.5299 10799.9n 0.5299 10800.0n 0.5299 11099.9n 0.5299 11100.0n 0.5299 11399.9n 0.5299 11400.0n 0.5299 11699.9n 0.5299 11700.0n 0.5299 11999.9n 0.5299 12000.0n 0.5299 12299.9n 0.5299 12300.0n 0.5299 12599.9n 0.5299 12600.0n 0.5299 12899.9n 0.5299 12900.0n 0.5299 13199.9n 0.5299 13200.0n 0.4228 13499.9n 0.4228 13500.0n 0.5299 13799.9n 0.5299 13800.0n 0.3158 14099.9n 0.3158 14100.0n 0.4228 14399.9n 0.4228 14400.0n 0.5299 14699.9n 0.5299 14700.0n 0.5299 14999.9n 0.5299 15000.0n 0.2000 15299.9n 0.2000 15300.0n 0.4228 15599.9n 0.4228 15600.0n 0.5299 15899.9n 0.5299 15900.0n 0.5299 16199.9n 0.5299 16200.0n 0.5299 16499.9n 0.5299 16500.0n 0.5299 16799.9n 0.5299 16800.0n 0.5299 17099.9n 0.5299 17100.0n 0.5299 17399.9n 0.5299 17400.0n 0.5299 17699.9n 0.5299 17700.0n 0.5299 17999.9n 0.5299 18000.0n 0.5299 18299.9n 0.5299 18300.0n 0.5299 18599.9n 0.5299 18600.0n 0.4228 18899.9n 0.4228 18900.0n 0.5299 19199.9n 0.5299 19200.0n 0.3158 19499.9n 0.3158 19500.0n 0.4228 19799.9n 0.4228 19800.0n 0.5299 20099.9n 0.5299 20100.0n 0.5299 20399.9n 0.5299 20400.0n 0.2000 20699.9n 0.2000 20700.0n 0.4228 20999.9n 0.4228 21000.0n 0.5299 21299.9n 0.5299 21300.0n 0.5299 21599.9n 0.5299 21600.0n 0.5299 21899.9n 0.5299 21900.0n 0.5299 22199.9n 0.5299 22200.0n 0.5299 22499.9n 0.5299 22500.0n 0.5299 22799.9n 0.5299 22800.0n 0.5299 23099.9n 0.5299 23100.0n 0.5299 23399.9n 0.5299 23400.0n 0.5299 23699.9n 0.5299 23700.0n 0.5299 23999.9n 0.5299 24000.0n 0.4228 24299.9n 0.4228 24300.0n 0.5299 24599.9n 0.5299 24600.0n 0.3158 24899.9n 0.3158 24900.0n 0.4228 25199.9n 0.4228 25200.0n 0.5299 25499.9n 0.5299 25500.0n 0.5299 25799.9n 0.5299 25800.0n 0.2000 26099.9n 0.2000 26100.0n 0.4228 26399.9n 0.4228 26400.0n 0.5299 26699.9n 0.5299 26700.0n 0.5299 26999.9n 0.5299 27000.0n 0.5299 27299.9n 0.5299 27300.0n 0.5299 27599.9n 0.5299 27600.0n 0.5299 27899.9n 0.5299 27900.0n 0.5299 28199.9n 0.5299 28200.0n 0.5299 28499.9n 0.5299 28500.0n 0.5299 28799.9n 0.5299 28800.0n 0.5299 29099.9n 0.5299 29100.0n 0.5299 29399.9n 0.5299 29400.0n 0.4228 29699.9n 0.4228 29700.0n 0.5299 29999.9n 0.5299 30000.0n 0.3158 30299.9n 0.3158 30300.0n 0.4228 30599.9n 0.4228 30600.0n 0.5299 30899.9n 0.5299 30900.0n 0.5299 31199.9n 0.5299 31200.0n 0.2000 31499.9n 0.2000 31500.0n 0.4228 31799.9n 0.4228 31800.0n 0.5299 32099.9n 0.5299 32100.0n 0.5299 32399.9n 0.5299 32400.0n 0.5299 32699.9n 0.5299 32700.0n 0.5299 32999.9n 0.5299 33000.0n 0.5299 33299.9n 0.5299 33300.0n 0.5299 33599.9n 0.5299 33600.0n 0.5299 33899.9n 0.5299 33900.0n 0.5299 34199.9n 0.5299 34200.0n 0.5299 34499.9n 0.5299 34500.0n 0.5299 34799.9n 0.5299 34800.0n 0.4228 35099.9n 0.4228 35100.0n 0.5299 35399.9n 0.5299 35400.0n 0.3158 35699.9n 0.3158 35700.0n 0.4228 35999.9n 0.4228 36000.0n 0.5299 36299.9n 0.5299 36300.0n 0.5299 36599.9n 0.5299 36600.0n 0.2000 36899.9n 0.2000 36900.0n 0.4228 37199.9n 0.4228 37200.0n 0.5299 37499.9n 0.5299 37500.0n 0.5299 37799.9n 0.5299 37800.0n 0.5299 38099.9n 0.5299 38100.0n 0.5299 38399.9n 0.5299 38400.0n 0.5299 38699.9n 0.5299 38700.0n 0.5299 38999.9n 0.5299 39000.0n 0.5299 39299.9n 0.5299 39300.0n 0.5299 39599.9n 0.5299 39600.0n 0.5299 39899.9n 0.5299 39900.0n 0.5299 40199.9n 0.5299 40200.0n 0.4228 40499.9n 0.4228 40500.0n 0.5299 40799.9n 0.5299 40800.0n 0.3158 41099.9n 0.3158 41100.0n 0.4228 41399.9n 0.4228 41400.0n 0.5299 41699.9n 0.5299 41700.0n 0.5299 41999.9n 0.5299 42000.0n 0.2000 42299.9n 0.2000 42300.0n 0.4228 42599.9n 0.4228 42600.0n 0.5299 42899.9n 0.5299 42900.0n 0.5299 43199.9n 0.5299 43200.0n 0.5299 43499.9n 0.5299 43500.0n 0.5299 43799.9n 0.5299 43800.0n 0.5299 44099.9n 0.5299 44100.0n 0.5299 44399.9n 0.5299 44400.0n 0.5299 44699.9n 0.5299 44700.0n 0.5299 44999.9n 0.5299 45000.0n 0.5299 45299.9n 0.5299 45300.0n 0.5299 45599.9n 0.5299 45600.0n 0.4228 45899.9n 0.4228 45900.0n 0.5299 46199.9n 0.5299 46200.0n 0.3158 46499.9n 0.3158 46500.0n 0.4228 46799.9n 0.4228 46800.0n 0.5299 47099.9n 0.5299 47100.0n 0.5299 47399.9n 0.5299 47400.0n 0.2000 47699.9n 0.2000 47700.0n 0.4228 47999.9n 0.4228 48000.0n 0.5299 48299.9n 0.5299 48300.0n 0.5299 48599.9n 0.5299 48600.0n 0.5299 48899.9n 0.5299 48900.0n 0.5299 49199.9n 0.5299 49200.0n 0.5299 49499.9n 0.5299 49500.0n 0.5299 49799.9n 0.5299 49800.0n 0.5299 50099.9n 0.5299 50100.0n 0.5299 50399.9n 0.5299 50400.0n 0.5299 50699.9n 0.5299 50700.0n 0.5299 50999.9n 0.5299 51000.0n 0.4228 51299.9n 0.4228 51300.0n 0.5299 51599.9n 0.5299 51600.0n 0.3158 51899.9n 0.3158 51900.0n 0.4228 52199.9n 0.4228 52200.0n 0.5299 52499.9n 0.5299 52500.0n 0.5299 52799.9n 0.5299 52800.0n 0.2000 53099.9n 0.2000 53100.0n 0.4228 53399.9n 0.4228 53400.0n 0.5299 53699.9n 0.5299 53700.0n 0.5299 53999.9n 0.5299 54000.0n 0.5299 54299.9n 0.5299 54300.0n 0.5299 54599.9n 0.5299 54600.0n 0.5299 54899.9n 0.5299 54900.0n 0.5299 55199.9n 0.5299 55200.0n 0.5299 55499.9n 0.5299 55500.0n 0.5299 55799.9n 0.5299 55800.0n 0.5299 56099.9n 0.5299 56100.0n 0.5299 56399.9n 0.5299 56400.0n 0.5299 56699.9n 0.5299 56700.0n 0.5299 56999.9n 0.5299 57000.0n 0.5299 57299.9n 0.5299 57300.0n 0.5299 57599.9n 0.5299 57600.0n 0.5299 57899.9n 0.5299 57900.0n 0.3158 58199.9n 0.3158 58200.0n 0.5299 58499.9n 0.5299 58500.0n 0.3158 58799.9n 0.3158 58800.0n 0.3158 59099.9n 0.3158 59100.0n 0.4228)
Vxp58 a_xp58 0 PWL(0.0n 0.3911 299.9n 0.3911 300.0n 0.4499 599.9n 0.4499 600.0n 0.5283 899.9n 0.5283 900.0n 0.4499 1199.9n 0.4499 1200.0n 0.3911 1499.9n 0.3911 1500.0n 0.4695 1799.9n 0.4695 1800.0n 0.4695 2099.9n 0.4695 2100.0n 0.3911 2399.9n 0.3911 2400.0n 0.7047 2699.9n 0.7047 2700.0n 0.5087 2999.9n 0.5087 3000.0n 0.6459 3299.9n 0.6459 3300.0n 0.6459 3599.9n 0.6459 3600.0n 0.3911 3899.9n 0.3911 3900.0n 0.3911 4199.9n 0.3911 4200.0n 0.7047 4499.9n 0.7047 4500.0n 0.6851 4799.9n 0.6851 4800.0n 0.4303 5099.9n 0.4303 5100.0n 0.3911 5399.9n 0.3911 5400.0n 0.3911 5699.9n 0.3911 5700.0n 0.4499 5999.9n 0.4499 6000.0n 0.5283 6299.9n 0.5283 6300.0n 0.4499 6599.9n 0.4499 6600.0n 0.3911 6899.9n 0.3911 6900.0n 0.4695 7199.9n 0.4695 7200.0n 0.4695 7499.9n 0.4695 7500.0n 0.3911 7799.9n 0.3911 7800.0n 0.7047 8099.9n 0.7047 8100.0n 0.5087 8399.9n 0.5087 8400.0n 0.6459 8699.9n 0.6459 8700.0n 0.6459 8999.9n 0.6459 9000.0n 0.3911 9299.9n 0.3911 9300.0n 0.3911 9599.9n 0.3911 9600.0n 0.7047 9899.9n 0.7047 9900.0n 0.6851 10199.9n 0.6851 10200.0n 0.4303 10499.9n 0.4303 10500.0n 0.3911 10799.9n 0.3911 10800.0n 0.3911 11099.9n 0.3911 11100.0n 0.4499 11399.9n 0.4499 11400.0n 0.5283 11699.9n 0.5283 11700.0n 0.4499 11999.9n 0.4499 12000.0n 0.3911 12299.9n 0.3911 12300.0n 0.4695 12599.9n 0.4695 12600.0n 0.4695 12899.9n 0.4695 12900.0n 0.3911 13199.9n 0.3911 13200.0n 0.7047 13499.9n 0.7047 13500.0n 0.5087 13799.9n 0.5087 13800.0n 0.6459 14099.9n 0.6459 14100.0n 0.6459 14399.9n 0.6459 14400.0n 0.3911 14699.9n 0.3911 14700.0n 0.3911 14999.9n 0.3911 15000.0n 0.7047 15299.9n 0.7047 15300.0n 0.6851 15599.9n 0.6851 15600.0n 0.4303 15899.9n 0.4303 15900.0n 0.3911 16199.9n 0.3911 16200.0n 0.3911 16499.9n 0.3911 16500.0n 0.4499 16799.9n 0.4499 16800.0n 0.5283 17099.9n 0.5283 17100.0n 0.4499 17399.9n 0.4499 17400.0n 0.3911 17699.9n 0.3911 17700.0n 0.4695 17999.9n 0.4695 18000.0n 0.4695 18299.9n 0.4695 18300.0n 0.3911 18599.9n 0.3911 18600.0n 0.7047 18899.9n 0.7047 18900.0n 0.5087 19199.9n 0.5087 19200.0n 0.6459 19499.9n 0.6459 19500.0n 0.6459 19799.9n 0.6459 19800.0n 0.3911 20099.9n 0.3911 20100.0n 0.3911 20399.9n 0.3911 20400.0n 0.7047 20699.9n 0.7047 20700.0n 0.6851 20999.9n 0.6851 21000.0n 0.4303 21299.9n 0.4303 21300.0n 0.3911 21599.9n 0.3911 21600.0n 0.3911 21899.9n 0.3911 21900.0n 0.4499 22199.9n 0.4499 22200.0n 0.5283 22499.9n 0.5283 22500.0n 0.4499 22799.9n 0.4499 22800.0n 0.3911 23099.9n 0.3911 23100.0n 0.4695 23399.9n 0.4695 23400.0n 0.4695 23699.9n 0.4695 23700.0n 0.3911 23999.9n 0.3911 24000.0n 0.7047 24299.9n 0.7047 24300.0n 0.5087 24599.9n 0.5087 24600.0n 0.6459 24899.9n 0.6459 24900.0n 0.6459 25199.9n 0.6459 25200.0n 0.3911 25499.9n 0.3911 25500.0n 0.3911 25799.9n 0.3911 25800.0n 0.7047 26099.9n 0.7047 26100.0n 0.6851 26399.9n 0.6851 26400.0n 0.4303 26699.9n 0.4303 26700.0n 0.3911 26999.9n 0.3911 27000.0n 0.3911 27299.9n 0.3911 27300.0n 0.4499 27599.9n 0.4499 27600.0n 0.5283 27899.9n 0.5283 27900.0n 0.4499 28199.9n 0.4499 28200.0n 0.3911 28499.9n 0.3911 28500.0n 0.4695 28799.9n 0.4695 28800.0n 0.4695 29099.9n 0.4695 29100.0n 0.3911 29399.9n 0.3911 29400.0n 0.7047 29699.9n 0.7047 29700.0n 0.5087 29999.9n 0.5087 30000.0n 0.6459 30299.9n 0.6459 30300.0n 0.6459 30599.9n 0.6459 30600.0n 0.3911 30899.9n 0.3911 30900.0n 0.3911 31199.9n 0.3911 31200.0n 0.7047 31499.9n 0.7047 31500.0n 0.6851 31799.9n 0.6851 31800.0n 0.4303 32099.9n 0.4303 32100.0n 0.3911 32399.9n 0.3911 32400.0n 0.3911 32699.9n 0.3911 32700.0n 0.4499 32999.9n 0.4499 33000.0n 0.5283 33299.9n 0.5283 33300.0n 0.4499 33599.9n 0.4499 33600.0n 0.3911 33899.9n 0.3911 33900.0n 0.4695 34199.9n 0.4695 34200.0n 0.4695 34499.9n 0.4695 34500.0n 0.3911 34799.9n 0.3911 34800.0n 0.7047 35099.9n 0.7047 35100.0n 0.5087 35399.9n 0.5087 35400.0n 0.6459 35699.9n 0.6459 35700.0n 0.6459 35999.9n 0.6459 36000.0n 0.3911 36299.9n 0.3911 36300.0n 0.3911 36599.9n 0.3911 36600.0n 0.7047 36899.9n 0.7047 36900.0n 0.6851 37199.9n 0.6851 37200.0n 0.4303 37499.9n 0.4303 37500.0n 0.3911 37799.9n 0.3911 37800.0n 0.3911 38099.9n 0.3911 38100.0n 0.4499 38399.9n 0.4499 38400.0n 0.5283 38699.9n 0.5283 38700.0n 0.4499 38999.9n 0.4499 39000.0n 0.3911 39299.9n 0.3911 39300.0n 0.4695 39599.9n 0.4695 39600.0n 0.4695 39899.9n 0.4695 39900.0n 0.3911 40199.9n 0.3911 40200.0n 0.7047 40499.9n 0.7047 40500.0n 0.5087 40799.9n 0.5087 40800.0n 0.6459 41099.9n 0.6459 41100.0n 0.6459 41399.9n 0.6459 41400.0n 0.3911 41699.9n 0.3911 41700.0n 0.3911 41999.9n 0.3911 42000.0n 0.7047 42299.9n 0.7047 42300.0n 0.6851 42599.9n 0.6851 42600.0n 0.4303 42899.9n 0.4303 42900.0n 0.3911 43199.9n 0.3911 43200.0n 0.3911 43499.9n 0.3911 43500.0n 0.4499 43799.9n 0.4499 43800.0n 0.5283 44099.9n 0.5283 44100.0n 0.4499 44399.9n 0.4499 44400.0n 0.3911 44699.9n 0.3911 44700.0n 0.4695 44999.9n 0.4695 45000.0n 0.4695 45299.9n 0.4695 45300.0n 0.3911 45599.9n 0.3911 45600.0n 0.7047 45899.9n 0.7047 45900.0n 0.5087 46199.9n 0.5087 46200.0n 0.6459 46499.9n 0.6459 46500.0n 0.6459 46799.9n 0.6459 46800.0n 0.3911 47099.9n 0.3911 47100.0n 0.3911 47399.9n 0.3911 47400.0n 0.7047 47699.9n 0.7047 47700.0n 0.6851 47999.9n 0.6851 48000.0n 0.4303 48299.9n 0.4303 48300.0n 0.3911 48599.9n 0.3911 48600.0n 0.3911 48899.9n 0.3911 48900.0n 0.4499 49199.9n 0.4499 49200.0n 0.5283 49499.9n 0.5283 49500.0n 0.4499 49799.9n 0.4499 49800.0n 0.3911 50099.9n 0.3911 50100.0n 0.4695 50399.9n 0.4695 50400.0n 0.4695 50699.9n 0.4695 50700.0n 0.3911 50999.9n 0.3911 51000.0n 0.7047 51299.9n 0.7047 51300.0n 0.5087 51599.9n 0.5087 51600.0n 0.6459 51899.9n 0.6459 51900.0n 0.6459 52199.9n 0.6459 52200.0n 0.3911 52499.9n 0.3911 52500.0n 0.3911 52799.9n 0.3911 52800.0n 0.7047 53099.9n 0.7047 53100.0n 0.6851 53399.9n 0.6851 53400.0n 0.4303 53699.9n 0.4303 53700.0n 0.3911 53999.9n 0.3911 54000.0n 0.4499 54299.9n 0.4499 54300.0n 0.4695 54599.9n 0.4695 54600.0n 0.4499 54899.9n 0.4499 54900.0n 0.4695 55199.9n 0.4695 55200.0n 0.4695 55499.9n 0.4695 55500.0n 0.4107 55799.9n 0.4107 55800.0n 0.3911 56099.9n 0.3911 56100.0n 0.4107 56399.9n 0.4107 56400.0n 0.3911 56699.9n 0.3911 56700.0n 0.4303 56999.9n 0.4303 57000.0n 0.3911 57299.9n 0.3911 57300.0n 0.4891 57599.9n 0.4891 57600.0n 0.7047 57899.9n 0.7047 57900.0n 0.6459 58199.9n 0.6459 58200.0n 0.5283 58499.9n 0.5283 58500.0n 0.6851 58799.9n 0.6851 58800.0n 0.7047 59099.9n 0.7047 59100.0n 0.6851)
Vxn58 a_xn58 0 PWL(0.0n 0.6089 299.9n 0.6089 300.0n 0.5501 599.9n 0.5501 600.0n 0.4717 899.9n 0.4717 900.0n 0.5501 1199.9n 0.5501 1200.0n 0.6089 1499.9n 0.6089 1500.0n 0.5305 1799.9n 0.5305 1800.0n 0.5305 2099.9n 0.5305 2100.0n 0.6089 2399.9n 0.6089 2400.0n 0.2953 2699.9n 0.2953 2700.0n 0.4913 2999.9n 0.4913 3000.0n 0.3541 3299.9n 0.3541 3300.0n 0.3541 3599.9n 0.3541 3600.0n 0.6089 3899.9n 0.6089 3900.0n 0.6089 4199.9n 0.6089 4200.0n 0.2953 4499.9n 0.2953 4500.0n 0.3149 4799.9n 0.3149 4800.0n 0.5697 5099.9n 0.5697 5100.0n 0.6089 5399.9n 0.6089 5400.0n 0.6089 5699.9n 0.6089 5700.0n 0.5501 5999.9n 0.5501 6000.0n 0.4717 6299.9n 0.4717 6300.0n 0.5501 6599.9n 0.5501 6600.0n 0.6089 6899.9n 0.6089 6900.0n 0.5305 7199.9n 0.5305 7200.0n 0.5305 7499.9n 0.5305 7500.0n 0.6089 7799.9n 0.6089 7800.0n 0.2953 8099.9n 0.2953 8100.0n 0.4913 8399.9n 0.4913 8400.0n 0.3541 8699.9n 0.3541 8700.0n 0.3541 8999.9n 0.3541 9000.0n 0.6089 9299.9n 0.6089 9300.0n 0.6089 9599.9n 0.6089 9600.0n 0.2953 9899.9n 0.2953 9900.0n 0.3149 10199.9n 0.3149 10200.0n 0.5697 10499.9n 0.5697 10500.0n 0.6089 10799.9n 0.6089 10800.0n 0.6089 11099.9n 0.6089 11100.0n 0.5501 11399.9n 0.5501 11400.0n 0.4717 11699.9n 0.4717 11700.0n 0.5501 11999.9n 0.5501 12000.0n 0.6089 12299.9n 0.6089 12300.0n 0.5305 12599.9n 0.5305 12600.0n 0.5305 12899.9n 0.5305 12900.0n 0.6089 13199.9n 0.6089 13200.0n 0.2953 13499.9n 0.2953 13500.0n 0.4913 13799.9n 0.4913 13800.0n 0.3541 14099.9n 0.3541 14100.0n 0.3541 14399.9n 0.3541 14400.0n 0.6089 14699.9n 0.6089 14700.0n 0.6089 14999.9n 0.6089 15000.0n 0.2953 15299.9n 0.2953 15300.0n 0.3149 15599.9n 0.3149 15600.0n 0.5697 15899.9n 0.5697 15900.0n 0.6089 16199.9n 0.6089 16200.0n 0.6089 16499.9n 0.6089 16500.0n 0.5501 16799.9n 0.5501 16800.0n 0.4717 17099.9n 0.4717 17100.0n 0.5501 17399.9n 0.5501 17400.0n 0.6089 17699.9n 0.6089 17700.0n 0.5305 17999.9n 0.5305 18000.0n 0.5305 18299.9n 0.5305 18300.0n 0.6089 18599.9n 0.6089 18600.0n 0.2953 18899.9n 0.2953 18900.0n 0.4913 19199.9n 0.4913 19200.0n 0.3541 19499.9n 0.3541 19500.0n 0.3541 19799.9n 0.3541 19800.0n 0.6089 20099.9n 0.6089 20100.0n 0.6089 20399.9n 0.6089 20400.0n 0.2953 20699.9n 0.2953 20700.0n 0.3149 20999.9n 0.3149 21000.0n 0.5697 21299.9n 0.5697 21300.0n 0.6089 21599.9n 0.6089 21600.0n 0.6089 21899.9n 0.6089 21900.0n 0.5501 22199.9n 0.5501 22200.0n 0.4717 22499.9n 0.4717 22500.0n 0.5501 22799.9n 0.5501 22800.0n 0.6089 23099.9n 0.6089 23100.0n 0.5305 23399.9n 0.5305 23400.0n 0.5305 23699.9n 0.5305 23700.0n 0.6089 23999.9n 0.6089 24000.0n 0.2953 24299.9n 0.2953 24300.0n 0.4913 24599.9n 0.4913 24600.0n 0.3541 24899.9n 0.3541 24900.0n 0.3541 25199.9n 0.3541 25200.0n 0.6089 25499.9n 0.6089 25500.0n 0.6089 25799.9n 0.6089 25800.0n 0.2953 26099.9n 0.2953 26100.0n 0.3149 26399.9n 0.3149 26400.0n 0.5697 26699.9n 0.5697 26700.0n 0.6089 26999.9n 0.6089 27000.0n 0.6089 27299.9n 0.6089 27300.0n 0.5501 27599.9n 0.5501 27600.0n 0.4717 27899.9n 0.4717 27900.0n 0.5501 28199.9n 0.5501 28200.0n 0.6089 28499.9n 0.6089 28500.0n 0.5305 28799.9n 0.5305 28800.0n 0.5305 29099.9n 0.5305 29100.0n 0.6089 29399.9n 0.6089 29400.0n 0.2953 29699.9n 0.2953 29700.0n 0.4913 29999.9n 0.4913 30000.0n 0.3541 30299.9n 0.3541 30300.0n 0.3541 30599.9n 0.3541 30600.0n 0.6089 30899.9n 0.6089 30900.0n 0.6089 31199.9n 0.6089 31200.0n 0.2953 31499.9n 0.2953 31500.0n 0.3149 31799.9n 0.3149 31800.0n 0.5697 32099.9n 0.5697 32100.0n 0.6089 32399.9n 0.6089 32400.0n 0.6089 32699.9n 0.6089 32700.0n 0.5501 32999.9n 0.5501 33000.0n 0.4717 33299.9n 0.4717 33300.0n 0.5501 33599.9n 0.5501 33600.0n 0.6089 33899.9n 0.6089 33900.0n 0.5305 34199.9n 0.5305 34200.0n 0.5305 34499.9n 0.5305 34500.0n 0.6089 34799.9n 0.6089 34800.0n 0.2953 35099.9n 0.2953 35100.0n 0.4913 35399.9n 0.4913 35400.0n 0.3541 35699.9n 0.3541 35700.0n 0.3541 35999.9n 0.3541 36000.0n 0.6089 36299.9n 0.6089 36300.0n 0.6089 36599.9n 0.6089 36600.0n 0.2953 36899.9n 0.2953 36900.0n 0.3149 37199.9n 0.3149 37200.0n 0.5697 37499.9n 0.5697 37500.0n 0.6089 37799.9n 0.6089 37800.0n 0.6089 38099.9n 0.6089 38100.0n 0.5501 38399.9n 0.5501 38400.0n 0.4717 38699.9n 0.4717 38700.0n 0.5501 38999.9n 0.5501 39000.0n 0.6089 39299.9n 0.6089 39300.0n 0.5305 39599.9n 0.5305 39600.0n 0.5305 39899.9n 0.5305 39900.0n 0.6089 40199.9n 0.6089 40200.0n 0.2953 40499.9n 0.2953 40500.0n 0.4913 40799.9n 0.4913 40800.0n 0.3541 41099.9n 0.3541 41100.0n 0.3541 41399.9n 0.3541 41400.0n 0.6089 41699.9n 0.6089 41700.0n 0.6089 41999.9n 0.6089 42000.0n 0.2953 42299.9n 0.2953 42300.0n 0.3149 42599.9n 0.3149 42600.0n 0.5697 42899.9n 0.5697 42900.0n 0.6089 43199.9n 0.6089 43200.0n 0.6089 43499.9n 0.6089 43500.0n 0.5501 43799.9n 0.5501 43800.0n 0.4717 44099.9n 0.4717 44100.0n 0.5501 44399.9n 0.5501 44400.0n 0.6089 44699.9n 0.6089 44700.0n 0.5305 44999.9n 0.5305 45000.0n 0.5305 45299.9n 0.5305 45300.0n 0.6089 45599.9n 0.6089 45600.0n 0.2953 45899.9n 0.2953 45900.0n 0.4913 46199.9n 0.4913 46200.0n 0.3541 46499.9n 0.3541 46500.0n 0.3541 46799.9n 0.3541 46800.0n 0.6089 47099.9n 0.6089 47100.0n 0.6089 47399.9n 0.6089 47400.0n 0.2953 47699.9n 0.2953 47700.0n 0.3149 47999.9n 0.3149 48000.0n 0.5697 48299.9n 0.5697 48300.0n 0.6089 48599.9n 0.6089 48600.0n 0.6089 48899.9n 0.6089 48900.0n 0.5501 49199.9n 0.5501 49200.0n 0.4717 49499.9n 0.4717 49500.0n 0.5501 49799.9n 0.5501 49800.0n 0.6089 50099.9n 0.6089 50100.0n 0.5305 50399.9n 0.5305 50400.0n 0.5305 50699.9n 0.5305 50700.0n 0.6089 50999.9n 0.6089 51000.0n 0.2953 51299.9n 0.2953 51300.0n 0.4913 51599.9n 0.4913 51600.0n 0.3541 51899.9n 0.3541 51900.0n 0.3541 52199.9n 0.3541 52200.0n 0.6089 52499.9n 0.6089 52500.0n 0.6089 52799.9n 0.6089 52800.0n 0.2953 53099.9n 0.2953 53100.0n 0.3149 53399.9n 0.3149 53400.0n 0.5697 53699.9n 0.5697 53700.0n 0.6089 53999.9n 0.6089 54000.0n 0.5501 54299.9n 0.5501 54300.0n 0.5305 54599.9n 0.5305 54600.0n 0.5501 54899.9n 0.5501 54900.0n 0.5305 55199.9n 0.5305 55200.0n 0.5305 55499.9n 0.5305 55500.0n 0.5893 55799.9n 0.5893 55800.0n 0.6089 56099.9n 0.6089 56100.0n 0.5893 56399.9n 0.5893 56400.0n 0.6089 56699.9n 0.6089 56700.0n 0.5697 56999.9n 0.5697 57000.0n 0.6089 57299.9n 0.6089 57300.0n 0.5109 57599.9n 0.5109 57600.0n 0.2953 57899.9n 0.2953 57900.0n 0.3541 58199.9n 0.3541 58200.0n 0.4717 58499.9n 0.4717 58500.0n 0.3149 58799.9n 0.3149 58800.0n 0.2953 59099.9n 0.2953 59100.0n 0.3149)
Vxp59 a_xp59 0 PWL(0.0n 0.2236 299.9n 0.2236 300.0n 0.5208 599.9n 0.5208 600.0n 0.5894 899.9n 0.5894 900.0n 0.5437 1199.9n 0.5437 1200.0n 0.2464 1499.9n 0.2464 1500.0n 0.4980 1799.9n 0.4980 1800.0n 0.5666 2099.9n 0.5666 2100.0n 0.2236 2399.9n 0.2236 2400.0n 0.5894 2699.9n 0.5894 2700.0n 0.5666 2999.9n 0.5666 3000.0n 0.5437 3299.9n 0.5437 3300.0n 0.5437 3599.9n 0.5437 3600.0n 0.3379 3899.9n 0.3379 3900.0n 0.4522 4199.9n 0.4522 4200.0n 0.5894 4499.9n 0.5894 4500.0n 0.5894 4799.9n 0.5894 4800.0n 0.4751 5099.9n 0.4751 5100.0n 0.2236 5399.9n 0.2236 5400.0n 0.2236 5699.9n 0.2236 5700.0n 0.5208 5999.9n 0.5208 6000.0n 0.5894 6299.9n 0.5894 6300.0n 0.5437 6599.9n 0.5437 6600.0n 0.2464 6899.9n 0.2464 6900.0n 0.4980 7199.9n 0.4980 7200.0n 0.5666 7499.9n 0.5666 7500.0n 0.2236 7799.9n 0.2236 7800.0n 0.5894 8099.9n 0.5894 8100.0n 0.5666 8399.9n 0.5666 8400.0n 0.5437 8699.9n 0.5437 8700.0n 0.5437 8999.9n 0.5437 9000.0n 0.3379 9299.9n 0.3379 9300.0n 0.4522 9599.9n 0.4522 9600.0n 0.5894 9899.9n 0.5894 9900.0n 0.5894 10199.9n 0.5894 10200.0n 0.4751 10499.9n 0.4751 10500.0n 0.2236 10799.9n 0.2236 10800.0n 0.2236 11099.9n 0.2236 11100.0n 0.5208 11399.9n 0.5208 11400.0n 0.5894 11699.9n 0.5894 11700.0n 0.5437 11999.9n 0.5437 12000.0n 0.2464 12299.9n 0.2464 12300.0n 0.4980 12599.9n 0.4980 12600.0n 0.5666 12899.9n 0.5666 12900.0n 0.2236 13199.9n 0.2236 13200.0n 0.5894 13499.9n 0.5894 13500.0n 0.5666 13799.9n 0.5666 13800.0n 0.5437 14099.9n 0.5437 14100.0n 0.5437 14399.9n 0.5437 14400.0n 0.3379 14699.9n 0.3379 14700.0n 0.4522 14999.9n 0.4522 15000.0n 0.5894 15299.9n 0.5894 15300.0n 0.5894 15599.9n 0.5894 15600.0n 0.4751 15899.9n 0.4751 15900.0n 0.2236 16199.9n 0.2236 16200.0n 0.2236 16499.9n 0.2236 16500.0n 0.5208 16799.9n 0.5208 16800.0n 0.5894 17099.9n 0.5894 17100.0n 0.5437 17399.9n 0.5437 17400.0n 0.2464 17699.9n 0.2464 17700.0n 0.4980 17999.9n 0.4980 18000.0n 0.5666 18299.9n 0.5666 18300.0n 0.2236 18599.9n 0.2236 18600.0n 0.5894 18899.9n 0.5894 18900.0n 0.5666 19199.9n 0.5666 19200.0n 0.5437 19499.9n 0.5437 19500.0n 0.5437 19799.9n 0.5437 19800.0n 0.3379 20099.9n 0.3379 20100.0n 0.4522 20399.9n 0.4522 20400.0n 0.5894 20699.9n 0.5894 20700.0n 0.5894 20999.9n 0.5894 21000.0n 0.4751 21299.9n 0.4751 21300.0n 0.2236 21599.9n 0.2236 21600.0n 0.2236 21899.9n 0.2236 21900.0n 0.5208 22199.9n 0.5208 22200.0n 0.5894 22499.9n 0.5894 22500.0n 0.5437 22799.9n 0.5437 22800.0n 0.2464 23099.9n 0.2464 23100.0n 0.4980 23399.9n 0.4980 23400.0n 0.5666 23699.9n 0.5666 23700.0n 0.2236 23999.9n 0.2236 24000.0n 0.5894 24299.9n 0.5894 24300.0n 0.5666 24599.9n 0.5666 24600.0n 0.5437 24899.9n 0.5437 24900.0n 0.5437 25199.9n 0.5437 25200.0n 0.3379 25499.9n 0.3379 25500.0n 0.4522 25799.9n 0.4522 25800.0n 0.5894 26099.9n 0.5894 26100.0n 0.5894 26399.9n 0.5894 26400.0n 0.4751 26699.9n 0.4751 26700.0n 0.2236 26999.9n 0.2236 27000.0n 0.2236 27299.9n 0.2236 27300.0n 0.5208 27599.9n 0.5208 27600.0n 0.5894 27899.9n 0.5894 27900.0n 0.5437 28199.9n 0.5437 28200.0n 0.2464 28499.9n 0.2464 28500.0n 0.4980 28799.9n 0.4980 28800.0n 0.5666 29099.9n 0.5666 29100.0n 0.2236 29399.9n 0.2236 29400.0n 0.5894 29699.9n 0.5894 29700.0n 0.5666 29999.9n 0.5666 30000.0n 0.5437 30299.9n 0.5437 30300.0n 0.5437 30599.9n 0.5437 30600.0n 0.3379 30899.9n 0.3379 30900.0n 0.4522 31199.9n 0.4522 31200.0n 0.5894 31499.9n 0.5894 31500.0n 0.5894 31799.9n 0.5894 31800.0n 0.4751 32099.9n 0.4751 32100.0n 0.2236 32399.9n 0.2236 32400.0n 0.2236 32699.9n 0.2236 32700.0n 0.5208 32999.9n 0.5208 33000.0n 0.5894 33299.9n 0.5894 33300.0n 0.5437 33599.9n 0.5437 33600.0n 0.2464 33899.9n 0.2464 33900.0n 0.4980 34199.9n 0.4980 34200.0n 0.5666 34499.9n 0.5666 34500.0n 0.2236 34799.9n 0.2236 34800.0n 0.5894 35099.9n 0.5894 35100.0n 0.5666 35399.9n 0.5666 35400.0n 0.5437 35699.9n 0.5437 35700.0n 0.5437 35999.9n 0.5437 36000.0n 0.3379 36299.9n 0.3379 36300.0n 0.4522 36599.9n 0.4522 36600.0n 0.5894 36899.9n 0.5894 36900.0n 0.5894 37199.9n 0.5894 37200.0n 0.4751 37499.9n 0.4751 37500.0n 0.2236 37799.9n 0.2236 37800.0n 0.2236 38099.9n 0.2236 38100.0n 0.5208 38399.9n 0.5208 38400.0n 0.5894 38699.9n 0.5894 38700.0n 0.5437 38999.9n 0.5437 39000.0n 0.2464 39299.9n 0.2464 39300.0n 0.4980 39599.9n 0.4980 39600.0n 0.5666 39899.9n 0.5666 39900.0n 0.2236 40199.9n 0.2236 40200.0n 0.5894 40499.9n 0.5894 40500.0n 0.5666 40799.9n 0.5666 40800.0n 0.5437 41099.9n 0.5437 41100.0n 0.5437 41399.9n 0.5437 41400.0n 0.3379 41699.9n 0.3379 41700.0n 0.4522 41999.9n 0.4522 42000.0n 0.5894 42299.9n 0.5894 42300.0n 0.5894 42599.9n 0.5894 42600.0n 0.4751 42899.9n 0.4751 42900.0n 0.2236 43199.9n 0.2236 43200.0n 0.2236 43499.9n 0.2236 43500.0n 0.5208 43799.9n 0.5208 43800.0n 0.5894 44099.9n 0.5894 44100.0n 0.5437 44399.9n 0.5437 44400.0n 0.2464 44699.9n 0.2464 44700.0n 0.4980 44999.9n 0.4980 45000.0n 0.5666 45299.9n 0.5666 45300.0n 0.2236 45599.9n 0.2236 45600.0n 0.5894 45899.9n 0.5894 45900.0n 0.5666 46199.9n 0.5666 46200.0n 0.5437 46499.9n 0.5437 46500.0n 0.5437 46799.9n 0.5437 46800.0n 0.3379 47099.9n 0.3379 47100.0n 0.4522 47399.9n 0.4522 47400.0n 0.5894 47699.9n 0.5894 47700.0n 0.5894 47999.9n 0.5894 48000.0n 0.4751 48299.9n 0.4751 48300.0n 0.2236 48599.9n 0.2236 48600.0n 0.2236 48899.9n 0.2236 48900.0n 0.5208 49199.9n 0.5208 49200.0n 0.5894 49499.9n 0.5894 49500.0n 0.5437 49799.9n 0.5437 49800.0n 0.2464 50099.9n 0.2464 50100.0n 0.4980 50399.9n 0.4980 50400.0n 0.5666 50699.9n 0.5666 50700.0n 0.2236 50999.9n 0.2236 51000.0n 0.5894 51299.9n 0.5894 51300.0n 0.5666 51599.9n 0.5666 51600.0n 0.5437 51899.9n 0.5437 51900.0n 0.5437 52199.9n 0.5437 52200.0n 0.3379 52499.9n 0.3379 52500.0n 0.4522 52799.9n 0.4522 52800.0n 0.5894 53099.9n 0.5894 53100.0n 0.5894 53399.9n 0.5894 53400.0n 0.4751 53699.9n 0.4751 53700.0n 0.2236 53999.9n 0.2236 54000.0n 0.5666 54299.9n 0.5666 54300.0n 0.4980 54599.9n 0.4980 54600.0n 0.5437 54899.9n 0.5437 54900.0n 0.5437 55199.9n 0.5437 55200.0n 0.5666 55499.9n 0.5666 55500.0n 0.5437 55799.9n 0.5437 55800.0n 0.4980 56099.9n 0.4980 56100.0n 0.3836 56399.9n 0.3836 56400.0n 0.2236 56699.9n 0.2236 56700.0n 0.4522 56999.9n 0.4522 57000.0n 0.2693 57299.9n 0.2693 57300.0n 0.5666 57599.9n 0.5666 57600.0n 0.5666 57899.9n 0.5666 57900.0n 0.4980 58199.9n 0.4980 58200.0n 0.5437 58499.9n 0.5437 58500.0n 0.5894 58799.9n 0.5894 58800.0n 0.5894 59099.9n 0.5894 59100.0n 0.5894)
Vxn59 a_xn59 0 PWL(0.0n 0.7764 299.9n 0.7764 300.0n 0.4792 599.9n 0.4792 600.0n 0.4106 899.9n 0.4106 900.0n 0.4563 1199.9n 0.4563 1200.0n 0.7536 1499.9n 0.7536 1500.0n 0.5020 1799.9n 0.5020 1800.0n 0.4334 2099.9n 0.4334 2100.0n 0.7764 2399.9n 0.7764 2400.0n 0.4106 2699.9n 0.4106 2700.0n 0.4334 2999.9n 0.4334 3000.0n 0.4563 3299.9n 0.4563 3300.0n 0.4563 3599.9n 0.4563 3600.0n 0.6621 3899.9n 0.6621 3900.0n 0.5478 4199.9n 0.5478 4200.0n 0.4106 4499.9n 0.4106 4500.0n 0.4106 4799.9n 0.4106 4800.0n 0.5249 5099.9n 0.5249 5100.0n 0.7764 5399.9n 0.7764 5400.0n 0.7764 5699.9n 0.7764 5700.0n 0.4792 5999.9n 0.4792 6000.0n 0.4106 6299.9n 0.4106 6300.0n 0.4563 6599.9n 0.4563 6600.0n 0.7536 6899.9n 0.7536 6900.0n 0.5020 7199.9n 0.5020 7200.0n 0.4334 7499.9n 0.4334 7500.0n 0.7764 7799.9n 0.7764 7800.0n 0.4106 8099.9n 0.4106 8100.0n 0.4334 8399.9n 0.4334 8400.0n 0.4563 8699.9n 0.4563 8700.0n 0.4563 8999.9n 0.4563 9000.0n 0.6621 9299.9n 0.6621 9300.0n 0.5478 9599.9n 0.5478 9600.0n 0.4106 9899.9n 0.4106 9900.0n 0.4106 10199.9n 0.4106 10200.0n 0.5249 10499.9n 0.5249 10500.0n 0.7764 10799.9n 0.7764 10800.0n 0.7764 11099.9n 0.7764 11100.0n 0.4792 11399.9n 0.4792 11400.0n 0.4106 11699.9n 0.4106 11700.0n 0.4563 11999.9n 0.4563 12000.0n 0.7536 12299.9n 0.7536 12300.0n 0.5020 12599.9n 0.5020 12600.0n 0.4334 12899.9n 0.4334 12900.0n 0.7764 13199.9n 0.7764 13200.0n 0.4106 13499.9n 0.4106 13500.0n 0.4334 13799.9n 0.4334 13800.0n 0.4563 14099.9n 0.4563 14100.0n 0.4563 14399.9n 0.4563 14400.0n 0.6621 14699.9n 0.6621 14700.0n 0.5478 14999.9n 0.5478 15000.0n 0.4106 15299.9n 0.4106 15300.0n 0.4106 15599.9n 0.4106 15600.0n 0.5249 15899.9n 0.5249 15900.0n 0.7764 16199.9n 0.7764 16200.0n 0.7764 16499.9n 0.7764 16500.0n 0.4792 16799.9n 0.4792 16800.0n 0.4106 17099.9n 0.4106 17100.0n 0.4563 17399.9n 0.4563 17400.0n 0.7536 17699.9n 0.7536 17700.0n 0.5020 17999.9n 0.5020 18000.0n 0.4334 18299.9n 0.4334 18300.0n 0.7764 18599.9n 0.7764 18600.0n 0.4106 18899.9n 0.4106 18900.0n 0.4334 19199.9n 0.4334 19200.0n 0.4563 19499.9n 0.4563 19500.0n 0.4563 19799.9n 0.4563 19800.0n 0.6621 20099.9n 0.6621 20100.0n 0.5478 20399.9n 0.5478 20400.0n 0.4106 20699.9n 0.4106 20700.0n 0.4106 20999.9n 0.4106 21000.0n 0.5249 21299.9n 0.5249 21300.0n 0.7764 21599.9n 0.7764 21600.0n 0.7764 21899.9n 0.7764 21900.0n 0.4792 22199.9n 0.4792 22200.0n 0.4106 22499.9n 0.4106 22500.0n 0.4563 22799.9n 0.4563 22800.0n 0.7536 23099.9n 0.7536 23100.0n 0.5020 23399.9n 0.5020 23400.0n 0.4334 23699.9n 0.4334 23700.0n 0.7764 23999.9n 0.7764 24000.0n 0.4106 24299.9n 0.4106 24300.0n 0.4334 24599.9n 0.4334 24600.0n 0.4563 24899.9n 0.4563 24900.0n 0.4563 25199.9n 0.4563 25200.0n 0.6621 25499.9n 0.6621 25500.0n 0.5478 25799.9n 0.5478 25800.0n 0.4106 26099.9n 0.4106 26100.0n 0.4106 26399.9n 0.4106 26400.0n 0.5249 26699.9n 0.5249 26700.0n 0.7764 26999.9n 0.7764 27000.0n 0.7764 27299.9n 0.7764 27300.0n 0.4792 27599.9n 0.4792 27600.0n 0.4106 27899.9n 0.4106 27900.0n 0.4563 28199.9n 0.4563 28200.0n 0.7536 28499.9n 0.7536 28500.0n 0.5020 28799.9n 0.5020 28800.0n 0.4334 29099.9n 0.4334 29100.0n 0.7764 29399.9n 0.7764 29400.0n 0.4106 29699.9n 0.4106 29700.0n 0.4334 29999.9n 0.4334 30000.0n 0.4563 30299.9n 0.4563 30300.0n 0.4563 30599.9n 0.4563 30600.0n 0.6621 30899.9n 0.6621 30900.0n 0.5478 31199.9n 0.5478 31200.0n 0.4106 31499.9n 0.4106 31500.0n 0.4106 31799.9n 0.4106 31800.0n 0.5249 32099.9n 0.5249 32100.0n 0.7764 32399.9n 0.7764 32400.0n 0.7764 32699.9n 0.7764 32700.0n 0.4792 32999.9n 0.4792 33000.0n 0.4106 33299.9n 0.4106 33300.0n 0.4563 33599.9n 0.4563 33600.0n 0.7536 33899.9n 0.7536 33900.0n 0.5020 34199.9n 0.5020 34200.0n 0.4334 34499.9n 0.4334 34500.0n 0.7764 34799.9n 0.7764 34800.0n 0.4106 35099.9n 0.4106 35100.0n 0.4334 35399.9n 0.4334 35400.0n 0.4563 35699.9n 0.4563 35700.0n 0.4563 35999.9n 0.4563 36000.0n 0.6621 36299.9n 0.6621 36300.0n 0.5478 36599.9n 0.5478 36600.0n 0.4106 36899.9n 0.4106 36900.0n 0.4106 37199.9n 0.4106 37200.0n 0.5249 37499.9n 0.5249 37500.0n 0.7764 37799.9n 0.7764 37800.0n 0.7764 38099.9n 0.7764 38100.0n 0.4792 38399.9n 0.4792 38400.0n 0.4106 38699.9n 0.4106 38700.0n 0.4563 38999.9n 0.4563 39000.0n 0.7536 39299.9n 0.7536 39300.0n 0.5020 39599.9n 0.5020 39600.0n 0.4334 39899.9n 0.4334 39900.0n 0.7764 40199.9n 0.7764 40200.0n 0.4106 40499.9n 0.4106 40500.0n 0.4334 40799.9n 0.4334 40800.0n 0.4563 41099.9n 0.4563 41100.0n 0.4563 41399.9n 0.4563 41400.0n 0.6621 41699.9n 0.6621 41700.0n 0.5478 41999.9n 0.5478 42000.0n 0.4106 42299.9n 0.4106 42300.0n 0.4106 42599.9n 0.4106 42600.0n 0.5249 42899.9n 0.5249 42900.0n 0.7764 43199.9n 0.7764 43200.0n 0.7764 43499.9n 0.7764 43500.0n 0.4792 43799.9n 0.4792 43800.0n 0.4106 44099.9n 0.4106 44100.0n 0.4563 44399.9n 0.4563 44400.0n 0.7536 44699.9n 0.7536 44700.0n 0.5020 44999.9n 0.5020 45000.0n 0.4334 45299.9n 0.4334 45300.0n 0.7764 45599.9n 0.7764 45600.0n 0.4106 45899.9n 0.4106 45900.0n 0.4334 46199.9n 0.4334 46200.0n 0.4563 46499.9n 0.4563 46500.0n 0.4563 46799.9n 0.4563 46800.0n 0.6621 47099.9n 0.6621 47100.0n 0.5478 47399.9n 0.5478 47400.0n 0.4106 47699.9n 0.4106 47700.0n 0.4106 47999.9n 0.4106 48000.0n 0.5249 48299.9n 0.5249 48300.0n 0.7764 48599.9n 0.7764 48600.0n 0.7764 48899.9n 0.7764 48900.0n 0.4792 49199.9n 0.4792 49200.0n 0.4106 49499.9n 0.4106 49500.0n 0.4563 49799.9n 0.4563 49800.0n 0.7536 50099.9n 0.7536 50100.0n 0.5020 50399.9n 0.5020 50400.0n 0.4334 50699.9n 0.4334 50700.0n 0.7764 50999.9n 0.7764 51000.0n 0.4106 51299.9n 0.4106 51300.0n 0.4334 51599.9n 0.4334 51600.0n 0.4563 51899.9n 0.4563 51900.0n 0.4563 52199.9n 0.4563 52200.0n 0.6621 52499.9n 0.6621 52500.0n 0.5478 52799.9n 0.5478 52800.0n 0.4106 53099.9n 0.4106 53100.0n 0.4106 53399.9n 0.4106 53400.0n 0.5249 53699.9n 0.5249 53700.0n 0.7764 53999.9n 0.7764 54000.0n 0.4334 54299.9n 0.4334 54300.0n 0.5020 54599.9n 0.5020 54600.0n 0.4563 54899.9n 0.4563 54900.0n 0.4563 55199.9n 0.4563 55200.0n 0.4334 55499.9n 0.4334 55500.0n 0.4563 55799.9n 0.4563 55800.0n 0.5020 56099.9n 0.5020 56100.0n 0.6164 56399.9n 0.6164 56400.0n 0.7764 56699.9n 0.7764 56700.0n 0.5478 56999.9n 0.5478 57000.0n 0.7307 57299.9n 0.7307 57300.0n 0.4334 57599.9n 0.4334 57600.0n 0.4334 57899.9n 0.4334 57900.0n 0.5020 58199.9n 0.5020 58200.0n 0.4563 58499.9n 0.4563 58500.0n 0.4106 58799.9n 0.4106 58800.0n 0.4106 59099.9n 0.4106 59100.0n 0.4106)
Vxp60 a_xp60 0 PWL(0.0n 0.4228 299.9n 0.4228 300.0n 0.5444 599.9n 0.5444 600.0n 0.5241 899.9n 0.5241 900.0n 0.5444 1199.9n 0.5444 1200.0n 0.5039 1499.9n 0.5039 1500.0n 0.5039 1799.9n 0.5039 1800.0n 0.5850 2099.9n 0.5850 2100.0n 0.3822 2399.9n 0.3822 2400.0n 0.5850 2699.9n 0.5850 2700.0n 0.4025 2999.9n 0.4025 3000.0n 0.5039 3299.9n 0.5039 3300.0n 0.5039 3599.9n 0.5039 3600.0n 0.5850 3899.9n 0.5850 3900.0n 0.4633 4199.9n 0.4633 4200.0n 0.5850 4499.9n 0.5850 4500.0n 0.5850 4799.9n 0.5850 4800.0n 0.5850 5099.9n 0.5850 5100.0n 0.3417 5399.9n 0.3417 5400.0n 0.4228 5699.9n 0.4228 5700.0n 0.5444 5999.9n 0.5444 6000.0n 0.5241 6299.9n 0.5241 6300.0n 0.5444 6599.9n 0.5444 6600.0n 0.5039 6899.9n 0.5039 6900.0n 0.5039 7199.9n 0.5039 7200.0n 0.5850 7499.9n 0.5850 7500.0n 0.3822 7799.9n 0.3822 7800.0n 0.5850 8099.9n 0.5850 8100.0n 0.4025 8399.9n 0.4025 8400.0n 0.5039 8699.9n 0.5039 8700.0n 0.5039 8999.9n 0.5039 9000.0n 0.5850 9299.9n 0.5850 9300.0n 0.4633 9599.9n 0.4633 9600.0n 0.5850 9899.9n 0.5850 9900.0n 0.5850 10199.9n 0.5850 10200.0n 0.5850 10499.9n 0.5850 10500.0n 0.3417 10799.9n 0.3417 10800.0n 0.4228 11099.9n 0.4228 11100.0n 0.5444 11399.9n 0.5444 11400.0n 0.5241 11699.9n 0.5241 11700.0n 0.5444 11999.9n 0.5444 12000.0n 0.5039 12299.9n 0.5039 12300.0n 0.5039 12599.9n 0.5039 12600.0n 0.5850 12899.9n 0.5850 12900.0n 0.3822 13199.9n 0.3822 13200.0n 0.5850 13499.9n 0.5850 13500.0n 0.4025 13799.9n 0.4025 13800.0n 0.5039 14099.9n 0.5039 14100.0n 0.5039 14399.9n 0.5039 14400.0n 0.5850 14699.9n 0.5850 14700.0n 0.4633 14999.9n 0.4633 15000.0n 0.5850 15299.9n 0.5850 15300.0n 0.5850 15599.9n 0.5850 15600.0n 0.5850 15899.9n 0.5850 15900.0n 0.3417 16199.9n 0.3417 16200.0n 0.4228 16499.9n 0.4228 16500.0n 0.5444 16799.9n 0.5444 16800.0n 0.5241 17099.9n 0.5241 17100.0n 0.5444 17399.9n 0.5444 17400.0n 0.5039 17699.9n 0.5039 17700.0n 0.5039 17999.9n 0.5039 18000.0n 0.5850 18299.9n 0.5850 18300.0n 0.3822 18599.9n 0.3822 18600.0n 0.5850 18899.9n 0.5850 18900.0n 0.4025 19199.9n 0.4025 19200.0n 0.5039 19499.9n 0.5039 19500.0n 0.5039 19799.9n 0.5039 19800.0n 0.5850 20099.9n 0.5850 20100.0n 0.4633 20399.9n 0.4633 20400.0n 0.5850 20699.9n 0.5850 20700.0n 0.5850 20999.9n 0.5850 21000.0n 0.5850 21299.9n 0.5850 21300.0n 0.3417 21599.9n 0.3417 21600.0n 0.4228 21899.9n 0.4228 21900.0n 0.5444 22199.9n 0.5444 22200.0n 0.5241 22499.9n 0.5241 22500.0n 0.5444 22799.9n 0.5444 22800.0n 0.5039 23099.9n 0.5039 23100.0n 0.5039 23399.9n 0.5039 23400.0n 0.5850 23699.9n 0.5850 23700.0n 0.3822 23999.9n 0.3822 24000.0n 0.5850 24299.9n 0.5850 24300.0n 0.4025 24599.9n 0.4025 24600.0n 0.5039 24899.9n 0.5039 24900.0n 0.5039 25199.9n 0.5039 25200.0n 0.5850 25499.9n 0.5850 25500.0n 0.4633 25799.9n 0.4633 25800.0n 0.5850 26099.9n 0.5850 26100.0n 0.5850 26399.9n 0.5850 26400.0n 0.5850 26699.9n 0.5850 26700.0n 0.3417 26999.9n 0.3417 27000.0n 0.4228 27299.9n 0.4228 27300.0n 0.5444 27599.9n 0.5444 27600.0n 0.5241 27899.9n 0.5241 27900.0n 0.5444 28199.9n 0.5444 28200.0n 0.5039 28499.9n 0.5039 28500.0n 0.5039 28799.9n 0.5039 28800.0n 0.5850 29099.9n 0.5850 29100.0n 0.3822 29399.9n 0.3822 29400.0n 0.5850 29699.9n 0.5850 29700.0n 0.4025 29999.9n 0.4025 30000.0n 0.5039 30299.9n 0.5039 30300.0n 0.5039 30599.9n 0.5039 30600.0n 0.5850 30899.9n 0.5850 30900.0n 0.4633 31199.9n 0.4633 31200.0n 0.5850 31499.9n 0.5850 31500.0n 0.5850 31799.9n 0.5850 31800.0n 0.5850 32099.9n 0.5850 32100.0n 0.3417 32399.9n 0.3417 32400.0n 0.4228 32699.9n 0.4228 32700.0n 0.5444 32999.9n 0.5444 33000.0n 0.5241 33299.9n 0.5241 33300.0n 0.5444 33599.9n 0.5444 33600.0n 0.5039 33899.9n 0.5039 33900.0n 0.5039 34199.9n 0.5039 34200.0n 0.5850 34499.9n 0.5850 34500.0n 0.3822 34799.9n 0.3822 34800.0n 0.5850 35099.9n 0.5850 35100.0n 0.4025 35399.9n 0.4025 35400.0n 0.5039 35699.9n 0.5039 35700.0n 0.5039 35999.9n 0.5039 36000.0n 0.5850 36299.9n 0.5850 36300.0n 0.4633 36599.9n 0.4633 36600.0n 0.5850 36899.9n 0.5850 36900.0n 0.5850 37199.9n 0.5850 37200.0n 0.5850 37499.9n 0.5850 37500.0n 0.3417 37799.9n 0.3417 37800.0n 0.4228 38099.9n 0.4228 38100.0n 0.5444 38399.9n 0.5444 38400.0n 0.5241 38699.9n 0.5241 38700.0n 0.5444 38999.9n 0.5444 39000.0n 0.5039 39299.9n 0.5039 39300.0n 0.5039 39599.9n 0.5039 39600.0n 0.5850 39899.9n 0.5850 39900.0n 0.3822 40199.9n 0.3822 40200.0n 0.5850 40499.9n 0.5850 40500.0n 0.4025 40799.9n 0.4025 40800.0n 0.5039 41099.9n 0.5039 41100.0n 0.5039 41399.9n 0.5039 41400.0n 0.5850 41699.9n 0.5850 41700.0n 0.4633 41999.9n 0.4633 42000.0n 0.5850 42299.9n 0.5850 42300.0n 0.5850 42599.9n 0.5850 42600.0n 0.5850 42899.9n 0.5850 42900.0n 0.3417 43199.9n 0.3417 43200.0n 0.4228 43499.9n 0.4228 43500.0n 0.5444 43799.9n 0.5444 43800.0n 0.5241 44099.9n 0.5241 44100.0n 0.5444 44399.9n 0.5444 44400.0n 0.5039 44699.9n 0.5039 44700.0n 0.5039 44999.9n 0.5039 45000.0n 0.5850 45299.9n 0.5850 45300.0n 0.3822 45599.9n 0.3822 45600.0n 0.5850 45899.9n 0.5850 45900.0n 0.4025 46199.9n 0.4025 46200.0n 0.5039 46499.9n 0.5039 46500.0n 0.5039 46799.9n 0.5039 46800.0n 0.5850 47099.9n 0.5850 47100.0n 0.4633 47399.9n 0.4633 47400.0n 0.5850 47699.9n 0.5850 47700.0n 0.5850 47999.9n 0.5850 48000.0n 0.5850 48299.9n 0.5850 48300.0n 0.3417 48599.9n 0.3417 48600.0n 0.4228 48899.9n 0.4228 48900.0n 0.5444 49199.9n 0.5444 49200.0n 0.5241 49499.9n 0.5241 49500.0n 0.5444 49799.9n 0.5444 49800.0n 0.5039 50099.9n 0.5039 50100.0n 0.5039 50399.9n 0.5039 50400.0n 0.5850 50699.9n 0.5850 50700.0n 0.3822 50999.9n 0.3822 51000.0n 0.5850 51299.9n 0.5850 51300.0n 0.4025 51599.9n 0.4025 51600.0n 0.5039 51899.9n 0.5039 51900.0n 0.5039 52199.9n 0.5039 52200.0n 0.5850 52499.9n 0.5850 52500.0n 0.4633 52799.9n 0.4633 52800.0n 0.5850 53099.9n 0.5850 53100.0n 0.5850 53399.9n 0.5850 53400.0n 0.5850 53699.9n 0.5850 53700.0n 0.3417 53999.9n 0.3417 54000.0n 0.5850 54299.9n 0.5850 54300.0n 0.5647 54599.9n 0.5647 54600.0n 0.5850 54899.9n 0.5850 54900.0n 0.5444 55199.9n 0.5444 55200.0n 0.5647 55499.9n 0.5647 55500.0n 0.5241 55799.9n 0.5241 55800.0n 0.5850 56099.9n 0.5850 56100.0n 0.5039 56399.9n 0.5039 56400.0n 0.4836 56699.9n 0.4836 56700.0n 0.5241 56999.9n 0.5241 57000.0n 0.5241 57299.9n 0.5241 57300.0n 0.5241 57599.9n 0.5241 57600.0n 0.5039 57899.9n 0.5039 57900.0n 0.4430 58199.9n 0.4430 58200.0n 0.5444 58499.9n 0.5444 58500.0n 0.5850 58799.9n 0.5850 58800.0n 0.5647 59099.9n 0.5647 59100.0n 0.5850)
Vxn60 a_xn60 0 PWL(0.0n 0.5772 299.9n 0.5772 300.0n 0.4556 599.9n 0.4556 600.0n 0.4759 899.9n 0.4759 900.0n 0.4556 1199.9n 0.4556 1200.0n 0.4961 1499.9n 0.4961 1500.0n 0.4961 1799.9n 0.4961 1800.0n 0.4150 2099.9n 0.4150 2100.0n 0.6178 2399.9n 0.6178 2400.0n 0.4150 2699.9n 0.4150 2700.0n 0.5975 2999.9n 0.5975 3000.0n 0.4961 3299.9n 0.4961 3300.0n 0.4961 3599.9n 0.4961 3600.0n 0.4150 3899.9n 0.4150 3900.0n 0.5367 4199.9n 0.5367 4200.0n 0.4150 4499.9n 0.4150 4500.0n 0.4150 4799.9n 0.4150 4800.0n 0.4150 5099.9n 0.4150 5100.0n 0.6583 5399.9n 0.6583 5400.0n 0.5772 5699.9n 0.5772 5700.0n 0.4556 5999.9n 0.4556 6000.0n 0.4759 6299.9n 0.4759 6300.0n 0.4556 6599.9n 0.4556 6600.0n 0.4961 6899.9n 0.4961 6900.0n 0.4961 7199.9n 0.4961 7200.0n 0.4150 7499.9n 0.4150 7500.0n 0.6178 7799.9n 0.6178 7800.0n 0.4150 8099.9n 0.4150 8100.0n 0.5975 8399.9n 0.5975 8400.0n 0.4961 8699.9n 0.4961 8700.0n 0.4961 8999.9n 0.4961 9000.0n 0.4150 9299.9n 0.4150 9300.0n 0.5367 9599.9n 0.5367 9600.0n 0.4150 9899.9n 0.4150 9900.0n 0.4150 10199.9n 0.4150 10200.0n 0.4150 10499.9n 0.4150 10500.0n 0.6583 10799.9n 0.6583 10800.0n 0.5772 11099.9n 0.5772 11100.0n 0.4556 11399.9n 0.4556 11400.0n 0.4759 11699.9n 0.4759 11700.0n 0.4556 11999.9n 0.4556 12000.0n 0.4961 12299.9n 0.4961 12300.0n 0.4961 12599.9n 0.4961 12600.0n 0.4150 12899.9n 0.4150 12900.0n 0.6178 13199.9n 0.6178 13200.0n 0.4150 13499.9n 0.4150 13500.0n 0.5975 13799.9n 0.5975 13800.0n 0.4961 14099.9n 0.4961 14100.0n 0.4961 14399.9n 0.4961 14400.0n 0.4150 14699.9n 0.4150 14700.0n 0.5367 14999.9n 0.5367 15000.0n 0.4150 15299.9n 0.4150 15300.0n 0.4150 15599.9n 0.4150 15600.0n 0.4150 15899.9n 0.4150 15900.0n 0.6583 16199.9n 0.6583 16200.0n 0.5772 16499.9n 0.5772 16500.0n 0.4556 16799.9n 0.4556 16800.0n 0.4759 17099.9n 0.4759 17100.0n 0.4556 17399.9n 0.4556 17400.0n 0.4961 17699.9n 0.4961 17700.0n 0.4961 17999.9n 0.4961 18000.0n 0.4150 18299.9n 0.4150 18300.0n 0.6178 18599.9n 0.6178 18600.0n 0.4150 18899.9n 0.4150 18900.0n 0.5975 19199.9n 0.5975 19200.0n 0.4961 19499.9n 0.4961 19500.0n 0.4961 19799.9n 0.4961 19800.0n 0.4150 20099.9n 0.4150 20100.0n 0.5367 20399.9n 0.5367 20400.0n 0.4150 20699.9n 0.4150 20700.0n 0.4150 20999.9n 0.4150 21000.0n 0.4150 21299.9n 0.4150 21300.0n 0.6583 21599.9n 0.6583 21600.0n 0.5772 21899.9n 0.5772 21900.0n 0.4556 22199.9n 0.4556 22200.0n 0.4759 22499.9n 0.4759 22500.0n 0.4556 22799.9n 0.4556 22800.0n 0.4961 23099.9n 0.4961 23100.0n 0.4961 23399.9n 0.4961 23400.0n 0.4150 23699.9n 0.4150 23700.0n 0.6178 23999.9n 0.6178 24000.0n 0.4150 24299.9n 0.4150 24300.0n 0.5975 24599.9n 0.5975 24600.0n 0.4961 24899.9n 0.4961 24900.0n 0.4961 25199.9n 0.4961 25200.0n 0.4150 25499.9n 0.4150 25500.0n 0.5367 25799.9n 0.5367 25800.0n 0.4150 26099.9n 0.4150 26100.0n 0.4150 26399.9n 0.4150 26400.0n 0.4150 26699.9n 0.4150 26700.0n 0.6583 26999.9n 0.6583 27000.0n 0.5772 27299.9n 0.5772 27300.0n 0.4556 27599.9n 0.4556 27600.0n 0.4759 27899.9n 0.4759 27900.0n 0.4556 28199.9n 0.4556 28200.0n 0.4961 28499.9n 0.4961 28500.0n 0.4961 28799.9n 0.4961 28800.0n 0.4150 29099.9n 0.4150 29100.0n 0.6178 29399.9n 0.6178 29400.0n 0.4150 29699.9n 0.4150 29700.0n 0.5975 29999.9n 0.5975 30000.0n 0.4961 30299.9n 0.4961 30300.0n 0.4961 30599.9n 0.4961 30600.0n 0.4150 30899.9n 0.4150 30900.0n 0.5367 31199.9n 0.5367 31200.0n 0.4150 31499.9n 0.4150 31500.0n 0.4150 31799.9n 0.4150 31800.0n 0.4150 32099.9n 0.4150 32100.0n 0.6583 32399.9n 0.6583 32400.0n 0.5772 32699.9n 0.5772 32700.0n 0.4556 32999.9n 0.4556 33000.0n 0.4759 33299.9n 0.4759 33300.0n 0.4556 33599.9n 0.4556 33600.0n 0.4961 33899.9n 0.4961 33900.0n 0.4961 34199.9n 0.4961 34200.0n 0.4150 34499.9n 0.4150 34500.0n 0.6178 34799.9n 0.6178 34800.0n 0.4150 35099.9n 0.4150 35100.0n 0.5975 35399.9n 0.5975 35400.0n 0.4961 35699.9n 0.4961 35700.0n 0.4961 35999.9n 0.4961 36000.0n 0.4150 36299.9n 0.4150 36300.0n 0.5367 36599.9n 0.5367 36600.0n 0.4150 36899.9n 0.4150 36900.0n 0.4150 37199.9n 0.4150 37200.0n 0.4150 37499.9n 0.4150 37500.0n 0.6583 37799.9n 0.6583 37800.0n 0.5772 38099.9n 0.5772 38100.0n 0.4556 38399.9n 0.4556 38400.0n 0.4759 38699.9n 0.4759 38700.0n 0.4556 38999.9n 0.4556 39000.0n 0.4961 39299.9n 0.4961 39300.0n 0.4961 39599.9n 0.4961 39600.0n 0.4150 39899.9n 0.4150 39900.0n 0.6178 40199.9n 0.6178 40200.0n 0.4150 40499.9n 0.4150 40500.0n 0.5975 40799.9n 0.5975 40800.0n 0.4961 41099.9n 0.4961 41100.0n 0.4961 41399.9n 0.4961 41400.0n 0.4150 41699.9n 0.4150 41700.0n 0.5367 41999.9n 0.5367 42000.0n 0.4150 42299.9n 0.4150 42300.0n 0.4150 42599.9n 0.4150 42600.0n 0.4150 42899.9n 0.4150 42900.0n 0.6583 43199.9n 0.6583 43200.0n 0.5772 43499.9n 0.5772 43500.0n 0.4556 43799.9n 0.4556 43800.0n 0.4759 44099.9n 0.4759 44100.0n 0.4556 44399.9n 0.4556 44400.0n 0.4961 44699.9n 0.4961 44700.0n 0.4961 44999.9n 0.4961 45000.0n 0.4150 45299.9n 0.4150 45300.0n 0.6178 45599.9n 0.6178 45600.0n 0.4150 45899.9n 0.4150 45900.0n 0.5975 46199.9n 0.5975 46200.0n 0.4961 46499.9n 0.4961 46500.0n 0.4961 46799.9n 0.4961 46800.0n 0.4150 47099.9n 0.4150 47100.0n 0.5367 47399.9n 0.5367 47400.0n 0.4150 47699.9n 0.4150 47700.0n 0.4150 47999.9n 0.4150 48000.0n 0.4150 48299.9n 0.4150 48300.0n 0.6583 48599.9n 0.6583 48600.0n 0.5772 48899.9n 0.5772 48900.0n 0.4556 49199.9n 0.4556 49200.0n 0.4759 49499.9n 0.4759 49500.0n 0.4556 49799.9n 0.4556 49800.0n 0.4961 50099.9n 0.4961 50100.0n 0.4961 50399.9n 0.4961 50400.0n 0.4150 50699.9n 0.4150 50700.0n 0.6178 50999.9n 0.6178 51000.0n 0.4150 51299.9n 0.4150 51300.0n 0.5975 51599.9n 0.5975 51600.0n 0.4961 51899.9n 0.4961 51900.0n 0.4961 52199.9n 0.4961 52200.0n 0.4150 52499.9n 0.4150 52500.0n 0.5367 52799.9n 0.5367 52800.0n 0.4150 53099.9n 0.4150 53100.0n 0.4150 53399.9n 0.4150 53400.0n 0.4150 53699.9n 0.4150 53700.0n 0.6583 53999.9n 0.6583 54000.0n 0.4150 54299.9n 0.4150 54300.0n 0.4353 54599.9n 0.4353 54600.0n 0.4150 54899.9n 0.4150 54900.0n 0.4556 55199.9n 0.4556 55200.0n 0.4353 55499.9n 0.4353 55500.0n 0.4759 55799.9n 0.4759 55800.0n 0.4150 56099.9n 0.4150 56100.0n 0.4961 56399.9n 0.4961 56400.0n 0.5164 56699.9n 0.5164 56700.0n 0.4759 56999.9n 0.4759 57000.0n 0.4759 57299.9n 0.4759 57300.0n 0.4759 57599.9n 0.4759 57600.0n 0.4961 57899.9n 0.4961 57900.0n 0.5570 58199.9n 0.5570 58200.0n 0.4556 58499.9n 0.4556 58500.0n 0.4150 58799.9n 0.4150 58800.0n 0.4353 59099.9n 0.4353 59100.0n 0.4150)
Vxp61 a_xp61 0 PWL(0.0n 0.6396 299.9n 0.6396 300.0n 0.4701 599.9n 0.4701 600.0n 0.4362 899.9n 0.4362 900.0n 0.4023 1199.9n 0.4023 1200.0n 0.6227 1499.9n 0.6227 1500.0n 0.4362 1799.9n 0.4362 1800.0n 0.5379 2099.9n 0.5379 2100.0n 0.6396 2399.9n 0.6396 2400.0n 0.6566 2699.9n 0.6566 2700.0n 0.4531 2999.9n 0.4531 3000.0n 0.5888 3299.9n 0.5888 3300.0n 0.5888 3599.9n 0.5888 3600.0n 0.4701 3899.9n 0.4701 3900.0n 0.3853 4199.9n 0.3853 4200.0n 0.5888 4499.9n 0.5888 4500.0n 0.6566 4799.9n 0.6566 4800.0n 0.5718 5099.9n 0.5718 5100.0n 0.6396 5399.9n 0.6396 5400.0n 0.6396 5699.9n 0.6396 5700.0n 0.4701 5999.9n 0.4701 6000.0n 0.4362 6299.9n 0.4362 6300.0n 0.4023 6599.9n 0.4023 6600.0n 0.6227 6899.9n 0.6227 6900.0n 0.4362 7199.9n 0.4362 7200.0n 0.5379 7499.9n 0.5379 7500.0n 0.6396 7799.9n 0.6396 7800.0n 0.6566 8099.9n 0.6566 8100.0n 0.4531 8399.9n 0.4531 8400.0n 0.5888 8699.9n 0.5888 8700.0n 0.5888 8999.9n 0.5888 9000.0n 0.4701 9299.9n 0.4701 9300.0n 0.3853 9599.9n 0.3853 9600.0n 0.5888 9899.9n 0.5888 9900.0n 0.6566 10199.9n 0.6566 10200.0n 0.5718 10499.9n 0.5718 10500.0n 0.6396 10799.9n 0.6396 10800.0n 0.6396 11099.9n 0.6396 11100.0n 0.4701 11399.9n 0.4701 11400.0n 0.4362 11699.9n 0.4362 11700.0n 0.4023 11999.9n 0.4023 12000.0n 0.6227 12299.9n 0.6227 12300.0n 0.4362 12599.9n 0.4362 12600.0n 0.5379 12899.9n 0.5379 12900.0n 0.6396 13199.9n 0.6396 13200.0n 0.6566 13499.9n 0.6566 13500.0n 0.4531 13799.9n 0.4531 13800.0n 0.5888 14099.9n 0.5888 14100.0n 0.5888 14399.9n 0.5888 14400.0n 0.4701 14699.9n 0.4701 14700.0n 0.3853 14999.9n 0.3853 15000.0n 0.5888 15299.9n 0.5888 15300.0n 0.6566 15599.9n 0.6566 15600.0n 0.5718 15899.9n 0.5718 15900.0n 0.6396 16199.9n 0.6396 16200.0n 0.6396 16499.9n 0.6396 16500.0n 0.4701 16799.9n 0.4701 16800.0n 0.4362 17099.9n 0.4362 17100.0n 0.4023 17399.9n 0.4023 17400.0n 0.6227 17699.9n 0.6227 17700.0n 0.4362 17999.9n 0.4362 18000.0n 0.5379 18299.9n 0.5379 18300.0n 0.6396 18599.9n 0.6396 18600.0n 0.6566 18899.9n 0.6566 18900.0n 0.4531 19199.9n 0.4531 19200.0n 0.5888 19499.9n 0.5888 19500.0n 0.5888 19799.9n 0.5888 19800.0n 0.4701 20099.9n 0.4701 20100.0n 0.3853 20399.9n 0.3853 20400.0n 0.5888 20699.9n 0.5888 20700.0n 0.6566 20999.9n 0.6566 21000.0n 0.5718 21299.9n 0.5718 21300.0n 0.6396 21599.9n 0.6396 21600.0n 0.6396 21899.9n 0.6396 21900.0n 0.4701 22199.9n 0.4701 22200.0n 0.4362 22499.9n 0.4362 22500.0n 0.4023 22799.9n 0.4023 22800.0n 0.6227 23099.9n 0.6227 23100.0n 0.4362 23399.9n 0.4362 23400.0n 0.5379 23699.9n 0.5379 23700.0n 0.6396 23999.9n 0.6396 24000.0n 0.6566 24299.9n 0.6566 24300.0n 0.4531 24599.9n 0.4531 24600.0n 0.5888 24899.9n 0.5888 24900.0n 0.5888 25199.9n 0.5888 25200.0n 0.4701 25499.9n 0.4701 25500.0n 0.3853 25799.9n 0.3853 25800.0n 0.5888 26099.9n 0.5888 26100.0n 0.6566 26399.9n 0.6566 26400.0n 0.5718 26699.9n 0.5718 26700.0n 0.6396 26999.9n 0.6396 27000.0n 0.6396 27299.9n 0.6396 27300.0n 0.4701 27599.9n 0.4701 27600.0n 0.4362 27899.9n 0.4362 27900.0n 0.4023 28199.9n 0.4023 28200.0n 0.6227 28499.9n 0.6227 28500.0n 0.4362 28799.9n 0.4362 28800.0n 0.5379 29099.9n 0.5379 29100.0n 0.6396 29399.9n 0.6396 29400.0n 0.6566 29699.9n 0.6566 29700.0n 0.4531 29999.9n 0.4531 30000.0n 0.5888 30299.9n 0.5888 30300.0n 0.5888 30599.9n 0.5888 30600.0n 0.4701 30899.9n 0.4701 30900.0n 0.3853 31199.9n 0.3853 31200.0n 0.5888 31499.9n 0.5888 31500.0n 0.6566 31799.9n 0.6566 31800.0n 0.5718 32099.9n 0.5718 32100.0n 0.6396 32399.9n 0.6396 32400.0n 0.6396 32699.9n 0.6396 32700.0n 0.4701 32999.9n 0.4701 33000.0n 0.4362 33299.9n 0.4362 33300.0n 0.4023 33599.9n 0.4023 33600.0n 0.6227 33899.9n 0.6227 33900.0n 0.4362 34199.9n 0.4362 34200.0n 0.5379 34499.9n 0.5379 34500.0n 0.6396 34799.9n 0.6396 34800.0n 0.6566 35099.9n 0.6566 35100.0n 0.4531 35399.9n 0.4531 35400.0n 0.5888 35699.9n 0.5888 35700.0n 0.5888 35999.9n 0.5888 36000.0n 0.4701 36299.9n 0.4701 36300.0n 0.3853 36599.9n 0.3853 36600.0n 0.5888 36899.9n 0.5888 36900.0n 0.6566 37199.9n 0.6566 37200.0n 0.5718 37499.9n 0.5718 37500.0n 0.6396 37799.9n 0.6396 37800.0n 0.6396 38099.9n 0.6396 38100.0n 0.4701 38399.9n 0.4701 38400.0n 0.4362 38699.9n 0.4362 38700.0n 0.4023 38999.9n 0.4023 39000.0n 0.6227 39299.9n 0.6227 39300.0n 0.4362 39599.9n 0.4362 39600.0n 0.5379 39899.9n 0.5379 39900.0n 0.6396 40199.9n 0.6396 40200.0n 0.6566 40499.9n 0.6566 40500.0n 0.4531 40799.9n 0.4531 40800.0n 0.5888 41099.9n 0.5888 41100.0n 0.5888 41399.9n 0.5888 41400.0n 0.4701 41699.9n 0.4701 41700.0n 0.3853 41999.9n 0.3853 42000.0n 0.5888 42299.9n 0.5888 42300.0n 0.6566 42599.9n 0.6566 42600.0n 0.5718 42899.9n 0.5718 42900.0n 0.6396 43199.9n 0.6396 43200.0n 0.6396 43499.9n 0.6396 43500.0n 0.4701 43799.9n 0.4701 43800.0n 0.4362 44099.9n 0.4362 44100.0n 0.4023 44399.9n 0.4023 44400.0n 0.6227 44699.9n 0.6227 44700.0n 0.4362 44999.9n 0.4362 45000.0n 0.5379 45299.9n 0.5379 45300.0n 0.6396 45599.9n 0.6396 45600.0n 0.6566 45899.9n 0.6566 45900.0n 0.4531 46199.9n 0.4531 46200.0n 0.5888 46499.9n 0.5888 46500.0n 0.5888 46799.9n 0.5888 46800.0n 0.4701 47099.9n 0.4701 47100.0n 0.3853 47399.9n 0.3853 47400.0n 0.5888 47699.9n 0.5888 47700.0n 0.6566 47999.9n 0.6566 48000.0n 0.5718 48299.9n 0.5718 48300.0n 0.6396 48599.9n 0.6396 48600.0n 0.6396 48899.9n 0.6396 48900.0n 0.4701 49199.9n 0.4701 49200.0n 0.4362 49499.9n 0.4362 49500.0n 0.4023 49799.9n 0.4023 49800.0n 0.6227 50099.9n 0.6227 50100.0n 0.4362 50399.9n 0.4362 50400.0n 0.5379 50699.9n 0.5379 50700.0n 0.6396 50999.9n 0.6396 51000.0n 0.6566 51299.9n 0.6566 51300.0n 0.4531 51599.9n 0.4531 51600.0n 0.5888 51899.9n 0.5888 51900.0n 0.5888 52199.9n 0.5888 52200.0n 0.4701 52499.9n 0.4701 52500.0n 0.3853 52799.9n 0.3853 52800.0n 0.5888 53099.9n 0.5888 53100.0n 0.6566 53399.9n 0.6566 53400.0n 0.5718 53699.9n 0.5718 53700.0n 0.6396 53999.9n 0.6396 54000.0n 0.4701 54299.9n 0.4701 54300.0n 0.4870 54599.9n 0.4870 54600.0n 0.6057 54899.9n 0.6057 54900.0n 0.4192 55199.9n 0.4192 55200.0n 0.4531 55499.9n 0.4531 55500.0n 0.4701 55799.9n 0.4701 55800.0n 0.4192 56099.9n 0.4192 56100.0n 0.5549 56399.9n 0.5549 56400.0n 0.5718 56699.9n 0.5718 56700.0n 0.6566 56999.9n 0.6566 57000.0n 0.6396 57299.9n 0.6396 57300.0n 0.4192 57599.9n 0.4192 57600.0n 0.5888 57899.9n 0.5888 57900.0n 0.3853 58199.9n 0.3853 58200.0n 0.6227 58499.9n 0.6227 58500.0n 0.6566 58799.9n 0.6566 58800.0n 0.5888 59099.9n 0.5888 59100.0n 0.6396)
Vxn61 a_xn61 0 PWL(0.0n 0.3604 299.9n 0.3604 300.0n 0.5299 599.9n 0.5299 600.0n 0.5638 899.9n 0.5638 900.0n 0.5977 1199.9n 0.5977 1200.0n 0.3773 1499.9n 0.3773 1500.0n 0.5638 1799.9n 0.5638 1800.0n 0.4621 2099.9n 0.4621 2100.0n 0.3604 2399.9n 0.3604 2400.0n 0.3434 2699.9n 0.3434 2700.0n 0.5469 2999.9n 0.5469 3000.0n 0.4112 3299.9n 0.4112 3300.0n 0.4112 3599.9n 0.4112 3600.0n 0.5299 3899.9n 0.5299 3900.0n 0.6147 4199.9n 0.6147 4200.0n 0.4112 4499.9n 0.4112 4500.0n 0.3434 4799.9n 0.3434 4800.0n 0.4282 5099.9n 0.4282 5100.0n 0.3604 5399.9n 0.3604 5400.0n 0.3604 5699.9n 0.3604 5700.0n 0.5299 5999.9n 0.5299 6000.0n 0.5638 6299.9n 0.5638 6300.0n 0.5977 6599.9n 0.5977 6600.0n 0.3773 6899.9n 0.3773 6900.0n 0.5638 7199.9n 0.5638 7200.0n 0.4621 7499.9n 0.4621 7500.0n 0.3604 7799.9n 0.3604 7800.0n 0.3434 8099.9n 0.3434 8100.0n 0.5469 8399.9n 0.5469 8400.0n 0.4112 8699.9n 0.4112 8700.0n 0.4112 8999.9n 0.4112 9000.0n 0.5299 9299.9n 0.5299 9300.0n 0.6147 9599.9n 0.6147 9600.0n 0.4112 9899.9n 0.4112 9900.0n 0.3434 10199.9n 0.3434 10200.0n 0.4282 10499.9n 0.4282 10500.0n 0.3604 10799.9n 0.3604 10800.0n 0.3604 11099.9n 0.3604 11100.0n 0.5299 11399.9n 0.5299 11400.0n 0.5638 11699.9n 0.5638 11700.0n 0.5977 11999.9n 0.5977 12000.0n 0.3773 12299.9n 0.3773 12300.0n 0.5638 12599.9n 0.5638 12600.0n 0.4621 12899.9n 0.4621 12900.0n 0.3604 13199.9n 0.3604 13200.0n 0.3434 13499.9n 0.3434 13500.0n 0.5469 13799.9n 0.5469 13800.0n 0.4112 14099.9n 0.4112 14100.0n 0.4112 14399.9n 0.4112 14400.0n 0.5299 14699.9n 0.5299 14700.0n 0.6147 14999.9n 0.6147 15000.0n 0.4112 15299.9n 0.4112 15300.0n 0.3434 15599.9n 0.3434 15600.0n 0.4282 15899.9n 0.4282 15900.0n 0.3604 16199.9n 0.3604 16200.0n 0.3604 16499.9n 0.3604 16500.0n 0.5299 16799.9n 0.5299 16800.0n 0.5638 17099.9n 0.5638 17100.0n 0.5977 17399.9n 0.5977 17400.0n 0.3773 17699.9n 0.3773 17700.0n 0.5638 17999.9n 0.5638 18000.0n 0.4621 18299.9n 0.4621 18300.0n 0.3604 18599.9n 0.3604 18600.0n 0.3434 18899.9n 0.3434 18900.0n 0.5469 19199.9n 0.5469 19200.0n 0.4112 19499.9n 0.4112 19500.0n 0.4112 19799.9n 0.4112 19800.0n 0.5299 20099.9n 0.5299 20100.0n 0.6147 20399.9n 0.6147 20400.0n 0.4112 20699.9n 0.4112 20700.0n 0.3434 20999.9n 0.3434 21000.0n 0.4282 21299.9n 0.4282 21300.0n 0.3604 21599.9n 0.3604 21600.0n 0.3604 21899.9n 0.3604 21900.0n 0.5299 22199.9n 0.5299 22200.0n 0.5638 22499.9n 0.5638 22500.0n 0.5977 22799.9n 0.5977 22800.0n 0.3773 23099.9n 0.3773 23100.0n 0.5638 23399.9n 0.5638 23400.0n 0.4621 23699.9n 0.4621 23700.0n 0.3604 23999.9n 0.3604 24000.0n 0.3434 24299.9n 0.3434 24300.0n 0.5469 24599.9n 0.5469 24600.0n 0.4112 24899.9n 0.4112 24900.0n 0.4112 25199.9n 0.4112 25200.0n 0.5299 25499.9n 0.5299 25500.0n 0.6147 25799.9n 0.6147 25800.0n 0.4112 26099.9n 0.4112 26100.0n 0.3434 26399.9n 0.3434 26400.0n 0.4282 26699.9n 0.4282 26700.0n 0.3604 26999.9n 0.3604 27000.0n 0.3604 27299.9n 0.3604 27300.0n 0.5299 27599.9n 0.5299 27600.0n 0.5638 27899.9n 0.5638 27900.0n 0.5977 28199.9n 0.5977 28200.0n 0.3773 28499.9n 0.3773 28500.0n 0.5638 28799.9n 0.5638 28800.0n 0.4621 29099.9n 0.4621 29100.0n 0.3604 29399.9n 0.3604 29400.0n 0.3434 29699.9n 0.3434 29700.0n 0.5469 29999.9n 0.5469 30000.0n 0.4112 30299.9n 0.4112 30300.0n 0.4112 30599.9n 0.4112 30600.0n 0.5299 30899.9n 0.5299 30900.0n 0.6147 31199.9n 0.6147 31200.0n 0.4112 31499.9n 0.4112 31500.0n 0.3434 31799.9n 0.3434 31800.0n 0.4282 32099.9n 0.4282 32100.0n 0.3604 32399.9n 0.3604 32400.0n 0.3604 32699.9n 0.3604 32700.0n 0.5299 32999.9n 0.5299 33000.0n 0.5638 33299.9n 0.5638 33300.0n 0.5977 33599.9n 0.5977 33600.0n 0.3773 33899.9n 0.3773 33900.0n 0.5638 34199.9n 0.5638 34200.0n 0.4621 34499.9n 0.4621 34500.0n 0.3604 34799.9n 0.3604 34800.0n 0.3434 35099.9n 0.3434 35100.0n 0.5469 35399.9n 0.5469 35400.0n 0.4112 35699.9n 0.4112 35700.0n 0.4112 35999.9n 0.4112 36000.0n 0.5299 36299.9n 0.5299 36300.0n 0.6147 36599.9n 0.6147 36600.0n 0.4112 36899.9n 0.4112 36900.0n 0.3434 37199.9n 0.3434 37200.0n 0.4282 37499.9n 0.4282 37500.0n 0.3604 37799.9n 0.3604 37800.0n 0.3604 38099.9n 0.3604 38100.0n 0.5299 38399.9n 0.5299 38400.0n 0.5638 38699.9n 0.5638 38700.0n 0.5977 38999.9n 0.5977 39000.0n 0.3773 39299.9n 0.3773 39300.0n 0.5638 39599.9n 0.5638 39600.0n 0.4621 39899.9n 0.4621 39900.0n 0.3604 40199.9n 0.3604 40200.0n 0.3434 40499.9n 0.3434 40500.0n 0.5469 40799.9n 0.5469 40800.0n 0.4112 41099.9n 0.4112 41100.0n 0.4112 41399.9n 0.4112 41400.0n 0.5299 41699.9n 0.5299 41700.0n 0.6147 41999.9n 0.6147 42000.0n 0.4112 42299.9n 0.4112 42300.0n 0.3434 42599.9n 0.3434 42600.0n 0.4282 42899.9n 0.4282 42900.0n 0.3604 43199.9n 0.3604 43200.0n 0.3604 43499.9n 0.3604 43500.0n 0.5299 43799.9n 0.5299 43800.0n 0.5638 44099.9n 0.5638 44100.0n 0.5977 44399.9n 0.5977 44400.0n 0.3773 44699.9n 0.3773 44700.0n 0.5638 44999.9n 0.5638 45000.0n 0.4621 45299.9n 0.4621 45300.0n 0.3604 45599.9n 0.3604 45600.0n 0.3434 45899.9n 0.3434 45900.0n 0.5469 46199.9n 0.5469 46200.0n 0.4112 46499.9n 0.4112 46500.0n 0.4112 46799.9n 0.4112 46800.0n 0.5299 47099.9n 0.5299 47100.0n 0.6147 47399.9n 0.6147 47400.0n 0.4112 47699.9n 0.4112 47700.0n 0.3434 47999.9n 0.3434 48000.0n 0.4282 48299.9n 0.4282 48300.0n 0.3604 48599.9n 0.3604 48600.0n 0.3604 48899.9n 0.3604 48900.0n 0.5299 49199.9n 0.5299 49200.0n 0.5638 49499.9n 0.5638 49500.0n 0.5977 49799.9n 0.5977 49800.0n 0.3773 50099.9n 0.3773 50100.0n 0.5638 50399.9n 0.5638 50400.0n 0.4621 50699.9n 0.4621 50700.0n 0.3604 50999.9n 0.3604 51000.0n 0.3434 51299.9n 0.3434 51300.0n 0.5469 51599.9n 0.5469 51600.0n 0.4112 51899.9n 0.4112 51900.0n 0.4112 52199.9n 0.4112 52200.0n 0.5299 52499.9n 0.5299 52500.0n 0.6147 52799.9n 0.6147 52800.0n 0.4112 53099.9n 0.4112 53100.0n 0.3434 53399.9n 0.3434 53400.0n 0.4282 53699.9n 0.4282 53700.0n 0.3604 53999.9n 0.3604 54000.0n 0.5299 54299.9n 0.5299 54300.0n 0.5130 54599.9n 0.5130 54600.0n 0.3943 54899.9n 0.3943 54900.0n 0.5808 55199.9n 0.5808 55200.0n 0.5469 55499.9n 0.5469 55500.0n 0.5299 55799.9n 0.5299 55800.0n 0.5808 56099.9n 0.5808 56100.0n 0.4451 56399.9n 0.4451 56400.0n 0.4282 56699.9n 0.4282 56700.0n 0.3434 56999.9n 0.3434 57000.0n 0.3604 57299.9n 0.3604 57300.0n 0.5808 57599.9n 0.5808 57600.0n 0.4112 57899.9n 0.4112 57900.0n 0.6147 58199.9n 0.6147 58200.0n 0.3773 58499.9n 0.3773 58500.0n 0.3434 58799.9n 0.3434 58800.0n 0.4112 59099.9n 0.4112 59100.0n 0.3604)
Vxp62 a_xp62 0 PWL(0.0n 0.4494 299.9n 0.4494 300.0n 0.4494 599.9n 0.4494 600.0n 0.4494 899.9n 0.4494 900.0n 0.4494 1199.9n 0.4494 1200.0n 0.5717 1499.9n 0.5717 1500.0n 0.4494 1799.9n 0.4494 1800.0n 0.4494 2099.9n 0.4494 2100.0n 0.5472 2399.9n 0.5472 2400.0n 0.6695 2699.9n 0.6695 2700.0n 0.5962 2999.9n 0.5962 3000.0n 0.6451 3299.9n 0.6451 3300.0n 0.4494 3599.9n 0.4494 3600.0n 0.4494 3899.9n 0.4494 3900.0n 0.4494 4199.9n 0.4494 4200.0n 0.7184 4499.9n 0.7184 4500.0n 0.8000 4799.9n 0.8000 4800.0n 0.4983 5099.9n 0.4983 5100.0n 0.5472 5399.9n 0.5472 5400.0n 0.4494 5699.9n 0.4494 5700.0n 0.4494 5999.9n 0.4494 6000.0n 0.4494 6299.9n 0.4494 6300.0n 0.4494 6599.9n 0.4494 6600.0n 0.5717 6899.9n 0.5717 6900.0n 0.4494 7199.9n 0.4494 7200.0n 0.4494 7499.9n 0.4494 7500.0n 0.5472 7799.9n 0.5472 7800.0n 0.6695 8099.9n 0.6695 8100.0n 0.5962 8399.9n 0.5962 8400.0n 0.6451 8699.9n 0.6451 8700.0n 0.4494 8999.9n 0.4494 9000.0n 0.4494 9299.9n 0.4494 9300.0n 0.4494 9599.9n 0.4494 9600.0n 0.7184 9899.9n 0.7184 9900.0n 0.8000 10199.9n 0.8000 10200.0n 0.4983 10499.9n 0.4983 10500.0n 0.5472 10799.9n 0.5472 10800.0n 0.4494 11099.9n 0.4494 11100.0n 0.4494 11399.9n 0.4494 11400.0n 0.4494 11699.9n 0.4494 11700.0n 0.4494 11999.9n 0.4494 12000.0n 0.5717 12299.9n 0.5717 12300.0n 0.4494 12599.9n 0.4494 12600.0n 0.4494 12899.9n 0.4494 12900.0n 0.5472 13199.9n 0.5472 13200.0n 0.6695 13499.9n 0.6695 13500.0n 0.5962 13799.9n 0.5962 13800.0n 0.6451 14099.9n 0.6451 14100.0n 0.4494 14399.9n 0.4494 14400.0n 0.4494 14699.9n 0.4494 14700.0n 0.4494 14999.9n 0.4494 15000.0n 0.7184 15299.9n 0.7184 15300.0n 0.8000 15599.9n 0.8000 15600.0n 0.4983 15899.9n 0.4983 15900.0n 0.5472 16199.9n 0.5472 16200.0n 0.4494 16499.9n 0.4494 16500.0n 0.4494 16799.9n 0.4494 16800.0n 0.4494 17099.9n 0.4494 17100.0n 0.4494 17399.9n 0.4494 17400.0n 0.5717 17699.9n 0.5717 17700.0n 0.4494 17999.9n 0.4494 18000.0n 0.4494 18299.9n 0.4494 18300.0n 0.5472 18599.9n 0.5472 18600.0n 0.6695 18899.9n 0.6695 18900.0n 0.5962 19199.9n 0.5962 19200.0n 0.6451 19499.9n 0.6451 19500.0n 0.4494 19799.9n 0.4494 19800.0n 0.4494 20099.9n 0.4494 20100.0n 0.4494 20399.9n 0.4494 20400.0n 0.7184 20699.9n 0.7184 20700.0n 0.8000 20999.9n 0.8000 21000.0n 0.4983 21299.9n 0.4983 21300.0n 0.5472 21599.9n 0.5472 21600.0n 0.4494 21899.9n 0.4494 21900.0n 0.4494 22199.9n 0.4494 22200.0n 0.4494 22499.9n 0.4494 22500.0n 0.4494 22799.9n 0.4494 22800.0n 0.5717 23099.9n 0.5717 23100.0n 0.4494 23399.9n 0.4494 23400.0n 0.4494 23699.9n 0.4494 23700.0n 0.5472 23999.9n 0.5472 24000.0n 0.6695 24299.9n 0.6695 24300.0n 0.5962 24599.9n 0.5962 24600.0n 0.6451 24899.9n 0.6451 24900.0n 0.4494 25199.9n 0.4494 25200.0n 0.4494 25499.9n 0.4494 25500.0n 0.4494 25799.9n 0.4494 25800.0n 0.7184 26099.9n 0.7184 26100.0n 0.8000 26399.9n 0.8000 26400.0n 0.4983 26699.9n 0.4983 26700.0n 0.5472 26999.9n 0.5472 27000.0n 0.4494 27299.9n 0.4494 27300.0n 0.4494 27599.9n 0.4494 27600.0n 0.4494 27899.9n 0.4494 27900.0n 0.4494 28199.9n 0.4494 28200.0n 0.5717 28499.9n 0.5717 28500.0n 0.4494 28799.9n 0.4494 28800.0n 0.4494 29099.9n 0.4494 29100.0n 0.5472 29399.9n 0.5472 29400.0n 0.6695 29699.9n 0.6695 29700.0n 0.5962 29999.9n 0.5962 30000.0n 0.6451 30299.9n 0.6451 30300.0n 0.4494 30599.9n 0.4494 30600.0n 0.4494 30899.9n 0.4494 30900.0n 0.4494 31199.9n 0.4494 31200.0n 0.7184 31499.9n 0.7184 31500.0n 0.8000 31799.9n 0.8000 31800.0n 0.4983 32099.9n 0.4983 32100.0n 0.5472 32399.9n 0.5472 32400.0n 0.4494 32699.9n 0.4494 32700.0n 0.4494 32999.9n 0.4494 33000.0n 0.4494 33299.9n 0.4494 33300.0n 0.4494 33599.9n 0.4494 33600.0n 0.5717 33899.9n 0.5717 33900.0n 0.4494 34199.9n 0.4494 34200.0n 0.4494 34499.9n 0.4494 34500.0n 0.5472 34799.9n 0.5472 34800.0n 0.6695 35099.9n 0.6695 35100.0n 0.5962 35399.9n 0.5962 35400.0n 0.6451 35699.9n 0.6451 35700.0n 0.4494 35999.9n 0.4494 36000.0n 0.4494 36299.9n 0.4494 36300.0n 0.4494 36599.9n 0.4494 36600.0n 0.7184 36899.9n 0.7184 36900.0n 0.8000 37199.9n 0.8000 37200.0n 0.4983 37499.9n 0.4983 37500.0n 0.5472 37799.9n 0.5472 37800.0n 0.4494 38099.9n 0.4494 38100.0n 0.4494 38399.9n 0.4494 38400.0n 0.4494 38699.9n 0.4494 38700.0n 0.4494 38999.9n 0.4494 39000.0n 0.5717 39299.9n 0.5717 39300.0n 0.4494 39599.9n 0.4494 39600.0n 0.4494 39899.9n 0.4494 39900.0n 0.5472 40199.9n 0.5472 40200.0n 0.6695 40499.9n 0.6695 40500.0n 0.5962 40799.9n 0.5962 40800.0n 0.6451 41099.9n 0.6451 41100.0n 0.4494 41399.9n 0.4494 41400.0n 0.4494 41699.9n 0.4494 41700.0n 0.4494 41999.9n 0.4494 42000.0n 0.7184 42299.9n 0.7184 42300.0n 0.8000 42599.9n 0.8000 42600.0n 0.4983 42899.9n 0.4983 42900.0n 0.5472 43199.9n 0.5472 43200.0n 0.4494 43499.9n 0.4494 43500.0n 0.4494 43799.9n 0.4494 43800.0n 0.4494 44099.9n 0.4494 44100.0n 0.4494 44399.9n 0.4494 44400.0n 0.5717 44699.9n 0.5717 44700.0n 0.4494 44999.9n 0.4494 45000.0n 0.4494 45299.9n 0.4494 45300.0n 0.5472 45599.9n 0.5472 45600.0n 0.6695 45899.9n 0.6695 45900.0n 0.5962 46199.9n 0.5962 46200.0n 0.6451 46499.9n 0.6451 46500.0n 0.4494 46799.9n 0.4494 46800.0n 0.4494 47099.9n 0.4494 47100.0n 0.4494 47399.9n 0.4494 47400.0n 0.7184 47699.9n 0.7184 47700.0n 0.8000 47999.9n 0.8000 48000.0n 0.4983 48299.9n 0.4983 48300.0n 0.5472 48599.9n 0.5472 48600.0n 0.4494 48899.9n 0.4494 48900.0n 0.4494 49199.9n 0.4494 49200.0n 0.4494 49499.9n 0.4494 49500.0n 0.4494 49799.9n 0.4494 49800.0n 0.5717 50099.9n 0.5717 50100.0n 0.4494 50399.9n 0.4494 50400.0n 0.4494 50699.9n 0.4494 50700.0n 0.5472 50999.9n 0.5472 51000.0n 0.6695 51299.9n 0.6695 51300.0n 0.5962 51599.9n 0.5962 51600.0n 0.6451 51899.9n 0.6451 51900.0n 0.4494 52199.9n 0.4494 52200.0n 0.4494 52499.9n 0.4494 52500.0n 0.4494 52799.9n 0.4494 52800.0n 0.7184 53099.9n 0.7184 53100.0n 0.8000 53399.9n 0.8000 53400.0n 0.4983 53699.9n 0.4983 53700.0n 0.5472 53999.9n 0.5472 54000.0n 0.4494 54299.9n 0.4494 54300.0n 0.4494 54599.9n 0.4494 54600.0n 0.5717 54899.9n 0.5717 54900.0n 0.4494 55199.9n 0.4494 55200.0n 0.4494 55499.9n 0.4494 55500.0n 0.4494 55799.9n 0.4494 55800.0n 0.4494 56099.9n 0.4494 56100.0n 0.4494 56399.9n 0.4494 56400.0n 0.4494 56699.9n 0.4494 56700.0n 0.6940 56999.9n 0.6940 57000.0n 0.4983 57299.9n 0.4983 57300.0n 0.4494 57599.9n 0.4494 57600.0n 0.5228 57899.9n 0.5228 57900.0n 0.4494 58199.9n 0.4494 58200.0n 0.7673 58499.9n 0.7673 58500.0n 0.7673 58799.9n 0.7673 58800.0n 0.6695 59099.9n 0.6695 59100.0n 0.5228)
Vxn62 a_xn62 0 PWL(0.0n 0.5506 299.9n 0.5506 300.0n 0.5506 599.9n 0.5506 600.0n 0.5506 899.9n 0.5506 900.0n 0.5506 1199.9n 0.5506 1200.0n 0.4283 1499.9n 0.4283 1500.0n 0.5506 1799.9n 0.5506 1800.0n 0.5506 2099.9n 0.5506 2100.0n 0.4528 2399.9n 0.4528 2400.0n 0.3305 2699.9n 0.3305 2700.0n 0.4038 2999.9n 0.4038 3000.0n 0.3549 3299.9n 0.3549 3300.0n 0.5506 3599.9n 0.5506 3600.0n 0.5506 3899.9n 0.5506 3900.0n 0.5506 4199.9n 0.5506 4200.0n 0.2816 4499.9n 0.2816 4500.0n 0.2000 4799.9n 0.2000 4800.0n 0.5017 5099.9n 0.5017 5100.0n 0.4528 5399.9n 0.4528 5400.0n 0.5506 5699.9n 0.5506 5700.0n 0.5506 5999.9n 0.5506 6000.0n 0.5506 6299.9n 0.5506 6300.0n 0.5506 6599.9n 0.5506 6600.0n 0.4283 6899.9n 0.4283 6900.0n 0.5506 7199.9n 0.5506 7200.0n 0.5506 7499.9n 0.5506 7500.0n 0.4528 7799.9n 0.4528 7800.0n 0.3305 8099.9n 0.3305 8100.0n 0.4038 8399.9n 0.4038 8400.0n 0.3549 8699.9n 0.3549 8700.0n 0.5506 8999.9n 0.5506 9000.0n 0.5506 9299.9n 0.5506 9300.0n 0.5506 9599.9n 0.5506 9600.0n 0.2816 9899.9n 0.2816 9900.0n 0.2000 10199.9n 0.2000 10200.0n 0.5017 10499.9n 0.5017 10500.0n 0.4528 10799.9n 0.4528 10800.0n 0.5506 11099.9n 0.5506 11100.0n 0.5506 11399.9n 0.5506 11400.0n 0.5506 11699.9n 0.5506 11700.0n 0.5506 11999.9n 0.5506 12000.0n 0.4283 12299.9n 0.4283 12300.0n 0.5506 12599.9n 0.5506 12600.0n 0.5506 12899.9n 0.5506 12900.0n 0.4528 13199.9n 0.4528 13200.0n 0.3305 13499.9n 0.3305 13500.0n 0.4038 13799.9n 0.4038 13800.0n 0.3549 14099.9n 0.3549 14100.0n 0.5506 14399.9n 0.5506 14400.0n 0.5506 14699.9n 0.5506 14700.0n 0.5506 14999.9n 0.5506 15000.0n 0.2816 15299.9n 0.2816 15300.0n 0.2000 15599.9n 0.2000 15600.0n 0.5017 15899.9n 0.5017 15900.0n 0.4528 16199.9n 0.4528 16200.0n 0.5506 16499.9n 0.5506 16500.0n 0.5506 16799.9n 0.5506 16800.0n 0.5506 17099.9n 0.5506 17100.0n 0.5506 17399.9n 0.5506 17400.0n 0.4283 17699.9n 0.4283 17700.0n 0.5506 17999.9n 0.5506 18000.0n 0.5506 18299.9n 0.5506 18300.0n 0.4528 18599.9n 0.4528 18600.0n 0.3305 18899.9n 0.3305 18900.0n 0.4038 19199.9n 0.4038 19200.0n 0.3549 19499.9n 0.3549 19500.0n 0.5506 19799.9n 0.5506 19800.0n 0.5506 20099.9n 0.5506 20100.0n 0.5506 20399.9n 0.5506 20400.0n 0.2816 20699.9n 0.2816 20700.0n 0.2000 20999.9n 0.2000 21000.0n 0.5017 21299.9n 0.5017 21300.0n 0.4528 21599.9n 0.4528 21600.0n 0.5506 21899.9n 0.5506 21900.0n 0.5506 22199.9n 0.5506 22200.0n 0.5506 22499.9n 0.5506 22500.0n 0.5506 22799.9n 0.5506 22800.0n 0.4283 23099.9n 0.4283 23100.0n 0.5506 23399.9n 0.5506 23400.0n 0.5506 23699.9n 0.5506 23700.0n 0.4528 23999.9n 0.4528 24000.0n 0.3305 24299.9n 0.3305 24300.0n 0.4038 24599.9n 0.4038 24600.0n 0.3549 24899.9n 0.3549 24900.0n 0.5506 25199.9n 0.5506 25200.0n 0.5506 25499.9n 0.5506 25500.0n 0.5506 25799.9n 0.5506 25800.0n 0.2816 26099.9n 0.2816 26100.0n 0.2000 26399.9n 0.2000 26400.0n 0.5017 26699.9n 0.5017 26700.0n 0.4528 26999.9n 0.4528 27000.0n 0.5506 27299.9n 0.5506 27300.0n 0.5506 27599.9n 0.5506 27600.0n 0.5506 27899.9n 0.5506 27900.0n 0.5506 28199.9n 0.5506 28200.0n 0.4283 28499.9n 0.4283 28500.0n 0.5506 28799.9n 0.5506 28800.0n 0.5506 29099.9n 0.5506 29100.0n 0.4528 29399.9n 0.4528 29400.0n 0.3305 29699.9n 0.3305 29700.0n 0.4038 29999.9n 0.4038 30000.0n 0.3549 30299.9n 0.3549 30300.0n 0.5506 30599.9n 0.5506 30600.0n 0.5506 30899.9n 0.5506 30900.0n 0.5506 31199.9n 0.5506 31200.0n 0.2816 31499.9n 0.2816 31500.0n 0.2000 31799.9n 0.2000 31800.0n 0.5017 32099.9n 0.5017 32100.0n 0.4528 32399.9n 0.4528 32400.0n 0.5506 32699.9n 0.5506 32700.0n 0.5506 32999.9n 0.5506 33000.0n 0.5506 33299.9n 0.5506 33300.0n 0.5506 33599.9n 0.5506 33600.0n 0.4283 33899.9n 0.4283 33900.0n 0.5506 34199.9n 0.5506 34200.0n 0.5506 34499.9n 0.5506 34500.0n 0.4528 34799.9n 0.4528 34800.0n 0.3305 35099.9n 0.3305 35100.0n 0.4038 35399.9n 0.4038 35400.0n 0.3549 35699.9n 0.3549 35700.0n 0.5506 35999.9n 0.5506 36000.0n 0.5506 36299.9n 0.5506 36300.0n 0.5506 36599.9n 0.5506 36600.0n 0.2816 36899.9n 0.2816 36900.0n 0.2000 37199.9n 0.2000 37200.0n 0.5017 37499.9n 0.5017 37500.0n 0.4528 37799.9n 0.4528 37800.0n 0.5506 38099.9n 0.5506 38100.0n 0.5506 38399.9n 0.5506 38400.0n 0.5506 38699.9n 0.5506 38700.0n 0.5506 38999.9n 0.5506 39000.0n 0.4283 39299.9n 0.4283 39300.0n 0.5506 39599.9n 0.5506 39600.0n 0.5506 39899.9n 0.5506 39900.0n 0.4528 40199.9n 0.4528 40200.0n 0.3305 40499.9n 0.3305 40500.0n 0.4038 40799.9n 0.4038 40800.0n 0.3549 41099.9n 0.3549 41100.0n 0.5506 41399.9n 0.5506 41400.0n 0.5506 41699.9n 0.5506 41700.0n 0.5506 41999.9n 0.5506 42000.0n 0.2816 42299.9n 0.2816 42300.0n 0.2000 42599.9n 0.2000 42600.0n 0.5017 42899.9n 0.5017 42900.0n 0.4528 43199.9n 0.4528 43200.0n 0.5506 43499.9n 0.5506 43500.0n 0.5506 43799.9n 0.5506 43800.0n 0.5506 44099.9n 0.5506 44100.0n 0.5506 44399.9n 0.5506 44400.0n 0.4283 44699.9n 0.4283 44700.0n 0.5506 44999.9n 0.5506 45000.0n 0.5506 45299.9n 0.5506 45300.0n 0.4528 45599.9n 0.4528 45600.0n 0.3305 45899.9n 0.3305 45900.0n 0.4038 46199.9n 0.4038 46200.0n 0.3549 46499.9n 0.3549 46500.0n 0.5506 46799.9n 0.5506 46800.0n 0.5506 47099.9n 0.5506 47100.0n 0.5506 47399.9n 0.5506 47400.0n 0.2816 47699.9n 0.2816 47700.0n 0.2000 47999.9n 0.2000 48000.0n 0.5017 48299.9n 0.5017 48300.0n 0.4528 48599.9n 0.4528 48600.0n 0.5506 48899.9n 0.5506 48900.0n 0.5506 49199.9n 0.5506 49200.0n 0.5506 49499.9n 0.5506 49500.0n 0.5506 49799.9n 0.5506 49800.0n 0.4283 50099.9n 0.4283 50100.0n 0.5506 50399.9n 0.5506 50400.0n 0.5506 50699.9n 0.5506 50700.0n 0.4528 50999.9n 0.4528 51000.0n 0.3305 51299.9n 0.3305 51300.0n 0.4038 51599.9n 0.4038 51600.0n 0.3549 51899.9n 0.3549 51900.0n 0.5506 52199.9n 0.5506 52200.0n 0.5506 52499.9n 0.5506 52500.0n 0.5506 52799.9n 0.5506 52800.0n 0.2816 53099.9n 0.2816 53100.0n 0.2000 53399.9n 0.2000 53400.0n 0.5017 53699.9n 0.5017 53700.0n 0.4528 53999.9n 0.4528 54000.0n 0.5506 54299.9n 0.5506 54300.0n 0.5506 54599.9n 0.5506 54600.0n 0.4283 54899.9n 0.4283 54900.0n 0.5506 55199.9n 0.5506 55200.0n 0.5506 55499.9n 0.5506 55500.0n 0.5506 55799.9n 0.5506 55800.0n 0.5506 56099.9n 0.5506 56100.0n 0.5506 56399.9n 0.5506 56400.0n 0.5506 56699.9n 0.5506 56700.0n 0.3060 56999.9n 0.3060 57000.0n 0.5017 57299.9n 0.5017 57300.0n 0.5506 57599.9n 0.5506 57600.0n 0.4772 57899.9n 0.4772 57900.0n 0.5506 58199.9n 0.5506 58200.0n 0.2327 58499.9n 0.2327 58500.0n 0.2327 58799.9n 0.2327 58800.0n 0.3305 59099.9n 0.3305 59100.0n 0.4772)
Vxp63 a_xp63 0 PWL(0.0n 0.4804 299.9n 0.4804 300.0n 0.4804 599.9n 0.4804 600.0n 0.4804 899.9n 0.4804 900.0n 0.4804 1199.9n 0.4804 1200.0n 0.4804 1499.9n 0.4804 1500.0n 0.4804 1799.9n 0.4804 1800.0n 0.4804 2099.9n 0.4804 2100.0n 0.4804 2399.9n 0.4804 2400.0n 0.4804 2699.9n 0.4804 2700.0n 0.5342 2999.9n 0.5342 3000.0n 0.5342 3299.9n 0.5342 3300.0n 0.4804 3599.9n 0.4804 3600.0n 0.4804 3899.9n 0.4804 3900.0n 0.4804 4199.9n 0.4804 4200.0n 0.4804 4499.9n 0.4804 4500.0n 0.7493 4799.9n 0.7493 4800.0n 0.4804 5099.9n 0.4804 5100.0n 0.4804 5399.9n 0.4804 5400.0n 0.4804 5699.9n 0.4804 5700.0n 0.4804 5999.9n 0.4804 6000.0n 0.4804 6299.9n 0.4804 6300.0n 0.4804 6599.9n 0.4804 6600.0n 0.4804 6899.9n 0.4804 6900.0n 0.4804 7199.9n 0.4804 7200.0n 0.4804 7499.9n 0.4804 7500.0n 0.4804 7799.9n 0.4804 7800.0n 0.4804 8099.9n 0.4804 8100.0n 0.5342 8399.9n 0.5342 8400.0n 0.5342 8699.9n 0.5342 8700.0n 0.4804 8999.9n 0.4804 9000.0n 0.4804 9299.9n 0.4804 9300.0n 0.4804 9599.9n 0.4804 9600.0n 0.4804 9899.9n 0.4804 9900.0n 0.7493 10199.9n 0.7493 10200.0n 0.4804 10499.9n 0.4804 10500.0n 0.4804 10799.9n 0.4804 10800.0n 0.4804 11099.9n 0.4804 11100.0n 0.4804 11399.9n 0.4804 11400.0n 0.4804 11699.9n 0.4804 11700.0n 0.4804 11999.9n 0.4804 12000.0n 0.4804 12299.9n 0.4804 12300.0n 0.4804 12599.9n 0.4804 12600.0n 0.4804 12899.9n 0.4804 12900.0n 0.4804 13199.9n 0.4804 13200.0n 0.4804 13499.9n 0.4804 13500.0n 0.5342 13799.9n 0.5342 13800.0n 0.5342 14099.9n 0.5342 14100.0n 0.4804 14399.9n 0.4804 14400.0n 0.4804 14699.9n 0.4804 14700.0n 0.4804 14999.9n 0.4804 15000.0n 0.4804 15299.9n 0.4804 15300.0n 0.7493 15599.9n 0.7493 15600.0n 0.4804 15899.9n 0.4804 15900.0n 0.4804 16199.9n 0.4804 16200.0n 0.4804 16499.9n 0.4804 16500.0n 0.4804 16799.9n 0.4804 16800.0n 0.4804 17099.9n 0.4804 17100.0n 0.4804 17399.9n 0.4804 17400.0n 0.4804 17699.9n 0.4804 17700.0n 0.4804 17999.9n 0.4804 18000.0n 0.4804 18299.9n 0.4804 18300.0n 0.4804 18599.9n 0.4804 18600.0n 0.4804 18899.9n 0.4804 18900.0n 0.5342 19199.9n 0.5342 19200.0n 0.5342 19499.9n 0.5342 19500.0n 0.4804 19799.9n 0.4804 19800.0n 0.4804 20099.9n 0.4804 20100.0n 0.4804 20399.9n 0.4804 20400.0n 0.4804 20699.9n 0.4804 20700.0n 0.7493 20999.9n 0.7493 21000.0n 0.4804 21299.9n 0.4804 21300.0n 0.4804 21599.9n 0.4804 21600.0n 0.4804 21899.9n 0.4804 21900.0n 0.4804 22199.9n 0.4804 22200.0n 0.4804 22499.9n 0.4804 22500.0n 0.4804 22799.9n 0.4804 22800.0n 0.4804 23099.9n 0.4804 23100.0n 0.4804 23399.9n 0.4804 23400.0n 0.4804 23699.9n 0.4804 23700.0n 0.4804 23999.9n 0.4804 24000.0n 0.4804 24299.9n 0.4804 24300.0n 0.5342 24599.9n 0.5342 24600.0n 0.5342 24899.9n 0.5342 24900.0n 0.4804 25199.9n 0.4804 25200.0n 0.4804 25499.9n 0.4804 25500.0n 0.4804 25799.9n 0.4804 25800.0n 0.4804 26099.9n 0.4804 26100.0n 0.7493 26399.9n 0.7493 26400.0n 0.4804 26699.9n 0.4804 26700.0n 0.4804 26999.9n 0.4804 27000.0n 0.4804 27299.9n 0.4804 27300.0n 0.4804 27599.9n 0.4804 27600.0n 0.4804 27899.9n 0.4804 27900.0n 0.4804 28199.9n 0.4804 28200.0n 0.4804 28499.9n 0.4804 28500.0n 0.4804 28799.9n 0.4804 28800.0n 0.4804 29099.9n 0.4804 29100.0n 0.4804 29399.9n 0.4804 29400.0n 0.4804 29699.9n 0.4804 29700.0n 0.5342 29999.9n 0.5342 30000.0n 0.5342 30299.9n 0.5342 30300.0n 0.4804 30599.9n 0.4804 30600.0n 0.4804 30899.9n 0.4804 30900.0n 0.4804 31199.9n 0.4804 31200.0n 0.4804 31499.9n 0.4804 31500.0n 0.7493 31799.9n 0.7493 31800.0n 0.4804 32099.9n 0.4804 32100.0n 0.4804 32399.9n 0.4804 32400.0n 0.4804 32699.9n 0.4804 32700.0n 0.4804 32999.9n 0.4804 33000.0n 0.4804 33299.9n 0.4804 33300.0n 0.4804 33599.9n 0.4804 33600.0n 0.4804 33899.9n 0.4804 33900.0n 0.4804 34199.9n 0.4804 34200.0n 0.4804 34499.9n 0.4804 34500.0n 0.4804 34799.9n 0.4804 34800.0n 0.4804 35099.9n 0.4804 35100.0n 0.5342 35399.9n 0.5342 35400.0n 0.5342 35699.9n 0.5342 35700.0n 0.4804 35999.9n 0.4804 36000.0n 0.4804 36299.9n 0.4804 36300.0n 0.4804 36599.9n 0.4804 36600.0n 0.4804 36899.9n 0.4804 36900.0n 0.7493 37199.9n 0.7493 37200.0n 0.4804 37499.9n 0.4804 37500.0n 0.4804 37799.9n 0.4804 37800.0n 0.4804 38099.9n 0.4804 38100.0n 0.4804 38399.9n 0.4804 38400.0n 0.4804 38699.9n 0.4804 38700.0n 0.4804 38999.9n 0.4804 39000.0n 0.4804 39299.9n 0.4804 39300.0n 0.4804 39599.9n 0.4804 39600.0n 0.4804 39899.9n 0.4804 39900.0n 0.4804 40199.9n 0.4804 40200.0n 0.4804 40499.9n 0.4804 40500.0n 0.5342 40799.9n 0.5342 40800.0n 0.5342 41099.9n 0.5342 41100.0n 0.4804 41399.9n 0.4804 41400.0n 0.4804 41699.9n 0.4804 41700.0n 0.4804 41999.9n 0.4804 42000.0n 0.4804 42299.9n 0.4804 42300.0n 0.7493 42599.9n 0.7493 42600.0n 0.4804 42899.9n 0.4804 42900.0n 0.4804 43199.9n 0.4804 43200.0n 0.4804 43499.9n 0.4804 43500.0n 0.4804 43799.9n 0.4804 43800.0n 0.4804 44099.9n 0.4804 44100.0n 0.4804 44399.9n 0.4804 44400.0n 0.4804 44699.9n 0.4804 44700.0n 0.4804 44999.9n 0.4804 45000.0n 0.4804 45299.9n 0.4804 45300.0n 0.4804 45599.9n 0.4804 45600.0n 0.4804 45899.9n 0.4804 45900.0n 0.5342 46199.9n 0.5342 46200.0n 0.5342 46499.9n 0.5342 46500.0n 0.4804 46799.9n 0.4804 46800.0n 0.4804 47099.9n 0.4804 47100.0n 0.4804 47399.9n 0.4804 47400.0n 0.4804 47699.9n 0.4804 47700.0n 0.7493 47999.9n 0.7493 48000.0n 0.4804 48299.9n 0.4804 48300.0n 0.4804 48599.9n 0.4804 48600.0n 0.4804 48899.9n 0.4804 48900.0n 0.4804 49199.9n 0.4804 49200.0n 0.4804 49499.9n 0.4804 49500.0n 0.4804 49799.9n 0.4804 49800.0n 0.4804 50099.9n 0.4804 50100.0n 0.4804 50399.9n 0.4804 50400.0n 0.4804 50699.9n 0.4804 50700.0n 0.4804 50999.9n 0.4804 51000.0n 0.4804 51299.9n 0.4804 51300.0n 0.5342 51599.9n 0.5342 51600.0n 0.5342 51899.9n 0.5342 51900.0n 0.4804 52199.9n 0.4804 52200.0n 0.4804 52499.9n 0.4804 52500.0n 0.4804 52799.9n 0.4804 52800.0n 0.4804 53099.9n 0.4804 53100.0n 0.7493 53399.9n 0.7493 53400.0n 0.4804 53699.9n 0.4804 53700.0n 0.4804 53999.9n 0.4804 54000.0n 0.4804 54299.9n 0.4804 54300.0n 0.4804 54599.9n 0.4804 54600.0n 0.4804 54899.9n 0.4804 54900.0n 0.4804 55199.9n 0.4804 55200.0n 0.4804 55499.9n 0.4804 55500.0n 0.4804 55799.9n 0.4804 55800.0n 0.4804 56099.9n 0.4804 56100.0n 0.4804 56399.9n 0.4804 56400.0n 0.4804 56699.9n 0.4804 56700.0n 0.6417 56999.9n 0.6417 57000.0n 0.4804 57299.9n 0.4804 57300.0n 0.4804 57599.9n 0.4804 57600.0n 0.4804 57899.9n 0.4804 57900.0n 0.4804 58199.9n 0.4804 58200.0n 0.4804 58499.9n 0.4804 58500.0n 0.4804 58799.9n 0.4804 58800.0n 0.4804 59099.9n 0.4804 59100.0n 0.4804)
Vxn63 a_xn63 0 PWL(0.0n 0.5196 299.9n 0.5196 300.0n 0.5196 599.9n 0.5196 600.0n 0.5196 899.9n 0.5196 900.0n 0.5196 1199.9n 0.5196 1200.0n 0.5196 1499.9n 0.5196 1500.0n 0.5196 1799.9n 0.5196 1800.0n 0.5196 2099.9n 0.5196 2100.0n 0.5196 2399.9n 0.5196 2400.0n 0.5196 2699.9n 0.5196 2700.0n 0.4658 2999.9n 0.4658 3000.0n 0.4658 3299.9n 0.4658 3300.0n 0.5196 3599.9n 0.5196 3600.0n 0.5196 3899.9n 0.5196 3900.0n 0.5196 4199.9n 0.5196 4200.0n 0.5196 4499.9n 0.5196 4500.0n 0.2507 4799.9n 0.2507 4800.0n 0.5196 5099.9n 0.5196 5100.0n 0.5196 5399.9n 0.5196 5400.0n 0.5196 5699.9n 0.5196 5700.0n 0.5196 5999.9n 0.5196 6000.0n 0.5196 6299.9n 0.5196 6300.0n 0.5196 6599.9n 0.5196 6600.0n 0.5196 6899.9n 0.5196 6900.0n 0.5196 7199.9n 0.5196 7200.0n 0.5196 7499.9n 0.5196 7500.0n 0.5196 7799.9n 0.5196 7800.0n 0.5196 8099.9n 0.5196 8100.0n 0.4658 8399.9n 0.4658 8400.0n 0.4658 8699.9n 0.4658 8700.0n 0.5196 8999.9n 0.5196 9000.0n 0.5196 9299.9n 0.5196 9300.0n 0.5196 9599.9n 0.5196 9600.0n 0.5196 9899.9n 0.5196 9900.0n 0.2507 10199.9n 0.2507 10200.0n 0.5196 10499.9n 0.5196 10500.0n 0.5196 10799.9n 0.5196 10800.0n 0.5196 11099.9n 0.5196 11100.0n 0.5196 11399.9n 0.5196 11400.0n 0.5196 11699.9n 0.5196 11700.0n 0.5196 11999.9n 0.5196 12000.0n 0.5196 12299.9n 0.5196 12300.0n 0.5196 12599.9n 0.5196 12600.0n 0.5196 12899.9n 0.5196 12900.0n 0.5196 13199.9n 0.5196 13200.0n 0.5196 13499.9n 0.5196 13500.0n 0.4658 13799.9n 0.4658 13800.0n 0.4658 14099.9n 0.4658 14100.0n 0.5196 14399.9n 0.5196 14400.0n 0.5196 14699.9n 0.5196 14700.0n 0.5196 14999.9n 0.5196 15000.0n 0.5196 15299.9n 0.5196 15300.0n 0.2507 15599.9n 0.2507 15600.0n 0.5196 15899.9n 0.5196 15900.0n 0.5196 16199.9n 0.5196 16200.0n 0.5196 16499.9n 0.5196 16500.0n 0.5196 16799.9n 0.5196 16800.0n 0.5196 17099.9n 0.5196 17100.0n 0.5196 17399.9n 0.5196 17400.0n 0.5196 17699.9n 0.5196 17700.0n 0.5196 17999.9n 0.5196 18000.0n 0.5196 18299.9n 0.5196 18300.0n 0.5196 18599.9n 0.5196 18600.0n 0.5196 18899.9n 0.5196 18900.0n 0.4658 19199.9n 0.4658 19200.0n 0.4658 19499.9n 0.4658 19500.0n 0.5196 19799.9n 0.5196 19800.0n 0.5196 20099.9n 0.5196 20100.0n 0.5196 20399.9n 0.5196 20400.0n 0.5196 20699.9n 0.5196 20700.0n 0.2507 20999.9n 0.2507 21000.0n 0.5196 21299.9n 0.5196 21300.0n 0.5196 21599.9n 0.5196 21600.0n 0.5196 21899.9n 0.5196 21900.0n 0.5196 22199.9n 0.5196 22200.0n 0.5196 22499.9n 0.5196 22500.0n 0.5196 22799.9n 0.5196 22800.0n 0.5196 23099.9n 0.5196 23100.0n 0.5196 23399.9n 0.5196 23400.0n 0.5196 23699.9n 0.5196 23700.0n 0.5196 23999.9n 0.5196 24000.0n 0.5196 24299.9n 0.5196 24300.0n 0.4658 24599.9n 0.4658 24600.0n 0.4658 24899.9n 0.4658 24900.0n 0.5196 25199.9n 0.5196 25200.0n 0.5196 25499.9n 0.5196 25500.0n 0.5196 25799.9n 0.5196 25800.0n 0.5196 26099.9n 0.5196 26100.0n 0.2507 26399.9n 0.2507 26400.0n 0.5196 26699.9n 0.5196 26700.0n 0.5196 26999.9n 0.5196 27000.0n 0.5196 27299.9n 0.5196 27300.0n 0.5196 27599.9n 0.5196 27600.0n 0.5196 27899.9n 0.5196 27900.0n 0.5196 28199.9n 0.5196 28200.0n 0.5196 28499.9n 0.5196 28500.0n 0.5196 28799.9n 0.5196 28800.0n 0.5196 29099.9n 0.5196 29100.0n 0.5196 29399.9n 0.5196 29400.0n 0.5196 29699.9n 0.5196 29700.0n 0.4658 29999.9n 0.4658 30000.0n 0.4658 30299.9n 0.4658 30300.0n 0.5196 30599.9n 0.5196 30600.0n 0.5196 30899.9n 0.5196 30900.0n 0.5196 31199.9n 0.5196 31200.0n 0.5196 31499.9n 0.5196 31500.0n 0.2507 31799.9n 0.2507 31800.0n 0.5196 32099.9n 0.5196 32100.0n 0.5196 32399.9n 0.5196 32400.0n 0.5196 32699.9n 0.5196 32700.0n 0.5196 32999.9n 0.5196 33000.0n 0.5196 33299.9n 0.5196 33300.0n 0.5196 33599.9n 0.5196 33600.0n 0.5196 33899.9n 0.5196 33900.0n 0.5196 34199.9n 0.5196 34200.0n 0.5196 34499.9n 0.5196 34500.0n 0.5196 34799.9n 0.5196 34800.0n 0.5196 35099.9n 0.5196 35100.0n 0.4658 35399.9n 0.4658 35400.0n 0.4658 35699.9n 0.4658 35700.0n 0.5196 35999.9n 0.5196 36000.0n 0.5196 36299.9n 0.5196 36300.0n 0.5196 36599.9n 0.5196 36600.0n 0.5196 36899.9n 0.5196 36900.0n 0.2507 37199.9n 0.2507 37200.0n 0.5196 37499.9n 0.5196 37500.0n 0.5196 37799.9n 0.5196 37800.0n 0.5196 38099.9n 0.5196 38100.0n 0.5196 38399.9n 0.5196 38400.0n 0.5196 38699.9n 0.5196 38700.0n 0.5196 38999.9n 0.5196 39000.0n 0.5196 39299.9n 0.5196 39300.0n 0.5196 39599.9n 0.5196 39600.0n 0.5196 39899.9n 0.5196 39900.0n 0.5196 40199.9n 0.5196 40200.0n 0.5196 40499.9n 0.5196 40500.0n 0.4658 40799.9n 0.4658 40800.0n 0.4658 41099.9n 0.4658 41100.0n 0.5196 41399.9n 0.5196 41400.0n 0.5196 41699.9n 0.5196 41700.0n 0.5196 41999.9n 0.5196 42000.0n 0.5196 42299.9n 0.5196 42300.0n 0.2507 42599.9n 0.2507 42600.0n 0.5196 42899.9n 0.5196 42900.0n 0.5196 43199.9n 0.5196 43200.0n 0.5196 43499.9n 0.5196 43500.0n 0.5196 43799.9n 0.5196 43800.0n 0.5196 44099.9n 0.5196 44100.0n 0.5196 44399.9n 0.5196 44400.0n 0.5196 44699.9n 0.5196 44700.0n 0.5196 44999.9n 0.5196 45000.0n 0.5196 45299.9n 0.5196 45300.0n 0.5196 45599.9n 0.5196 45600.0n 0.5196 45899.9n 0.5196 45900.0n 0.4658 46199.9n 0.4658 46200.0n 0.4658 46499.9n 0.4658 46500.0n 0.5196 46799.9n 0.5196 46800.0n 0.5196 47099.9n 0.5196 47100.0n 0.5196 47399.9n 0.5196 47400.0n 0.5196 47699.9n 0.5196 47700.0n 0.2507 47999.9n 0.2507 48000.0n 0.5196 48299.9n 0.5196 48300.0n 0.5196 48599.9n 0.5196 48600.0n 0.5196 48899.9n 0.5196 48900.0n 0.5196 49199.9n 0.5196 49200.0n 0.5196 49499.9n 0.5196 49500.0n 0.5196 49799.9n 0.5196 49800.0n 0.5196 50099.9n 0.5196 50100.0n 0.5196 50399.9n 0.5196 50400.0n 0.5196 50699.9n 0.5196 50700.0n 0.5196 50999.9n 0.5196 51000.0n 0.5196 51299.9n 0.5196 51300.0n 0.4658 51599.9n 0.4658 51600.0n 0.4658 51899.9n 0.4658 51900.0n 0.5196 52199.9n 0.5196 52200.0n 0.5196 52499.9n 0.5196 52500.0n 0.5196 52799.9n 0.5196 52800.0n 0.5196 53099.9n 0.5196 53100.0n 0.2507 53399.9n 0.2507 53400.0n 0.5196 53699.9n 0.5196 53700.0n 0.5196 53999.9n 0.5196 54000.0n 0.5196 54299.9n 0.5196 54300.0n 0.5196 54599.9n 0.5196 54600.0n 0.5196 54899.9n 0.5196 54900.0n 0.5196 55199.9n 0.5196 55200.0n 0.5196 55499.9n 0.5196 55500.0n 0.5196 55799.9n 0.5196 55800.0n 0.5196 56099.9n 0.5196 56100.0n 0.5196 56399.9n 0.5196 56400.0n 0.5196 56699.9n 0.5196 56700.0n 0.3583 56999.9n 0.3583 57000.0n 0.5196 57299.9n 0.5196 57300.0n 0.5196 57599.9n 0.5196 57600.0n 0.5196 57899.9n 0.5196 57900.0n 0.5196 58199.9n 0.5196 58200.0n 0.5196 58499.9n 0.5196 58500.0n 0.5196 58799.9n 0.5196 58800.0n 0.5196 59099.9n 0.5196 59100.0n 0.5196)
Vxop0 xop0 0 PWL(0.0n 0.2500 299.9n 0.2500 300.0n 0.7500 599.9n 0.7500 600.0n 0.7500 899.9n 0.7500 900.0n 0.7500 1199.9n 0.7500 1200.0n 0.2500 1499.9n 0.2500 1500.0n 0.7500 1799.9n 0.7500 1800.0n 0.7500 2099.9n 0.7500 2100.0n 0.2500 2399.9n 0.2500 2400.0n 0.2500 2699.9n 0.2500 2700.0n 0.2500 2999.9n 0.2500 3000.0n 0.2500 3299.9n 0.2500 3300.0n 0.2500 3599.9n 0.2500 3600.0n 0.2500 3899.9n 0.2500 3900.0n 0.2500 4199.9n 0.2500 4200.0n 0.2500 4499.9n 0.2500 4500.0n 0.2500 4799.9n 0.2500 4800.0n 0.7500 5099.9n 0.7500 5100.0n 0.2500 5399.9n 0.2500 5400.0n 0.2500 5699.9n 0.2500 5700.0n 0.7500 5999.9n 0.7500 6000.0n 0.7500 6299.9n 0.7500 6300.0n 0.7500 6599.9n 0.7500 6600.0n 0.2500 6899.9n 0.2500 6900.0n 0.7500 7199.9n 0.7500 7200.0n 0.7500 7499.9n 0.7500 7500.0n 0.2500 7799.9n 0.2500 7800.0n 0.2500 8099.9n 0.2500 8100.0n 0.2500 8399.9n 0.2500 8400.0n 0.2500 8699.9n 0.2500 8700.0n 0.2500 8999.9n 0.2500 9000.0n 0.2500 9299.9n 0.2500 9300.0n 0.2500 9599.9n 0.2500 9600.0n 0.2500 9899.9n 0.2500 9900.0n 0.2500 10199.9n 0.2500 10200.0n 0.7500 10499.9n 0.7500 10500.0n 0.2500 10799.9n 0.2500 10800.0n 0.2500 11099.9n 0.2500 11100.0n 0.7500 11399.9n 0.7500 11400.0n 0.7500 11699.9n 0.7500 11700.0n 0.7500 11999.9n 0.7500 12000.0n 0.2500 12299.9n 0.2500 12300.0n 0.7500 12599.9n 0.7500 12600.0n 0.7500 12899.9n 0.7500 12900.0n 0.2500 13199.9n 0.2500 13200.0n 0.2500 13499.9n 0.2500 13500.0n 0.2500 13799.9n 0.2500 13800.0n 0.2500 14099.9n 0.2500 14100.0n 0.2500 14399.9n 0.2500 14400.0n 0.2500 14699.9n 0.2500 14700.0n 0.2500 14999.9n 0.2500 15000.0n 0.2500 15299.9n 0.2500 15300.0n 0.2500 15599.9n 0.2500 15600.0n 0.7500 15899.9n 0.7500 15900.0n 0.2500 16199.9n 0.2500 16200.0n 0.2500 16499.9n 0.2500 16500.0n 0.7500 16799.9n 0.7500 16800.0n 0.7500 17099.9n 0.7500 17100.0n 0.7500 17399.9n 0.7500 17400.0n 0.2500 17699.9n 0.2500 17700.0n 0.7500 17999.9n 0.7500 18000.0n 0.7500 18299.9n 0.7500 18300.0n 0.2500 18599.9n 0.2500 18600.0n 0.2500 18899.9n 0.2500 18900.0n 0.2500 19199.9n 0.2500 19200.0n 0.2500 19499.9n 0.2500 19500.0n 0.2500 19799.9n 0.2500 19800.0n 0.2500 20099.9n 0.2500 20100.0n 0.2500 20399.9n 0.2500 20400.0n 0.2500 20699.9n 0.2500 20700.0n 0.2500 20999.9n 0.2500 21000.0n 0.7500 21299.9n 0.7500 21300.0n 0.2500 21599.9n 0.2500 21600.0n 0.2500 21899.9n 0.2500 21900.0n 0.7500 22199.9n 0.7500 22200.0n 0.7500 22499.9n 0.7500 22500.0n 0.7500 22799.9n 0.7500 22800.0n 0.2500 23099.9n 0.2500 23100.0n 0.7500 23399.9n 0.7500 23400.0n 0.7500 23699.9n 0.7500 23700.0n 0.2500 23999.9n 0.2500 24000.0n 0.2500 24299.9n 0.2500 24300.0n 0.2500 24599.9n 0.2500 24600.0n 0.2500 24899.9n 0.2500 24900.0n 0.2500 25199.9n 0.2500 25200.0n 0.2500 25499.9n 0.2500 25500.0n 0.2500 25799.9n 0.2500 25800.0n 0.2500 26099.9n 0.2500 26100.0n 0.2500 26399.9n 0.2500 26400.0n 0.7500 26699.9n 0.7500 26700.0n 0.2500 26999.9n 0.2500 27000.0n 0.2500 27299.9n 0.2500 27300.0n 0.7500 27599.9n 0.7500 27600.0n 0.7500 27899.9n 0.7500 27900.0n 0.7500 28199.9n 0.7500 28200.0n 0.2500 28499.9n 0.2500 28500.0n 0.7500 28799.9n 0.7500 28800.0n 0.7500 29099.9n 0.7500 29100.0n 0.2500 29399.9n 0.2500 29400.0n 0.2500 29699.9n 0.2500 29700.0n 0.2500 29999.9n 0.2500 30000.0n 0.2500 30299.9n 0.2500 30300.0n 0.2500 30599.9n 0.2500 30600.0n 0.2500 30899.9n 0.2500 30900.0n 0.2500 31199.9n 0.2500 31200.0n 0.2500 31499.9n 0.2500 31500.0n 0.2500 31799.9n 0.2500 31800.0n 0.7500 32099.9n 0.7500 32100.0n 0.2500 32399.9n 0.2500 32400.0n 0.2500 32699.9n 0.2500 32700.0n 0.7500 32999.9n 0.7500 33000.0n 0.7500 33299.9n 0.7500 33300.0n 0.7500 33599.9n 0.7500 33600.0n 0.2500 33899.9n 0.2500 33900.0n 0.7500 34199.9n 0.7500 34200.0n 0.7500 34499.9n 0.7500 34500.0n 0.2500 34799.9n 0.2500 34800.0n 0.2500 35099.9n 0.2500 35100.0n 0.2500 35399.9n 0.2500 35400.0n 0.2500 35699.9n 0.2500 35700.0n 0.2500 35999.9n 0.2500 36000.0n 0.2500 36299.9n 0.2500 36300.0n 0.2500 36599.9n 0.2500 36600.0n 0.2500 36899.9n 0.2500 36900.0n 0.2500 37199.9n 0.2500 37200.0n 0.7500 37499.9n 0.7500 37500.0n 0.2500 37799.9n 0.2500 37800.0n 0.2500 38099.9n 0.2500 38100.0n 0.7500 38399.9n 0.7500 38400.0n 0.7500 38699.9n 0.7500 38700.0n 0.7500 38999.9n 0.7500 39000.0n 0.2500 39299.9n 0.2500 39300.0n 0.7500 39599.9n 0.7500 39600.0n 0.7500 39899.9n 0.7500 39900.0n 0.2500 40199.9n 0.2500 40200.0n 0.2500 40499.9n 0.2500 40500.0n 0.2500 40799.9n 0.2500 40800.0n 0.2500 41099.9n 0.2500 41100.0n 0.2500 41399.9n 0.2500 41400.0n 0.2500 41699.9n 0.2500 41700.0n 0.2500 41999.9n 0.2500 42000.0n 0.2500 42299.9n 0.2500 42300.0n 0.2500 42599.9n 0.2500 42600.0n 0.7500 42899.9n 0.7500 42900.0n 0.2500 43199.9n 0.2500 43200.0n 0.2500 43499.9n 0.2500 43500.0n 0.7500 43799.9n 0.7500 43800.0n 0.7500 44099.9n 0.7500 44100.0n 0.7500 44399.9n 0.7500 44400.0n 0.2500 44699.9n 0.2500 44700.0n 0.7500 44999.9n 0.7500 45000.0n 0.7500 45299.9n 0.7500 45300.0n 0.2500 45599.9n 0.2500 45600.0n 0.2500 45899.9n 0.2500 45900.0n 0.2500 46199.9n 0.2500 46200.0n 0.2500 46499.9n 0.2500 46500.0n 0.2500 46799.9n 0.2500 46800.0n 0.2500 47099.9n 0.2500 47100.0n 0.2500 47399.9n 0.2500 47400.0n 0.2500 47699.9n 0.2500 47700.0n 0.2500 47999.9n 0.2500 48000.0n 0.7500 48299.9n 0.7500 48300.0n 0.2500 48599.9n 0.2500 48600.0n 0.2500 48899.9n 0.2500 48900.0n 0.7500 49199.9n 0.7500 49200.0n 0.7500 49499.9n 0.7500 49500.0n 0.7500 49799.9n 0.7500 49800.0n 0.2500 50099.9n 0.2500 50100.0n 0.7500 50399.9n 0.7500 50400.0n 0.7500 50699.9n 0.7500 50700.0n 0.2500 50999.9n 0.2500 51000.0n 0.2500 51299.9n 0.2500 51300.0n 0.2500 51599.9n 0.2500 51600.0n 0.2500 51899.9n 0.2500 51900.0n 0.2500 52199.9n 0.2500 52200.0n 0.2500 52499.9n 0.2500 52500.0n 0.2500 52799.9n 0.2500 52800.0n 0.2500 53099.9n 0.2500 53100.0n 0.2500 53399.9n 0.2500 53400.0n 0.7500 53699.9n 0.7500 53700.0n 0.2500 53999.9n 0.2500 54000.0n 0.7500 54299.9n 0.7500 54300.0n 0.7500 54599.9n 0.7500 54600.0n 0.7500 54899.9n 0.7500 54900.0n 0.7500 55199.9n 0.7500 55200.0n 0.7500 55499.9n 0.7500 55500.0n 0.7500 55799.9n 0.7500 55800.0n 0.2500 56099.9n 0.2500 56100.0n 0.2500 56399.9n 0.2500 56400.0n 0.2500 56699.9n 0.2500 56700.0n 0.2500 56999.9n 0.2500 57000.0n 0.2500 57299.9n 0.2500 57300.0n 0.2500 57599.9n 0.2500 57600.0n 0.2500 57899.9n 0.2500 57900.0n 0.2500 58199.9n 0.2500 58200.0n 0.2500 58499.9n 0.2500 58500.0n 0.2500 58799.9n 0.2500 58800.0n 0.2500 59099.9n 0.2500 59100.0n 0.2500)
Vxon0 xon0 0 PWL(0.0n 0.7500 299.9n 0.7500 300.0n 0.2500 599.9n 0.2500 600.0n 0.2500 899.9n 0.2500 900.0n 0.2500 1199.9n 0.2500 1200.0n 0.7500 1499.9n 0.7500 1500.0n 0.2500 1799.9n 0.2500 1800.0n 0.2500 2099.9n 0.2500 2100.0n 0.7500 2399.9n 0.7500 2400.0n 0.7500 2699.9n 0.7500 2700.0n 0.7500 2999.9n 0.7500 3000.0n 0.7500 3299.9n 0.7500 3300.0n 0.7500 3599.9n 0.7500 3600.0n 0.7500 3899.9n 0.7500 3900.0n 0.7500 4199.9n 0.7500 4200.0n 0.7500 4499.9n 0.7500 4500.0n 0.7500 4799.9n 0.7500 4800.0n 0.2500 5099.9n 0.2500 5100.0n 0.7500 5399.9n 0.7500 5400.0n 0.7500 5699.9n 0.7500 5700.0n 0.2500 5999.9n 0.2500 6000.0n 0.2500 6299.9n 0.2500 6300.0n 0.2500 6599.9n 0.2500 6600.0n 0.7500 6899.9n 0.7500 6900.0n 0.2500 7199.9n 0.2500 7200.0n 0.2500 7499.9n 0.2500 7500.0n 0.7500 7799.9n 0.7500 7800.0n 0.7500 8099.9n 0.7500 8100.0n 0.7500 8399.9n 0.7500 8400.0n 0.7500 8699.9n 0.7500 8700.0n 0.7500 8999.9n 0.7500 9000.0n 0.7500 9299.9n 0.7500 9300.0n 0.7500 9599.9n 0.7500 9600.0n 0.7500 9899.9n 0.7500 9900.0n 0.7500 10199.9n 0.7500 10200.0n 0.2500 10499.9n 0.2500 10500.0n 0.7500 10799.9n 0.7500 10800.0n 0.7500 11099.9n 0.7500 11100.0n 0.2500 11399.9n 0.2500 11400.0n 0.2500 11699.9n 0.2500 11700.0n 0.2500 11999.9n 0.2500 12000.0n 0.7500 12299.9n 0.7500 12300.0n 0.2500 12599.9n 0.2500 12600.0n 0.2500 12899.9n 0.2500 12900.0n 0.7500 13199.9n 0.7500 13200.0n 0.7500 13499.9n 0.7500 13500.0n 0.7500 13799.9n 0.7500 13800.0n 0.7500 14099.9n 0.7500 14100.0n 0.7500 14399.9n 0.7500 14400.0n 0.7500 14699.9n 0.7500 14700.0n 0.7500 14999.9n 0.7500 15000.0n 0.7500 15299.9n 0.7500 15300.0n 0.7500 15599.9n 0.7500 15600.0n 0.2500 15899.9n 0.2500 15900.0n 0.7500 16199.9n 0.7500 16200.0n 0.7500 16499.9n 0.7500 16500.0n 0.2500 16799.9n 0.2500 16800.0n 0.2500 17099.9n 0.2500 17100.0n 0.2500 17399.9n 0.2500 17400.0n 0.7500 17699.9n 0.7500 17700.0n 0.2500 17999.9n 0.2500 18000.0n 0.2500 18299.9n 0.2500 18300.0n 0.7500 18599.9n 0.7500 18600.0n 0.7500 18899.9n 0.7500 18900.0n 0.7500 19199.9n 0.7500 19200.0n 0.7500 19499.9n 0.7500 19500.0n 0.7500 19799.9n 0.7500 19800.0n 0.7500 20099.9n 0.7500 20100.0n 0.7500 20399.9n 0.7500 20400.0n 0.7500 20699.9n 0.7500 20700.0n 0.7500 20999.9n 0.7500 21000.0n 0.2500 21299.9n 0.2500 21300.0n 0.7500 21599.9n 0.7500 21600.0n 0.7500 21899.9n 0.7500 21900.0n 0.2500 22199.9n 0.2500 22200.0n 0.2500 22499.9n 0.2500 22500.0n 0.2500 22799.9n 0.2500 22800.0n 0.7500 23099.9n 0.7500 23100.0n 0.2500 23399.9n 0.2500 23400.0n 0.2500 23699.9n 0.2500 23700.0n 0.7500 23999.9n 0.7500 24000.0n 0.7500 24299.9n 0.7500 24300.0n 0.7500 24599.9n 0.7500 24600.0n 0.7500 24899.9n 0.7500 24900.0n 0.7500 25199.9n 0.7500 25200.0n 0.7500 25499.9n 0.7500 25500.0n 0.7500 25799.9n 0.7500 25800.0n 0.7500 26099.9n 0.7500 26100.0n 0.7500 26399.9n 0.7500 26400.0n 0.2500 26699.9n 0.2500 26700.0n 0.7500 26999.9n 0.7500 27000.0n 0.7500 27299.9n 0.7500 27300.0n 0.2500 27599.9n 0.2500 27600.0n 0.2500 27899.9n 0.2500 27900.0n 0.2500 28199.9n 0.2500 28200.0n 0.7500 28499.9n 0.7500 28500.0n 0.2500 28799.9n 0.2500 28800.0n 0.2500 29099.9n 0.2500 29100.0n 0.7500 29399.9n 0.7500 29400.0n 0.7500 29699.9n 0.7500 29700.0n 0.7500 29999.9n 0.7500 30000.0n 0.7500 30299.9n 0.7500 30300.0n 0.7500 30599.9n 0.7500 30600.0n 0.7500 30899.9n 0.7500 30900.0n 0.7500 31199.9n 0.7500 31200.0n 0.7500 31499.9n 0.7500 31500.0n 0.7500 31799.9n 0.7500 31800.0n 0.2500 32099.9n 0.2500 32100.0n 0.7500 32399.9n 0.7500 32400.0n 0.7500 32699.9n 0.7500 32700.0n 0.2500 32999.9n 0.2500 33000.0n 0.2500 33299.9n 0.2500 33300.0n 0.2500 33599.9n 0.2500 33600.0n 0.7500 33899.9n 0.7500 33900.0n 0.2500 34199.9n 0.2500 34200.0n 0.2500 34499.9n 0.2500 34500.0n 0.7500 34799.9n 0.7500 34800.0n 0.7500 35099.9n 0.7500 35100.0n 0.7500 35399.9n 0.7500 35400.0n 0.7500 35699.9n 0.7500 35700.0n 0.7500 35999.9n 0.7500 36000.0n 0.7500 36299.9n 0.7500 36300.0n 0.7500 36599.9n 0.7500 36600.0n 0.7500 36899.9n 0.7500 36900.0n 0.7500 37199.9n 0.7500 37200.0n 0.2500 37499.9n 0.2500 37500.0n 0.7500 37799.9n 0.7500 37800.0n 0.7500 38099.9n 0.7500 38100.0n 0.2500 38399.9n 0.2500 38400.0n 0.2500 38699.9n 0.2500 38700.0n 0.2500 38999.9n 0.2500 39000.0n 0.7500 39299.9n 0.7500 39300.0n 0.2500 39599.9n 0.2500 39600.0n 0.2500 39899.9n 0.2500 39900.0n 0.7500 40199.9n 0.7500 40200.0n 0.7500 40499.9n 0.7500 40500.0n 0.7500 40799.9n 0.7500 40800.0n 0.7500 41099.9n 0.7500 41100.0n 0.7500 41399.9n 0.7500 41400.0n 0.7500 41699.9n 0.7500 41700.0n 0.7500 41999.9n 0.7500 42000.0n 0.7500 42299.9n 0.7500 42300.0n 0.7500 42599.9n 0.7500 42600.0n 0.2500 42899.9n 0.2500 42900.0n 0.7500 43199.9n 0.7500 43200.0n 0.7500 43499.9n 0.7500 43500.0n 0.2500 43799.9n 0.2500 43800.0n 0.2500 44099.9n 0.2500 44100.0n 0.2500 44399.9n 0.2500 44400.0n 0.7500 44699.9n 0.7500 44700.0n 0.2500 44999.9n 0.2500 45000.0n 0.2500 45299.9n 0.2500 45300.0n 0.7500 45599.9n 0.7500 45600.0n 0.7500 45899.9n 0.7500 45900.0n 0.7500 46199.9n 0.7500 46200.0n 0.7500 46499.9n 0.7500 46500.0n 0.7500 46799.9n 0.7500 46800.0n 0.7500 47099.9n 0.7500 47100.0n 0.7500 47399.9n 0.7500 47400.0n 0.7500 47699.9n 0.7500 47700.0n 0.7500 47999.9n 0.7500 48000.0n 0.2500 48299.9n 0.2500 48300.0n 0.7500 48599.9n 0.7500 48600.0n 0.7500 48899.9n 0.7500 48900.0n 0.2500 49199.9n 0.2500 49200.0n 0.2500 49499.9n 0.2500 49500.0n 0.2500 49799.9n 0.2500 49800.0n 0.7500 50099.9n 0.7500 50100.0n 0.2500 50399.9n 0.2500 50400.0n 0.2500 50699.9n 0.2500 50700.0n 0.7500 50999.9n 0.7500 51000.0n 0.7500 51299.9n 0.7500 51300.0n 0.7500 51599.9n 0.7500 51600.0n 0.7500 51899.9n 0.7500 51900.0n 0.7500 52199.9n 0.7500 52200.0n 0.7500 52499.9n 0.7500 52500.0n 0.7500 52799.9n 0.7500 52800.0n 0.7500 53099.9n 0.7500 53100.0n 0.7500 53399.9n 0.7500 53400.0n 0.2500 53699.9n 0.2500 53700.0n 0.7500 53999.9n 0.7500 54000.0n 0.2500 54299.9n 0.2500 54300.0n 0.2500 54599.9n 0.2500 54600.0n 0.2500 54899.9n 0.2500 54900.0n 0.2500 55199.9n 0.2500 55200.0n 0.2500 55499.9n 0.2500 55500.0n 0.2500 55799.9n 0.2500 55800.0n 0.7500 56099.9n 0.7500 56100.0n 0.7500 56399.9n 0.7500 56400.0n 0.7500 56699.9n 0.7500 56700.0n 0.7500 56999.9n 0.7500 57000.0n 0.7500 57299.9n 0.7500 57300.0n 0.7500 57599.9n 0.7500 57600.0n 0.7500 57899.9n 0.7500 57900.0n 0.7500 58199.9n 0.7500 58200.0n 0.7500 58499.9n 0.7500 58500.0n 0.7500 58799.9n 0.7500 58800.0n 0.7500 59099.9n 0.7500 59100.0n 0.7500)
Vxop1 xop1 0 PWL(0.0n 0.7500 299.9n 0.7500 300.0n 0.2500 599.9n 0.2500 600.0n 0.2500 899.9n 0.2500 900.0n 0.2500 1199.9n 0.2500 1200.0n 0.7500 1499.9n 0.7500 1500.0n 0.2500 1799.9n 0.2500 1800.0n 0.2500 2099.9n 0.2500 2100.0n 0.7500 2399.9n 0.7500 2400.0n 0.2500 2699.9n 0.2500 2700.0n 0.2500 2999.9n 0.2500 3000.0n 0.2500 3299.9n 0.2500 3300.0n 0.2500 3599.9n 0.2500 3600.0n 0.7500 3899.9n 0.7500 3900.0n 0.7500 4199.9n 0.7500 4200.0n 0.2500 4499.9n 0.2500 4500.0n 0.2500 4799.9n 0.2500 4800.0n 0.2500 5099.9n 0.2500 5100.0n 0.7500 5399.9n 0.7500 5400.0n 0.7500 5699.9n 0.7500 5700.0n 0.2500 5999.9n 0.2500 6000.0n 0.2500 6299.9n 0.2500 6300.0n 0.2500 6599.9n 0.2500 6600.0n 0.7500 6899.9n 0.7500 6900.0n 0.2500 7199.9n 0.2500 7200.0n 0.2500 7499.9n 0.2500 7500.0n 0.7500 7799.9n 0.7500 7800.0n 0.2500 8099.9n 0.2500 8100.0n 0.2500 8399.9n 0.2500 8400.0n 0.2500 8699.9n 0.2500 8700.0n 0.2500 8999.9n 0.2500 9000.0n 0.7500 9299.9n 0.7500 9300.0n 0.7500 9599.9n 0.7500 9600.0n 0.2500 9899.9n 0.2500 9900.0n 0.2500 10199.9n 0.2500 10200.0n 0.2500 10499.9n 0.2500 10500.0n 0.7500 10799.9n 0.7500 10800.0n 0.7500 11099.9n 0.7500 11100.0n 0.2500 11399.9n 0.2500 11400.0n 0.2500 11699.9n 0.2500 11700.0n 0.2500 11999.9n 0.2500 12000.0n 0.7500 12299.9n 0.7500 12300.0n 0.2500 12599.9n 0.2500 12600.0n 0.2500 12899.9n 0.2500 12900.0n 0.7500 13199.9n 0.7500 13200.0n 0.2500 13499.9n 0.2500 13500.0n 0.2500 13799.9n 0.2500 13800.0n 0.2500 14099.9n 0.2500 14100.0n 0.2500 14399.9n 0.2500 14400.0n 0.7500 14699.9n 0.7500 14700.0n 0.7500 14999.9n 0.7500 15000.0n 0.2500 15299.9n 0.2500 15300.0n 0.2500 15599.9n 0.2500 15600.0n 0.2500 15899.9n 0.2500 15900.0n 0.7500 16199.9n 0.7500 16200.0n 0.7500 16499.9n 0.7500 16500.0n 0.2500 16799.9n 0.2500 16800.0n 0.2500 17099.9n 0.2500 17100.0n 0.2500 17399.9n 0.2500 17400.0n 0.7500 17699.9n 0.7500 17700.0n 0.2500 17999.9n 0.2500 18000.0n 0.2500 18299.9n 0.2500 18300.0n 0.7500 18599.9n 0.7500 18600.0n 0.2500 18899.9n 0.2500 18900.0n 0.2500 19199.9n 0.2500 19200.0n 0.2500 19499.9n 0.2500 19500.0n 0.2500 19799.9n 0.2500 19800.0n 0.7500 20099.9n 0.7500 20100.0n 0.7500 20399.9n 0.7500 20400.0n 0.2500 20699.9n 0.2500 20700.0n 0.2500 20999.9n 0.2500 21000.0n 0.2500 21299.9n 0.2500 21300.0n 0.7500 21599.9n 0.7500 21600.0n 0.7500 21899.9n 0.7500 21900.0n 0.2500 22199.9n 0.2500 22200.0n 0.2500 22499.9n 0.2500 22500.0n 0.2500 22799.9n 0.2500 22800.0n 0.7500 23099.9n 0.7500 23100.0n 0.2500 23399.9n 0.2500 23400.0n 0.2500 23699.9n 0.2500 23700.0n 0.7500 23999.9n 0.7500 24000.0n 0.2500 24299.9n 0.2500 24300.0n 0.2500 24599.9n 0.2500 24600.0n 0.2500 24899.9n 0.2500 24900.0n 0.2500 25199.9n 0.2500 25200.0n 0.7500 25499.9n 0.7500 25500.0n 0.7500 25799.9n 0.7500 25800.0n 0.2500 26099.9n 0.2500 26100.0n 0.2500 26399.9n 0.2500 26400.0n 0.2500 26699.9n 0.2500 26700.0n 0.7500 26999.9n 0.7500 27000.0n 0.7500 27299.9n 0.7500 27300.0n 0.2500 27599.9n 0.2500 27600.0n 0.2500 27899.9n 0.2500 27900.0n 0.2500 28199.9n 0.2500 28200.0n 0.7500 28499.9n 0.7500 28500.0n 0.2500 28799.9n 0.2500 28800.0n 0.2500 29099.9n 0.2500 29100.0n 0.7500 29399.9n 0.7500 29400.0n 0.2500 29699.9n 0.2500 29700.0n 0.2500 29999.9n 0.2500 30000.0n 0.2500 30299.9n 0.2500 30300.0n 0.2500 30599.9n 0.2500 30600.0n 0.7500 30899.9n 0.7500 30900.0n 0.7500 31199.9n 0.7500 31200.0n 0.2500 31499.9n 0.2500 31500.0n 0.2500 31799.9n 0.2500 31800.0n 0.2500 32099.9n 0.2500 32100.0n 0.7500 32399.9n 0.7500 32400.0n 0.7500 32699.9n 0.7500 32700.0n 0.2500 32999.9n 0.2500 33000.0n 0.2500 33299.9n 0.2500 33300.0n 0.2500 33599.9n 0.2500 33600.0n 0.7500 33899.9n 0.7500 33900.0n 0.2500 34199.9n 0.2500 34200.0n 0.2500 34499.9n 0.2500 34500.0n 0.7500 34799.9n 0.7500 34800.0n 0.2500 35099.9n 0.2500 35100.0n 0.2500 35399.9n 0.2500 35400.0n 0.2500 35699.9n 0.2500 35700.0n 0.2500 35999.9n 0.2500 36000.0n 0.7500 36299.9n 0.7500 36300.0n 0.7500 36599.9n 0.7500 36600.0n 0.2500 36899.9n 0.2500 36900.0n 0.2500 37199.9n 0.2500 37200.0n 0.2500 37499.9n 0.2500 37500.0n 0.7500 37799.9n 0.7500 37800.0n 0.7500 38099.9n 0.7500 38100.0n 0.2500 38399.9n 0.2500 38400.0n 0.2500 38699.9n 0.2500 38700.0n 0.2500 38999.9n 0.2500 39000.0n 0.7500 39299.9n 0.7500 39300.0n 0.2500 39599.9n 0.2500 39600.0n 0.2500 39899.9n 0.2500 39900.0n 0.7500 40199.9n 0.7500 40200.0n 0.2500 40499.9n 0.2500 40500.0n 0.2500 40799.9n 0.2500 40800.0n 0.2500 41099.9n 0.2500 41100.0n 0.2500 41399.9n 0.2500 41400.0n 0.7500 41699.9n 0.7500 41700.0n 0.7500 41999.9n 0.7500 42000.0n 0.2500 42299.9n 0.2500 42300.0n 0.2500 42599.9n 0.2500 42600.0n 0.2500 42899.9n 0.2500 42900.0n 0.7500 43199.9n 0.7500 43200.0n 0.7500 43499.9n 0.7500 43500.0n 0.2500 43799.9n 0.2500 43800.0n 0.2500 44099.9n 0.2500 44100.0n 0.2500 44399.9n 0.2500 44400.0n 0.7500 44699.9n 0.7500 44700.0n 0.2500 44999.9n 0.2500 45000.0n 0.2500 45299.9n 0.2500 45300.0n 0.7500 45599.9n 0.7500 45600.0n 0.2500 45899.9n 0.2500 45900.0n 0.2500 46199.9n 0.2500 46200.0n 0.2500 46499.9n 0.2500 46500.0n 0.2500 46799.9n 0.2500 46800.0n 0.7500 47099.9n 0.7500 47100.0n 0.7500 47399.9n 0.7500 47400.0n 0.2500 47699.9n 0.2500 47700.0n 0.2500 47999.9n 0.2500 48000.0n 0.2500 48299.9n 0.2500 48300.0n 0.7500 48599.9n 0.7500 48600.0n 0.7500 48899.9n 0.7500 48900.0n 0.2500 49199.9n 0.2500 49200.0n 0.2500 49499.9n 0.2500 49500.0n 0.2500 49799.9n 0.2500 49800.0n 0.7500 50099.9n 0.7500 50100.0n 0.2500 50399.9n 0.2500 50400.0n 0.2500 50699.9n 0.2500 50700.0n 0.7500 50999.9n 0.7500 51000.0n 0.2500 51299.9n 0.2500 51300.0n 0.2500 51599.9n 0.2500 51600.0n 0.2500 51899.9n 0.2500 51900.0n 0.2500 52199.9n 0.2500 52200.0n 0.7500 52499.9n 0.7500 52500.0n 0.7500 52799.9n 0.7500 52800.0n 0.2500 53099.9n 0.2500 53100.0n 0.2500 53399.9n 0.2500 53400.0n 0.2500 53699.9n 0.2500 53700.0n 0.7500 53999.9n 0.7500 54000.0n 0.2500 54299.9n 0.2500 54300.0n 0.2500 54599.9n 0.2500 54600.0n 0.2500 54899.9n 0.2500 54900.0n 0.2500 55199.9n 0.2500 55200.0n 0.2500 55499.9n 0.2500 55500.0n 0.2500 55799.9n 0.2500 55800.0n 0.7500 56099.9n 0.7500 56100.0n 0.7500 56399.9n 0.7500 56400.0n 0.7500 56699.9n 0.7500 56700.0n 0.7500 56999.9n 0.7500 57000.0n 0.7500 57299.9n 0.7500 57300.0n 0.7500 57599.9n 0.7500 57600.0n 0.2500 57899.9n 0.2500 57900.0n 0.2500 58199.9n 0.2500 58200.0n 0.2500 58499.9n 0.2500 58500.0n 0.2500 58799.9n 0.2500 58800.0n 0.2500 59099.9n 0.2500 59100.0n 0.2500)
Vxon1 xon1 0 PWL(0.0n 0.2500 299.9n 0.2500 300.0n 0.7500 599.9n 0.7500 600.0n 0.7500 899.9n 0.7500 900.0n 0.7500 1199.9n 0.7500 1200.0n 0.2500 1499.9n 0.2500 1500.0n 0.7500 1799.9n 0.7500 1800.0n 0.7500 2099.9n 0.7500 2100.0n 0.2500 2399.9n 0.2500 2400.0n 0.7500 2699.9n 0.7500 2700.0n 0.7500 2999.9n 0.7500 3000.0n 0.7500 3299.9n 0.7500 3300.0n 0.7500 3599.9n 0.7500 3600.0n 0.2500 3899.9n 0.2500 3900.0n 0.2500 4199.9n 0.2500 4200.0n 0.7500 4499.9n 0.7500 4500.0n 0.7500 4799.9n 0.7500 4800.0n 0.7500 5099.9n 0.7500 5100.0n 0.2500 5399.9n 0.2500 5400.0n 0.2500 5699.9n 0.2500 5700.0n 0.7500 5999.9n 0.7500 6000.0n 0.7500 6299.9n 0.7500 6300.0n 0.7500 6599.9n 0.7500 6600.0n 0.2500 6899.9n 0.2500 6900.0n 0.7500 7199.9n 0.7500 7200.0n 0.7500 7499.9n 0.7500 7500.0n 0.2500 7799.9n 0.2500 7800.0n 0.7500 8099.9n 0.7500 8100.0n 0.7500 8399.9n 0.7500 8400.0n 0.7500 8699.9n 0.7500 8700.0n 0.7500 8999.9n 0.7500 9000.0n 0.2500 9299.9n 0.2500 9300.0n 0.2500 9599.9n 0.2500 9600.0n 0.7500 9899.9n 0.7500 9900.0n 0.7500 10199.9n 0.7500 10200.0n 0.7500 10499.9n 0.7500 10500.0n 0.2500 10799.9n 0.2500 10800.0n 0.2500 11099.9n 0.2500 11100.0n 0.7500 11399.9n 0.7500 11400.0n 0.7500 11699.9n 0.7500 11700.0n 0.7500 11999.9n 0.7500 12000.0n 0.2500 12299.9n 0.2500 12300.0n 0.7500 12599.9n 0.7500 12600.0n 0.7500 12899.9n 0.7500 12900.0n 0.2500 13199.9n 0.2500 13200.0n 0.7500 13499.9n 0.7500 13500.0n 0.7500 13799.9n 0.7500 13800.0n 0.7500 14099.9n 0.7500 14100.0n 0.7500 14399.9n 0.7500 14400.0n 0.2500 14699.9n 0.2500 14700.0n 0.2500 14999.9n 0.2500 15000.0n 0.7500 15299.9n 0.7500 15300.0n 0.7500 15599.9n 0.7500 15600.0n 0.7500 15899.9n 0.7500 15900.0n 0.2500 16199.9n 0.2500 16200.0n 0.2500 16499.9n 0.2500 16500.0n 0.7500 16799.9n 0.7500 16800.0n 0.7500 17099.9n 0.7500 17100.0n 0.7500 17399.9n 0.7500 17400.0n 0.2500 17699.9n 0.2500 17700.0n 0.7500 17999.9n 0.7500 18000.0n 0.7500 18299.9n 0.7500 18300.0n 0.2500 18599.9n 0.2500 18600.0n 0.7500 18899.9n 0.7500 18900.0n 0.7500 19199.9n 0.7500 19200.0n 0.7500 19499.9n 0.7500 19500.0n 0.7500 19799.9n 0.7500 19800.0n 0.2500 20099.9n 0.2500 20100.0n 0.2500 20399.9n 0.2500 20400.0n 0.7500 20699.9n 0.7500 20700.0n 0.7500 20999.9n 0.7500 21000.0n 0.7500 21299.9n 0.7500 21300.0n 0.2500 21599.9n 0.2500 21600.0n 0.2500 21899.9n 0.2500 21900.0n 0.7500 22199.9n 0.7500 22200.0n 0.7500 22499.9n 0.7500 22500.0n 0.7500 22799.9n 0.7500 22800.0n 0.2500 23099.9n 0.2500 23100.0n 0.7500 23399.9n 0.7500 23400.0n 0.7500 23699.9n 0.7500 23700.0n 0.2500 23999.9n 0.2500 24000.0n 0.7500 24299.9n 0.7500 24300.0n 0.7500 24599.9n 0.7500 24600.0n 0.7500 24899.9n 0.7500 24900.0n 0.7500 25199.9n 0.7500 25200.0n 0.2500 25499.9n 0.2500 25500.0n 0.2500 25799.9n 0.2500 25800.0n 0.7500 26099.9n 0.7500 26100.0n 0.7500 26399.9n 0.7500 26400.0n 0.7500 26699.9n 0.7500 26700.0n 0.2500 26999.9n 0.2500 27000.0n 0.2500 27299.9n 0.2500 27300.0n 0.7500 27599.9n 0.7500 27600.0n 0.7500 27899.9n 0.7500 27900.0n 0.7500 28199.9n 0.7500 28200.0n 0.2500 28499.9n 0.2500 28500.0n 0.7500 28799.9n 0.7500 28800.0n 0.7500 29099.9n 0.7500 29100.0n 0.2500 29399.9n 0.2500 29400.0n 0.7500 29699.9n 0.7500 29700.0n 0.7500 29999.9n 0.7500 30000.0n 0.7500 30299.9n 0.7500 30300.0n 0.7500 30599.9n 0.7500 30600.0n 0.2500 30899.9n 0.2500 30900.0n 0.2500 31199.9n 0.2500 31200.0n 0.7500 31499.9n 0.7500 31500.0n 0.7500 31799.9n 0.7500 31800.0n 0.7500 32099.9n 0.7500 32100.0n 0.2500 32399.9n 0.2500 32400.0n 0.2500 32699.9n 0.2500 32700.0n 0.7500 32999.9n 0.7500 33000.0n 0.7500 33299.9n 0.7500 33300.0n 0.7500 33599.9n 0.7500 33600.0n 0.2500 33899.9n 0.2500 33900.0n 0.7500 34199.9n 0.7500 34200.0n 0.7500 34499.9n 0.7500 34500.0n 0.2500 34799.9n 0.2500 34800.0n 0.7500 35099.9n 0.7500 35100.0n 0.7500 35399.9n 0.7500 35400.0n 0.7500 35699.9n 0.7500 35700.0n 0.7500 35999.9n 0.7500 36000.0n 0.2500 36299.9n 0.2500 36300.0n 0.2500 36599.9n 0.2500 36600.0n 0.7500 36899.9n 0.7500 36900.0n 0.7500 37199.9n 0.7500 37200.0n 0.7500 37499.9n 0.7500 37500.0n 0.2500 37799.9n 0.2500 37800.0n 0.2500 38099.9n 0.2500 38100.0n 0.7500 38399.9n 0.7500 38400.0n 0.7500 38699.9n 0.7500 38700.0n 0.7500 38999.9n 0.7500 39000.0n 0.2500 39299.9n 0.2500 39300.0n 0.7500 39599.9n 0.7500 39600.0n 0.7500 39899.9n 0.7500 39900.0n 0.2500 40199.9n 0.2500 40200.0n 0.7500 40499.9n 0.7500 40500.0n 0.7500 40799.9n 0.7500 40800.0n 0.7500 41099.9n 0.7500 41100.0n 0.7500 41399.9n 0.7500 41400.0n 0.2500 41699.9n 0.2500 41700.0n 0.2500 41999.9n 0.2500 42000.0n 0.7500 42299.9n 0.7500 42300.0n 0.7500 42599.9n 0.7500 42600.0n 0.7500 42899.9n 0.7500 42900.0n 0.2500 43199.9n 0.2500 43200.0n 0.2500 43499.9n 0.2500 43500.0n 0.7500 43799.9n 0.7500 43800.0n 0.7500 44099.9n 0.7500 44100.0n 0.7500 44399.9n 0.7500 44400.0n 0.2500 44699.9n 0.2500 44700.0n 0.7500 44999.9n 0.7500 45000.0n 0.7500 45299.9n 0.7500 45300.0n 0.2500 45599.9n 0.2500 45600.0n 0.7500 45899.9n 0.7500 45900.0n 0.7500 46199.9n 0.7500 46200.0n 0.7500 46499.9n 0.7500 46500.0n 0.7500 46799.9n 0.7500 46800.0n 0.2500 47099.9n 0.2500 47100.0n 0.2500 47399.9n 0.2500 47400.0n 0.7500 47699.9n 0.7500 47700.0n 0.7500 47999.9n 0.7500 48000.0n 0.7500 48299.9n 0.7500 48300.0n 0.2500 48599.9n 0.2500 48600.0n 0.2500 48899.9n 0.2500 48900.0n 0.7500 49199.9n 0.7500 49200.0n 0.7500 49499.9n 0.7500 49500.0n 0.7500 49799.9n 0.7500 49800.0n 0.2500 50099.9n 0.2500 50100.0n 0.7500 50399.9n 0.7500 50400.0n 0.7500 50699.9n 0.7500 50700.0n 0.2500 50999.9n 0.2500 51000.0n 0.7500 51299.9n 0.7500 51300.0n 0.7500 51599.9n 0.7500 51600.0n 0.7500 51899.9n 0.7500 51900.0n 0.7500 52199.9n 0.7500 52200.0n 0.2500 52499.9n 0.2500 52500.0n 0.2500 52799.9n 0.2500 52800.0n 0.7500 53099.9n 0.7500 53100.0n 0.7500 53399.9n 0.7500 53400.0n 0.7500 53699.9n 0.7500 53700.0n 0.2500 53999.9n 0.2500 54000.0n 0.7500 54299.9n 0.7500 54300.0n 0.7500 54599.9n 0.7500 54600.0n 0.7500 54899.9n 0.7500 54900.0n 0.7500 55199.9n 0.7500 55200.0n 0.7500 55499.9n 0.7500 55500.0n 0.7500 55799.9n 0.7500 55800.0n 0.2500 56099.9n 0.2500 56100.0n 0.2500 56399.9n 0.2500 56400.0n 0.2500 56699.9n 0.2500 56700.0n 0.2500 56999.9n 0.2500 57000.0n 0.2500 57299.9n 0.2500 57300.0n 0.2500 57599.9n 0.2500 57600.0n 0.7500 57899.9n 0.7500 57900.0n 0.7500 58199.9n 0.7500 58200.0n 0.7500 58499.9n 0.7500 58500.0n 0.7500 58799.9n 0.7500 58800.0n 0.7500 59099.9n 0.7500 59100.0n 0.7500)
Vxop2 xop2 0 PWL(0.0n 0.2500 299.9n 0.2500 300.0n 0.2500 599.9n 0.2500 600.0n 0.2500 899.9n 0.2500 900.0n 0.2500 1199.9n 0.2500 1200.0n 0.2500 1499.9n 0.2500 1500.0n 0.2500 1799.9n 0.2500 1800.0n 0.2500 2099.9n 0.2500 2100.0n 0.2500 2399.9n 0.2500 2400.0n 0.7500 2699.9n 0.7500 2700.0n 0.7500 2999.9n 0.7500 3000.0n 0.7500 3299.9n 0.7500 3300.0n 0.7500 3599.9n 0.7500 3600.0n 0.2500 3899.9n 0.2500 3900.0n 0.2500 4199.9n 0.2500 4200.0n 0.7500 4499.9n 0.7500 4500.0n 0.7500 4799.9n 0.7500 4800.0n 0.2500 5099.9n 0.2500 5100.0n 0.2500 5399.9n 0.2500 5400.0n 0.2500 5699.9n 0.2500 5700.0n 0.2500 5999.9n 0.2500 6000.0n 0.2500 6299.9n 0.2500 6300.0n 0.2500 6599.9n 0.2500 6600.0n 0.2500 6899.9n 0.2500 6900.0n 0.2500 7199.9n 0.2500 7200.0n 0.2500 7499.9n 0.2500 7500.0n 0.2500 7799.9n 0.2500 7800.0n 0.7500 8099.9n 0.7500 8100.0n 0.7500 8399.9n 0.7500 8400.0n 0.7500 8699.9n 0.7500 8700.0n 0.7500 8999.9n 0.7500 9000.0n 0.2500 9299.9n 0.2500 9300.0n 0.2500 9599.9n 0.2500 9600.0n 0.7500 9899.9n 0.7500 9900.0n 0.7500 10199.9n 0.7500 10200.0n 0.2500 10499.9n 0.2500 10500.0n 0.2500 10799.9n 0.2500 10800.0n 0.2500 11099.9n 0.2500 11100.0n 0.2500 11399.9n 0.2500 11400.0n 0.2500 11699.9n 0.2500 11700.0n 0.2500 11999.9n 0.2500 12000.0n 0.2500 12299.9n 0.2500 12300.0n 0.2500 12599.9n 0.2500 12600.0n 0.2500 12899.9n 0.2500 12900.0n 0.2500 13199.9n 0.2500 13200.0n 0.7500 13499.9n 0.7500 13500.0n 0.7500 13799.9n 0.7500 13800.0n 0.7500 14099.9n 0.7500 14100.0n 0.7500 14399.9n 0.7500 14400.0n 0.2500 14699.9n 0.2500 14700.0n 0.2500 14999.9n 0.2500 15000.0n 0.7500 15299.9n 0.7500 15300.0n 0.7500 15599.9n 0.7500 15600.0n 0.2500 15899.9n 0.2500 15900.0n 0.2500 16199.9n 0.2500 16200.0n 0.2500 16499.9n 0.2500 16500.0n 0.2500 16799.9n 0.2500 16800.0n 0.2500 17099.9n 0.2500 17100.0n 0.2500 17399.9n 0.2500 17400.0n 0.2500 17699.9n 0.2500 17700.0n 0.2500 17999.9n 0.2500 18000.0n 0.2500 18299.9n 0.2500 18300.0n 0.2500 18599.9n 0.2500 18600.0n 0.7500 18899.9n 0.7500 18900.0n 0.7500 19199.9n 0.7500 19200.0n 0.7500 19499.9n 0.7500 19500.0n 0.7500 19799.9n 0.7500 19800.0n 0.2500 20099.9n 0.2500 20100.0n 0.2500 20399.9n 0.2500 20400.0n 0.7500 20699.9n 0.7500 20700.0n 0.7500 20999.9n 0.7500 21000.0n 0.2500 21299.9n 0.2500 21300.0n 0.2500 21599.9n 0.2500 21600.0n 0.2500 21899.9n 0.2500 21900.0n 0.2500 22199.9n 0.2500 22200.0n 0.2500 22499.9n 0.2500 22500.0n 0.2500 22799.9n 0.2500 22800.0n 0.2500 23099.9n 0.2500 23100.0n 0.2500 23399.9n 0.2500 23400.0n 0.2500 23699.9n 0.2500 23700.0n 0.2500 23999.9n 0.2500 24000.0n 0.7500 24299.9n 0.7500 24300.0n 0.7500 24599.9n 0.7500 24600.0n 0.7500 24899.9n 0.7500 24900.0n 0.7500 25199.9n 0.7500 25200.0n 0.2500 25499.9n 0.2500 25500.0n 0.2500 25799.9n 0.2500 25800.0n 0.7500 26099.9n 0.7500 26100.0n 0.7500 26399.9n 0.7500 26400.0n 0.2500 26699.9n 0.2500 26700.0n 0.2500 26999.9n 0.2500 27000.0n 0.2500 27299.9n 0.2500 27300.0n 0.2500 27599.9n 0.2500 27600.0n 0.2500 27899.9n 0.2500 27900.0n 0.2500 28199.9n 0.2500 28200.0n 0.2500 28499.9n 0.2500 28500.0n 0.2500 28799.9n 0.2500 28800.0n 0.2500 29099.9n 0.2500 29100.0n 0.2500 29399.9n 0.2500 29400.0n 0.7500 29699.9n 0.7500 29700.0n 0.7500 29999.9n 0.7500 30000.0n 0.7500 30299.9n 0.7500 30300.0n 0.7500 30599.9n 0.7500 30600.0n 0.2500 30899.9n 0.2500 30900.0n 0.2500 31199.9n 0.2500 31200.0n 0.7500 31499.9n 0.7500 31500.0n 0.7500 31799.9n 0.7500 31800.0n 0.2500 32099.9n 0.2500 32100.0n 0.2500 32399.9n 0.2500 32400.0n 0.2500 32699.9n 0.2500 32700.0n 0.2500 32999.9n 0.2500 33000.0n 0.2500 33299.9n 0.2500 33300.0n 0.2500 33599.9n 0.2500 33600.0n 0.2500 33899.9n 0.2500 33900.0n 0.2500 34199.9n 0.2500 34200.0n 0.2500 34499.9n 0.2500 34500.0n 0.2500 34799.9n 0.2500 34800.0n 0.7500 35099.9n 0.7500 35100.0n 0.7500 35399.9n 0.7500 35400.0n 0.7500 35699.9n 0.7500 35700.0n 0.7500 35999.9n 0.7500 36000.0n 0.2500 36299.9n 0.2500 36300.0n 0.2500 36599.9n 0.2500 36600.0n 0.7500 36899.9n 0.7500 36900.0n 0.7500 37199.9n 0.7500 37200.0n 0.2500 37499.9n 0.2500 37500.0n 0.2500 37799.9n 0.2500 37800.0n 0.2500 38099.9n 0.2500 38100.0n 0.2500 38399.9n 0.2500 38400.0n 0.2500 38699.9n 0.2500 38700.0n 0.2500 38999.9n 0.2500 39000.0n 0.2500 39299.9n 0.2500 39300.0n 0.2500 39599.9n 0.2500 39600.0n 0.2500 39899.9n 0.2500 39900.0n 0.2500 40199.9n 0.2500 40200.0n 0.7500 40499.9n 0.7500 40500.0n 0.7500 40799.9n 0.7500 40800.0n 0.7500 41099.9n 0.7500 41100.0n 0.7500 41399.9n 0.7500 41400.0n 0.2500 41699.9n 0.2500 41700.0n 0.2500 41999.9n 0.2500 42000.0n 0.7500 42299.9n 0.7500 42300.0n 0.7500 42599.9n 0.7500 42600.0n 0.2500 42899.9n 0.2500 42900.0n 0.2500 43199.9n 0.2500 43200.0n 0.2500 43499.9n 0.2500 43500.0n 0.2500 43799.9n 0.2500 43800.0n 0.2500 44099.9n 0.2500 44100.0n 0.2500 44399.9n 0.2500 44400.0n 0.2500 44699.9n 0.2500 44700.0n 0.2500 44999.9n 0.2500 45000.0n 0.2500 45299.9n 0.2500 45300.0n 0.2500 45599.9n 0.2500 45600.0n 0.7500 45899.9n 0.7500 45900.0n 0.7500 46199.9n 0.7500 46200.0n 0.7500 46499.9n 0.7500 46500.0n 0.7500 46799.9n 0.7500 46800.0n 0.2500 47099.9n 0.2500 47100.0n 0.2500 47399.9n 0.2500 47400.0n 0.7500 47699.9n 0.7500 47700.0n 0.7500 47999.9n 0.7500 48000.0n 0.2500 48299.9n 0.2500 48300.0n 0.2500 48599.9n 0.2500 48600.0n 0.2500 48899.9n 0.2500 48900.0n 0.2500 49199.9n 0.2500 49200.0n 0.2500 49499.9n 0.2500 49500.0n 0.2500 49799.9n 0.2500 49800.0n 0.2500 50099.9n 0.2500 50100.0n 0.2500 50399.9n 0.2500 50400.0n 0.2500 50699.9n 0.2500 50700.0n 0.2500 50999.9n 0.2500 51000.0n 0.7500 51299.9n 0.7500 51300.0n 0.7500 51599.9n 0.7500 51600.0n 0.7500 51899.9n 0.7500 51900.0n 0.7500 52199.9n 0.7500 52200.0n 0.2500 52499.9n 0.2500 52500.0n 0.2500 52799.9n 0.2500 52800.0n 0.7500 53099.9n 0.7500 53100.0n 0.7500 53399.9n 0.7500 53400.0n 0.2500 53699.9n 0.2500 53700.0n 0.2500 53999.9n 0.2500 54000.0n 0.2500 54299.9n 0.2500 54300.0n 0.2500 54599.9n 0.2500 54600.0n 0.2500 54899.9n 0.2500 54900.0n 0.2500 55199.9n 0.2500 55200.0n 0.2500 55499.9n 0.2500 55500.0n 0.2500 55799.9n 0.2500 55800.0n 0.2500 56099.9n 0.2500 56100.0n 0.2500 56399.9n 0.2500 56400.0n 0.2500 56699.9n 0.2500 56700.0n 0.2500 56999.9n 0.2500 57000.0n 0.2500 57299.9n 0.2500 57300.0n 0.2500 57599.9n 0.2500 57600.0n 0.7500 57899.9n 0.7500 57900.0n 0.7500 58199.9n 0.7500 58200.0n 0.7500 58499.9n 0.7500 58500.0n 0.7500 58799.9n 0.7500 58800.0n 0.7500 59099.9n 0.7500 59100.0n 0.7500)
Vxon2 xon2 0 PWL(0.0n 0.7500 299.9n 0.7500 300.0n 0.7500 599.9n 0.7500 600.0n 0.7500 899.9n 0.7500 900.0n 0.7500 1199.9n 0.7500 1200.0n 0.7500 1499.9n 0.7500 1500.0n 0.7500 1799.9n 0.7500 1800.0n 0.7500 2099.9n 0.7500 2100.0n 0.7500 2399.9n 0.7500 2400.0n 0.2500 2699.9n 0.2500 2700.0n 0.2500 2999.9n 0.2500 3000.0n 0.2500 3299.9n 0.2500 3300.0n 0.2500 3599.9n 0.2500 3600.0n 0.7500 3899.9n 0.7500 3900.0n 0.7500 4199.9n 0.7500 4200.0n 0.2500 4499.9n 0.2500 4500.0n 0.2500 4799.9n 0.2500 4800.0n 0.7500 5099.9n 0.7500 5100.0n 0.7500 5399.9n 0.7500 5400.0n 0.7500 5699.9n 0.7500 5700.0n 0.7500 5999.9n 0.7500 6000.0n 0.7500 6299.9n 0.7500 6300.0n 0.7500 6599.9n 0.7500 6600.0n 0.7500 6899.9n 0.7500 6900.0n 0.7500 7199.9n 0.7500 7200.0n 0.7500 7499.9n 0.7500 7500.0n 0.7500 7799.9n 0.7500 7800.0n 0.2500 8099.9n 0.2500 8100.0n 0.2500 8399.9n 0.2500 8400.0n 0.2500 8699.9n 0.2500 8700.0n 0.2500 8999.9n 0.2500 9000.0n 0.7500 9299.9n 0.7500 9300.0n 0.7500 9599.9n 0.7500 9600.0n 0.2500 9899.9n 0.2500 9900.0n 0.2500 10199.9n 0.2500 10200.0n 0.7500 10499.9n 0.7500 10500.0n 0.7500 10799.9n 0.7500 10800.0n 0.7500 11099.9n 0.7500 11100.0n 0.7500 11399.9n 0.7500 11400.0n 0.7500 11699.9n 0.7500 11700.0n 0.7500 11999.9n 0.7500 12000.0n 0.7500 12299.9n 0.7500 12300.0n 0.7500 12599.9n 0.7500 12600.0n 0.7500 12899.9n 0.7500 12900.0n 0.7500 13199.9n 0.7500 13200.0n 0.2500 13499.9n 0.2500 13500.0n 0.2500 13799.9n 0.2500 13800.0n 0.2500 14099.9n 0.2500 14100.0n 0.2500 14399.9n 0.2500 14400.0n 0.7500 14699.9n 0.7500 14700.0n 0.7500 14999.9n 0.7500 15000.0n 0.2500 15299.9n 0.2500 15300.0n 0.2500 15599.9n 0.2500 15600.0n 0.7500 15899.9n 0.7500 15900.0n 0.7500 16199.9n 0.7500 16200.0n 0.7500 16499.9n 0.7500 16500.0n 0.7500 16799.9n 0.7500 16800.0n 0.7500 17099.9n 0.7500 17100.0n 0.7500 17399.9n 0.7500 17400.0n 0.7500 17699.9n 0.7500 17700.0n 0.7500 17999.9n 0.7500 18000.0n 0.7500 18299.9n 0.7500 18300.0n 0.7500 18599.9n 0.7500 18600.0n 0.2500 18899.9n 0.2500 18900.0n 0.2500 19199.9n 0.2500 19200.0n 0.2500 19499.9n 0.2500 19500.0n 0.2500 19799.9n 0.2500 19800.0n 0.7500 20099.9n 0.7500 20100.0n 0.7500 20399.9n 0.7500 20400.0n 0.2500 20699.9n 0.2500 20700.0n 0.2500 20999.9n 0.2500 21000.0n 0.7500 21299.9n 0.7500 21300.0n 0.7500 21599.9n 0.7500 21600.0n 0.7500 21899.9n 0.7500 21900.0n 0.7500 22199.9n 0.7500 22200.0n 0.7500 22499.9n 0.7500 22500.0n 0.7500 22799.9n 0.7500 22800.0n 0.7500 23099.9n 0.7500 23100.0n 0.7500 23399.9n 0.7500 23400.0n 0.7500 23699.9n 0.7500 23700.0n 0.7500 23999.9n 0.7500 24000.0n 0.2500 24299.9n 0.2500 24300.0n 0.2500 24599.9n 0.2500 24600.0n 0.2500 24899.9n 0.2500 24900.0n 0.2500 25199.9n 0.2500 25200.0n 0.7500 25499.9n 0.7500 25500.0n 0.7500 25799.9n 0.7500 25800.0n 0.2500 26099.9n 0.2500 26100.0n 0.2500 26399.9n 0.2500 26400.0n 0.7500 26699.9n 0.7500 26700.0n 0.7500 26999.9n 0.7500 27000.0n 0.7500 27299.9n 0.7500 27300.0n 0.7500 27599.9n 0.7500 27600.0n 0.7500 27899.9n 0.7500 27900.0n 0.7500 28199.9n 0.7500 28200.0n 0.7500 28499.9n 0.7500 28500.0n 0.7500 28799.9n 0.7500 28800.0n 0.7500 29099.9n 0.7500 29100.0n 0.7500 29399.9n 0.7500 29400.0n 0.2500 29699.9n 0.2500 29700.0n 0.2500 29999.9n 0.2500 30000.0n 0.2500 30299.9n 0.2500 30300.0n 0.2500 30599.9n 0.2500 30600.0n 0.7500 30899.9n 0.7500 30900.0n 0.7500 31199.9n 0.7500 31200.0n 0.2500 31499.9n 0.2500 31500.0n 0.2500 31799.9n 0.2500 31800.0n 0.7500 32099.9n 0.7500 32100.0n 0.7500 32399.9n 0.7500 32400.0n 0.7500 32699.9n 0.7500 32700.0n 0.7500 32999.9n 0.7500 33000.0n 0.7500 33299.9n 0.7500 33300.0n 0.7500 33599.9n 0.7500 33600.0n 0.7500 33899.9n 0.7500 33900.0n 0.7500 34199.9n 0.7500 34200.0n 0.7500 34499.9n 0.7500 34500.0n 0.7500 34799.9n 0.7500 34800.0n 0.2500 35099.9n 0.2500 35100.0n 0.2500 35399.9n 0.2500 35400.0n 0.2500 35699.9n 0.2500 35700.0n 0.2500 35999.9n 0.2500 36000.0n 0.7500 36299.9n 0.7500 36300.0n 0.7500 36599.9n 0.7500 36600.0n 0.2500 36899.9n 0.2500 36900.0n 0.2500 37199.9n 0.2500 37200.0n 0.7500 37499.9n 0.7500 37500.0n 0.7500 37799.9n 0.7500 37800.0n 0.7500 38099.9n 0.7500 38100.0n 0.7500 38399.9n 0.7500 38400.0n 0.7500 38699.9n 0.7500 38700.0n 0.7500 38999.9n 0.7500 39000.0n 0.7500 39299.9n 0.7500 39300.0n 0.7500 39599.9n 0.7500 39600.0n 0.7500 39899.9n 0.7500 39900.0n 0.7500 40199.9n 0.7500 40200.0n 0.2500 40499.9n 0.2500 40500.0n 0.2500 40799.9n 0.2500 40800.0n 0.2500 41099.9n 0.2500 41100.0n 0.2500 41399.9n 0.2500 41400.0n 0.7500 41699.9n 0.7500 41700.0n 0.7500 41999.9n 0.7500 42000.0n 0.2500 42299.9n 0.2500 42300.0n 0.2500 42599.9n 0.2500 42600.0n 0.7500 42899.9n 0.7500 42900.0n 0.7500 43199.9n 0.7500 43200.0n 0.7500 43499.9n 0.7500 43500.0n 0.7500 43799.9n 0.7500 43800.0n 0.7500 44099.9n 0.7500 44100.0n 0.7500 44399.9n 0.7500 44400.0n 0.7500 44699.9n 0.7500 44700.0n 0.7500 44999.9n 0.7500 45000.0n 0.7500 45299.9n 0.7500 45300.0n 0.7500 45599.9n 0.7500 45600.0n 0.2500 45899.9n 0.2500 45900.0n 0.2500 46199.9n 0.2500 46200.0n 0.2500 46499.9n 0.2500 46500.0n 0.2500 46799.9n 0.2500 46800.0n 0.7500 47099.9n 0.7500 47100.0n 0.7500 47399.9n 0.7500 47400.0n 0.2500 47699.9n 0.2500 47700.0n 0.2500 47999.9n 0.2500 48000.0n 0.7500 48299.9n 0.7500 48300.0n 0.7500 48599.9n 0.7500 48600.0n 0.7500 48899.9n 0.7500 48900.0n 0.7500 49199.9n 0.7500 49200.0n 0.7500 49499.9n 0.7500 49500.0n 0.7500 49799.9n 0.7500 49800.0n 0.7500 50099.9n 0.7500 50100.0n 0.7500 50399.9n 0.7500 50400.0n 0.7500 50699.9n 0.7500 50700.0n 0.7500 50999.9n 0.7500 51000.0n 0.2500 51299.9n 0.2500 51300.0n 0.2500 51599.9n 0.2500 51600.0n 0.2500 51899.9n 0.2500 51900.0n 0.2500 52199.9n 0.2500 52200.0n 0.7500 52499.9n 0.7500 52500.0n 0.7500 52799.9n 0.7500 52800.0n 0.2500 53099.9n 0.2500 53100.0n 0.2500 53399.9n 0.2500 53400.0n 0.7500 53699.9n 0.7500 53700.0n 0.7500 53999.9n 0.7500 54000.0n 0.7500 54299.9n 0.7500 54300.0n 0.7500 54599.9n 0.7500 54600.0n 0.7500 54899.9n 0.7500 54900.0n 0.7500 55199.9n 0.7500 55200.0n 0.7500 55499.9n 0.7500 55500.0n 0.7500 55799.9n 0.7500 55800.0n 0.7500 56099.9n 0.7500 56100.0n 0.7500 56399.9n 0.7500 56400.0n 0.7500 56699.9n 0.7500 56700.0n 0.7500 56999.9n 0.7500 57000.0n 0.7500 57299.9n 0.7500 57300.0n 0.7500 57599.9n 0.7500 57600.0n 0.2500 57899.9n 0.2500 57900.0n 0.2500 58199.9n 0.2500 58200.0n 0.2500 58499.9n 0.2500 58500.0n 0.2500 58799.9n 0.2500 58800.0n 0.2500 59099.9n 0.2500 59100.0n 0.2500)
Cwp_0_0 wp_0_0 0 20p
Cwn_0_0 wn_0_0 0 20p
Rwp_0_0 wp_0_0 wcm 2g
Rwn_0_0 wn_0_0 wcm 2g
X_syn_0_0 a_xp0 a_xn0 wp_0_0 wn_0_0 mop0 mon0 vdd vbsyn gsyn
Cwp_1_0 wp_1_0 0 20p
Cwn_1_0 wn_1_0 0 20p
Rwp_1_0 wp_1_0 wcm 2g
Rwn_1_0 wn_1_0 wcm 2g
X_syn_1_0 a_xp1 a_xn1 wp_1_0 wn_1_0 mop0 mon0 vdd vbsyn gsyn
Cwp_2_0 wp_2_0 0 20p
Cwn_2_0 wn_2_0 0 20p
Rwp_2_0 wp_2_0 wcm 2g
Rwn_2_0 wn_2_0 wcm 2g
X_syn_2_0 a_xp2 a_xn2 wp_2_0 wn_2_0 mop0 mon0 vdd vbsyn gsyn
Cwp_3_0 wp_3_0 0 20p
Cwn_3_0 wn_3_0 0 20p
Rwp_3_0 wp_3_0 wcm 2g
Rwn_3_0 wn_3_0 wcm 2g
X_syn_3_0 a_xp3 a_xn3 wp_3_0 wn_3_0 mop0 mon0 vdd vbsyn gsyn
Cwp_4_0 wp_4_0 0 20p
Cwn_4_0 wn_4_0 0 20p
Rwp_4_0 wp_4_0 wcm 2g
Rwn_4_0 wn_4_0 wcm 2g
X_syn_4_0 a_xp4 a_xn4 wp_4_0 wn_4_0 mop0 mon0 vdd vbsyn gsyn
Cwp_5_0 wp_5_0 0 20p
Cwn_5_0 wn_5_0 0 20p
Rwp_5_0 wp_5_0 wcm 2g
Rwn_5_0 wn_5_0 wcm 2g
X_syn_5_0 a_xp5 a_xn5 wp_5_0 wn_5_0 mop0 mon0 vdd vbsyn gsyn
Cwp_6_0 wp_6_0 0 20p
Cwn_6_0 wn_6_0 0 20p
Rwp_6_0 wp_6_0 wcm 2g
Rwn_6_0 wn_6_0 wcm 2g
X_syn_6_0 a_xp6 a_xn6 wp_6_0 wn_6_0 mop0 mon0 vdd vbsyn gsyn
Cwp_7_0 wp_7_0 0 20p
Cwn_7_0 wn_7_0 0 20p
Rwp_7_0 wp_7_0 wcm 2g
Rwn_7_0 wn_7_0 wcm 2g
X_syn_7_0 a_xp7 a_xn7 wp_7_0 wn_7_0 mop0 mon0 vdd vbsyn gsyn
Cwp_8_0 wp_8_0 0 20p
Cwn_8_0 wn_8_0 0 20p
Rwp_8_0 wp_8_0 wcm 2g
Rwn_8_0 wn_8_0 wcm 2g
X_syn_8_0 a_xp8 a_xn8 wp_8_0 wn_8_0 mop0 mon0 vdd vbsyn gsyn
Cwp_9_0 wp_9_0 0 20p
Cwn_9_0 wn_9_0 0 20p
Rwp_9_0 wp_9_0 wcm 2g
Rwn_9_0 wn_9_0 wcm 2g
X_syn_9_0 a_xp9 a_xn9 wp_9_0 wn_9_0 mop0 mon0 vdd vbsyn gsyn
Cwp_10_0 wp_10_0 0 20p
Cwn_10_0 wn_10_0 0 20p
Rwp_10_0 wp_10_0 wcm 2g
Rwn_10_0 wn_10_0 wcm 2g
X_syn_10_0 a_xp10 a_xn10 wp_10_0 wn_10_0 mop0 mon0 vdd vbsyn gsyn
Cwp_11_0 wp_11_0 0 20p
Cwn_11_0 wn_11_0 0 20p
Rwp_11_0 wp_11_0 wcm 2g
Rwn_11_0 wn_11_0 wcm 2g
X_syn_11_0 a_xp11 a_xn11 wp_11_0 wn_11_0 mop0 mon0 vdd vbsyn gsyn
Cwp_12_0 wp_12_0 0 20p
Cwn_12_0 wn_12_0 0 20p
Rwp_12_0 wp_12_0 wcm 2g
Rwn_12_0 wn_12_0 wcm 2g
X_syn_12_0 a_xp12 a_xn12 wp_12_0 wn_12_0 mop0 mon0 vdd vbsyn gsyn
Cwp_13_0 wp_13_0 0 20p
Cwn_13_0 wn_13_0 0 20p
Rwp_13_0 wp_13_0 wcm 2g
Rwn_13_0 wn_13_0 wcm 2g
X_syn_13_0 a_xp13 a_xn13 wp_13_0 wn_13_0 mop0 mon0 vdd vbsyn gsyn
Cwp_14_0 wp_14_0 0 20p
Cwn_14_0 wn_14_0 0 20p
Rwp_14_0 wp_14_0 wcm 2g
Rwn_14_0 wn_14_0 wcm 2g
X_syn_14_0 a_xp14 a_xn14 wp_14_0 wn_14_0 mop0 mon0 vdd vbsyn gsyn
Cwp_15_0 wp_15_0 0 20p
Cwn_15_0 wn_15_0 0 20p
Rwp_15_0 wp_15_0 wcm 2g
Rwn_15_0 wn_15_0 wcm 2g
X_syn_15_0 a_xp15 a_xn15 wp_15_0 wn_15_0 mop0 mon0 vdd vbsyn gsyn
Cwp_16_0 wp_16_0 0 20p
Cwn_16_0 wn_16_0 0 20p
Rwp_16_0 wp_16_0 wcm 2g
Rwn_16_0 wn_16_0 wcm 2g
X_syn_16_0 a_xp16 a_xn16 wp_16_0 wn_16_0 mop0 mon0 vdd vbsyn gsyn
Cwp_17_0 wp_17_0 0 20p
Cwn_17_0 wn_17_0 0 20p
Rwp_17_0 wp_17_0 wcm 2g
Rwn_17_0 wn_17_0 wcm 2g
X_syn_17_0 a_xp17 a_xn17 wp_17_0 wn_17_0 mop0 mon0 vdd vbsyn gsyn
Cwp_18_0 wp_18_0 0 20p
Cwn_18_0 wn_18_0 0 20p
Rwp_18_0 wp_18_0 wcm 2g
Rwn_18_0 wn_18_0 wcm 2g
X_syn_18_0 a_xp18 a_xn18 wp_18_0 wn_18_0 mop0 mon0 vdd vbsyn gsyn
Cwp_19_0 wp_19_0 0 20p
Cwn_19_0 wn_19_0 0 20p
Rwp_19_0 wp_19_0 wcm 2g
Rwn_19_0 wn_19_0 wcm 2g
X_syn_19_0 a_xp19 a_xn19 wp_19_0 wn_19_0 mop0 mon0 vdd vbsyn gsyn
Cwp_20_0 wp_20_0 0 20p
Cwn_20_0 wn_20_0 0 20p
Rwp_20_0 wp_20_0 wcm 2g
Rwn_20_0 wn_20_0 wcm 2g
X_syn_20_0 a_xp20 a_xn20 wp_20_0 wn_20_0 mop0 mon0 vdd vbsyn gsyn
Cwp_21_0 wp_21_0 0 20p
Cwn_21_0 wn_21_0 0 20p
Rwp_21_0 wp_21_0 wcm 2g
Rwn_21_0 wn_21_0 wcm 2g
X_syn_21_0 a_xp21 a_xn21 wp_21_0 wn_21_0 mop0 mon0 vdd vbsyn gsyn
Cwp_22_0 wp_22_0 0 20p
Cwn_22_0 wn_22_0 0 20p
Rwp_22_0 wp_22_0 wcm 2g
Rwn_22_0 wn_22_0 wcm 2g
X_syn_22_0 a_xp22 a_xn22 wp_22_0 wn_22_0 mop0 mon0 vdd vbsyn gsyn
Cwp_23_0 wp_23_0 0 20p
Cwn_23_0 wn_23_0 0 20p
Rwp_23_0 wp_23_0 wcm 2g
Rwn_23_0 wn_23_0 wcm 2g
X_syn_23_0 a_xp23 a_xn23 wp_23_0 wn_23_0 mop0 mon0 vdd vbsyn gsyn
Cwp_24_0 wp_24_0 0 20p
Cwn_24_0 wn_24_0 0 20p
Rwp_24_0 wp_24_0 wcm 2g
Rwn_24_0 wn_24_0 wcm 2g
X_syn_24_0 a_xp24 a_xn24 wp_24_0 wn_24_0 mop0 mon0 vdd vbsyn gsyn
Cwp_25_0 wp_25_0 0 20p
Cwn_25_0 wn_25_0 0 20p
Rwp_25_0 wp_25_0 wcm 2g
Rwn_25_0 wn_25_0 wcm 2g
X_syn_25_0 a_xp25 a_xn25 wp_25_0 wn_25_0 mop0 mon0 vdd vbsyn gsyn
Cwp_26_0 wp_26_0 0 20p
Cwn_26_0 wn_26_0 0 20p
Rwp_26_0 wp_26_0 wcm 2g
Rwn_26_0 wn_26_0 wcm 2g
X_syn_26_0 a_xp26 a_xn26 wp_26_0 wn_26_0 mop0 mon0 vdd vbsyn gsyn
Cwp_27_0 wp_27_0 0 20p
Cwn_27_0 wn_27_0 0 20p
Rwp_27_0 wp_27_0 wcm 2g
Rwn_27_0 wn_27_0 wcm 2g
X_syn_27_0 a_xp27 a_xn27 wp_27_0 wn_27_0 mop0 mon0 vdd vbsyn gsyn
Cwp_28_0 wp_28_0 0 20p
Cwn_28_0 wn_28_0 0 20p
Rwp_28_0 wp_28_0 wcm 2g
Rwn_28_0 wn_28_0 wcm 2g
X_syn_28_0 a_xp28 a_xn28 wp_28_0 wn_28_0 mop0 mon0 vdd vbsyn gsyn
Cwp_29_0 wp_29_0 0 20p
Cwn_29_0 wn_29_0 0 20p
Rwp_29_0 wp_29_0 wcm 2g
Rwn_29_0 wn_29_0 wcm 2g
X_syn_29_0 a_xp29 a_xn29 wp_29_0 wn_29_0 mop0 mon0 vdd vbsyn gsyn
Cwp_30_0 wp_30_0 0 20p
Cwn_30_0 wn_30_0 0 20p
Rwp_30_0 wp_30_0 wcm 2g
Rwn_30_0 wn_30_0 wcm 2g
X_syn_30_0 a_xp30 a_xn30 wp_30_0 wn_30_0 mop0 mon0 vdd vbsyn gsyn
Cwp_31_0 wp_31_0 0 20p
Cwn_31_0 wn_31_0 0 20p
Rwp_31_0 wp_31_0 wcm 2g
Rwn_31_0 wn_31_0 wcm 2g
X_syn_31_0 a_xp31 a_xn31 wp_31_0 wn_31_0 mop0 mon0 vdd vbsyn gsyn
Cwp_32_0 wp_32_0 0 20p
Cwn_32_0 wn_32_0 0 20p
Rwp_32_0 wp_32_0 wcm 2g
Rwn_32_0 wn_32_0 wcm 2g
X_syn_32_0 a_xp32 a_xn32 wp_32_0 wn_32_0 mop0 mon0 vdd vbsyn gsyn
Cwp_33_0 wp_33_0 0 20p
Cwn_33_0 wn_33_0 0 20p
Rwp_33_0 wp_33_0 wcm 2g
Rwn_33_0 wn_33_0 wcm 2g
X_syn_33_0 a_xp33 a_xn33 wp_33_0 wn_33_0 mop0 mon0 vdd vbsyn gsyn
Cwp_34_0 wp_34_0 0 20p
Cwn_34_0 wn_34_0 0 20p
Rwp_34_0 wp_34_0 wcm 2g
Rwn_34_0 wn_34_0 wcm 2g
X_syn_34_0 a_xp34 a_xn34 wp_34_0 wn_34_0 mop0 mon0 vdd vbsyn gsyn
Cwp_35_0 wp_35_0 0 20p
Cwn_35_0 wn_35_0 0 20p
Rwp_35_0 wp_35_0 wcm 2g
Rwn_35_0 wn_35_0 wcm 2g
X_syn_35_0 a_xp35 a_xn35 wp_35_0 wn_35_0 mop0 mon0 vdd vbsyn gsyn
Cwp_36_0 wp_36_0 0 20p
Cwn_36_0 wn_36_0 0 20p
Rwp_36_0 wp_36_0 wcm 2g
Rwn_36_0 wn_36_0 wcm 2g
X_syn_36_0 a_xp36 a_xn36 wp_36_0 wn_36_0 mop0 mon0 vdd vbsyn gsyn
Cwp_37_0 wp_37_0 0 20p
Cwn_37_0 wn_37_0 0 20p
Rwp_37_0 wp_37_0 wcm 2g
Rwn_37_0 wn_37_0 wcm 2g
X_syn_37_0 a_xp37 a_xn37 wp_37_0 wn_37_0 mop0 mon0 vdd vbsyn gsyn
Cwp_38_0 wp_38_0 0 20p
Cwn_38_0 wn_38_0 0 20p
Rwp_38_0 wp_38_0 wcm 2g
Rwn_38_0 wn_38_0 wcm 2g
X_syn_38_0 a_xp38 a_xn38 wp_38_0 wn_38_0 mop0 mon0 vdd vbsyn gsyn
Cwp_39_0 wp_39_0 0 20p
Cwn_39_0 wn_39_0 0 20p
Rwp_39_0 wp_39_0 wcm 2g
Rwn_39_0 wn_39_0 wcm 2g
X_syn_39_0 a_xp39 a_xn39 wp_39_0 wn_39_0 mop0 mon0 vdd vbsyn gsyn
Cwp_40_0 wp_40_0 0 20p
Cwn_40_0 wn_40_0 0 20p
Rwp_40_0 wp_40_0 wcm 2g
Rwn_40_0 wn_40_0 wcm 2g
X_syn_40_0 a_xp40 a_xn40 wp_40_0 wn_40_0 mop0 mon0 vdd vbsyn gsyn
Cwp_41_0 wp_41_0 0 20p
Cwn_41_0 wn_41_0 0 20p
Rwp_41_0 wp_41_0 wcm 2g
Rwn_41_0 wn_41_0 wcm 2g
X_syn_41_0 a_xp41 a_xn41 wp_41_0 wn_41_0 mop0 mon0 vdd vbsyn gsyn
Cwp_42_0 wp_42_0 0 20p
Cwn_42_0 wn_42_0 0 20p
Rwp_42_0 wp_42_0 wcm 2g
Rwn_42_0 wn_42_0 wcm 2g
X_syn_42_0 a_xp42 a_xn42 wp_42_0 wn_42_0 mop0 mon0 vdd vbsyn gsyn
Cwp_43_0 wp_43_0 0 20p
Cwn_43_0 wn_43_0 0 20p
Rwp_43_0 wp_43_0 wcm 2g
Rwn_43_0 wn_43_0 wcm 2g
X_syn_43_0 a_xp43 a_xn43 wp_43_0 wn_43_0 mop0 mon0 vdd vbsyn gsyn
Cwp_44_0 wp_44_0 0 20p
Cwn_44_0 wn_44_0 0 20p
Rwp_44_0 wp_44_0 wcm 2g
Rwn_44_0 wn_44_0 wcm 2g
X_syn_44_0 a_xp44 a_xn44 wp_44_0 wn_44_0 mop0 mon0 vdd vbsyn gsyn
Cwp_45_0 wp_45_0 0 20p
Cwn_45_0 wn_45_0 0 20p
Rwp_45_0 wp_45_0 wcm 2g
Rwn_45_0 wn_45_0 wcm 2g
X_syn_45_0 a_xp45 a_xn45 wp_45_0 wn_45_0 mop0 mon0 vdd vbsyn gsyn
Cwp_46_0 wp_46_0 0 20p
Cwn_46_0 wn_46_0 0 20p
Rwp_46_0 wp_46_0 wcm 2g
Rwn_46_0 wn_46_0 wcm 2g
X_syn_46_0 a_xp46 a_xn46 wp_46_0 wn_46_0 mop0 mon0 vdd vbsyn gsyn
Cwp_47_0 wp_47_0 0 20p
Cwn_47_0 wn_47_0 0 20p
Rwp_47_0 wp_47_0 wcm 2g
Rwn_47_0 wn_47_0 wcm 2g
X_syn_47_0 a_xp47 a_xn47 wp_47_0 wn_47_0 mop0 mon0 vdd vbsyn gsyn
Cwp_48_0 wp_48_0 0 20p
Cwn_48_0 wn_48_0 0 20p
Rwp_48_0 wp_48_0 wcm 2g
Rwn_48_0 wn_48_0 wcm 2g
X_syn_48_0 a_xp48 a_xn48 wp_48_0 wn_48_0 mop0 mon0 vdd vbsyn gsyn
Cwp_49_0 wp_49_0 0 20p
Cwn_49_0 wn_49_0 0 20p
Rwp_49_0 wp_49_0 wcm 2g
Rwn_49_0 wn_49_0 wcm 2g
X_syn_49_0 a_xp49 a_xn49 wp_49_0 wn_49_0 mop0 mon0 vdd vbsyn gsyn
Cwp_50_0 wp_50_0 0 20p
Cwn_50_0 wn_50_0 0 20p
Rwp_50_0 wp_50_0 wcm 2g
Rwn_50_0 wn_50_0 wcm 2g
X_syn_50_0 a_xp50 a_xn50 wp_50_0 wn_50_0 mop0 mon0 vdd vbsyn gsyn
Cwp_51_0 wp_51_0 0 20p
Cwn_51_0 wn_51_0 0 20p
Rwp_51_0 wp_51_0 wcm 2g
Rwn_51_0 wn_51_0 wcm 2g
X_syn_51_0 a_xp51 a_xn51 wp_51_0 wn_51_0 mop0 mon0 vdd vbsyn gsyn
Cwp_52_0 wp_52_0 0 20p
Cwn_52_0 wn_52_0 0 20p
Rwp_52_0 wp_52_0 wcm 2g
Rwn_52_0 wn_52_0 wcm 2g
X_syn_52_0 a_xp52 a_xn52 wp_52_0 wn_52_0 mop0 mon0 vdd vbsyn gsyn
Cwp_53_0 wp_53_0 0 20p
Cwn_53_0 wn_53_0 0 20p
Rwp_53_0 wp_53_0 wcm 2g
Rwn_53_0 wn_53_0 wcm 2g
X_syn_53_0 a_xp53 a_xn53 wp_53_0 wn_53_0 mop0 mon0 vdd vbsyn gsyn
Cwp_54_0 wp_54_0 0 20p
Cwn_54_0 wn_54_0 0 20p
Rwp_54_0 wp_54_0 wcm 2g
Rwn_54_0 wn_54_0 wcm 2g
X_syn_54_0 a_xp54 a_xn54 wp_54_0 wn_54_0 mop0 mon0 vdd vbsyn gsyn
Cwp_55_0 wp_55_0 0 20p
Cwn_55_0 wn_55_0 0 20p
Rwp_55_0 wp_55_0 wcm 2g
Rwn_55_0 wn_55_0 wcm 2g
X_syn_55_0 a_xp55 a_xn55 wp_55_0 wn_55_0 mop0 mon0 vdd vbsyn gsyn
Cwp_56_0 wp_56_0 0 20p
Cwn_56_0 wn_56_0 0 20p
Rwp_56_0 wp_56_0 wcm 2g
Rwn_56_0 wn_56_0 wcm 2g
X_syn_56_0 a_xp56 a_xn56 wp_56_0 wn_56_0 mop0 mon0 vdd vbsyn gsyn
Cwp_57_0 wp_57_0 0 20p
Cwn_57_0 wn_57_0 0 20p
Rwp_57_0 wp_57_0 wcm 2g
Rwn_57_0 wn_57_0 wcm 2g
X_syn_57_0 a_xp57 a_xn57 wp_57_0 wn_57_0 mop0 mon0 vdd vbsyn gsyn
Cwp_58_0 wp_58_0 0 20p
Cwn_58_0 wn_58_0 0 20p
Rwp_58_0 wp_58_0 wcm 2g
Rwn_58_0 wn_58_0 wcm 2g
X_syn_58_0 a_xp58 a_xn58 wp_58_0 wn_58_0 mop0 mon0 vdd vbsyn gsyn
Cwp_59_0 wp_59_0 0 20p
Cwn_59_0 wn_59_0 0 20p
Rwp_59_0 wp_59_0 wcm 2g
Rwn_59_0 wn_59_0 wcm 2g
X_syn_59_0 a_xp59 a_xn59 wp_59_0 wn_59_0 mop0 mon0 vdd vbsyn gsyn
Cwp_60_0 wp_60_0 0 20p
Cwn_60_0 wn_60_0 0 20p
Rwp_60_0 wp_60_0 wcm 2g
Rwn_60_0 wn_60_0 wcm 2g
X_syn_60_0 a_xp60 a_xn60 wp_60_0 wn_60_0 mop0 mon0 vdd vbsyn gsyn
Cwp_61_0 wp_61_0 0 20p
Cwn_61_0 wn_61_0 0 20p
Rwp_61_0 wp_61_0 wcm 2g
Rwn_61_0 wn_61_0 wcm 2g
X_syn_61_0 a_xp61 a_xn61 wp_61_0 wn_61_0 mop0 mon0 vdd vbsyn gsyn
Cwp_62_0 wp_62_0 0 20p
Cwn_62_0 wn_62_0 0 20p
Rwp_62_0 wp_62_0 wcm 2g
Rwn_62_0 wn_62_0 wcm 2g
X_syn_62_0 a_xp62 a_xn62 wp_62_0 wn_62_0 mop0 mon0 vdd vbsyn gsyn
Cwp_63_0 wp_63_0 0 20p
Cwn_63_0 wn_63_0 0 20p
Rwp_63_0 wp_63_0 wcm 2g
Rwn_63_0 wn_63_0 wcm 2g
X_syn_63_0 a_xp63 a_xn63 wp_63_0 wn_63_0 mop0 mon0 vdd vbsyn gsyn
Xcm_mo0 mop0 mon0 vdd cmld
Rmo0 mop0 mon0 40k
Xeo0 xop0 xon0 mop0 mon0 eop0 eon0 vdd gm esub
X_lrn_0_0 eop0 eon0 a_xp0 a_xn0 wp_0_0 wn_0_0 vdd gbl gprod
X_lrn_1_0 eop0 eon0 a_xp1 a_xn1 wp_1_0 wn_1_0 vdd gbl gprod
X_lrn_2_0 eop0 eon0 a_xp2 a_xn2 wp_2_0 wn_2_0 vdd gbl gprod
X_lrn_3_0 eop0 eon0 a_xp3 a_xn3 wp_3_0 wn_3_0 vdd gbl gprod
X_lrn_4_0 eop0 eon0 a_xp4 a_xn4 wp_4_0 wn_4_0 vdd gbl gprod
X_lrn_5_0 eop0 eon0 a_xp5 a_xn5 wp_5_0 wn_5_0 vdd gbl gprod
X_lrn_6_0 eop0 eon0 a_xp6 a_xn6 wp_6_0 wn_6_0 vdd gbl gprod
X_lrn_7_0 eop0 eon0 a_xp7 a_xn7 wp_7_0 wn_7_0 vdd gbl gprod
X_lrn_8_0 eop0 eon0 a_xp8 a_xn8 wp_8_0 wn_8_0 vdd gbl gprod
X_lrn_9_0 eop0 eon0 a_xp9 a_xn9 wp_9_0 wn_9_0 vdd gbl gprod
X_lrn_10_0 eop0 eon0 a_xp10 a_xn10 wp_10_0 wn_10_0 vdd gbl gprod
X_lrn_11_0 eop0 eon0 a_xp11 a_xn11 wp_11_0 wn_11_0 vdd gbl gprod
X_lrn_12_0 eop0 eon0 a_xp12 a_xn12 wp_12_0 wn_12_0 vdd gbl gprod
X_lrn_13_0 eop0 eon0 a_xp13 a_xn13 wp_13_0 wn_13_0 vdd gbl gprod
X_lrn_14_0 eop0 eon0 a_xp14 a_xn14 wp_14_0 wn_14_0 vdd gbl gprod
X_lrn_15_0 eop0 eon0 a_xp15 a_xn15 wp_15_0 wn_15_0 vdd gbl gprod
X_lrn_16_0 eop0 eon0 a_xp16 a_xn16 wp_16_0 wn_16_0 vdd gbl gprod
X_lrn_17_0 eop0 eon0 a_xp17 a_xn17 wp_17_0 wn_17_0 vdd gbl gprod
X_lrn_18_0 eop0 eon0 a_xp18 a_xn18 wp_18_0 wn_18_0 vdd gbl gprod
X_lrn_19_0 eop0 eon0 a_xp19 a_xn19 wp_19_0 wn_19_0 vdd gbl gprod
X_lrn_20_0 eop0 eon0 a_xp20 a_xn20 wp_20_0 wn_20_0 vdd gbl gprod
X_lrn_21_0 eop0 eon0 a_xp21 a_xn21 wp_21_0 wn_21_0 vdd gbl gprod
X_lrn_22_0 eop0 eon0 a_xp22 a_xn22 wp_22_0 wn_22_0 vdd gbl gprod
X_lrn_23_0 eop0 eon0 a_xp23 a_xn23 wp_23_0 wn_23_0 vdd gbl gprod
X_lrn_24_0 eop0 eon0 a_xp24 a_xn24 wp_24_0 wn_24_0 vdd gbl gprod
X_lrn_25_0 eop0 eon0 a_xp25 a_xn25 wp_25_0 wn_25_0 vdd gbl gprod
X_lrn_26_0 eop0 eon0 a_xp26 a_xn26 wp_26_0 wn_26_0 vdd gbl gprod
X_lrn_27_0 eop0 eon0 a_xp27 a_xn27 wp_27_0 wn_27_0 vdd gbl gprod
X_lrn_28_0 eop0 eon0 a_xp28 a_xn28 wp_28_0 wn_28_0 vdd gbl gprod
X_lrn_29_0 eop0 eon0 a_xp29 a_xn29 wp_29_0 wn_29_0 vdd gbl gprod
X_lrn_30_0 eop0 eon0 a_xp30 a_xn30 wp_30_0 wn_30_0 vdd gbl gprod
X_lrn_31_0 eop0 eon0 a_xp31 a_xn31 wp_31_0 wn_31_0 vdd gbl gprod
X_lrn_32_0 eop0 eon0 a_xp32 a_xn32 wp_32_0 wn_32_0 vdd gbl gprod
X_lrn_33_0 eop0 eon0 a_xp33 a_xn33 wp_33_0 wn_33_0 vdd gbl gprod
X_lrn_34_0 eop0 eon0 a_xp34 a_xn34 wp_34_0 wn_34_0 vdd gbl gprod
X_lrn_35_0 eop0 eon0 a_xp35 a_xn35 wp_35_0 wn_35_0 vdd gbl gprod
X_lrn_36_0 eop0 eon0 a_xp36 a_xn36 wp_36_0 wn_36_0 vdd gbl gprod
X_lrn_37_0 eop0 eon0 a_xp37 a_xn37 wp_37_0 wn_37_0 vdd gbl gprod
X_lrn_38_0 eop0 eon0 a_xp38 a_xn38 wp_38_0 wn_38_0 vdd gbl gprod
X_lrn_39_0 eop0 eon0 a_xp39 a_xn39 wp_39_0 wn_39_0 vdd gbl gprod
X_lrn_40_0 eop0 eon0 a_xp40 a_xn40 wp_40_0 wn_40_0 vdd gbl gprod
X_lrn_41_0 eop0 eon0 a_xp41 a_xn41 wp_41_0 wn_41_0 vdd gbl gprod
X_lrn_42_0 eop0 eon0 a_xp42 a_xn42 wp_42_0 wn_42_0 vdd gbl gprod
X_lrn_43_0 eop0 eon0 a_xp43 a_xn43 wp_43_0 wn_43_0 vdd gbl gprod
X_lrn_44_0 eop0 eon0 a_xp44 a_xn44 wp_44_0 wn_44_0 vdd gbl gprod
X_lrn_45_0 eop0 eon0 a_xp45 a_xn45 wp_45_0 wn_45_0 vdd gbl gprod
X_lrn_46_0 eop0 eon0 a_xp46 a_xn46 wp_46_0 wn_46_0 vdd gbl gprod
X_lrn_47_0 eop0 eon0 a_xp47 a_xn47 wp_47_0 wn_47_0 vdd gbl gprod
X_lrn_48_0 eop0 eon0 a_xp48 a_xn48 wp_48_0 wn_48_0 vdd gbl gprod
X_lrn_49_0 eop0 eon0 a_xp49 a_xn49 wp_49_0 wn_49_0 vdd gbl gprod
X_lrn_50_0 eop0 eon0 a_xp50 a_xn50 wp_50_0 wn_50_0 vdd gbl gprod
X_lrn_51_0 eop0 eon0 a_xp51 a_xn51 wp_51_0 wn_51_0 vdd gbl gprod
X_lrn_52_0 eop0 eon0 a_xp52 a_xn52 wp_52_0 wn_52_0 vdd gbl gprod
X_lrn_53_0 eop0 eon0 a_xp53 a_xn53 wp_53_0 wn_53_0 vdd gbl gprod
X_lrn_54_0 eop0 eon0 a_xp54 a_xn54 wp_54_0 wn_54_0 vdd gbl gprod
X_lrn_55_0 eop0 eon0 a_xp55 a_xn55 wp_55_0 wn_55_0 vdd gbl gprod
X_lrn_56_0 eop0 eon0 a_xp56 a_xn56 wp_56_0 wn_56_0 vdd gbl gprod
X_lrn_57_0 eop0 eon0 a_xp57 a_xn57 wp_57_0 wn_57_0 vdd gbl gprod
X_lrn_58_0 eop0 eon0 a_xp58 a_xn58 wp_58_0 wn_58_0 vdd gbl gprod
X_lrn_59_0 eop0 eon0 a_xp59 a_xn59 wp_59_0 wn_59_0 vdd gbl gprod
X_lrn_60_0 eop0 eon0 a_xp60 a_xn60 wp_60_0 wn_60_0 vdd gbl gprod
X_lrn_61_0 eop0 eon0 a_xp61 a_xn61 wp_61_0 wn_61_0 vdd gbl gprod
X_lrn_62_0 eop0 eon0 a_xp62 a_xn62 wp_62_0 wn_62_0 vdd gbl gprod
X_lrn_63_0 eop0 eon0 a_xp63 a_xn63 wp_63_0 wn_63_0 vdd gbl gprod
Cwp_0_1 wp_0_1 0 20p
Cwn_0_1 wn_0_1 0 20p
Rwp_0_1 wp_0_1 wcm 2g
Rwn_0_1 wn_0_1 wcm 2g
X_syn_0_1 a_xp0 a_xn0 wp_0_1 wn_0_1 mop1 mon1 vdd vbsyn gsyn
Cwp_1_1 wp_1_1 0 20p
Cwn_1_1 wn_1_1 0 20p
Rwp_1_1 wp_1_1 wcm 2g
Rwn_1_1 wn_1_1 wcm 2g
X_syn_1_1 a_xp1 a_xn1 wp_1_1 wn_1_1 mop1 mon1 vdd vbsyn gsyn
Cwp_2_1 wp_2_1 0 20p
Cwn_2_1 wn_2_1 0 20p
Rwp_2_1 wp_2_1 wcm 2g
Rwn_2_1 wn_2_1 wcm 2g
X_syn_2_1 a_xp2 a_xn2 wp_2_1 wn_2_1 mop1 mon1 vdd vbsyn gsyn
Cwp_3_1 wp_3_1 0 20p
Cwn_3_1 wn_3_1 0 20p
Rwp_3_1 wp_3_1 wcm 2g
Rwn_3_1 wn_3_1 wcm 2g
X_syn_3_1 a_xp3 a_xn3 wp_3_1 wn_3_1 mop1 mon1 vdd vbsyn gsyn
Cwp_4_1 wp_4_1 0 20p
Cwn_4_1 wn_4_1 0 20p
Rwp_4_1 wp_4_1 wcm 2g
Rwn_4_1 wn_4_1 wcm 2g
X_syn_4_1 a_xp4 a_xn4 wp_4_1 wn_4_1 mop1 mon1 vdd vbsyn gsyn
Cwp_5_1 wp_5_1 0 20p
Cwn_5_1 wn_5_1 0 20p
Rwp_5_1 wp_5_1 wcm 2g
Rwn_5_1 wn_5_1 wcm 2g
X_syn_5_1 a_xp5 a_xn5 wp_5_1 wn_5_1 mop1 mon1 vdd vbsyn gsyn
Cwp_6_1 wp_6_1 0 20p
Cwn_6_1 wn_6_1 0 20p
Rwp_6_1 wp_6_1 wcm 2g
Rwn_6_1 wn_6_1 wcm 2g
X_syn_6_1 a_xp6 a_xn6 wp_6_1 wn_6_1 mop1 mon1 vdd vbsyn gsyn
Cwp_7_1 wp_7_1 0 20p
Cwn_7_1 wn_7_1 0 20p
Rwp_7_1 wp_7_1 wcm 2g
Rwn_7_1 wn_7_1 wcm 2g
X_syn_7_1 a_xp7 a_xn7 wp_7_1 wn_7_1 mop1 mon1 vdd vbsyn gsyn
Cwp_8_1 wp_8_1 0 20p
Cwn_8_1 wn_8_1 0 20p
Rwp_8_1 wp_8_1 wcm 2g
Rwn_8_1 wn_8_1 wcm 2g
X_syn_8_1 a_xp8 a_xn8 wp_8_1 wn_8_1 mop1 mon1 vdd vbsyn gsyn
Cwp_9_1 wp_9_1 0 20p
Cwn_9_1 wn_9_1 0 20p
Rwp_9_1 wp_9_1 wcm 2g
Rwn_9_1 wn_9_1 wcm 2g
X_syn_9_1 a_xp9 a_xn9 wp_9_1 wn_9_1 mop1 mon1 vdd vbsyn gsyn
Cwp_10_1 wp_10_1 0 20p
Cwn_10_1 wn_10_1 0 20p
Rwp_10_1 wp_10_1 wcm 2g
Rwn_10_1 wn_10_1 wcm 2g
X_syn_10_1 a_xp10 a_xn10 wp_10_1 wn_10_1 mop1 mon1 vdd vbsyn gsyn
Cwp_11_1 wp_11_1 0 20p
Cwn_11_1 wn_11_1 0 20p
Rwp_11_1 wp_11_1 wcm 2g
Rwn_11_1 wn_11_1 wcm 2g
X_syn_11_1 a_xp11 a_xn11 wp_11_1 wn_11_1 mop1 mon1 vdd vbsyn gsyn
Cwp_12_1 wp_12_1 0 20p
Cwn_12_1 wn_12_1 0 20p
Rwp_12_1 wp_12_1 wcm 2g
Rwn_12_1 wn_12_1 wcm 2g
X_syn_12_1 a_xp12 a_xn12 wp_12_1 wn_12_1 mop1 mon1 vdd vbsyn gsyn
Cwp_13_1 wp_13_1 0 20p
Cwn_13_1 wn_13_1 0 20p
Rwp_13_1 wp_13_1 wcm 2g
Rwn_13_1 wn_13_1 wcm 2g
X_syn_13_1 a_xp13 a_xn13 wp_13_1 wn_13_1 mop1 mon1 vdd vbsyn gsyn
Cwp_14_1 wp_14_1 0 20p
Cwn_14_1 wn_14_1 0 20p
Rwp_14_1 wp_14_1 wcm 2g
Rwn_14_1 wn_14_1 wcm 2g
X_syn_14_1 a_xp14 a_xn14 wp_14_1 wn_14_1 mop1 mon1 vdd vbsyn gsyn
Cwp_15_1 wp_15_1 0 20p
Cwn_15_1 wn_15_1 0 20p
Rwp_15_1 wp_15_1 wcm 2g
Rwn_15_1 wn_15_1 wcm 2g
X_syn_15_1 a_xp15 a_xn15 wp_15_1 wn_15_1 mop1 mon1 vdd vbsyn gsyn
Cwp_16_1 wp_16_1 0 20p
Cwn_16_1 wn_16_1 0 20p
Rwp_16_1 wp_16_1 wcm 2g
Rwn_16_1 wn_16_1 wcm 2g
X_syn_16_1 a_xp16 a_xn16 wp_16_1 wn_16_1 mop1 mon1 vdd vbsyn gsyn
Cwp_17_1 wp_17_1 0 20p
Cwn_17_1 wn_17_1 0 20p
Rwp_17_1 wp_17_1 wcm 2g
Rwn_17_1 wn_17_1 wcm 2g
X_syn_17_1 a_xp17 a_xn17 wp_17_1 wn_17_1 mop1 mon1 vdd vbsyn gsyn
Cwp_18_1 wp_18_1 0 20p
Cwn_18_1 wn_18_1 0 20p
Rwp_18_1 wp_18_1 wcm 2g
Rwn_18_1 wn_18_1 wcm 2g
X_syn_18_1 a_xp18 a_xn18 wp_18_1 wn_18_1 mop1 mon1 vdd vbsyn gsyn
Cwp_19_1 wp_19_1 0 20p
Cwn_19_1 wn_19_1 0 20p
Rwp_19_1 wp_19_1 wcm 2g
Rwn_19_1 wn_19_1 wcm 2g
X_syn_19_1 a_xp19 a_xn19 wp_19_1 wn_19_1 mop1 mon1 vdd vbsyn gsyn
Cwp_20_1 wp_20_1 0 20p
Cwn_20_1 wn_20_1 0 20p
Rwp_20_1 wp_20_1 wcm 2g
Rwn_20_1 wn_20_1 wcm 2g
X_syn_20_1 a_xp20 a_xn20 wp_20_1 wn_20_1 mop1 mon1 vdd vbsyn gsyn
Cwp_21_1 wp_21_1 0 20p
Cwn_21_1 wn_21_1 0 20p
Rwp_21_1 wp_21_1 wcm 2g
Rwn_21_1 wn_21_1 wcm 2g
X_syn_21_1 a_xp21 a_xn21 wp_21_1 wn_21_1 mop1 mon1 vdd vbsyn gsyn
Cwp_22_1 wp_22_1 0 20p
Cwn_22_1 wn_22_1 0 20p
Rwp_22_1 wp_22_1 wcm 2g
Rwn_22_1 wn_22_1 wcm 2g
X_syn_22_1 a_xp22 a_xn22 wp_22_1 wn_22_1 mop1 mon1 vdd vbsyn gsyn
Cwp_23_1 wp_23_1 0 20p
Cwn_23_1 wn_23_1 0 20p
Rwp_23_1 wp_23_1 wcm 2g
Rwn_23_1 wn_23_1 wcm 2g
X_syn_23_1 a_xp23 a_xn23 wp_23_1 wn_23_1 mop1 mon1 vdd vbsyn gsyn
Cwp_24_1 wp_24_1 0 20p
Cwn_24_1 wn_24_1 0 20p
Rwp_24_1 wp_24_1 wcm 2g
Rwn_24_1 wn_24_1 wcm 2g
X_syn_24_1 a_xp24 a_xn24 wp_24_1 wn_24_1 mop1 mon1 vdd vbsyn gsyn
Cwp_25_1 wp_25_1 0 20p
Cwn_25_1 wn_25_1 0 20p
Rwp_25_1 wp_25_1 wcm 2g
Rwn_25_1 wn_25_1 wcm 2g
X_syn_25_1 a_xp25 a_xn25 wp_25_1 wn_25_1 mop1 mon1 vdd vbsyn gsyn
Cwp_26_1 wp_26_1 0 20p
Cwn_26_1 wn_26_1 0 20p
Rwp_26_1 wp_26_1 wcm 2g
Rwn_26_1 wn_26_1 wcm 2g
X_syn_26_1 a_xp26 a_xn26 wp_26_1 wn_26_1 mop1 mon1 vdd vbsyn gsyn
Cwp_27_1 wp_27_1 0 20p
Cwn_27_1 wn_27_1 0 20p
Rwp_27_1 wp_27_1 wcm 2g
Rwn_27_1 wn_27_1 wcm 2g
X_syn_27_1 a_xp27 a_xn27 wp_27_1 wn_27_1 mop1 mon1 vdd vbsyn gsyn
Cwp_28_1 wp_28_1 0 20p
Cwn_28_1 wn_28_1 0 20p
Rwp_28_1 wp_28_1 wcm 2g
Rwn_28_1 wn_28_1 wcm 2g
X_syn_28_1 a_xp28 a_xn28 wp_28_1 wn_28_1 mop1 mon1 vdd vbsyn gsyn
Cwp_29_1 wp_29_1 0 20p
Cwn_29_1 wn_29_1 0 20p
Rwp_29_1 wp_29_1 wcm 2g
Rwn_29_1 wn_29_1 wcm 2g
X_syn_29_1 a_xp29 a_xn29 wp_29_1 wn_29_1 mop1 mon1 vdd vbsyn gsyn
Cwp_30_1 wp_30_1 0 20p
Cwn_30_1 wn_30_1 0 20p
Rwp_30_1 wp_30_1 wcm 2g
Rwn_30_1 wn_30_1 wcm 2g
X_syn_30_1 a_xp30 a_xn30 wp_30_1 wn_30_1 mop1 mon1 vdd vbsyn gsyn
Cwp_31_1 wp_31_1 0 20p
Cwn_31_1 wn_31_1 0 20p
Rwp_31_1 wp_31_1 wcm 2g
Rwn_31_1 wn_31_1 wcm 2g
X_syn_31_1 a_xp31 a_xn31 wp_31_1 wn_31_1 mop1 mon1 vdd vbsyn gsyn
Cwp_32_1 wp_32_1 0 20p
Cwn_32_1 wn_32_1 0 20p
Rwp_32_1 wp_32_1 wcm 2g
Rwn_32_1 wn_32_1 wcm 2g
X_syn_32_1 a_xp32 a_xn32 wp_32_1 wn_32_1 mop1 mon1 vdd vbsyn gsyn
Cwp_33_1 wp_33_1 0 20p
Cwn_33_1 wn_33_1 0 20p
Rwp_33_1 wp_33_1 wcm 2g
Rwn_33_1 wn_33_1 wcm 2g
X_syn_33_1 a_xp33 a_xn33 wp_33_1 wn_33_1 mop1 mon1 vdd vbsyn gsyn
Cwp_34_1 wp_34_1 0 20p
Cwn_34_1 wn_34_1 0 20p
Rwp_34_1 wp_34_1 wcm 2g
Rwn_34_1 wn_34_1 wcm 2g
X_syn_34_1 a_xp34 a_xn34 wp_34_1 wn_34_1 mop1 mon1 vdd vbsyn gsyn
Cwp_35_1 wp_35_1 0 20p
Cwn_35_1 wn_35_1 0 20p
Rwp_35_1 wp_35_1 wcm 2g
Rwn_35_1 wn_35_1 wcm 2g
X_syn_35_1 a_xp35 a_xn35 wp_35_1 wn_35_1 mop1 mon1 vdd vbsyn gsyn
Cwp_36_1 wp_36_1 0 20p
Cwn_36_1 wn_36_1 0 20p
Rwp_36_1 wp_36_1 wcm 2g
Rwn_36_1 wn_36_1 wcm 2g
X_syn_36_1 a_xp36 a_xn36 wp_36_1 wn_36_1 mop1 mon1 vdd vbsyn gsyn
Cwp_37_1 wp_37_1 0 20p
Cwn_37_1 wn_37_1 0 20p
Rwp_37_1 wp_37_1 wcm 2g
Rwn_37_1 wn_37_1 wcm 2g
X_syn_37_1 a_xp37 a_xn37 wp_37_1 wn_37_1 mop1 mon1 vdd vbsyn gsyn
Cwp_38_1 wp_38_1 0 20p
Cwn_38_1 wn_38_1 0 20p
Rwp_38_1 wp_38_1 wcm 2g
Rwn_38_1 wn_38_1 wcm 2g
X_syn_38_1 a_xp38 a_xn38 wp_38_1 wn_38_1 mop1 mon1 vdd vbsyn gsyn
Cwp_39_1 wp_39_1 0 20p
Cwn_39_1 wn_39_1 0 20p
Rwp_39_1 wp_39_1 wcm 2g
Rwn_39_1 wn_39_1 wcm 2g
X_syn_39_1 a_xp39 a_xn39 wp_39_1 wn_39_1 mop1 mon1 vdd vbsyn gsyn
Cwp_40_1 wp_40_1 0 20p
Cwn_40_1 wn_40_1 0 20p
Rwp_40_1 wp_40_1 wcm 2g
Rwn_40_1 wn_40_1 wcm 2g
X_syn_40_1 a_xp40 a_xn40 wp_40_1 wn_40_1 mop1 mon1 vdd vbsyn gsyn
Cwp_41_1 wp_41_1 0 20p
Cwn_41_1 wn_41_1 0 20p
Rwp_41_1 wp_41_1 wcm 2g
Rwn_41_1 wn_41_1 wcm 2g
X_syn_41_1 a_xp41 a_xn41 wp_41_1 wn_41_1 mop1 mon1 vdd vbsyn gsyn
Cwp_42_1 wp_42_1 0 20p
Cwn_42_1 wn_42_1 0 20p
Rwp_42_1 wp_42_1 wcm 2g
Rwn_42_1 wn_42_1 wcm 2g
X_syn_42_1 a_xp42 a_xn42 wp_42_1 wn_42_1 mop1 mon1 vdd vbsyn gsyn
Cwp_43_1 wp_43_1 0 20p
Cwn_43_1 wn_43_1 0 20p
Rwp_43_1 wp_43_1 wcm 2g
Rwn_43_1 wn_43_1 wcm 2g
X_syn_43_1 a_xp43 a_xn43 wp_43_1 wn_43_1 mop1 mon1 vdd vbsyn gsyn
Cwp_44_1 wp_44_1 0 20p
Cwn_44_1 wn_44_1 0 20p
Rwp_44_1 wp_44_1 wcm 2g
Rwn_44_1 wn_44_1 wcm 2g
X_syn_44_1 a_xp44 a_xn44 wp_44_1 wn_44_1 mop1 mon1 vdd vbsyn gsyn
Cwp_45_1 wp_45_1 0 20p
Cwn_45_1 wn_45_1 0 20p
Rwp_45_1 wp_45_1 wcm 2g
Rwn_45_1 wn_45_1 wcm 2g
X_syn_45_1 a_xp45 a_xn45 wp_45_1 wn_45_1 mop1 mon1 vdd vbsyn gsyn
Cwp_46_1 wp_46_1 0 20p
Cwn_46_1 wn_46_1 0 20p
Rwp_46_1 wp_46_1 wcm 2g
Rwn_46_1 wn_46_1 wcm 2g
X_syn_46_1 a_xp46 a_xn46 wp_46_1 wn_46_1 mop1 mon1 vdd vbsyn gsyn
Cwp_47_1 wp_47_1 0 20p
Cwn_47_1 wn_47_1 0 20p
Rwp_47_1 wp_47_1 wcm 2g
Rwn_47_1 wn_47_1 wcm 2g
X_syn_47_1 a_xp47 a_xn47 wp_47_1 wn_47_1 mop1 mon1 vdd vbsyn gsyn
Cwp_48_1 wp_48_1 0 20p
Cwn_48_1 wn_48_1 0 20p
Rwp_48_1 wp_48_1 wcm 2g
Rwn_48_1 wn_48_1 wcm 2g
X_syn_48_1 a_xp48 a_xn48 wp_48_1 wn_48_1 mop1 mon1 vdd vbsyn gsyn
Cwp_49_1 wp_49_1 0 20p
Cwn_49_1 wn_49_1 0 20p
Rwp_49_1 wp_49_1 wcm 2g
Rwn_49_1 wn_49_1 wcm 2g
X_syn_49_1 a_xp49 a_xn49 wp_49_1 wn_49_1 mop1 mon1 vdd vbsyn gsyn
Cwp_50_1 wp_50_1 0 20p
Cwn_50_1 wn_50_1 0 20p
Rwp_50_1 wp_50_1 wcm 2g
Rwn_50_1 wn_50_1 wcm 2g
X_syn_50_1 a_xp50 a_xn50 wp_50_1 wn_50_1 mop1 mon1 vdd vbsyn gsyn
Cwp_51_1 wp_51_1 0 20p
Cwn_51_1 wn_51_1 0 20p
Rwp_51_1 wp_51_1 wcm 2g
Rwn_51_1 wn_51_1 wcm 2g
X_syn_51_1 a_xp51 a_xn51 wp_51_1 wn_51_1 mop1 mon1 vdd vbsyn gsyn
Cwp_52_1 wp_52_1 0 20p
Cwn_52_1 wn_52_1 0 20p
Rwp_52_1 wp_52_1 wcm 2g
Rwn_52_1 wn_52_1 wcm 2g
X_syn_52_1 a_xp52 a_xn52 wp_52_1 wn_52_1 mop1 mon1 vdd vbsyn gsyn
Cwp_53_1 wp_53_1 0 20p
Cwn_53_1 wn_53_1 0 20p
Rwp_53_1 wp_53_1 wcm 2g
Rwn_53_1 wn_53_1 wcm 2g
X_syn_53_1 a_xp53 a_xn53 wp_53_1 wn_53_1 mop1 mon1 vdd vbsyn gsyn
Cwp_54_1 wp_54_1 0 20p
Cwn_54_1 wn_54_1 0 20p
Rwp_54_1 wp_54_1 wcm 2g
Rwn_54_1 wn_54_1 wcm 2g
X_syn_54_1 a_xp54 a_xn54 wp_54_1 wn_54_1 mop1 mon1 vdd vbsyn gsyn
Cwp_55_1 wp_55_1 0 20p
Cwn_55_1 wn_55_1 0 20p
Rwp_55_1 wp_55_1 wcm 2g
Rwn_55_1 wn_55_1 wcm 2g
X_syn_55_1 a_xp55 a_xn55 wp_55_1 wn_55_1 mop1 mon1 vdd vbsyn gsyn
Cwp_56_1 wp_56_1 0 20p
Cwn_56_1 wn_56_1 0 20p
Rwp_56_1 wp_56_1 wcm 2g
Rwn_56_1 wn_56_1 wcm 2g
X_syn_56_1 a_xp56 a_xn56 wp_56_1 wn_56_1 mop1 mon1 vdd vbsyn gsyn
Cwp_57_1 wp_57_1 0 20p
Cwn_57_1 wn_57_1 0 20p
Rwp_57_1 wp_57_1 wcm 2g
Rwn_57_1 wn_57_1 wcm 2g
X_syn_57_1 a_xp57 a_xn57 wp_57_1 wn_57_1 mop1 mon1 vdd vbsyn gsyn
Cwp_58_1 wp_58_1 0 20p
Cwn_58_1 wn_58_1 0 20p
Rwp_58_1 wp_58_1 wcm 2g
Rwn_58_1 wn_58_1 wcm 2g
X_syn_58_1 a_xp58 a_xn58 wp_58_1 wn_58_1 mop1 mon1 vdd vbsyn gsyn
Cwp_59_1 wp_59_1 0 20p
Cwn_59_1 wn_59_1 0 20p
Rwp_59_1 wp_59_1 wcm 2g
Rwn_59_1 wn_59_1 wcm 2g
X_syn_59_1 a_xp59 a_xn59 wp_59_1 wn_59_1 mop1 mon1 vdd vbsyn gsyn
Cwp_60_1 wp_60_1 0 20p
Cwn_60_1 wn_60_1 0 20p
Rwp_60_1 wp_60_1 wcm 2g
Rwn_60_1 wn_60_1 wcm 2g
X_syn_60_1 a_xp60 a_xn60 wp_60_1 wn_60_1 mop1 mon1 vdd vbsyn gsyn
Cwp_61_1 wp_61_1 0 20p
Cwn_61_1 wn_61_1 0 20p
Rwp_61_1 wp_61_1 wcm 2g
Rwn_61_1 wn_61_1 wcm 2g
X_syn_61_1 a_xp61 a_xn61 wp_61_1 wn_61_1 mop1 mon1 vdd vbsyn gsyn
Cwp_62_1 wp_62_1 0 20p
Cwn_62_1 wn_62_1 0 20p
Rwp_62_1 wp_62_1 wcm 2g
Rwn_62_1 wn_62_1 wcm 2g
X_syn_62_1 a_xp62 a_xn62 wp_62_1 wn_62_1 mop1 mon1 vdd vbsyn gsyn
Cwp_63_1 wp_63_1 0 20p
Cwn_63_1 wn_63_1 0 20p
Rwp_63_1 wp_63_1 wcm 2g
Rwn_63_1 wn_63_1 wcm 2g
X_syn_63_1 a_xp63 a_xn63 wp_63_1 wn_63_1 mop1 mon1 vdd vbsyn gsyn
Xcm_mo1 mop1 mon1 vdd cmld
Rmo1 mop1 mon1 40k
Xeo1 xop1 xon1 mop1 mon1 eop1 eon1 vdd gm esub
X_lrn_0_1 eop1 eon1 a_xp0 a_xn0 wp_0_1 wn_0_1 vdd gbl gprod
X_lrn_1_1 eop1 eon1 a_xp1 a_xn1 wp_1_1 wn_1_1 vdd gbl gprod
X_lrn_2_1 eop1 eon1 a_xp2 a_xn2 wp_2_1 wn_2_1 vdd gbl gprod
X_lrn_3_1 eop1 eon1 a_xp3 a_xn3 wp_3_1 wn_3_1 vdd gbl gprod
X_lrn_4_1 eop1 eon1 a_xp4 a_xn4 wp_4_1 wn_4_1 vdd gbl gprod
X_lrn_5_1 eop1 eon1 a_xp5 a_xn5 wp_5_1 wn_5_1 vdd gbl gprod
X_lrn_6_1 eop1 eon1 a_xp6 a_xn6 wp_6_1 wn_6_1 vdd gbl gprod
X_lrn_7_1 eop1 eon1 a_xp7 a_xn7 wp_7_1 wn_7_1 vdd gbl gprod
X_lrn_8_1 eop1 eon1 a_xp8 a_xn8 wp_8_1 wn_8_1 vdd gbl gprod
X_lrn_9_1 eop1 eon1 a_xp9 a_xn9 wp_9_1 wn_9_1 vdd gbl gprod
X_lrn_10_1 eop1 eon1 a_xp10 a_xn10 wp_10_1 wn_10_1 vdd gbl gprod
X_lrn_11_1 eop1 eon1 a_xp11 a_xn11 wp_11_1 wn_11_1 vdd gbl gprod
X_lrn_12_1 eop1 eon1 a_xp12 a_xn12 wp_12_1 wn_12_1 vdd gbl gprod
X_lrn_13_1 eop1 eon1 a_xp13 a_xn13 wp_13_1 wn_13_1 vdd gbl gprod
X_lrn_14_1 eop1 eon1 a_xp14 a_xn14 wp_14_1 wn_14_1 vdd gbl gprod
X_lrn_15_1 eop1 eon1 a_xp15 a_xn15 wp_15_1 wn_15_1 vdd gbl gprod
X_lrn_16_1 eop1 eon1 a_xp16 a_xn16 wp_16_1 wn_16_1 vdd gbl gprod
X_lrn_17_1 eop1 eon1 a_xp17 a_xn17 wp_17_1 wn_17_1 vdd gbl gprod
X_lrn_18_1 eop1 eon1 a_xp18 a_xn18 wp_18_1 wn_18_1 vdd gbl gprod
X_lrn_19_1 eop1 eon1 a_xp19 a_xn19 wp_19_1 wn_19_1 vdd gbl gprod
X_lrn_20_1 eop1 eon1 a_xp20 a_xn20 wp_20_1 wn_20_1 vdd gbl gprod
X_lrn_21_1 eop1 eon1 a_xp21 a_xn21 wp_21_1 wn_21_1 vdd gbl gprod
X_lrn_22_1 eop1 eon1 a_xp22 a_xn22 wp_22_1 wn_22_1 vdd gbl gprod
X_lrn_23_1 eop1 eon1 a_xp23 a_xn23 wp_23_1 wn_23_1 vdd gbl gprod
X_lrn_24_1 eop1 eon1 a_xp24 a_xn24 wp_24_1 wn_24_1 vdd gbl gprod
X_lrn_25_1 eop1 eon1 a_xp25 a_xn25 wp_25_1 wn_25_1 vdd gbl gprod
X_lrn_26_1 eop1 eon1 a_xp26 a_xn26 wp_26_1 wn_26_1 vdd gbl gprod
X_lrn_27_1 eop1 eon1 a_xp27 a_xn27 wp_27_1 wn_27_1 vdd gbl gprod
X_lrn_28_1 eop1 eon1 a_xp28 a_xn28 wp_28_1 wn_28_1 vdd gbl gprod
X_lrn_29_1 eop1 eon1 a_xp29 a_xn29 wp_29_1 wn_29_1 vdd gbl gprod
X_lrn_30_1 eop1 eon1 a_xp30 a_xn30 wp_30_1 wn_30_1 vdd gbl gprod
X_lrn_31_1 eop1 eon1 a_xp31 a_xn31 wp_31_1 wn_31_1 vdd gbl gprod
X_lrn_32_1 eop1 eon1 a_xp32 a_xn32 wp_32_1 wn_32_1 vdd gbl gprod
X_lrn_33_1 eop1 eon1 a_xp33 a_xn33 wp_33_1 wn_33_1 vdd gbl gprod
X_lrn_34_1 eop1 eon1 a_xp34 a_xn34 wp_34_1 wn_34_1 vdd gbl gprod
X_lrn_35_1 eop1 eon1 a_xp35 a_xn35 wp_35_1 wn_35_1 vdd gbl gprod
X_lrn_36_1 eop1 eon1 a_xp36 a_xn36 wp_36_1 wn_36_1 vdd gbl gprod
X_lrn_37_1 eop1 eon1 a_xp37 a_xn37 wp_37_1 wn_37_1 vdd gbl gprod
X_lrn_38_1 eop1 eon1 a_xp38 a_xn38 wp_38_1 wn_38_1 vdd gbl gprod
X_lrn_39_1 eop1 eon1 a_xp39 a_xn39 wp_39_1 wn_39_1 vdd gbl gprod
X_lrn_40_1 eop1 eon1 a_xp40 a_xn40 wp_40_1 wn_40_1 vdd gbl gprod
X_lrn_41_1 eop1 eon1 a_xp41 a_xn41 wp_41_1 wn_41_1 vdd gbl gprod
X_lrn_42_1 eop1 eon1 a_xp42 a_xn42 wp_42_1 wn_42_1 vdd gbl gprod
X_lrn_43_1 eop1 eon1 a_xp43 a_xn43 wp_43_1 wn_43_1 vdd gbl gprod
X_lrn_44_1 eop1 eon1 a_xp44 a_xn44 wp_44_1 wn_44_1 vdd gbl gprod
X_lrn_45_1 eop1 eon1 a_xp45 a_xn45 wp_45_1 wn_45_1 vdd gbl gprod
X_lrn_46_1 eop1 eon1 a_xp46 a_xn46 wp_46_1 wn_46_1 vdd gbl gprod
X_lrn_47_1 eop1 eon1 a_xp47 a_xn47 wp_47_1 wn_47_1 vdd gbl gprod
X_lrn_48_1 eop1 eon1 a_xp48 a_xn48 wp_48_1 wn_48_1 vdd gbl gprod
X_lrn_49_1 eop1 eon1 a_xp49 a_xn49 wp_49_1 wn_49_1 vdd gbl gprod
X_lrn_50_1 eop1 eon1 a_xp50 a_xn50 wp_50_1 wn_50_1 vdd gbl gprod
X_lrn_51_1 eop1 eon1 a_xp51 a_xn51 wp_51_1 wn_51_1 vdd gbl gprod
X_lrn_52_1 eop1 eon1 a_xp52 a_xn52 wp_52_1 wn_52_1 vdd gbl gprod
X_lrn_53_1 eop1 eon1 a_xp53 a_xn53 wp_53_1 wn_53_1 vdd gbl gprod
X_lrn_54_1 eop1 eon1 a_xp54 a_xn54 wp_54_1 wn_54_1 vdd gbl gprod
X_lrn_55_1 eop1 eon1 a_xp55 a_xn55 wp_55_1 wn_55_1 vdd gbl gprod
X_lrn_56_1 eop1 eon1 a_xp56 a_xn56 wp_56_1 wn_56_1 vdd gbl gprod
X_lrn_57_1 eop1 eon1 a_xp57 a_xn57 wp_57_1 wn_57_1 vdd gbl gprod
X_lrn_58_1 eop1 eon1 a_xp58 a_xn58 wp_58_1 wn_58_1 vdd gbl gprod
X_lrn_59_1 eop1 eon1 a_xp59 a_xn59 wp_59_1 wn_59_1 vdd gbl gprod
X_lrn_60_1 eop1 eon1 a_xp60 a_xn60 wp_60_1 wn_60_1 vdd gbl gprod
X_lrn_61_1 eop1 eon1 a_xp61 a_xn61 wp_61_1 wn_61_1 vdd gbl gprod
X_lrn_62_1 eop1 eon1 a_xp62 a_xn62 wp_62_1 wn_62_1 vdd gbl gprod
X_lrn_63_1 eop1 eon1 a_xp63 a_xn63 wp_63_1 wn_63_1 vdd gbl gprod
Cwp_0_2 wp_0_2 0 20p
Cwn_0_2 wn_0_2 0 20p
Rwp_0_2 wp_0_2 wcm 2g
Rwn_0_2 wn_0_2 wcm 2g
X_syn_0_2 a_xp0 a_xn0 wp_0_2 wn_0_2 mop2 mon2 vdd vbsyn gsyn
Cwp_1_2 wp_1_2 0 20p
Cwn_1_2 wn_1_2 0 20p
Rwp_1_2 wp_1_2 wcm 2g
Rwn_1_2 wn_1_2 wcm 2g
X_syn_1_2 a_xp1 a_xn1 wp_1_2 wn_1_2 mop2 mon2 vdd vbsyn gsyn
Cwp_2_2 wp_2_2 0 20p
Cwn_2_2 wn_2_2 0 20p
Rwp_2_2 wp_2_2 wcm 2g
Rwn_2_2 wn_2_2 wcm 2g
X_syn_2_2 a_xp2 a_xn2 wp_2_2 wn_2_2 mop2 mon2 vdd vbsyn gsyn
Cwp_3_2 wp_3_2 0 20p
Cwn_3_2 wn_3_2 0 20p
Rwp_3_2 wp_3_2 wcm 2g
Rwn_3_2 wn_3_2 wcm 2g
X_syn_3_2 a_xp3 a_xn3 wp_3_2 wn_3_2 mop2 mon2 vdd vbsyn gsyn
Cwp_4_2 wp_4_2 0 20p
Cwn_4_2 wn_4_2 0 20p
Rwp_4_2 wp_4_2 wcm 2g
Rwn_4_2 wn_4_2 wcm 2g
X_syn_4_2 a_xp4 a_xn4 wp_4_2 wn_4_2 mop2 mon2 vdd vbsyn gsyn
Cwp_5_2 wp_5_2 0 20p
Cwn_5_2 wn_5_2 0 20p
Rwp_5_2 wp_5_2 wcm 2g
Rwn_5_2 wn_5_2 wcm 2g
X_syn_5_2 a_xp5 a_xn5 wp_5_2 wn_5_2 mop2 mon2 vdd vbsyn gsyn
Cwp_6_2 wp_6_2 0 20p
Cwn_6_2 wn_6_2 0 20p
Rwp_6_2 wp_6_2 wcm 2g
Rwn_6_2 wn_6_2 wcm 2g
X_syn_6_2 a_xp6 a_xn6 wp_6_2 wn_6_2 mop2 mon2 vdd vbsyn gsyn
Cwp_7_2 wp_7_2 0 20p
Cwn_7_2 wn_7_2 0 20p
Rwp_7_2 wp_7_2 wcm 2g
Rwn_7_2 wn_7_2 wcm 2g
X_syn_7_2 a_xp7 a_xn7 wp_7_2 wn_7_2 mop2 mon2 vdd vbsyn gsyn
Cwp_8_2 wp_8_2 0 20p
Cwn_8_2 wn_8_2 0 20p
Rwp_8_2 wp_8_2 wcm 2g
Rwn_8_2 wn_8_2 wcm 2g
X_syn_8_2 a_xp8 a_xn8 wp_8_2 wn_8_2 mop2 mon2 vdd vbsyn gsyn
Cwp_9_2 wp_9_2 0 20p
Cwn_9_2 wn_9_2 0 20p
Rwp_9_2 wp_9_2 wcm 2g
Rwn_9_2 wn_9_2 wcm 2g
X_syn_9_2 a_xp9 a_xn9 wp_9_2 wn_9_2 mop2 mon2 vdd vbsyn gsyn
Cwp_10_2 wp_10_2 0 20p
Cwn_10_2 wn_10_2 0 20p
Rwp_10_2 wp_10_2 wcm 2g
Rwn_10_2 wn_10_2 wcm 2g
X_syn_10_2 a_xp10 a_xn10 wp_10_2 wn_10_2 mop2 mon2 vdd vbsyn gsyn
Cwp_11_2 wp_11_2 0 20p
Cwn_11_2 wn_11_2 0 20p
Rwp_11_2 wp_11_2 wcm 2g
Rwn_11_2 wn_11_2 wcm 2g
X_syn_11_2 a_xp11 a_xn11 wp_11_2 wn_11_2 mop2 mon2 vdd vbsyn gsyn
Cwp_12_2 wp_12_2 0 20p
Cwn_12_2 wn_12_2 0 20p
Rwp_12_2 wp_12_2 wcm 2g
Rwn_12_2 wn_12_2 wcm 2g
X_syn_12_2 a_xp12 a_xn12 wp_12_2 wn_12_2 mop2 mon2 vdd vbsyn gsyn
Cwp_13_2 wp_13_2 0 20p
Cwn_13_2 wn_13_2 0 20p
Rwp_13_2 wp_13_2 wcm 2g
Rwn_13_2 wn_13_2 wcm 2g
X_syn_13_2 a_xp13 a_xn13 wp_13_2 wn_13_2 mop2 mon2 vdd vbsyn gsyn
Cwp_14_2 wp_14_2 0 20p
Cwn_14_2 wn_14_2 0 20p
Rwp_14_2 wp_14_2 wcm 2g
Rwn_14_2 wn_14_2 wcm 2g
X_syn_14_2 a_xp14 a_xn14 wp_14_2 wn_14_2 mop2 mon2 vdd vbsyn gsyn
Cwp_15_2 wp_15_2 0 20p
Cwn_15_2 wn_15_2 0 20p
Rwp_15_2 wp_15_2 wcm 2g
Rwn_15_2 wn_15_2 wcm 2g
X_syn_15_2 a_xp15 a_xn15 wp_15_2 wn_15_2 mop2 mon2 vdd vbsyn gsyn
Cwp_16_2 wp_16_2 0 20p
Cwn_16_2 wn_16_2 0 20p
Rwp_16_2 wp_16_2 wcm 2g
Rwn_16_2 wn_16_2 wcm 2g
X_syn_16_2 a_xp16 a_xn16 wp_16_2 wn_16_2 mop2 mon2 vdd vbsyn gsyn
Cwp_17_2 wp_17_2 0 20p
Cwn_17_2 wn_17_2 0 20p
Rwp_17_2 wp_17_2 wcm 2g
Rwn_17_2 wn_17_2 wcm 2g
X_syn_17_2 a_xp17 a_xn17 wp_17_2 wn_17_2 mop2 mon2 vdd vbsyn gsyn
Cwp_18_2 wp_18_2 0 20p
Cwn_18_2 wn_18_2 0 20p
Rwp_18_2 wp_18_2 wcm 2g
Rwn_18_2 wn_18_2 wcm 2g
X_syn_18_2 a_xp18 a_xn18 wp_18_2 wn_18_2 mop2 mon2 vdd vbsyn gsyn
Cwp_19_2 wp_19_2 0 20p
Cwn_19_2 wn_19_2 0 20p
Rwp_19_2 wp_19_2 wcm 2g
Rwn_19_2 wn_19_2 wcm 2g
X_syn_19_2 a_xp19 a_xn19 wp_19_2 wn_19_2 mop2 mon2 vdd vbsyn gsyn
Cwp_20_2 wp_20_2 0 20p
Cwn_20_2 wn_20_2 0 20p
Rwp_20_2 wp_20_2 wcm 2g
Rwn_20_2 wn_20_2 wcm 2g
X_syn_20_2 a_xp20 a_xn20 wp_20_2 wn_20_2 mop2 mon2 vdd vbsyn gsyn
Cwp_21_2 wp_21_2 0 20p
Cwn_21_2 wn_21_2 0 20p
Rwp_21_2 wp_21_2 wcm 2g
Rwn_21_2 wn_21_2 wcm 2g
X_syn_21_2 a_xp21 a_xn21 wp_21_2 wn_21_2 mop2 mon2 vdd vbsyn gsyn
Cwp_22_2 wp_22_2 0 20p
Cwn_22_2 wn_22_2 0 20p
Rwp_22_2 wp_22_2 wcm 2g
Rwn_22_2 wn_22_2 wcm 2g
X_syn_22_2 a_xp22 a_xn22 wp_22_2 wn_22_2 mop2 mon2 vdd vbsyn gsyn
Cwp_23_2 wp_23_2 0 20p
Cwn_23_2 wn_23_2 0 20p
Rwp_23_2 wp_23_2 wcm 2g
Rwn_23_2 wn_23_2 wcm 2g
X_syn_23_2 a_xp23 a_xn23 wp_23_2 wn_23_2 mop2 mon2 vdd vbsyn gsyn
Cwp_24_2 wp_24_2 0 20p
Cwn_24_2 wn_24_2 0 20p
Rwp_24_2 wp_24_2 wcm 2g
Rwn_24_2 wn_24_2 wcm 2g
X_syn_24_2 a_xp24 a_xn24 wp_24_2 wn_24_2 mop2 mon2 vdd vbsyn gsyn
Cwp_25_2 wp_25_2 0 20p
Cwn_25_2 wn_25_2 0 20p
Rwp_25_2 wp_25_2 wcm 2g
Rwn_25_2 wn_25_2 wcm 2g
X_syn_25_2 a_xp25 a_xn25 wp_25_2 wn_25_2 mop2 mon2 vdd vbsyn gsyn
Cwp_26_2 wp_26_2 0 20p
Cwn_26_2 wn_26_2 0 20p
Rwp_26_2 wp_26_2 wcm 2g
Rwn_26_2 wn_26_2 wcm 2g
X_syn_26_2 a_xp26 a_xn26 wp_26_2 wn_26_2 mop2 mon2 vdd vbsyn gsyn
Cwp_27_2 wp_27_2 0 20p
Cwn_27_2 wn_27_2 0 20p
Rwp_27_2 wp_27_2 wcm 2g
Rwn_27_2 wn_27_2 wcm 2g
X_syn_27_2 a_xp27 a_xn27 wp_27_2 wn_27_2 mop2 mon2 vdd vbsyn gsyn
Cwp_28_2 wp_28_2 0 20p
Cwn_28_2 wn_28_2 0 20p
Rwp_28_2 wp_28_2 wcm 2g
Rwn_28_2 wn_28_2 wcm 2g
X_syn_28_2 a_xp28 a_xn28 wp_28_2 wn_28_2 mop2 mon2 vdd vbsyn gsyn
Cwp_29_2 wp_29_2 0 20p
Cwn_29_2 wn_29_2 0 20p
Rwp_29_2 wp_29_2 wcm 2g
Rwn_29_2 wn_29_2 wcm 2g
X_syn_29_2 a_xp29 a_xn29 wp_29_2 wn_29_2 mop2 mon2 vdd vbsyn gsyn
Cwp_30_2 wp_30_2 0 20p
Cwn_30_2 wn_30_2 0 20p
Rwp_30_2 wp_30_2 wcm 2g
Rwn_30_2 wn_30_2 wcm 2g
X_syn_30_2 a_xp30 a_xn30 wp_30_2 wn_30_2 mop2 mon2 vdd vbsyn gsyn
Cwp_31_2 wp_31_2 0 20p
Cwn_31_2 wn_31_2 0 20p
Rwp_31_2 wp_31_2 wcm 2g
Rwn_31_2 wn_31_2 wcm 2g
X_syn_31_2 a_xp31 a_xn31 wp_31_2 wn_31_2 mop2 mon2 vdd vbsyn gsyn
Cwp_32_2 wp_32_2 0 20p
Cwn_32_2 wn_32_2 0 20p
Rwp_32_2 wp_32_2 wcm 2g
Rwn_32_2 wn_32_2 wcm 2g
X_syn_32_2 a_xp32 a_xn32 wp_32_2 wn_32_2 mop2 mon2 vdd vbsyn gsyn
Cwp_33_2 wp_33_2 0 20p
Cwn_33_2 wn_33_2 0 20p
Rwp_33_2 wp_33_2 wcm 2g
Rwn_33_2 wn_33_2 wcm 2g
X_syn_33_2 a_xp33 a_xn33 wp_33_2 wn_33_2 mop2 mon2 vdd vbsyn gsyn
Cwp_34_2 wp_34_2 0 20p
Cwn_34_2 wn_34_2 0 20p
Rwp_34_2 wp_34_2 wcm 2g
Rwn_34_2 wn_34_2 wcm 2g
X_syn_34_2 a_xp34 a_xn34 wp_34_2 wn_34_2 mop2 mon2 vdd vbsyn gsyn
Cwp_35_2 wp_35_2 0 20p
Cwn_35_2 wn_35_2 0 20p
Rwp_35_2 wp_35_2 wcm 2g
Rwn_35_2 wn_35_2 wcm 2g
X_syn_35_2 a_xp35 a_xn35 wp_35_2 wn_35_2 mop2 mon2 vdd vbsyn gsyn
Cwp_36_2 wp_36_2 0 20p
Cwn_36_2 wn_36_2 0 20p
Rwp_36_2 wp_36_2 wcm 2g
Rwn_36_2 wn_36_2 wcm 2g
X_syn_36_2 a_xp36 a_xn36 wp_36_2 wn_36_2 mop2 mon2 vdd vbsyn gsyn
Cwp_37_2 wp_37_2 0 20p
Cwn_37_2 wn_37_2 0 20p
Rwp_37_2 wp_37_2 wcm 2g
Rwn_37_2 wn_37_2 wcm 2g
X_syn_37_2 a_xp37 a_xn37 wp_37_2 wn_37_2 mop2 mon2 vdd vbsyn gsyn
Cwp_38_2 wp_38_2 0 20p
Cwn_38_2 wn_38_2 0 20p
Rwp_38_2 wp_38_2 wcm 2g
Rwn_38_2 wn_38_2 wcm 2g
X_syn_38_2 a_xp38 a_xn38 wp_38_2 wn_38_2 mop2 mon2 vdd vbsyn gsyn
Cwp_39_2 wp_39_2 0 20p
Cwn_39_2 wn_39_2 0 20p
Rwp_39_2 wp_39_2 wcm 2g
Rwn_39_2 wn_39_2 wcm 2g
X_syn_39_2 a_xp39 a_xn39 wp_39_2 wn_39_2 mop2 mon2 vdd vbsyn gsyn
Cwp_40_2 wp_40_2 0 20p
Cwn_40_2 wn_40_2 0 20p
Rwp_40_2 wp_40_2 wcm 2g
Rwn_40_2 wn_40_2 wcm 2g
X_syn_40_2 a_xp40 a_xn40 wp_40_2 wn_40_2 mop2 mon2 vdd vbsyn gsyn
Cwp_41_2 wp_41_2 0 20p
Cwn_41_2 wn_41_2 0 20p
Rwp_41_2 wp_41_2 wcm 2g
Rwn_41_2 wn_41_2 wcm 2g
X_syn_41_2 a_xp41 a_xn41 wp_41_2 wn_41_2 mop2 mon2 vdd vbsyn gsyn
Cwp_42_2 wp_42_2 0 20p
Cwn_42_2 wn_42_2 0 20p
Rwp_42_2 wp_42_2 wcm 2g
Rwn_42_2 wn_42_2 wcm 2g
X_syn_42_2 a_xp42 a_xn42 wp_42_2 wn_42_2 mop2 mon2 vdd vbsyn gsyn
Cwp_43_2 wp_43_2 0 20p
Cwn_43_2 wn_43_2 0 20p
Rwp_43_2 wp_43_2 wcm 2g
Rwn_43_2 wn_43_2 wcm 2g
X_syn_43_2 a_xp43 a_xn43 wp_43_2 wn_43_2 mop2 mon2 vdd vbsyn gsyn
Cwp_44_2 wp_44_2 0 20p
Cwn_44_2 wn_44_2 0 20p
Rwp_44_2 wp_44_2 wcm 2g
Rwn_44_2 wn_44_2 wcm 2g
X_syn_44_2 a_xp44 a_xn44 wp_44_2 wn_44_2 mop2 mon2 vdd vbsyn gsyn
Cwp_45_2 wp_45_2 0 20p
Cwn_45_2 wn_45_2 0 20p
Rwp_45_2 wp_45_2 wcm 2g
Rwn_45_2 wn_45_2 wcm 2g
X_syn_45_2 a_xp45 a_xn45 wp_45_2 wn_45_2 mop2 mon2 vdd vbsyn gsyn
Cwp_46_2 wp_46_2 0 20p
Cwn_46_2 wn_46_2 0 20p
Rwp_46_2 wp_46_2 wcm 2g
Rwn_46_2 wn_46_2 wcm 2g
X_syn_46_2 a_xp46 a_xn46 wp_46_2 wn_46_2 mop2 mon2 vdd vbsyn gsyn
Cwp_47_2 wp_47_2 0 20p
Cwn_47_2 wn_47_2 0 20p
Rwp_47_2 wp_47_2 wcm 2g
Rwn_47_2 wn_47_2 wcm 2g
X_syn_47_2 a_xp47 a_xn47 wp_47_2 wn_47_2 mop2 mon2 vdd vbsyn gsyn
Cwp_48_2 wp_48_2 0 20p
Cwn_48_2 wn_48_2 0 20p
Rwp_48_2 wp_48_2 wcm 2g
Rwn_48_2 wn_48_2 wcm 2g
X_syn_48_2 a_xp48 a_xn48 wp_48_2 wn_48_2 mop2 mon2 vdd vbsyn gsyn
Cwp_49_2 wp_49_2 0 20p
Cwn_49_2 wn_49_2 0 20p
Rwp_49_2 wp_49_2 wcm 2g
Rwn_49_2 wn_49_2 wcm 2g
X_syn_49_2 a_xp49 a_xn49 wp_49_2 wn_49_2 mop2 mon2 vdd vbsyn gsyn
Cwp_50_2 wp_50_2 0 20p
Cwn_50_2 wn_50_2 0 20p
Rwp_50_2 wp_50_2 wcm 2g
Rwn_50_2 wn_50_2 wcm 2g
X_syn_50_2 a_xp50 a_xn50 wp_50_2 wn_50_2 mop2 mon2 vdd vbsyn gsyn
Cwp_51_2 wp_51_2 0 20p
Cwn_51_2 wn_51_2 0 20p
Rwp_51_2 wp_51_2 wcm 2g
Rwn_51_2 wn_51_2 wcm 2g
X_syn_51_2 a_xp51 a_xn51 wp_51_2 wn_51_2 mop2 mon2 vdd vbsyn gsyn
Cwp_52_2 wp_52_2 0 20p
Cwn_52_2 wn_52_2 0 20p
Rwp_52_2 wp_52_2 wcm 2g
Rwn_52_2 wn_52_2 wcm 2g
X_syn_52_2 a_xp52 a_xn52 wp_52_2 wn_52_2 mop2 mon2 vdd vbsyn gsyn
Cwp_53_2 wp_53_2 0 20p
Cwn_53_2 wn_53_2 0 20p
Rwp_53_2 wp_53_2 wcm 2g
Rwn_53_2 wn_53_2 wcm 2g
X_syn_53_2 a_xp53 a_xn53 wp_53_2 wn_53_2 mop2 mon2 vdd vbsyn gsyn
Cwp_54_2 wp_54_2 0 20p
Cwn_54_2 wn_54_2 0 20p
Rwp_54_2 wp_54_2 wcm 2g
Rwn_54_2 wn_54_2 wcm 2g
X_syn_54_2 a_xp54 a_xn54 wp_54_2 wn_54_2 mop2 mon2 vdd vbsyn gsyn
Cwp_55_2 wp_55_2 0 20p
Cwn_55_2 wn_55_2 0 20p
Rwp_55_2 wp_55_2 wcm 2g
Rwn_55_2 wn_55_2 wcm 2g
X_syn_55_2 a_xp55 a_xn55 wp_55_2 wn_55_2 mop2 mon2 vdd vbsyn gsyn
Cwp_56_2 wp_56_2 0 20p
Cwn_56_2 wn_56_2 0 20p
Rwp_56_2 wp_56_2 wcm 2g
Rwn_56_2 wn_56_2 wcm 2g
X_syn_56_2 a_xp56 a_xn56 wp_56_2 wn_56_2 mop2 mon2 vdd vbsyn gsyn
Cwp_57_2 wp_57_2 0 20p
Cwn_57_2 wn_57_2 0 20p
Rwp_57_2 wp_57_2 wcm 2g
Rwn_57_2 wn_57_2 wcm 2g
X_syn_57_2 a_xp57 a_xn57 wp_57_2 wn_57_2 mop2 mon2 vdd vbsyn gsyn
Cwp_58_2 wp_58_2 0 20p
Cwn_58_2 wn_58_2 0 20p
Rwp_58_2 wp_58_2 wcm 2g
Rwn_58_2 wn_58_2 wcm 2g
X_syn_58_2 a_xp58 a_xn58 wp_58_2 wn_58_2 mop2 mon2 vdd vbsyn gsyn
Cwp_59_2 wp_59_2 0 20p
Cwn_59_2 wn_59_2 0 20p
Rwp_59_2 wp_59_2 wcm 2g
Rwn_59_2 wn_59_2 wcm 2g
X_syn_59_2 a_xp59 a_xn59 wp_59_2 wn_59_2 mop2 mon2 vdd vbsyn gsyn
Cwp_60_2 wp_60_2 0 20p
Cwn_60_2 wn_60_2 0 20p
Rwp_60_2 wp_60_2 wcm 2g
Rwn_60_2 wn_60_2 wcm 2g
X_syn_60_2 a_xp60 a_xn60 wp_60_2 wn_60_2 mop2 mon2 vdd vbsyn gsyn
Cwp_61_2 wp_61_2 0 20p
Cwn_61_2 wn_61_2 0 20p
Rwp_61_2 wp_61_2 wcm 2g
Rwn_61_2 wn_61_2 wcm 2g
X_syn_61_2 a_xp61 a_xn61 wp_61_2 wn_61_2 mop2 mon2 vdd vbsyn gsyn
Cwp_62_2 wp_62_2 0 20p
Cwn_62_2 wn_62_2 0 20p
Rwp_62_2 wp_62_2 wcm 2g
Rwn_62_2 wn_62_2 wcm 2g
X_syn_62_2 a_xp62 a_xn62 wp_62_2 wn_62_2 mop2 mon2 vdd vbsyn gsyn
Cwp_63_2 wp_63_2 0 20p
Cwn_63_2 wn_63_2 0 20p
Rwp_63_2 wp_63_2 wcm 2g
Rwn_63_2 wn_63_2 wcm 2g
X_syn_63_2 a_xp63 a_xn63 wp_63_2 wn_63_2 mop2 mon2 vdd vbsyn gsyn
Xcm_mo2 mop2 mon2 vdd cmld
Rmo2 mop2 mon2 40k
Xeo2 xop2 xon2 mop2 mon2 eop2 eon2 vdd gm esub
X_lrn_0_2 eop2 eon2 a_xp0 a_xn0 wp_0_2 wn_0_2 vdd gbl gprod
X_lrn_1_2 eop2 eon2 a_xp1 a_xn1 wp_1_2 wn_1_2 vdd gbl gprod
X_lrn_2_2 eop2 eon2 a_xp2 a_xn2 wp_2_2 wn_2_2 vdd gbl gprod
X_lrn_3_2 eop2 eon2 a_xp3 a_xn3 wp_3_2 wn_3_2 vdd gbl gprod
X_lrn_4_2 eop2 eon2 a_xp4 a_xn4 wp_4_2 wn_4_2 vdd gbl gprod
X_lrn_5_2 eop2 eon2 a_xp5 a_xn5 wp_5_2 wn_5_2 vdd gbl gprod
X_lrn_6_2 eop2 eon2 a_xp6 a_xn6 wp_6_2 wn_6_2 vdd gbl gprod
X_lrn_7_2 eop2 eon2 a_xp7 a_xn7 wp_7_2 wn_7_2 vdd gbl gprod
X_lrn_8_2 eop2 eon2 a_xp8 a_xn8 wp_8_2 wn_8_2 vdd gbl gprod
X_lrn_9_2 eop2 eon2 a_xp9 a_xn9 wp_9_2 wn_9_2 vdd gbl gprod
X_lrn_10_2 eop2 eon2 a_xp10 a_xn10 wp_10_2 wn_10_2 vdd gbl gprod
X_lrn_11_2 eop2 eon2 a_xp11 a_xn11 wp_11_2 wn_11_2 vdd gbl gprod
X_lrn_12_2 eop2 eon2 a_xp12 a_xn12 wp_12_2 wn_12_2 vdd gbl gprod
X_lrn_13_2 eop2 eon2 a_xp13 a_xn13 wp_13_2 wn_13_2 vdd gbl gprod
X_lrn_14_2 eop2 eon2 a_xp14 a_xn14 wp_14_2 wn_14_2 vdd gbl gprod
X_lrn_15_2 eop2 eon2 a_xp15 a_xn15 wp_15_2 wn_15_2 vdd gbl gprod
X_lrn_16_2 eop2 eon2 a_xp16 a_xn16 wp_16_2 wn_16_2 vdd gbl gprod
X_lrn_17_2 eop2 eon2 a_xp17 a_xn17 wp_17_2 wn_17_2 vdd gbl gprod
X_lrn_18_2 eop2 eon2 a_xp18 a_xn18 wp_18_2 wn_18_2 vdd gbl gprod
X_lrn_19_2 eop2 eon2 a_xp19 a_xn19 wp_19_2 wn_19_2 vdd gbl gprod
X_lrn_20_2 eop2 eon2 a_xp20 a_xn20 wp_20_2 wn_20_2 vdd gbl gprod
X_lrn_21_2 eop2 eon2 a_xp21 a_xn21 wp_21_2 wn_21_2 vdd gbl gprod
X_lrn_22_2 eop2 eon2 a_xp22 a_xn22 wp_22_2 wn_22_2 vdd gbl gprod
X_lrn_23_2 eop2 eon2 a_xp23 a_xn23 wp_23_2 wn_23_2 vdd gbl gprod
X_lrn_24_2 eop2 eon2 a_xp24 a_xn24 wp_24_2 wn_24_2 vdd gbl gprod
X_lrn_25_2 eop2 eon2 a_xp25 a_xn25 wp_25_2 wn_25_2 vdd gbl gprod
X_lrn_26_2 eop2 eon2 a_xp26 a_xn26 wp_26_2 wn_26_2 vdd gbl gprod
X_lrn_27_2 eop2 eon2 a_xp27 a_xn27 wp_27_2 wn_27_2 vdd gbl gprod
X_lrn_28_2 eop2 eon2 a_xp28 a_xn28 wp_28_2 wn_28_2 vdd gbl gprod
X_lrn_29_2 eop2 eon2 a_xp29 a_xn29 wp_29_2 wn_29_2 vdd gbl gprod
X_lrn_30_2 eop2 eon2 a_xp30 a_xn30 wp_30_2 wn_30_2 vdd gbl gprod
X_lrn_31_2 eop2 eon2 a_xp31 a_xn31 wp_31_2 wn_31_2 vdd gbl gprod
X_lrn_32_2 eop2 eon2 a_xp32 a_xn32 wp_32_2 wn_32_2 vdd gbl gprod
X_lrn_33_2 eop2 eon2 a_xp33 a_xn33 wp_33_2 wn_33_2 vdd gbl gprod
X_lrn_34_2 eop2 eon2 a_xp34 a_xn34 wp_34_2 wn_34_2 vdd gbl gprod
X_lrn_35_2 eop2 eon2 a_xp35 a_xn35 wp_35_2 wn_35_2 vdd gbl gprod
X_lrn_36_2 eop2 eon2 a_xp36 a_xn36 wp_36_2 wn_36_2 vdd gbl gprod
X_lrn_37_2 eop2 eon2 a_xp37 a_xn37 wp_37_2 wn_37_2 vdd gbl gprod
X_lrn_38_2 eop2 eon2 a_xp38 a_xn38 wp_38_2 wn_38_2 vdd gbl gprod
X_lrn_39_2 eop2 eon2 a_xp39 a_xn39 wp_39_2 wn_39_2 vdd gbl gprod
X_lrn_40_2 eop2 eon2 a_xp40 a_xn40 wp_40_2 wn_40_2 vdd gbl gprod
X_lrn_41_2 eop2 eon2 a_xp41 a_xn41 wp_41_2 wn_41_2 vdd gbl gprod
X_lrn_42_2 eop2 eon2 a_xp42 a_xn42 wp_42_2 wn_42_2 vdd gbl gprod
X_lrn_43_2 eop2 eon2 a_xp43 a_xn43 wp_43_2 wn_43_2 vdd gbl gprod
X_lrn_44_2 eop2 eon2 a_xp44 a_xn44 wp_44_2 wn_44_2 vdd gbl gprod
X_lrn_45_2 eop2 eon2 a_xp45 a_xn45 wp_45_2 wn_45_2 vdd gbl gprod
X_lrn_46_2 eop2 eon2 a_xp46 a_xn46 wp_46_2 wn_46_2 vdd gbl gprod
X_lrn_47_2 eop2 eon2 a_xp47 a_xn47 wp_47_2 wn_47_2 vdd gbl gprod
X_lrn_48_2 eop2 eon2 a_xp48 a_xn48 wp_48_2 wn_48_2 vdd gbl gprod
X_lrn_49_2 eop2 eon2 a_xp49 a_xn49 wp_49_2 wn_49_2 vdd gbl gprod
X_lrn_50_2 eop2 eon2 a_xp50 a_xn50 wp_50_2 wn_50_2 vdd gbl gprod
X_lrn_51_2 eop2 eon2 a_xp51 a_xn51 wp_51_2 wn_51_2 vdd gbl gprod
X_lrn_52_2 eop2 eon2 a_xp52 a_xn52 wp_52_2 wn_52_2 vdd gbl gprod
X_lrn_53_2 eop2 eon2 a_xp53 a_xn53 wp_53_2 wn_53_2 vdd gbl gprod
X_lrn_54_2 eop2 eon2 a_xp54 a_xn54 wp_54_2 wn_54_2 vdd gbl gprod
X_lrn_55_2 eop2 eon2 a_xp55 a_xn55 wp_55_2 wn_55_2 vdd gbl gprod
X_lrn_56_2 eop2 eon2 a_xp56 a_xn56 wp_56_2 wn_56_2 vdd gbl gprod
X_lrn_57_2 eop2 eon2 a_xp57 a_xn57 wp_57_2 wn_57_2 vdd gbl gprod
X_lrn_58_2 eop2 eon2 a_xp58 a_xn58 wp_58_2 wn_58_2 vdd gbl gprod
X_lrn_59_2 eop2 eon2 a_xp59 a_xn59 wp_59_2 wn_59_2 vdd gbl gprod
X_lrn_60_2 eop2 eon2 a_xp60 a_xn60 wp_60_2 wn_60_2 vdd gbl gprod
X_lrn_61_2 eop2 eon2 a_xp61 a_xn61 wp_61_2 wn_61_2 vdd gbl gprod
X_lrn_62_2 eop2 eon2 a_xp62 a_xn62 wp_62_2 wn_62_2 vdd gbl gprod
X_lrn_63_2 eop2 eon2 a_xp63 a_xn63 wp_63_2 wn_63_2 vdd gbl gprod
.ic v(wp_0_0)=0.4021 v(wn_0_0)=0.5979
.ic v(wp_1_0)=0.3669 v(wn_1_0)=0.6331
.ic v(wp_2_0)=0.4220 v(wn_2_0)=0.5780
.ic v(wp_3_0)=0.5110 v(wn_3_0)=0.4890
.ic v(wp_4_0)=0.4284 v(wn_4_0)=0.5716
.ic v(wp_5_0)=0.4562 v(wn_5_0)=0.5438
.ic v(wp_6_0)=0.4122 v(wn_6_0)=0.5878
.ic v(wp_7_0)=0.4442 v(wn_7_0)=0.5558
.ic v(wp_8_0)=0.4096 v(wn_8_0)=0.5904
.ic v(wp_9_0)=0.5331 v(wn_9_0)=0.4669
.ic v(wp_10_0)=0.5715 v(wn_10_0)=0.4285
.ic v(wp_11_0)=0.4568 v(wn_11_0)=0.5432
.ic v(wp_12_0)=0.4813 v(wn_12_0)=0.5187
.ic v(wp_13_0)=0.4477 v(wn_13_0)=0.5523
.ic v(wp_14_0)=0.5478 v(wn_14_0)=0.4522
.ic v(wp_15_0)=0.5080 v(wn_15_0)=0.4920
.ic v(wp_16_0)=0.6435 v(wn_16_0)=0.3565
.ic v(wp_17_0)=0.4014 v(wn_17_0)=0.5986
.ic v(wp_18_0)=0.5326 v(wn_18_0)=0.4674
.ic v(wp_19_0)=0.5400 v(wn_19_0)=0.4600
.ic v(wp_20_0)=0.4676 v(wn_20_0)=0.5324
.ic v(wp_21_0)=0.5525 v(wn_21_0)=0.4475
.ic v(wp_22_0)=0.3705 v(wn_22_0)=0.6295
.ic v(wp_23_0)=0.6907 v(wn_23_0)=0.3093
.ic v(wp_24_0)=0.3792 v(wn_24_0)=0.6208
.ic v(wp_25_0)=0.5828 v(wn_25_0)=0.4172
.ic v(wp_26_0)=0.3991 v(wn_26_0)=0.6009
.ic v(wp_27_0)=0.6036 v(wn_27_0)=0.3964
.ic v(wp_28_0)=0.4654 v(wn_28_0)=0.5346
.ic v(wp_29_0)=0.5143 v(wn_29_0)=0.4857
.ic v(wp_30_0)=0.5048 v(wn_30_0)=0.4952
.ic v(wp_31_0)=0.5991 v(wn_31_0)=0.4009
.ic v(wp_32_0)=0.4711 v(wn_32_0)=0.5289
.ic v(wp_33_0)=0.3000 v(wn_33_0)=0.7670
.ic v(wp_34_0)=0.4316 v(wn_34_0)=0.5684
.ic v(wp_35_0)=0.5165 v(wn_35_0)=0.4835
.ic v(wp_36_0)=0.4604 v(wn_36_0)=0.5396
.ic v(wp_37_0)=0.5693 v(wn_37_0)=0.4307
.ic v(wp_38_0)=0.5914 v(wn_38_0)=0.4086
.ic v(wp_39_0)=0.4867 v(wn_39_0)=0.5133
.ic v(wp_40_0)=0.3659 v(wn_40_0)=0.6341
.ic v(wp_41_0)=0.6246 v(wn_41_0)=0.3754
.ic v(wp_42_0)=0.5975 v(wn_42_0)=0.4025
.ic v(wp_43_0)=0.4731 v(wn_43_0)=0.5269
.ic v(wp_44_0)=0.6897 v(wn_44_0)=0.3103
.ic v(wp_45_0)=0.4686 v(wn_45_0)=0.5314
.ic v(wp_46_0)=0.3977 v(wn_46_0)=0.6023
.ic v(wp_47_0)=0.4860 v(wn_47_0)=0.5140
.ic v(wp_48_0)=0.5970 v(wn_48_0)=0.4030
.ic v(wp_49_0)=0.4156 v(wn_49_0)=0.5844
.ic v(wp_50_0)=0.6756 v(wn_50_0)=0.3244
.ic v(wp_51_0)=0.4193 v(wn_51_0)=0.5807
.ic v(wp_52_0)=0.5859 v(wn_52_0)=0.4141
.ic v(wp_53_0)=0.5490 v(wn_53_0)=0.4510
.ic v(wp_54_0)=0.4861 v(wn_54_0)=0.5139
.ic v(wp_55_0)=0.5972 v(wn_55_0)=0.4028
.ic v(wp_56_0)=0.3650 v(wn_56_0)=0.6350
.ic v(wp_57_0)=0.6222 v(wn_57_0)=0.3778
.ic v(wp_58_0)=0.4943 v(wn_58_0)=0.5057
.ic v(wp_59_0)=0.4512 v(wn_59_0)=0.5488
.ic v(wp_60_0)=0.5674 v(wn_60_0)=0.4326
.ic v(wp_61_0)=0.5954 v(wn_61_0)=0.4046
.ic v(wp_62_0)=0.5693 v(wn_62_0)=0.4307
.ic v(wp_63_0)=0.6800 v(wn_63_0)=0.3200
.ic v(wp_0_1)=0.5973 v(wn_0_1)=0.4027
.ic v(wp_1_1)=0.6155 v(wn_1_1)=0.3845
.ic v(wp_2_1)=0.4514 v(wn_2_1)=0.5486
.ic v(wp_3_1)=0.5096 v(wn_3_1)=0.4904
.ic v(wp_4_1)=0.5507 v(wn_4_1)=0.4493
.ic v(wp_5_1)=0.4984 v(wn_5_1)=0.5016
.ic v(wp_6_1)=0.5271 v(wn_6_1)=0.4729
.ic v(wp_7_1)=0.5383 v(wn_7_1)=0.4617
.ic v(wp_8_1)=0.5760 v(wn_8_1)=0.4240
.ic v(wp_9_1)=0.4909 v(wn_9_1)=0.5091
.ic v(wp_10_1)=0.4685 v(wn_10_1)=0.5315
.ic v(wp_11_1)=0.4255 v(wn_11_1)=0.5745
.ic v(wp_12_1)=0.4197 v(wn_12_1)=0.5803
.ic v(wp_13_1)=0.6055 v(wn_13_1)=0.3945
.ic v(wp_14_1)=0.4924 v(wn_14_1)=0.5076
.ic v(wp_15_1)=0.5708 v(wn_15_1)=0.4292
.ic v(wp_16_1)=0.3832 v(wn_16_1)=0.6168
.ic v(wp_17_1)=0.3256 v(wn_17_1)=0.6744
.ic v(wp_18_1)=0.4056 v(wn_18_1)=0.5944
.ic v(wp_19_1)=0.6032 v(wn_19_1)=0.3968
.ic v(wp_20_1)=0.5961 v(wn_20_1)=0.4039
.ic v(wp_21_1)=0.5299 v(wn_21_1)=0.4701
.ic v(wp_22_1)=0.4278 v(wn_22_1)=0.5722
.ic v(wp_23_1)=0.4882 v(wn_23_1)=0.5118
.ic v(wp_24_1)=0.4732 v(wn_24_1)=0.5268
.ic v(wp_25_1)=0.4690 v(wn_25_1)=0.5310
.ic v(wp_26_1)=0.3000 v(wn_26_1)=0.7255
.ic v(wp_27_1)=0.4228 v(wn_27_1)=0.5772
.ic v(wp_28_1)=0.4829 v(wn_28_1)=0.5171
.ic v(wp_29_1)=0.6365 v(wn_29_1)=0.3635
.ic v(wp_30_1)=0.5145 v(wn_30_1)=0.4855
.ic v(wp_31_1)=0.6261 v(wn_31_1)=0.3739
.ic v(wp_32_1)=0.4646 v(wn_32_1)=0.5354
.ic v(wp_33_1)=0.4773 v(wn_33_1)=0.5227
.ic v(wp_34_1)=0.3000 v(wn_34_1)=0.8509
.ic v(wp_35_1)=0.5417 v(wn_35_1)=0.4583
.ic v(wp_36_1)=0.5492 v(wn_36_1)=0.4508
.ic v(wp_37_1)=0.6587 v(wn_37_1)=0.3413
.ic v(wp_38_1)=0.4562 v(wn_38_1)=0.5438
.ic v(wp_39_1)=0.5085 v(wn_39_1)=0.4915
.ic v(wp_40_1)=0.4365 v(wn_40_1)=0.5635
.ic v(wp_41_1)=0.3941 v(wn_41_1)=0.6059
.ic v(wp_42_1)=0.4358 v(wn_42_1)=0.5642
.ic v(wp_43_1)=0.4690 v(wn_43_1)=0.5310
.ic v(wp_44_1)=0.6220 v(wn_44_1)=0.3780
.ic v(wp_45_1)=0.5002 v(wn_45_1)=0.4998
.ic v(wp_46_1)=0.4289 v(wn_46_1)=0.5711
.ic v(wp_47_1)=0.5128 v(wn_47_1)=0.4872
.ic v(wp_48_1)=0.5196 v(wn_48_1)=0.4804
.ic v(wp_49_1)=0.4391 v(wn_49_1)=0.5609
.ic v(wp_50_1)=0.6029 v(wn_50_1)=0.3971
.ic v(wp_51_1)=0.3300 v(wn_51_1)=0.6700
.ic v(wp_52_1)=0.4808 v(wn_52_1)=0.5192
.ic v(wp_53_1)=0.5599 v(wn_53_1)=0.4401
.ic v(wp_54_1)=0.3795 v(wn_54_1)=0.6205
.ic v(wp_55_1)=0.5325 v(wn_55_1)=0.4675
.ic v(wp_56_1)=0.6164 v(wn_56_1)=0.3836
.ic v(wp_57_1)=0.5408 v(wn_57_1)=0.4592
.ic v(wp_58_1)=0.3479 v(wn_58_1)=0.6521
.ic v(wp_59_1)=0.4345 v(wn_59_1)=0.5655
.ic v(wp_60_1)=0.6109 v(wn_60_1)=0.3891
.ic v(wp_61_1)=0.5269 v(wn_61_1)=0.4731
.ic v(wp_62_1)=0.4991 v(wn_62_1)=0.5009
.ic v(wp_63_1)=0.5397 v(wn_63_1)=0.4603
.ic v(wp_0_2)=0.5649 v(wn_0_2)=0.4351
.ic v(wp_1_2)=0.4362 v(wn_1_2)=0.5638
.ic v(wp_2_2)=0.4739 v(wn_2_2)=0.5261
.ic v(wp_3_2)=0.5129 v(wn_3_2)=0.4871
.ic v(wp_4_2)=0.4510 v(wn_4_2)=0.5490
.ic v(wp_5_2)=0.4880 v(wn_5_2)=0.5120
.ic v(wp_6_2)=0.6168 v(wn_6_2)=0.3832
.ic v(wp_7_2)=0.4129 v(wn_7_2)=0.5871
.ic v(wp_8_2)=0.6734 v(wn_8_2)=0.3266
.ic v(wp_9_2)=0.6691 v(wn_9_2)=0.3309
.ic v(wp_10_2)=0.3458 v(wn_10_2)=0.6542
.ic v(wp_11_2)=0.4873 v(wn_11_2)=0.5127
.ic v(wp_12_2)=0.5308 v(wn_12_2)=0.4692
.ic v(wp_13_2)=0.4315 v(wn_13_2)=0.5685
.ic v(wp_14_2)=0.4333 v(wn_14_2)=0.5667
.ic v(wp_15_2)=0.4786 v(wn_15_2)=0.5214
.ic v(wp_16_2)=0.5665 v(wn_16_2)=0.4335
.ic v(wp_17_2)=0.4540 v(wn_17_2)=0.5460
.ic v(wp_18_2)=0.6644 v(wn_18_2)=0.3356
.ic v(wp_19_2)=0.5261 v(wn_19_2)=0.4739
.ic v(wp_20_2)=0.4908 v(wn_20_2)=0.5092
.ic v(wp_21_2)=0.6304 v(wn_21_2)=0.3696
.ic v(wp_22_2)=0.5564 v(wn_22_2)=0.4436
.ic v(wp_23_2)=0.5332 v(wn_23_2)=0.4668
.ic v(wp_24_2)=0.4702 v(wn_24_2)=0.5298
.ic v(wp_25_2)=0.6633 v(wn_25_2)=0.3367
.ic v(wp_26_2)=0.5731 v(wn_26_2)=0.4269
.ic v(wp_27_2)=0.4817 v(wn_27_2)=0.5183
.ic v(wp_28_2)=0.3581 v(wn_28_2)=0.6419
.ic v(wp_29_2)=0.5336 v(wn_29_2)=0.4664
.ic v(wp_30_2)=0.3971 v(wn_30_2)=0.6029
.ic v(wp_31_2)=0.3456 v(wn_31_2)=0.6544
.ic v(wp_32_2)=0.4749 v(wn_32_2)=0.5251
.ic v(wp_33_2)=0.5253 v(wn_33_2)=0.4747
.ic v(wp_34_2)=0.6154 v(wn_34_2)=0.3846
.ic v(wp_35_2)=0.5254 v(wn_35_2)=0.4746
.ic v(wp_36_2)=0.5725 v(wn_36_2)=0.4275
.ic v(wp_37_2)=0.3897 v(wn_37_2)=0.6103
.ic v(wp_38_2)=0.4980 v(wn_38_2)=0.5020
.ic v(wp_39_2)=0.5112 v(wn_39_2)=0.4888
.ic v(wp_40_2)=0.5776 v(wn_40_2)=0.4224
.ic v(wp_41_2)=0.5104 v(wn_41_2)=0.4896
.ic v(wp_42_2)=0.5724 v(wn_42_2)=0.4276
.ic v(wp_43_2)=0.4546 v(wn_43_2)=0.5454
.ic v(wp_44_2)=0.5322 v(wn_44_2)=0.4678
.ic v(wp_45_2)=0.5373 v(wn_45_2)=0.4627
.ic v(wp_46_2)=0.3875 v(wn_46_2)=0.6125
.ic v(wp_47_2)=0.5158 v(wn_47_2)=0.4842
.ic v(wp_48_2)=0.4712 v(wn_48_2)=0.5288
.ic v(wp_49_2)=0.3286 v(wn_49_2)=0.6714
.ic v(wp_50_2)=0.5863 v(wn_50_2)=0.4137
.ic v(wp_51_2)=0.4674 v(wn_51_2)=0.5326
.ic v(wp_52_2)=0.4233 v(wn_52_2)=0.5767
.ic v(wp_53_2)=0.4660 v(wn_53_2)=0.5340
.ic v(wp_54_2)=0.5124 v(wn_54_2)=0.4876
.ic v(wp_55_2)=0.6357 v(wn_55_2)=0.3643
.ic v(wp_56_2)=0.4851 v(wn_56_2)=0.5149
.ic v(wp_57_2)=0.5425 v(wn_57_2)=0.4575
.ic v(wp_58_2)=0.6236 v(wn_58_2)=0.3764
.ic v(wp_59_2)=0.5480 v(wn_59_2)=0.4520
.ic v(wp_60_2)=0.5962 v(wn_60_2)=0.4038
.ic v(wp_61_2)=0.4571 v(wn_61_2)=0.5429
.ic v(wp_62_2)=0.5694 v(wn_62_2)=0.4306
.ic v(wp_63_2)=0.4948 v(wn_63_2)=0.5052
.tran 4n 59400n uic
.options gmin=1e-10 reltol=2e-3 cshunt=1e-14
.control
run
wrdata pc1mcs1_1.dat v(mop0) v(mon0) v(mop1) v(mon1) v(mop2) v(mon2)
.endc
.end
