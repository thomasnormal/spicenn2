pc1
.model NNR NMOS (LEVEL=1 VTO=0.2 KP=120u LAMBDA=0.02 GAMMA=0 PHI=0.7)
.model PNR PMOS (LEVEL=1 VTO=-0.2 KP=40u LAMBDA=0.02 GAMMA=0 PHI=0.7)
.subckt gsyn inp inn wp wn outp outn vdd vbn
Mtail nt vbn 0 0 NNR W=400u L=100u
M5 na wp nt 0 NNR W=200u L=100u
M6 nb wn nt 0 NNR W=200u L=100u
M1 outp inp na 0 NNR W=200u L=100u
M2 outn inn na 0 NNR W=200u L=100u
M3 outn inp nb 0 NNR W=200u L=100u
M4 outp inn nb 0 NNR W=200u L=100u
.ends
.subckt cmld p n vdd
Rcs1 p cmx 300k
Rcs2 n cmx 300k
MLp p cmx vdd vdd PNR W=1000u L=100u
MLn n cmx vdd vdd PNR W=1000u L=100u
.ends
Vdd vdd 0 1.0
Vbsyn vbsyn 0 0.45
Vxp0 a_xp0 0 0.5
Vxn0 a_xn0 0 0.5
Vxp1 a_xp1 0 0.5
Vxn1 a_xn1 0 0.5
Vxp2 a_xp2 0 0.5
Vxn2 a_xn2 0 0.5
Vxp3 a_xp3 0 0.5
Vxn3 a_xn3 0 0.5
Vxp4 a_xp4 0 0.5
Vxn4 a_xn4 0 0.5
Vxp5 a_xp5 0 0.5
Vxn5 a_xn5 0 0.5
Vxp6 a_xp6 0 0.5
Vxn6 a_xn6 0 0.5
Vxp7 a_xp7 0 0.5
Vxn7 a_xn7 0 0.5
Vxp8 a_xp8 0 0.5
Vxn8 a_xn8 0 0.5
Vxp9 a_xp9 0 0.5
Vxn9 a_xn9 0 0.5
Vxp10 a_xp10 0 0.5
Vxn10 a_xn10 0 0.5
Vxp11 a_xp11 0 0.5
Vxn11 a_xn11 0 0.5
Vxp12 a_xp12 0 0.5
Vxn12 a_xn12 0 0.5
Vxp13 a_xp13 0 0.5
Vxn13 a_xn13 0 0.5
Vxp14 a_xp14 0 0.5
Vxn14 a_xn14 0 0.5
Vxp15 a_xp15 0 0.5
Vxn15 a_xn15 0 0.5
Vxp16 a_xp16 0 0.5
Vxn16 a_xn16 0 0.5
Vxp17 a_xp17 0 0.5
Vxn17 a_xn17 0 0.5
Vxp18 a_xp18 0 0.5
Vxn18 a_xn18 0 0.5
Vxp19 a_xp19 0 0.5
Vxn19 a_xn19 0 0.5
Vxp20 a_xp20 0 0.5
Vxn20 a_xn20 0 0.5
Vxp21 a_xp21 0 0.5
Vxn21 a_xn21 0 0.5
Vxp22 a_xp22 0 0.5
Vxn22 a_xn22 0 0.5
Vxp23 a_xp23 0 0.5
Vxn23 a_xn23 0 0.5
Vxp24 a_xp24 0 0.5
Vxn24 a_xn24 0 0.5
Vxp25 a_xp25 0 0.5
Vxn25 a_xn25 0 0.5
Vxp26 a_xp26 0 0.5
Vxn26 a_xn26 0 0.5
Vxp27 a_xp27 0 0.5
Vxn27 a_xn27 0 0.5
Vxp28 a_xp28 0 0.5
Vxn28 a_xn28 0 0.5
Vxp29 a_xp29 0 0.5
Vxn29 a_xn29 0 0.5
Vxp30 a_xp30 0 0.5
Vxn30 a_xn30 0 0.5
Vxp31 a_xp31 0 0.5
Vxn31 a_xn31 0 0.5
Vxp32 a_xp32 0 0.5
Vxn32 a_xn32 0 0.5
Vxp33 a_xp33 0 0.5
Vxn33 a_xn33 0 0.5
Vxp34 a_xp34 0 0.5
Vxn34 a_xn34 0 0.5
Vxp35 a_xp35 0 0.5
Vxn35 a_xn35 0 0.5
Vxp36 a_xp36 0 0.5
Vxn36 a_xn36 0 0.5
Vxp37 a_xp37 0 0.5
Vxn37 a_xn37 0 0.5
Vxp38 a_xp38 0 0.5
Vxn38 a_xn38 0 0.5
Vxp39 a_xp39 0 0.5
Vxn39 a_xn39 0 0.5
Vxp40 a_xp40 0 0.5
Vxn40 a_xn40 0 0.5
Vxp41 a_xp41 0 0.5
Vxn41 a_xn41 0 0.5
Vxp42 a_xp42 0 0.5
Vxn42 a_xn42 0 0.5
Vxp43 a_xp43 0 0.5
Vxn43 a_xn43 0 0.5
Vxp44 a_xp44 0 0.5
Vxn44 a_xn44 0 0.5
Vxp45 a_xp45 0 0.5
Vxn45 a_xn45 0 0.5
Vxp46 a_xp46 0 0.5
Vxn46 a_xn46 0 0.5
Vxp47 a_xp47 0 0.5
Vxn47 a_xn47 0 0.5
Vxp48 a_xp48 0 0.5
Vxn48 a_xn48 0 0.5
Vxp49 a_xp49 0 0.5
Vxn49 a_xn49 0 0.5
Vxp50 a_xp50 0 0.5
Vxn50 a_xn50 0 0.5
Vxp51 a_xp51 0 0.5
Vxn51 a_xn51 0 0.5
Vxp52 a_xp52 0 0.5
Vxn52 a_xn52 0 0.5
Vxp53 a_xp53 0 0.5
Vxn53 a_xn53 0 0.5
Vxp54 a_xp54 0 0.5
Vxn54 a_xn54 0 0.5
Vxp55 a_xp55 0 0.5
Vxn55 a_xn55 0 0.5
Vxp56 a_xp56 0 0.5
Vxn56 a_xn56 0 0.5
Vxp57 a_xp57 0 0.5
Vxn57 a_xn57 0 0.5
Vxp58 a_xp58 0 0.5
Vxn58 a_xn58 0 0.5
Vxp59 a_xp59 0 0.5
Vxn59 a_xn59 0 0.5
Vxp60 a_xp60 0 0.5
Vxn60 a_xn60 0 0.5
Vxp61 a_xp61 0 0.5
Vxn61 a_xn61 0 0.5
Vxp62 a_xp62 0 0.5
Vxn62 a_xn62 0 0.5
Vxp63 a_xp63 0 0.5
Vxn63 a_xn63 0 0.5
Vwp_0_0 wp_0_0 0 0.484500704160151
Vwn_0_0 wn_0_0 0 0.515499295839849
Vwp_1_0 wp_1_0 0 0.52531676852165
Vwn_1_0 wn_1_0 0 0.47468323147835007
Vwp_2_0 wp_2_0 0 0.4933598830874947
Vwn_2_0 wn_2_0 0 0.5066401169125053
Vwp_3_0 wp_3_0 0 0.47900622830864337
Vwn_3_0 wn_3_0 0 0.5209937716913566
Vwp_4_0 wp_4_0 0 0.49328642919508864
Vwn_4_0 wn_4_0 0 0.5067135708049114
Vwp_5_0 wp_5_0 0 0.48264111738312027
Vwn_5_0 wn_5_0 0 0.5173588826168797
Vwp_6_0 wp_6_0 0 0.5023685624859375
Vwn_6_0 wn_6_0 0 0.4976314375140625
Vwp_7_0 wp_7_0 0 0.4937095314185732
Vwn_7_0 wn_7_0 0 0.5062904685814268
Vwp_8_0 wp_8_0 0 0.4841386367498411
Vwn_8_0 wn_8_0 0 0.5158613632501589
Vwp_9_0 wp_9_0 0 0.5090264923845579
Vwn_9_0 wn_9_0 0 0.4909735076154421
Vwp_10_0 wp_10_0 0 0.49034849131296865
Vwn_10_0 wn_10_0 0 0.5096515086870314
Vwp_11_0 wp_11_0 0 0.5108564185259669
Vwn_11_0 wn_11_0 0 0.4891435814740332
Vwp_12_0 wp_12_0 0 0.5189147525580008
Vwn_12_0 wn_12_0 0 0.4810852474419992
Vwp_13_0 wp_13_0 0 0.4945707083747115
Vwn_13_0 wn_13_0 0 0.5054292916252885
Vwp_14_0 wp_14_0 0 0.4903022844116121
Vwn_14_0 wn_14_0 0 0.5096977155883878
Vwp_15_0 wp_15_0 0 0.5029894409889403
Vwn_15_0 wn_15_0 0 0.4970105590110597
Vwp_16_0 wp_16_0 0 0.5133717431191854
Vwn_16_0 wn_16_0 0 0.48662825688081457
Vwp_17_0 wp_17_0 0 0.4999581040787445
Vwn_17_0 wn_17_0 0 0.5000418959212555
Vwp_18_0 wp_18_0 0 0.502099337751819
Vwn_18_0 wn_18_0 0 0.49790066224818097
Vwp_19_0 wp_19_0 0 0.499596638101334
Vwn_19_0 wn_19_0 0 0.5004033618986661
Vwp_20_0 wp_20_0 0 0.5046682193222626
Vwn_20_0 wn_20_0 0 0.4953317806777374
Vwp_21_0 wp_21_0 0 0.5094311451928617
Vwn_21_0 wn_21_0 0 0.4905688548071383
Vwp_22_0 wp_22_0 0 0.48940905614132774
Vwn_22_0 wn_22_0 0 0.5105909438586722
Vwp_23_0 wp_23_0 0 0.49276199245808816
Vwn_23_0 wn_23_0 0 0.5072380075419118
Vwp_24_0 wp_24_0 0 0.5006538339154293
Vwn_24_0 wn_24_0 0 0.4993461660845707
Vwp_25_0 wp_25_0 0 0.4900140179473814
Vwn_25_0 wn_25_0 0 0.5099859820526186
Vwp_26_0 wp_26_0 0 0.5020418817509474
Vwn_26_0 wn_26_0 0 0.49795811824905256
Vwp_27_0 wp_27_0 0 0.5080422367317755
Vwn_27_0 wn_27_0 0 0.49195776326822444
Vwp_28_0 wp_28_0 0 0.49967417213119053
Vwn_28_0 wn_28_0 0 0.5003258278688095
Vwp_29_0 wp_29_0 0 0.4909467549299087
Vwn_29_0 wn_29_0 0 0.5090532450700913
Vwp_30_0 wp_30_0 0 0.4883419651280779
Vwn_30_0 wn_30_0 0 0.5116580348719221
Vwp_31_0 wp_31_0 0 0.5262683815630841
Vwn_31_0 wn_31_0 0 0.47373161843691586
Vwp_32_0 wp_32_0 0 0.5131775876078251
Vwn_32_0 wn_32_0 0 0.48682241239217494
Vwp_33_0 wp_33_0 0 0.48320117755518655
Vwn_33_0 wn_33_0 0 0.5167988224448135
Vwp_34_0 wp_34_0 0 0.4873845984198825
Vwn_34_0 wn_34_0 0 0.5126154015801175
Vwp_35_0 wp_35_0 0 0.5281076706541568
Vwn_35_0 wn_35_0 0 0.4718923293458432
Vwp_36_0 wp_36_0 0 0.5226694655829394
Vwn_36_0 wn_36_0 0 0.47733053441706064
Vwp_37_0 wp_37_0 0 0.5019226447898384
Vwn_37_0 wn_37_0 0 0.49807735521016155
Vwp_38_0 wp_38_0 0 0.5173677334972094
Vwn_38_0 wn_38_0 0 0.4826322665027906
Vwp_39_0 wp_39_0 0 0.47769528053016674
Vwn_39_0 wn_39_0 0 0.5223047194698333
Vwp_40_0 wp_40_0 0 0.5000196793268559
Vwn_40_0 wn_40_0 0 0.4999803206731442
Vwp_41_0 wp_41_0 0 0.5111121377403406
Vwn_41_0 wn_41_0 0 0.4888878622596594
Vwp_42_0 wp_42_0 0 0.47210048972918006
Vwn_42_0 wn_42_0 0 0.5278995102708199
Vwp_43_0 wp_43_0 0 0.4882550865491488
Vwn_43_0 wn_43_0 0 0.5117449134508512
Vwp_44_0 wp_44_0 0 0.5117428227250755
Vwn_44_0 wn_44_0 0 0.48825717727492446
Vwp_45_0 wp_45_0 0 0.5169744482568138
Vwn_45_0 wn_45_0 0 0.4830255517431862
Vwp_46_0 wp_46_0 0 0.49110038785172677
Vwn_46_0 wn_46_0 0 0.5088996121482732
Vwp_47_0 wp_47_0 0 0.5043471415846806
Vwn_47_0 wn_47_0 0 0.4956528584153194
Vwp_48_0 wp_48_0 0 0.5240106883131089
Vwn_48_0 wn_48_0 0 0.4759893116868911
Vwp_49_0 wp_49_0 0 0.49427100371025195
Vwn_49_0 wn_49_0 0 0.505728996289748
Vwp_50_0 wp_50_0 0 0.47999953919874827
Vwn_50_0 wn_50_0 0 0.5200004608012517
Vwp_51_0 wp_51_0 0 0.4990788859056558
Vwn_51_0 wn_51_0 0 0.5009211140943441
Vwp_52_0 wp_52_0 0 0.49410263537736615
Vwn_52_0 wn_52_0 0 0.5058973646226339
Vwp_53_0 wp_53_0 0 0.5195157241420605
Vwn_53_0 wn_53_0 0 0.4804842758579395
Vwp_54_0 wp_54_0 0 0.502401733399082
Vwn_54_0 wn_54_0 0 0.49759826660091805
Vwp_55_0 wp_55_0 0 0.48796858114006963
Vwn_55_0 wn_55_0 0 0.5120314188599304
Vwp_56_0 wp_56_0 0 0.5360081685400763
Vwn_56_0 wn_56_0 0 0.4639918314599237
Vwp_57_0 wp_57_0 0 0.4924982449694404
Vwn_57_0 wn_57_0 0 0.5075017550305596
Vwp_58_0 wp_58_0 0 0.507086686970448
Vwn_58_0 wn_58_0 0 0.492913313029552
Vwp_59_0 wp_59_0 0 0.5101434731449924
Vwn_59_0 wn_59_0 0 0.4898565268550076
Vwp_60_0 wp_60_0 0 0.511764831307461
Vwn_60_0 wn_60_0 0 0.48823516869253897
Vwp_61_0 wp_61_0 0 0.502593738467628
Vwn_61_0 wn_61_0 0 0.497406261532372
Vwp_62_0 wp_62_0 0 0.5088001075822205
Vwn_62_0 wn_62_0 0 0.49119989241777945
Vwp_63_0 wp_63_0 0 0.4989814680573197
Vwn_63_0 wn_63_0 0 0.5010185319426803
Vwp_0_1 wp_0_1 0 0.4787122703636134
Vwn_0_1 wn_0_1 0 0.5212877296363866
Vwp_1_1 wp_1_1 0 0.4967028407111577
Vwn_1_1 wn_1_1 0 0.5032971592888423
Vwp_2_1 wp_2_1 0 0.497023819090952
Vwn_2_1 wn_2_1 0 0.5029761809090479
Vwp_3_1 wp_3_1 0 0.49733419614224017
Vwn_3_1 wn_3_1 0 0.5026658038577598
Vwp_4_1 wp_4_1 0 0.5020413760062407
Vwn_4_1 wn_4_1 0 0.49795862399375934
Vwp_5_1 wp_5_1 0 0.4906294567311998
Vwn_5_1 wn_5_1 0 0.5093705432688003
Vwp_6_1 wp_6_1 0 0.5198488623146988
Vwn_6_1 wn_6_1 0 0.4801511376853012
Vwp_7_1 wp_7_1 0 0.5235007234990999
Vwn_7_1 wn_7_1 0 0.4764992765009001
Vwp_8_1 wp_8_1 0 0.46699457575493786
Vwn_8_1 wn_8_1 0 0.5330054242450621
Vwp_9_1 wp_9_1 0 0.5001398903436589
Vwn_9_1 wn_9_1 0 0.4998601096563411
Vwp_10_1 wp_10_1 0 0.48934108202086246
Vwn_10_1 wn_10_1 0 0.5106589179791375
Vwp_11_1 wp_11_1 0 0.46090634200015984
Vwn_11_1 wn_11_1 0 0.5390936579998402
Vwp_12_1 wp_12_1 0 0.5061520385247675
Vwn_12_1 wn_12_1 0 0.4938479614752325
Vwp_13_1 wp_13_1 0 0.4907180058339706
Vwn_13_1 wn_13_1 0 0.5092819941660294
Vwp_14_1 wp_14_1 0 0.4943639810513187
Vwn_14_1 wn_14_1 0 0.5056360189486813
Vwp_15_1 wp_15_1 0 0.49022633071493954
Vwn_15_1 wn_15_1 0 0.5097736692850605
Vwp_16_1 wp_16_1 0 0.5163050824303195
Vwn_16_1 wn_16_1 0 0.48369491756968047
Vwp_17_1 wp_17_1 0 0.518589471361134
Vwn_17_1 wn_17_1 0 0.48141052863886596
Vwp_18_1 wp_18_1 0 0.504151930717746
Vwn_18_1 wn_18_1 0 0.495848069282254
Vwp_19_1 wp_19_1 0 0.5103966331335932
Vwn_19_1 wn_19_1 0 0.4896033668664068
Vwp_20_1 wp_20_1 0 0.49831357544336163
Vwn_20_1 wn_20_1 0 0.5016864245566384
Vwp_21_1 wp_21_1 0 0.5021023885975593
Vwn_21_1 wn_21_1 0 0.49789761140244077
Vwp_22_1 wp_22_1 0 0.4888735606132919
Vwn_22_1 wn_22_1 0 0.5111264393867081
Vwp_23_1 wp_23_1 0 0.5005181420313712
Vwn_23_1 wn_23_1 0 0.49948185796862876
Vwp_24_1 wp_24_1 0 0.4892949425867413
Vwn_24_1 wn_24_1 0 0.5107050574132588
Vwp_25_1 wp_25_1 0 0.5055953935951037
Vwn_25_1 wn_25_1 0 0.49440460640489625
Vwp_26_1 wp_26_1 0 0.5124099680722255
Vwn_26_1 wn_26_1 0 0.48759003192777456
Vwp_27_1 wp_27_1 0 0.5046656413919137
Vwn_27_1 wn_27_1 0 0.4953343586080863
Vwp_28_1 wp_28_1 0 0.5177619365118373
Vwn_28_1 wn_28_1 0 0.48223806348816267
Vwp_29_1 wp_29_1 0 0.54035367912713
Vwn_29_1 wn_29_1 0 0.4596463208728701
Vwp_30_1 wp_30_1 0 0.4684015821915006
Vwn_30_1 wn_30_1 0 0.5315984178084994
Vwp_31_1 wp_31_1 0 0.500205260289833
Vwn_31_1 wn_31_1 0 0.499794739710167
Vwp_32_1 wp_32_1 0 0.49146979189040524
Vwn_32_1 wn_32_1 0 0.5085302081095948
Vwp_33_1 wp_33_1 0 0.4931495677875955
Vwn_33_1 wn_33_1 0 0.5068504322124046
Vwp_34_1 wp_34_1 0 0.47962737348868373
Vwn_34_1 wn_34_1 0 0.5203726265113162
Vwp_35_1 wp_35_1 0 0.5007880286102149
Vwn_35_1 wn_35_1 0 0.4992119713897851
Vwp_36_1 wp_36_1 0 0.49612590935536677
Vwn_36_1 wn_36_1 0 0.5038740906446333
Vwp_37_1 wp_37_1 0 0.4905084396532018
Vwn_37_1 wn_37_1 0 0.5094915603467982
Vwp_38_1 wp_38_1 0 0.4961851606154676
Vwn_38_1 wn_38_1 0 0.5038148393845324
Vwp_39_1 wp_39_1 0 0.49110884356432055
Vwn_39_1 wn_39_1 0 0.5088911564356795
Vwp_40_1 wp_40_1 0 0.4648561710795811
Vwn_40_1 wn_40_1 0 0.5351438289204189
Vwp_41_1 wp_41_1 0 0.516161134498114
Vwn_41_1 wn_41_1 0 0.483838865501886
Vwp_42_1 wp_42_1 0 0.4954479100250827
Vwn_42_1 wn_42_1 0 0.5045520899749173
Vwp_43_1 wp_43_1 0 0.48575543979159413
Vwn_43_1 wn_43_1 0 0.5142445602084058
Vwp_44_1 wp_44_1 0 0.5045961812275171
Vwn_44_1 wn_44_1 0 0.4954038187724829
Vwp_45_1 wp_45_1 0 0.4900634242554775
Vwn_45_1 wn_45_1 0 0.5099365757445224
Vwp_46_1 wp_46_1 0 0.46739003729662015
Vwn_46_1 wn_46_1 0 0.5326099627033799
Vwp_47_1 wp_47_1 0 0.5133035355373513
Vwn_47_1 wn_47_1 0 0.48669646446264875
Vwp_48_1 wp_48_1 0 0.4748493627850642
Vwn_48_1 wn_48_1 0 0.5251506372149358
Vwp_49_1 wp_49_1 0 0.49672389367811914
Vwn_49_1 wn_49_1 0 0.5032761063218809
Vwp_50_1 wp_50_1 0 0.50180234369556
Vwn_50_1 wn_50_1 0 0.4981976563044401
Vwp_51_1 wp_51_1 0 0.520245024444561
Vwn_51_1 wn_51_1 0 0.479754975555439
Vwp_52_1 wp_52_1 0 0.5178509100572277
Vwn_52_1 wn_52_1 0 0.4821490899427723
Vwp_53_1 wp_53_1 0 0.5024862211179136
Vwn_53_1 wn_53_1 0 0.4975137788820863
Vwp_54_1 wp_54_1 0 0.4885491264066206
Vwn_54_1 wn_54_1 0 0.5114508735933794
Vwp_55_1 wp_55_1 0 0.4937615426085931
Vwn_55_1 wn_55_1 0 0.5062384573914069
Vwp_56_1 wp_56_1 0 0.5163155254585972
Vwn_56_1 wn_56_1 0 0.4836844745414029
Vwp_57_1 wp_57_1 0 0.5267967402379531
Vwn_57_1 wn_57_1 0 0.47320325976204697
Vwp_58_1 wp_58_1 0 0.5081568297146971
Vwn_58_1 wn_58_1 0 0.49184317028530283
Vwp_59_1 wp_59_1 0 0.4903273322313074
Vwn_59_1 wn_59_1 0 0.5096726677686926
Vwp_60_1 wp_60_1 0 0.5154405814647242
Vwn_60_1 wn_60_1 0 0.48455941853527584
Vwp_61_1 wp_61_1 0 0.49437139888987536
Vwn_61_1 wn_61_1 0 0.5056286011101246
Vwp_62_1 wp_62_1 0 0.49388225999532964
Vwn_62_1 wn_62_1 0 0.5061177400046704
Vwp_63_1 wp_63_1 0 0.4958154701449961
Vwn_63_1 wn_63_1 0 0.504184529855004
Vwp_0_2 wp_0_2 0 0.5088522347568639
Vwn_0_2 wn_0_2 0 0.49114776524313614
Vwp_1_2 wp_1_2 0 0.5041291230622129
Vwn_1_2 wn_1_2 0 0.49587087693778714
Vwp_2_2 wp_2_2 0 0.5148920212936262
Vwn_2_2 wn_2_2 0 0.48510797870637373
Vwp_3_2 wp_3_2 0 0.5194458993540312
Vwn_3_2 wn_3_2 0 0.4805541006459688
Vwp_4_2 wp_4_2 0 0.5076986838215508
Vwn_4_2 wn_4_2 0 0.49230131617844924
Vwp_5_2 wp_5_2 0 0.46501604742337826
Vwn_5_2 wn_5_2 0 0.5349839525766218
Vwp_6_2 wp_6_2 0 0.47455103701274765
Vwn_6_2 wn_6_2 0 0.5254489629872523
Vwp_7_2 wp_7_2 0 0.5023788247809292
Vwn_7_2 wn_7_2 0 0.49762117521907073
Vwp_8_2 wp_8_2 0 0.49902938756255016
Vwn_8_2 wn_8_2 0 0.5009706124374498
Vwp_9_2 wp_9_2 0 0.532387941443671
Vwn_9_2 wn_9_2 0 0.46761205855632904
Vwp_10_2 wp_10_2 0 0.4995467890984019
Vwn_10_2 wn_10_2 0 0.5004532109015981
Vwp_11_2 wp_11_2 0 0.4977108510074594
Vwn_11_2 wn_11_2 0 0.5022891489925406
Vwp_12_2 wp_12_2 0 0.5141583214773418
Vwn_12_2 wn_12_2 0 0.48584167852265825
Vwp_13_2 wp_13_2 0 0.5159665013638122
Vwn_13_2 wn_13_2 0 0.4840334986361879
Vwp_14_2 wp_14_2 0 0.4964688477994361
Vwn_14_2 wn_14_2 0 0.5035311522005639
Vwp_15_2 wp_15_2 0 0.5070980314726292
Vwn_15_2 wn_15_2 0 0.4929019685273708
Vwp_16_2 wp_16_2 0 0.48299679989673466
Vwn_16_2 wn_16_2 0 0.5170032001032654
Vwp_17_2 wp_17_2 0 0.4858527233734165
Vwn_17_2 wn_17_2 0 0.5141472766265834
Vwp_18_2 wp_18_2 0 0.5184960971771438
Vwn_18_2 wn_18_2 0 0.4815039028228562
Vwp_19_2 wp_19_2 0 0.47889296584903684
Vwn_19_2 wn_19_2 0 0.5211070341509632
Vwp_20_2 wp_20_2 0 0.5138346893978073
Vwn_20_2 wn_20_2 0 0.4861653106021927
Vwp_21_2 wp_21_2 0 0.510168325755445
Vwn_21_2 wn_21_2 0 0.489831674244555
Vwp_22_2 wp_22_2 0 0.5115463285895857
Vwn_22_2 wn_22_2 0 0.48845367141041424
Vwp_23_2 wp_23_2 0 0.513692472642472
Vwn_23_2 wn_23_2 0 0.4863075273575281
Vwp_24_2 wp_24_2 0 0.5084579452922663
Vwn_24_2 wn_24_2 0 0.4915420547077337
Vwp_25_2 wp_25_2 0 0.46787811760939824
Vwn_25_2 wn_25_2 0 0.5321218823906018
Vwp_26_2 wp_26_2 0 0.48493430729177806
Vwn_26_2 wn_26_2 0 0.5150656927082219
Vwp_27_2 wp_27_2 0 0.4909803253561755
Vwn_27_2 wn_27_2 0 0.5090196746438245
Vwp_28_2 wp_28_2 0 0.5137223072429905
Vwn_28_2 wn_28_2 0 0.48627769275700955
Vwp_29_2 wp_29_2 0 0.4830829208386319
Vwn_29_2 wn_29_2 0 0.5169170791613681
Vwp_30_2 wp_30_2 0 0.48942657437922704
Vwn_30_2 wn_30_2 0 0.510573425620773
Vwp_31_2 wp_31_2 0 0.49455781937695587
Vwn_31_2 wn_31_2 0 0.5054421806230441
Vwp_32_2 wp_32_2 0 0.5197464762996781
Vwn_32_2 wn_32_2 0 0.480253523700322
Vwp_33_2 wp_33_2 0 0.47838420825390965
Vwn_33_2 wn_33_2 0 0.5216157917460904
Vwp_34_2 wp_34_2 0 0.4796910566424379
Vwn_34_2 wn_34_2 0 0.5203089433575621
Vwp_35_2 wp_35_2 0 0.5094074178675482
Vwn_35_2 wn_35_2 0 0.49059258213245177
Vwp_36_2 wp_36_2 0 0.46811708175086086
Vwn_36_2 wn_36_2 0 0.5318829182491391
Vwp_37_2 wp_37_2 0 0.5049796689871263
Vwn_37_2 wn_37_2 0 0.4950203310128737
Vwp_38_2 wp_38_2 0 0.4931893861678105
Vwn_38_2 wn_38_2 0 0.5068106138321895
Vwp_39_2 wp_39_2 0 0.4763457287640316
Vwn_39_2 wn_39_2 0 0.5236542712359684
Vwp_40_2 wp_40_2 0 0.4936959290591762
Vwn_40_2 wn_40_2 0 0.5063040709408237
Vwp_41_2 wp_41_2 0 0.48496794548589534
Vwn_41_2 wn_41_2 0 0.5150320545141046
Vwp_42_2 wp_42_2 0 0.5025167713163057
Vwn_42_2 wn_42_2 0 0.4974832286836943
Vwp_43_2 wp_43_2 0 0.5054573311325234
Vwn_43_2 wn_43_2 0 0.49454266886747655
Vwp_44_2 wp_44_2 0 0.5223344237723422
Vwn_44_2 wn_44_2 0 0.4776655762276579
Vwp_45_2 wp_45_2 0 0.4998082214599303
Vwn_45_2 wn_45_2 0 0.5001917785400697
Vwp_46_2 wp_46_2 0 0.5015083025363282
Vwn_46_2 wn_46_2 0 0.49849169746367183
Vwp_47_2 wp_47_2 0 0.4913403381225545
Vwn_47_2 wn_47_2 0 0.5086596618774455
Vwp_48_2 wp_48_2 0 0.49964547319557606
Vwn_48_2 wn_48_2 0 0.5003545268044239
Vwp_49_2 wp_49_2 0 0.5157440369581621
Vwn_49_2 wn_49_2 0 0.4842559630418379
Vwp_50_2 wp_50_2 0 0.4711142643522241
Vwn_50_2 wn_50_2 0 0.5288857356477759
Vwp_51_2 wp_51_2 0 0.5098869331477571
Vwn_51_2 wn_51_2 0 0.49011306685224293
Vwp_52_2 wp_52_2 0 0.49197234594366684
Vwn_52_2 wn_52_2 0 0.5080276540563332
Vwp_53_2 wp_53_2 0 0.5011083534472455
Vwn_53_2 wn_53_2 0 0.49889164655275453
Vwp_54_2 wp_54_2 0 0.5048756723004657
Vwn_54_2 wn_54_2 0 0.49512432769953435
Vwp_55_2 wp_55_2 0 0.5127589125613778
Vwn_55_2 wn_55_2 0 0.4872410874386221
Vwp_56_2 wp_56_2 0 0.5035760486070155
Vwn_56_2 wn_56_2 0 0.49642395139298445
Vwp_57_2 wp_57_2 0 0.4941123475188136
Vwn_57_2 wn_57_2 0 0.5058876524811864
Vwp_58_2 wp_58_2 0 0.5046754151734005
Vwn_58_2 wn_58_2 0 0.4953245848265995
Vwp_59_2 wp_59_2 0 0.5001780971514266
Vwn_59_2 wn_59_2 0 0.4998219028485734
Vwp_60_2 wp_60_2 0 0.4969325022642965
Vwn_60_2 wn_60_2 0 0.5030674977357035
Vwp_61_2 wp_61_2 0 0.5030772152322449
Vwn_61_2 wn_61_2 0 0.4969227847677551
Vwp_62_2 wp_62_2 0 0.5131037073096524
Vwn_62_2 wn_62_2 0 0.4868962926903476
Vwp_63_2 wp_63_2 0 0.5020749806789598
Vwn_63_2 wn_63_2 0 0.4979250193210401
Vwp_0_3 wp_0_3 0 0.5023320388097869
Vwn_0_3 wn_0_3 0 0.49766796119021306
Vwp_1_3 wp_1_3 0 0.48068734397722523
Vwn_1_3 wn_1_3 0 0.5193126560227748
Vwp_2_3 wp_2_3 0 0.49809483145626826
Vwn_2_3 wn_2_3 0 0.5019051685437317
Vwp_3_3 wp_3_3 0 0.47212973728253904
Vwn_3_3 wn_3_3 0 0.527870262717461
Vwp_4_3 wp_4_3 0 0.5108001596777666
Vwn_4_3 wn_4_3 0 0.48919984032223335
Vwp_5_3 wp_5_3 0 0.48591119434052443
Vwn_5_3 wn_5_3 0 0.5140888056594756
Vwp_6_3 wp_6_3 0 0.5194307235715899
Vwn_6_3 wn_6_3 0 0.48056927642841013
Vwp_7_3 wp_7_3 0 0.5449015568690786
Vwn_7_3 wn_7_3 0 0.45509844313092135
Vwp_8_3 wp_8_3 0 0.49403901149916024
Vwn_8_3 wn_8_3 0 0.5059609885008397
Vwp_9_3 wp_9_3 0 0.5199444525093181
Vwn_9_3 wn_9_3 0 0.48005554749068197
Vwp_10_3 wp_10_3 0 0.5060539843158928
Vwn_10_3 wn_10_3 0 0.4939460156841072
Vwp_11_3 wp_11_3 0 0.49164519059043627
Vwn_11_3 wn_11_3 0 0.5083548094095638
Vwp_12_3 wp_12_3 0 0.48738033056417185
Vwn_12_3 wn_12_3 0 0.5126196694358282
Vwp_13_3 wp_13_3 0 0.5084291253518017
Vwn_13_3 wn_13_3 0 0.4915708746481982
Vwp_14_3 wp_14_3 0 0.5209223276729257
Vwn_14_3 wn_14_3 0 0.4790776723270743
Vwp_15_3 wp_15_3 0 0.5053055819591293
Vwn_15_3 wn_15_3 0 0.49469441804087066
Vwp_16_3 wp_16_3 0 0.4773215287373152
Vwn_16_3 wn_16_3 0 0.5226784712626849
Vwp_17_3 wp_17_3 0 0.48436610665767904
Vwn_17_3 wn_17_3 0 0.515633893342321
Vwp_18_3 wp_18_3 0 0.49658038551861766
Vwn_18_3 wn_18_3 0 0.5034196144813824
Vwp_19_3 wp_19_3 0 0.5203574941556147
Vwn_19_3 wn_19_3 0 0.4796425058443853
Vwp_20_3 wp_20_3 0 0.5042512298245401
Vwn_20_3 wn_20_3 0 0.4957487701754599
Vwp_21_3 wp_21_3 0 0.5049089294009067
Vwn_21_3 wn_21_3 0 0.4950910705990933
Vwp_22_3 wp_22_3 0 0.5181575562419751
Vwn_22_3 wn_22_3 0 0.48184244375802493
Vwp_23_3 wp_23_3 0 0.49693106817308513
Vwn_23_3 wn_23_3 0 0.5030689318269149
Vwp_24_3 wp_24_3 0 0.49866325989913984
Vwn_24_3 wn_24_3 0 0.5013367401008602
Vwp_25_3 wp_25_3 0 0.4972720083278672
Vwn_25_3 wn_25_3 0 0.5027279916721328
Vwp_26_3 wp_26_3 0 0.47333059123146315
Vwn_26_3 wn_26_3 0 0.5266694087685369
Vwp_27_3 wp_27_3 0 0.5070001823701064
Vwn_27_3 wn_27_3 0 0.49299981762989364
Vwp_28_3 wp_28_3 0 0.5061625819192638
Vwn_28_3 wn_28_3 0 0.4938374180807362
Vwp_29_3 wp_29_3 0 0.5146316361532458
Vwn_29_3 wn_29_3 0 0.48536836384675414
Vwp_30_3 wp_30_3 0 0.48216645208716896
Vwn_30_3 wn_30_3 0 0.5178335479128311
Vwp_31_3 wp_31_3 0 0.4877620515059218
Vwn_31_3 wn_31_3 0 0.5122379484940782
Vwp_32_3 wp_32_3 0 0.5140170426019643
Vwn_32_3 wn_32_3 0 0.48598295739803565
Vwp_33_3 wp_33_3 0 0.5048459243064481
Vwn_33_3 wn_33_3 0 0.49515407569355185
Vwp_34_3 wp_34_3 0 0.5206253853569176
Vwn_34_3 wn_34_3 0 0.47937461464308245
Vwp_35_3 wp_35_3 0 0.4870545164354932
Vwn_35_3 wn_35_3 0 0.5129454835645069
Vwp_36_3 wp_36_3 0 0.5030120450744816
Vwn_36_3 wn_36_3 0 0.49698795492551845
Vwp_37_3 wp_37_3 0 0.4898600388449916
Vwn_37_3 wn_37_3 0 0.5101399611550084
Vwp_38_3 wp_38_3 0 0.5046462999589241
Vwn_38_3 wn_38_3 0 0.49535370004107593
Vwp_39_3 wp_39_3 0 0.49272432807696287
Vwn_39_3 wn_39_3 0 0.5072756719230371
Vwp_40_3 wp_40_3 0 0.5080395065894348
Vwn_40_3 wn_40_3 0 0.4919604934105653
Vwp_41_3 wp_41_3 0 0.5162204562475766
Vwn_41_3 wn_41_3 0 0.48377954375242344
Vwp_42_3 wp_42_3 0 0.5101290573505464
Vwn_42_3 wn_42_3 0 0.4898709426494537
Vwp_43_3 wp_43_3 0 0.47287590360037907
Vwn_43_3 wn_43_3 0 0.5271240963996209
Vwp_44_3 wp_44_3 0 0.5141060545745457
Vwn_44_3 wn_44_3 0 0.4858939454254543
Vwp_45_3 wp_45_3 0 0.5067131324190223
Vwn_45_3 wn_45_3 0 0.4932868675809777
Vwp_46_3 wp_46_3 0 0.4843546895786139
Vwn_46_3 wn_46_3 0 0.5156453104213862
Vwp_47_3 wp_47_3 0 0.4867135078247047
Vwn_47_3 wn_47_3 0 0.5132864921752953
Vwp_48_3 wp_48_3 0 0.5001246008647461
Vwn_48_3 wn_48_3 0 0.4998753991352539
Vwp_49_3 wp_49_3 0 0.5086029407551452
Vwn_49_3 wn_49_3 0 0.4913970592448548
Vwp_50_3 wp_50_3 0 0.49323948639466747
Vwn_50_3 wn_50_3 0 0.5067605136053325
Vwp_51_3 wp_51_3 0 0.47566232495008237
Vwn_51_3 wn_51_3 0 0.5243376750499176
Vwp_52_3 wp_52_3 0 0.5042236861550966
Vwn_52_3 wn_52_3 0 0.4957763138449034
Vwp_53_3 wp_53_3 0 0.5025471295694517
Vwn_53_3 wn_53_3 0 0.49745287043054837
Vwp_54_3 wp_54_3 0 0.5366169925353914
Vwn_54_3 wn_54_3 0 0.46338300746460864
Vwp_55_3 wp_55_3 0 0.4806716095402801
Vwn_55_3 wn_55_3 0 0.5193283904597199
Vwp_56_3 wp_56_3 0 0.5378562583484888
Vwn_56_3 wn_56_3 0 0.46214374165151123
Vwp_57_3 wp_57_3 0 0.5261705352096984
Vwn_57_3 wn_57_3 0 0.47382946479030164
Vwp_58_3 wp_58_3 0 0.5045468422540846
Vwn_58_3 wn_58_3 0 0.49545315774591536
Vwp_59_3 wp_59_3 0 0.5248847617466428
Vwn_59_3 wn_59_3 0 0.4751152382533573
Vwp_60_3 wp_60_3 0 0.5014484058581846
Vwn_60_3 wn_60_3 0 0.4985515941418153
Vwp_61_3 wp_61_3 0 0.5146675580576273
Vwn_61_3 wn_61_3 0 0.4853324419423727
Vwp_62_3 wp_62_3 0 0.48899351252926493
Vwn_62_3 wn_62_3 0 0.5110064874707351
Vwp_63_3 wp_63_3 0 0.5011954691930239
Vwn_63_3 wn_63_3 0 0.49880453080697607
Vwp_0_4 wp_0_4 0 0.48478107044543944
Vwn_0_4 wn_0_4 0 0.5152189295545605
Vwp_1_4 wp_1_4 0 0.4763679356242991
Vwn_1_4 wn_1_4 0 0.5236320643757009
Vwp_2_4 wp_2_4 0 0.49592509175621835
Vwn_2_4 wn_2_4 0 0.5040749082437816
Vwp_3_4 wp_3_4 0 0.4901165922740233
Vwn_3_4 wn_3_4 0 0.5098834077259767
Vwp_4_4 wp_4_4 0 0.508592184538943
Vwn_4_4 wn_4_4 0 0.491407815461057
Vwp_5_4 wp_5_4 0 0.5190620586231137
Vwn_5_4 wn_5_4 0 0.4809379413768863
Vwp_6_4 wp_6_4 0 0.49746270527717973
Vwn_6_4 wn_6_4 0 0.5025372947228203
Vwp_7_4 wp_7_4 0 0.5008839836823176
Vwn_7_4 wn_7_4 0 0.4991160163176824
Vwp_8_4 wp_8_4 0 0.5028187911783081
Vwn_8_4 wn_8_4 0 0.4971812088216919
Vwp_9_4 wp_9_4 0 0.4748304769029106
Vwn_9_4 wn_9_4 0 0.5251695230970894
Vwp_10_4 wp_10_4 0 0.5040362159423311
Vwn_10_4 wn_10_4 0 0.49596378405766894
Vwp_11_4 wp_11_4 0 0.5001702577078732
Vwn_11_4 wn_11_4 0 0.4998297422921269
Vwp_12_4 wp_12_4 0 0.4993051559666812
Vwn_12_4 wn_12_4 0 0.5006948440333189
Vwp_13_4 wp_13_4 0 0.4834943754797907
Vwn_13_4 wn_13_4 0 0.5165056245202093
Vwp_14_4 wp_14_4 0 0.47027179933332314
Vwn_14_4 wn_14_4 0 0.5297282006666768
Vwp_15_4 wp_15_4 0 0.4962460949010937
Vwn_15_4 wn_15_4 0 0.5037539050989063
Vwp_16_4 wp_16_4 0 0.5047423512570343
Vwn_16_4 wn_16_4 0 0.49525764874296574
Vwp_17_4 wp_17_4 0 0.5201136955234367
Vwn_17_4 wn_17_4 0 0.47988630447656333
Vwp_18_4 wp_18_4 0 0.5169676398058318
Vwn_18_4 wn_18_4 0 0.4830323601941682
Vwp_19_4 wp_19_4 0 0.5218297656649116
Vwn_19_4 wn_19_4 0 0.47817023433508843
Vwp_20_4 wp_20_4 0 0.5055492668351192
Vwn_20_4 wn_20_4 0 0.49445073316488075
Vwp_21_4 wp_21_4 0 0.5173425121857494
Vwn_21_4 wn_21_4 0 0.4826574878142506
Vwp_22_4 wp_22_4 0 0.4969098362602705
Vwn_22_4 wn_22_4 0 0.5030901637397295
Vwp_23_4 wp_23_4 0 0.5094265008329227
Vwn_23_4 wn_23_4 0 0.4905734991670772
Vwp_24_4 wp_24_4 0 0.5139772183160194
Vwn_24_4 wn_24_4 0 0.48602278168398066
Vwp_25_4 wp_25_4 0 0.5403398722517176
Vwn_25_4 wn_25_4 0 0.45966012774828235
Vwp_26_4 wp_26_4 0 0.5036394557794639
Vwn_26_4 wn_26_4 0 0.49636054422053616
Vwp_27_4 wp_27_4 0 0.48091145526566986
Vwn_27_4 wn_27_4 0 0.5190885447343301
Vwp_28_4 wp_28_4 0 0.5206659944633899
Vwn_28_4 wn_28_4 0 0.4793340055366101
Vwp_29_4 wp_29_4 0 0.4881305145560447
Vwn_29_4 wn_29_4 0 0.5118694854439553
Vwp_30_4 wp_30_4 0 0.49908984203045065
Vwn_30_4 wn_30_4 0 0.5009101579695493
Vwp_31_4 wp_31_4 0 0.49558677918860033
Vwn_31_4 wn_31_4 0 0.5044132208113996
Vwp_32_4 wp_32_4 0 0.486383651345944
Vwn_32_4 wn_32_4 0 0.5136163486540559
Vwp_33_4 wp_33_4 0 0.5200215884075583
Vwn_33_4 wn_33_4 0 0.47997841159244176
Vwp_34_4 wp_34_4 0 0.5089409163256703
Vwn_34_4 wn_34_4 0 0.49105908367432966
Vwp_35_4 wp_35_4 0 0.4908196185136135
Vwn_35_4 wn_35_4 0 0.5091803814863864
Vwp_36_4 wp_36_4 0 0.501040080523506
Vwn_36_4 wn_36_4 0 0.49895991947649404
Vwp_37_4 wp_37_4 0 0.4935014656822152
Vwn_37_4 wn_37_4 0 0.5064985343177848
Vwp_38_4 wp_38_4 0 0.5092279340947096
Vwn_38_4 wn_38_4 0 0.49077206590529043
Vwp_39_4 wp_39_4 0 0.49432164363536335
Vwn_39_4 wn_39_4 0 0.5056783563646366
Vwp_40_4 wp_40_4 0 0.4885075483153902
Vwn_40_4 wn_40_4 0 0.5114924516846098
Vwp_41_4 wp_41_4 0 0.49033538750448746
Vwn_41_4 wn_41_4 0 0.5096646124955125
Vwp_42_4 wp_42_4 0 0.49344719516943875
Vwn_42_4 wn_42_4 0 0.5065528048305613
Vwp_43_4 wp_43_4 0 0.5043405079733392
Vwn_43_4 wn_43_4 0 0.4956594920266608
Vwp_44_4 wp_44_4 0 0.48621687329436053
Vwn_44_4 wn_44_4 0 0.5137831267056395
Vwp_45_4 wp_45_4 0 0.4986594547202205
Vwn_45_4 wn_45_4 0 0.5013405452797796
Vwp_46_4 wp_46_4 0 0.506653715515138
Vwn_46_4 wn_46_4 0 0.4933462844848619
Vwp_47_4 wp_47_4 0 0.535059127525009
Vwn_47_4 wn_47_4 0 0.4649408724749911
Vwp_48_4 wp_48_4 0 0.5128436821255475
Vwn_48_4 wn_48_4 0 0.48715631787445246
Vwp_49_4 wp_49_4 0 0.4552435241778437
Vwn_49_4 wn_49_4 0 0.5447564758221564
Vwp_50_4 wp_50_4 0 0.4923338598958671
Vwn_50_4 wn_50_4 0 0.5076661401041329
Vwp_51_4 wp_51_4 0 0.49404612138763376
Vwn_51_4 wn_51_4 0 0.5059538786123662
Vwp_52_4 wp_52_4 0 0.5048057799673947
Vwn_52_4 wn_52_4 0 0.49519422003260527
Vwp_53_4 wp_53_4 0 0.5235407886614114
Vwn_53_4 wn_53_4 0 0.4764592113385886
Vwp_54_4 wp_54_4 0 0.5111311297488554
Vwn_54_4 wn_54_4 0 0.48886887025114456
Vwp_55_4 wp_55_4 0 0.4654563505939427
Vwn_55_4 wn_55_4 0 0.5345436494060573
Vwp_56_4 wp_56_4 0 0.5046046614291231
Vwn_56_4 wn_56_4 0 0.4953953385708769
Vwp_57_4 wp_57_4 0 0.5016209476496813
Vwn_57_4 wn_57_4 0 0.4983790523503187
Vwp_58_4 wp_58_4 0 0.5061947273501088
Vwn_58_4 wn_58_4 0 0.4938052726498911
Vwp_59_4 wp_59_4 0 0.5203830341534301
Vwn_59_4 wn_59_4 0 0.47961696584656993
Vwp_60_4 wp_60_4 0 0.4836372272441091
Vwn_60_4 wn_60_4 0 0.5163627727558909
Vwp_61_4 wp_61_4 0 0.5165460521803171
Vwn_61_4 wn_61_4 0 0.48345394781968287
Vwp_62_4 wp_62_4 0 0.4751920423113694
Vwn_62_4 wn_62_4 0 0.5248079576886306
Vwp_63_4 wp_63_4 0 0.5007623365511628
Vwn_63_4 wn_63_4 0 0.4992376634488372
Xcm_mo0 mop0 mon0 vdd cmld
Rnd_mo0 mop0 mon0 20k
X_0_0 a_xp0 a_xn0 wp_0_0 wn_0_0 mop0 mon0 vdd vbsyn gsyn
X_1_0 a_xp1 a_xn1 wp_1_0 wn_1_0 mop0 mon0 vdd vbsyn gsyn
X_2_0 a_xp2 a_xn2 wp_2_0 wn_2_0 mop0 mon0 vdd vbsyn gsyn
X_3_0 a_xp3 a_xn3 wp_3_0 wn_3_0 mop0 mon0 vdd vbsyn gsyn
X_4_0 a_xp4 a_xn4 wp_4_0 wn_4_0 mop0 mon0 vdd vbsyn gsyn
X_5_0 a_xp5 a_xn5 wp_5_0 wn_5_0 mop0 mon0 vdd vbsyn gsyn
X_6_0 a_xp6 a_xn6 wp_6_0 wn_6_0 mop0 mon0 vdd vbsyn gsyn
X_7_0 a_xp7 a_xn7 wp_7_0 wn_7_0 mop0 mon0 vdd vbsyn gsyn
X_8_0 a_xp8 a_xn8 wp_8_0 wn_8_0 mop0 mon0 vdd vbsyn gsyn
X_9_0 a_xp9 a_xn9 wp_9_0 wn_9_0 mop0 mon0 vdd vbsyn gsyn
X_10_0 a_xp10 a_xn10 wp_10_0 wn_10_0 mop0 mon0 vdd vbsyn gsyn
X_11_0 a_xp11 a_xn11 wp_11_0 wn_11_0 mop0 mon0 vdd vbsyn gsyn
X_12_0 a_xp12 a_xn12 wp_12_0 wn_12_0 mop0 mon0 vdd vbsyn gsyn
X_13_0 a_xp13 a_xn13 wp_13_0 wn_13_0 mop0 mon0 vdd vbsyn gsyn
X_14_0 a_xp14 a_xn14 wp_14_0 wn_14_0 mop0 mon0 vdd vbsyn gsyn
X_15_0 a_xp15 a_xn15 wp_15_0 wn_15_0 mop0 mon0 vdd vbsyn gsyn
X_16_0 a_xp16 a_xn16 wp_16_0 wn_16_0 mop0 mon0 vdd vbsyn gsyn
X_17_0 a_xp17 a_xn17 wp_17_0 wn_17_0 mop0 mon0 vdd vbsyn gsyn
X_18_0 a_xp18 a_xn18 wp_18_0 wn_18_0 mop0 mon0 vdd vbsyn gsyn
X_19_0 a_xp19 a_xn19 wp_19_0 wn_19_0 mop0 mon0 vdd vbsyn gsyn
X_20_0 a_xp20 a_xn20 wp_20_0 wn_20_0 mop0 mon0 vdd vbsyn gsyn
X_21_0 a_xp21 a_xn21 wp_21_0 wn_21_0 mop0 mon0 vdd vbsyn gsyn
X_22_0 a_xp22 a_xn22 wp_22_0 wn_22_0 mop0 mon0 vdd vbsyn gsyn
X_23_0 a_xp23 a_xn23 wp_23_0 wn_23_0 mop0 mon0 vdd vbsyn gsyn
X_24_0 a_xp24 a_xn24 wp_24_0 wn_24_0 mop0 mon0 vdd vbsyn gsyn
X_25_0 a_xp25 a_xn25 wp_25_0 wn_25_0 mop0 mon0 vdd vbsyn gsyn
X_26_0 a_xp26 a_xn26 wp_26_0 wn_26_0 mop0 mon0 vdd vbsyn gsyn
X_27_0 a_xp27 a_xn27 wp_27_0 wn_27_0 mop0 mon0 vdd vbsyn gsyn
X_28_0 a_xp28 a_xn28 wp_28_0 wn_28_0 mop0 mon0 vdd vbsyn gsyn
X_29_0 a_xp29 a_xn29 wp_29_0 wn_29_0 mop0 mon0 vdd vbsyn gsyn
X_30_0 a_xp30 a_xn30 wp_30_0 wn_30_0 mop0 mon0 vdd vbsyn gsyn
X_31_0 a_xp31 a_xn31 wp_31_0 wn_31_0 mop0 mon0 vdd vbsyn gsyn
X_32_0 a_xp32 a_xn32 wp_32_0 wn_32_0 mop0 mon0 vdd vbsyn gsyn
X_33_0 a_xp33 a_xn33 wp_33_0 wn_33_0 mop0 mon0 vdd vbsyn gsyn
X_34_0 a_xp34 a_xn34 wp_34_0 wn_34_0 mop0 mon0 vdd vbsyn gsyn
X_35_0 a_xp35 a_xn35 wp_35_0 wn_35_0 mop0 mon0 vdd vbsyn gsyn
X_36_0 a_xp36 a_xn36 wp_36_0 wn_36_0 mop0 mon0 vdd vbsyn gsyn
X_37_0 a_xp37 a_xn37 wp_37_0 wn_37_0 mop0 mon0 vdd vbsyn gsyn
X_38_0 a_xp38 a_xn38 wp_38_0 wn_38_0 mop0 mon0 vdd vbsyn gsyn
X_39_0 a_xp39 a_xn39 wp_39_0 wn_39_0 mop0 mon0 vdd vbsyn gsyn
X_40_0 a_xp40 a_xn40 wp_40_0 wn_40_0 mop0 mon0 vdd vbsyn gsyn
X_41_0 a_xp41 a_xn41 wp_41_0 wn_41_0 mop0 mon0 vdd vbsyn gsyn
X_42_0 a_xp42 a_xn42 wp_42_0 wn_42_0 mop0 mon0 vdd vbsyn gsyn
X_43_0 a_xp43 a_xn43 wp_43_0 wn_43_0 mop0 mon0 vdd vbsyn gsyn
X_44_0 a_xp44 a_xn44 wp_44_0 wn_44_0 mop0 mon0 vdd vbsyn gsyn
X_45_0 a_xp45 a_xn45 wp_45_0 wn_45_0 mop0 mon0 vdd vbsyn gsyn
X_46_0 a_xp46 a_xn46 wp_46_0 wn_46_0 mop0 mon0 vdd vbsyn gsyn
X_47_0 a_xp47 a_xn47 wp_47_0 wn_47_0 mop0 mon0 vdd vbsyn gsyn
X_48_0 a_xp48 a_xn48 wp_48_0 wn_48_0 mop0 mon0 vdd vbsyn gsyn
X_49_0 a_xp49 a_xn49 wp_49_0 wn_49_0 mop0 mon0 vdd vbsyn gsyn
X_50_0 a_xp50 a_xn50 wp_50_0 wn_50_0 mop0 mon0 vdd vbsyn gsyn
X_51_0 a_xp51 a_xn51 wp_51_0 wn_51_0 mop0 mon0 vdd vbsyn gsyn
X_52_0 a_xp52 a_xn52 wp_52_0 wn_52_0 mop0 mon0 vdd vbsyn gsyn
X_53_0 a_xp53 a_xn53 wp_53_0 wn_53_0 mop0 mon0 vdd vbsyn gsyn
X_54_0 a_xp54 a_xn54 wp_54_0 wn_54_0 mop0 mon0 vdd vbsyn gsyn
X_55_0 a_xp55 a_xn55 wp_55_0 wn_55_0 mop0 mon0 vdd vbsyn gsyn
X_56_0 a_xp56 a_xn56 wp_56_0 wn_56_0 mop0 mon0 vdd vbsyn gsyn
X_57_0 a_xp57 a_xn57 wp_57_0 wn_57_0 mop0 mon0 vdd vbsyn gsyn
X_58_0 a_xp58 a_xn58 wp_58_0 wn_58_0 mop0 mon0 vdd vbsyn gsyn
X_59_0 a_xp59 a_xn59 wp_59_0 wn_59_0 mop0 mon0 vdd vbsyn gsyn
X_60_0 a_xp60 a_xn60 wp_60_0 wn_60_0 mop0 mon0 vdd vbsyn gsyn
X_61_0 a_xp61 a_xn61 wp_61_0 wn_61_0 mop0 mon0 vdd vbsyn gsyn
X_62_0 a_xp62 a_xn62 wp_62_0 wn_62_0 mop0 mon0 vdd vbsyn gsyn
X_63_0 a_xp63 a_xn63 wp_63_0 wn_63_0 mop0 mon0 vdd vbsyn gsyn
Xcm_mo1 mop1 mon1 vdd cmld
Rnd_mo1 mop1 mon1 20k
X_0_1 a_xp0 a_xn0 wp_0_1 wn_0_1 mop1 mon1 vdd vbsyn gsyn
X_1_1 a_xp1 a_xn1 wp_1_1 wn_1_1 mop1 mon1 vdd vbsyn gsyn
X_2_1 a_xp2 a_xn2 wp_2_1 wn_2_1 mop1 mon1 vdd vbsyn gsyn
X_3_1 a_xp3 a_xn3 wp_3_1 wn_3_1 mop1 mon1 vdd vbsyn gsyn
X_4_1 a_xp4 a_xn4 wp_4_1 wn_4_1 mop1 mon1 vdd vbsyn gsyn
X_5_1 a_xp5 a_xn5 wp_5_1 wn_5_1 mop1 mon1 vdd vbsyn gsyn
X_6_1 a_xp6 a_xn6 wp_6_1 wn_6_1 mop1 mon1 vdd vbsyn gsyn
X_7_1 a_xp7 a_xn7 wp_7_1 wn_7_1 mop1 mon1 vdd vbsyn gsyn
X_8_1 a_xp8 a_xn8 wp_8_1 wn_8_1 mop1 mon1 vdd vbsyn gsyn
X_9_1 a_xp9 a_xn9 wp_9_1 wn_9_1 mop1 mon1 vdd vbsyn gsyn
X_10_1 a_xp10 a_xn10 wp_10_1 wn_10_1 mop1 mon1 vdd vbsyn gsyn
X_11_1 a_xp11 a_xn11 wp_11_1 wn_11_1 mop1 mon1 vdd vbsyn gsyn
X_12_1 a_xp12 a_xn12 wp_12_1 wn_12_1 mop1 mon1 vdd vbsyn gsyn
X_13_1 a_xp13 a_xn13 wp_13_1 wn_13_1 mop1 mon1 vdd vbsyn gsyn
X_14_1 a_xp14 a_xn14 wp_14_1 wn_14_1 mop1 mon1 vdd vbsyn gsyn
X_15_1 a_xp15 a_xn15 wp_15_1 wn_15_1 mop1 mon1 vdd vbsyn gsyn
X_16_1 a_xp16 a_xn16 wp_16_1 wn_16_1 mop1 mon1 vdd vbsyn gsyn
X_17_1 a_xp17 a_xn17 wp_17_1 wn_17_1 mop1 mon1 vdd vbsyn gsyn
X_18_1 a_xp18 a_xn18 wp_18_1 wn_18_1 mop1 mon1 vdd vbsyn gsyn
X_19_1 a_xp19 a_xn19 wp_19_1 wn_19_1 mop1 mon1 vdd vbsyn gsyn
X_20_1 a_xp20 a_xn20 wp_20_1 wn_20_1 mop1 mon1 vdd vbsyn gsyn
X_21_1 a_xp21 a_xn21 wp_21_1 wn_21_1 mop1 mon1 vdd vbsyn gsyn
X_22_1 a_xp22 a_xn22 wp_22_1 wn_22_1 mop1 mon1 vdd vbsyn gsyn
X_23_1 a_xp23 a_xn23 wp_23_1 wn_23_1 mop1 mon1 vdd vbsyn gsyn
X_24_1 a_xp24 a_xn24 wp_24_1 wn_24_1 mop1 mon1 vdd vbsyn gsyn
X_25_1 a_xp25 a_xn25 wp_25_1 wn_25_1 mop1 mon1 vdd vbsyn gsyn
X_26_1 a_xp26 a_xn26 wp_26_1 wn_26_1 mop1 mon1 vdd vbsyn gsyn
X_27_1 a_xp27 a_xn27 wp_27_1 wn_27_1 mop1 mon1 vdd vbsyn gsyn
X_28_1 a_xp28 a_xn28 wp_28_1 wn_28_1 mop1 mon1 vdd vbsyn gsyn
X_29_1 a_xp29 a_xn29 wp_29_1 wn_29_1 mop1 mon1 vdd vbsyn gsyn
X_30_1 a_xp30 a_xn30 wp_30_1 wn_30_1 mop1 mon1 vdd vbsyn gsyn
X_31_1 a_xp31 a_xn31 wp_31_1 wn_31_1 mop1 mon1 vdd vbsyn gsyn
X_32_1 a_xp32 a_xn32 wp_32_1 wn_32_1 mop1 mon1 vdd vbsyn gsyn
X_33_1 a_xp33 a_xn33 wp_33_1 wn_33_1 mop1 mon1 vdd vbsyn gsyn
X_34_1 a_xp34 a_xn34 wp_34_1 wn_34_1 mop1 mon1 vdd vbsyn gsyn
X_35_1 a_xp35 a_xn35 wp_35_1 wn_35_1 mop1 mon1 vdd vbsyn gsyn
X_36_1 a_xp36 a_xn36 wp_36_1 wn_36_1 mop1 mon1 vdd vbsyn gsyn
X_37_1 a_xp37 a_xn37 wp_37_1 wn_37_1 mop1 mon1 vdd vbsyn gsyn
X_38_1 a_xp38 a_xn38 wp_38_1 wn_38_1 mop1 mon1 vdd vbsyn gsyn
X_39_1 a_xp39 a_xn39 wp_39_1 wn_39_1 mop1 mon1 vdd vbsyn gsyn
X_40_1 a_xp40 a_xn40 wp_40_1 wn_40_1 mop1 mon1 vdd vbsyn gsyn
X_41_1 a_xp41 a_xn41 wp_41_1 wn_41_1 mop1 mon1 vdd vbsyn gsyn
X_42_1 a_xp42 a_xn42 wp_42_1 wn_42_1 mop1 mon1 vdd vbsyn gsyn
X_43_1 a_xp43 a_xn43 wp_43_1 wn_43_1 mop1 mon1 vdd vbsyn gsyn
X_44_1 a_xp44 a_xn44 wp_44_1 wn_44_1 mop1 mon1 vdd vbsyn gsyn
X_45_1 a_xp45 a_xn45 wp_45_1 wn_45_1 mop1 mon1 vdd vbsyn gsyn
X_46_1 a_xp46 a_xn46 wp_46_1 wn_46_1 mop1 mon1 vdd vbsyn gsyn
X_47_1 a_xp47 a_xn47 wp_47_1 wn_47_1 mop1 mon1 vdd vbsyn gsyn
X_48_1 a_xp48 a_xn48 wp_48_1 wn_48_1 mop1 mon1 vdd vbsyn gsyn
X_49_1 a_xp49 a_xn49 wp_49_1 wn_49_1 mop1 mon1 vdd vbsyn gsyn
X_50_1 a_xp50 a_xn50 wp_50_1 wn_50_1 mop1 mon1 vdd vbsyn gsyn
X_51_1 a_xp51 a_xn51 wp_51_1 wn_51_1 mop1 mon1 vdd vbsyn gsyn
X_52_1 a_xp52 a_xn52 wp_52_1 wn_52_1 mop1 mon1 vdd vbsyn gsyn
X_53_1 a_xp53 a_xn53 wp_53_1 wn_53_1 mop1 mon1 vdd vbsyn gsyn
X_54_1 a_xp54 a_xn54 wp_54_1 wn_54_1 mop1 mon1 vdd vbsyn gsyn
X_55_1 a_xp55 a_xn55 wp_55_1 wn_55_1 mop1 mon1 vdd vbsyn gsyn
X_56_1 a_xp56 a_xn56 wp_56_1 wn_56_1 mop1 mon1 vdd vbsyn gsyn
X_57_1 a_xp57 a_xn57 wp_57_1 wn_57_1 mop1 mon1 vdd vbsyn gsyn
X_58_1 a_xp58 a_xn58 wp_58_1 wn_58_1 mop1 mon1 vdd vbsyn gsyn
X_59_1 a_xp59 a_xn59 wp_59_1 wn_59_1 mop1 mon1 vdd vbsyn gsyn
X_60_1 a_xp60 a_xn60 wp_60_1 wn_60_1 mop1 mon1 vdd vbsyn gsyn
X_61_1 a_xp61 a_xn61 wp_61_1 wn_61_1 mop1 mon1 vdd vbsyn gsyn
X_62_1 a_xp62 a_xn62 wp_62_1 wn_62_1 mop1 mon1 vdd vbsyn gsyn
X_63_1 a_xp63 a_xn63 wp_63_1 wn_63_1 mop1 mon1 vdd vbsyn gsyn
Xcm_mo2 mop2 mon2 vdd cmld
Rnd_mo2 mop2 mon2 20k
X_0_2 a_xp0 a_xn0 wp_0_2 wn_0_2 mop2 mon2 vdd vbsyn gsyn
X_1_2 a_xp1 a_xn1 wp_1_2 wn_1_2 mop2 mon2 vdd vbsyn gsyn
X_2_2 a_xp2 a_xn2 wp_2_2 wn_2_2 mop2 mon2 vdd vbsyn gsyn
X_3_2 a_xp3 a_xn3 wp_3_2 wn_3_2 mop2 mon2 vdd vbsyn gsyn
X_4_2 a_xp4 a_xn4 wp_4_2 wn_4_2 mop2 mon2 vdd vbsyn gsyn
X_5_2 a_xp5 a_xn5 wp_5_2 wn_5_2 mop2 mon2 vdd vbsyn gsyn
X_6_2 a_xp6 a_xn6 wp_6_2 wn_6_2 mop2 mon2 vdd vbsyn gsyn
X_7_2 a_xp7 a_xn7 wp_7_2 wn_7_2 mop2 mon2 vdd vbsyn gsyn
X_8_2 a_xp8 a_xn8 wp_8_2 wn_8_2 mop2 mon2 vdd vbsyn gsyn
X_9_2 a_xp9 a_xn9 wp_9_2 wn_9_2 mop2 mon2 vdd vbsyn gsyn
X_10_2 a_xp10 a_xn10 wp_10_2 wn_10_2 mop2 mon2 vdd vbsyn gsyn
X_11_2 a_xp11 a_xn11 wp_11_2 wn_11_2 mop2 mon2 vdd vbsyn gsyn
X_12_2 a_xp12 a_xn12 wp_12_2 wn_12_2 mop2 mon2 vdd vbsyn gsyn
X_13_2 a_xp13 a_xn13 wp_13_2 wn_13_2 mop2 mon2 vdd vbsyn gsyn
X_14_2 a_xp14 a_xn14 wp_14_2 wn_14_2 mop2 mon2 vdd vbsyn gsyn
X_15_2 a_xp15 a_xn15 wp_15_2 wn_15_2 mop2 mon2 vdd vbsyn gsyn
X_16_2 a_xp16 a_xn16 wp_16_2 wn_16_2 mop2 mon2 vdd vbsyn gsyn
X_17_2 a_xp17 a_xn17 wp_17_2 wn_17_2 mop2 mon2 vdd vbsyn gsyn
X_18_2 a_xp18 a_xn18 wp_18_2 wn_18_2 mop2 mon2 vdd vbsyn gsyn
X_19_2 a_xp19 a_xn19 wp_19_2 wn_19_2 mop2 mon2 vdd vbsyn gsyn
X_20_2 a_xp20 a_xn20 wp_20_2 wn_20_2 mop2 mon2 vdd vbsyn gsyn
X_21_2 a_xp21 a_xn21 wp_21_2 wn_21_2 mop2 mon2 vdd vbsyn gsyn
X_22_2 a_xp22 a_xn22 wp_22_2 wn_22_2 mop2 mon2 vdd vbsyn gsyn
X_23_2 a_xp23 a_xn23 wp_23_2 wn_23_2 mop2 mon2 vdd vbsyn gsyn
X_24_2 a_xp24 a_xn24 wp_24_2 wn_24_2 mop2 mon2 vdd vbsyn gsyn
X_25_2 a_xp25 a_xn25 wp_25_2 wn_25_2 mop2 mon2 vdd vbsyn gsyn
X_26_2 a_xp26 a_xn26 wp_26_2 wn_26_2 mop2 mon2 vdd vbsyn gsyn
X_27_2 a_xp27 a_xn27 wp_27_2 wn_27_2 mop2 mon2 vdd vbsyn gsyn
X_28_2 a_xp28 a_xn28 wp_28_2 wn_28_2 mop2 mon2 vdd vbsyn gsyn
X_29_2 a_xp29 a_xn29 wp_29_2 wn_29_2 mop2 mon2 vdd vbsyn gsyn
X_30_2 a_xp30 a_xn30 wp_30_2 wn_30_2 mop2 mon2 vdd vbsyn gsyn
X_31_2 a_xp31 a_xn31 wp_31_2 wn_31_2 mop2 mon2 vdd vbsyn gsyn
X_32_2 a_xp32 a_xn32 wp_32_2 wn_32_2 mop2 mon2 vdd vbsyn gsyn
X_33_2 a_xp33 a_xn33 wp_33_2 wn_33_2 mop2 mon2 vdd vbsyn gsyn
X_34_2 a_xp34 a_xn34 wp_34_2 wn_34_2 mop2 mon2 vdd vbsyn gsyn
X_35_2 a_xp35 a_xn35 wp_35_2 wn_35_2 mop2 mon2 vdd vbsyn gsyn
X_36_2 a_xp36 a_xn36 wp_36_2 wn_36_2 mop2 mon2 vdd vbsyn gsyn
X_37_2 a_xp37 a_xn37 wp_37_2 wn_37_2 mop2 mon2 vdd vbsyn gsyn
X_38_2 a_xp38 a_xn38 wp_38_2 wn_38_2 mop2 mon2 vdd vbsyn gsyn
X_39_2 a_xp39 a_xn39 wp_39_2 wn_39_2 mop2 mon2 vdd vbsyn gsyn
X_40_2 a_xp40 a_xn40 wp_40_2 wn_40_2 mop2 mon2 vdd vbsyn gsyn
X_41_2 a_xp41 a_xn41 wp_41_2 wn_41_2 mop2 mon2 vdd vbsyn gsyn
X_42_2 a_xp42 a_xn42 wp_42_2 wn_42_2 mop2 mon2 vdd vbsyn gsyn
X_43_2 a_xp43 a_xn43 wp_43_2 wn_43_2 mop2 mon2 vdd vbsyn gsyn
X_44_2 a_xp44 a_xn44 wp_44_2 wn_44_2 mop2 mon2 vdd vbsyn gsyn
X_45_2 a_xp45 a_xn45 wp_45_2 wn_45_2 mop2 mon2 vdd vbsyn gsyn
X_46_2 a_xp46 a_xn46 wp_46_2 wn_46_2 mop2 mon2 vdd vbsyn gsyn
X_47_2 a_xp47 a_xn47 wp_47_2 wn_47_2 mop2 mon2 vdd vbsyn gsyn
X_48_2 a_xp48 a_xn48 wp_48_2 wn_48_2 mop2 mon2 vdd vbsyn gsyn
X_49_2 a_xp49 a_xn49 wp_49_2 wn_49_2 mop2 mon2 vdd vbsyn gsyn
X_50_2 a_xp50 a_xn50 wp_50_2 wn_50_2 mop2 mon2 vdd vbsyn gsyn
X_51_2 a_xp51 a_xn51 wp_51_2 wn_51_2 mop2 mon2 vdd vbsyn gsyn
X_52_2 a_xp52 a_xn52 wp_52_2 wn_52_2 mop2 mon2 vdd vbsyn gsyn
X_53_2 a_xp53 a_xn53 wp_53_2 wn_53_2 mop2 mon2 vdd vbsyn gsyn
X_54_2 a_xp54 a_xn54 wp_54_2 wn_54_2 mop2 mon2 vdd vbsyn gsyn
X_55_2 a_xp55 a_xn55 wp_55_2 wn_55_2 mop2 mon2 vdd vbsyn gsyn
X_56_2 a_xp56 a_xn56 wp_56_2 wn_56_2 mop2 mon2 vdd vbsyn gsyn
X_57_2 a_xp57 a_xn57 wp_57_2 wn_57_2 mop2 mon2 vdd vbsyn gsyn
X_58_2 a_xp58 a_xn58 wp_58_2 wn_58_2 mop2 mon2 vdd vbsyn gsyn
X_59_2 a_xp59 a_xn59 wp_59_2 wn_59_2 mop2 mon2 vdd vbsyn gsyn
X_60_2 a_xp60 a_xn60 wp_60_2 wn_60_2 mop2 mon2 vdd vbsyn gsyn
X_61_2 a_xp61 a_xn61 wp_61_2 wn_61_2 mop2 mon2 vdd vbsyn gsyn
X_62_2 a_xp62 a_xn62 wp_62_2 wn_62_2 mop2 mon2 vdd vbsyn gsyn
X_63_2 a_xp63 a_xn63 wp_63_2 wn_63_2 mop2 mon2 vdd vbsyn gsyn
Xcm_mo3 mop3 mon3 vdd cmld
Rnd_mo3 mop3 mon3 20k
X_0_3 a_xp0 a_xn0 wp_0_3 wn_0_3 mop3 mon3 vdd vbsyn gsyn
X_1_3 a_xp1 a_xn1 wp_1_3 wn_1_3 mop3 mon3 vdd vbsyn gsyn
X_2_3 a_xp2 a_xn2 wp_2_3 wn_2_3 mop3 mon3 vdd vbsyn gsyn
X_3_3 a_xp3 a_xn3 wp_3_3 wn_3_3 mop3 mon3 vdd vbsyn gsyn
X_4_3 a_xp4 a_xn4 wp_4_3 wn_4_3 mop3 mon3 vdd vbsyn gsyn
X_5_3 a_xp5 a_xn5 wp_5_3 wn_5_3 mop3 mon3 vdd vbsyn gsyn
X_6_3 a_xp6 a_xn6 wp_6_3 wn_6_3 mop3 mon3 vdd vbsyn gsyn
X_7_3 a_xp7 a_xn7 wp_7_3 wn_7_3 mop3 mon3 vdd vbsyn gsyn
X_8_3 a_xp8 a_xn8 wp_8_3 wn_8_3 mop3 mon3 vdd vbsyn gsyn
X_9_3 a_xp9 a_xn9 wp_9_3 wn_9_3 mop3 mon3 vdd vbsyn gsyn
X_10_3 a_xp10 a_xn10 wp_10_3 wn_10_3 mop3 mon3 vdd vbsyn gsyn
X_11_3 a_xp11 a_xn11 wp_11_3 wn_11_3 mop3 mon3 vdd vbsyn gsyn
X_12_3 a_xp12 a_xn12 wp_12_3 wn_12_3 mop3 mon3 vdd vbsyn gsyn
X_13_3 a_xp13 a_xn13 wp_13_3 wn_13_3 mop3 mon3 vdd vbsyn gsyn
X_14_3 a_xp14 a_xn14 wp_14_3 wn_14_3 mop3 mon3 vdd vbsyn gsyn
X_15_3 a_xp15 a_xn15 wp_15_3 wn_15_3 mop3 mon3 vdd vbsyn gsyn
X_16_3 a_xp16 a_xn16 wp_16_3 wn_16_3 mop3 mon3 vdd vbsyn gsyn
X_17_3 a_xp17 a_xn17 wp_17_3 wn_17_3 mop3 mon3 vdd vbsyn gsyn
X_18_3 a_xp18 a_xn18 wp_18_3 wn_18_3 mop3 mon3 vdd vbsyn gsyn
X_19_3 a_xp19 a_xn19 wp_19_3 wn_19_3 mop3 mon3 vdd vbsyn gsyn
X_20_3 a_xp20 a_xn20 wp_20_3 wn_20_3 mop3 mon3 vdd vbsyn gsyn
X_21_3 a_xp21 a_xn21 wp_21_3 wn_21_3 mop3 mon3 vdd vbsyn gsyn
X_22_3 a_xp22 a_xn22 wp_22_3 wn_22_3 mop3 mon3 vdd vbsyn gsyn
X_23_3 a_xp23 a_xn23 wp_23_3 wn_23_3 mop3 mon3 vdd vbsyn gsyn
X_24_3 a_xp24 a_xn24 wp_24_3 wn_24_3 mop3 mon3 vdd vbsyn gsyn
X_25_3 a_xp25 a_xn25 wp_25_3 wn_25_3 mop3 mon3 vdd vbsyn gsyn
X_26_3 a_xp26 a_xn26 wp_26_3 wn_26_3 mop3 mon3 vdd vbsyn gsyn
X_27_3 a_xp27 a_xn27 wp_27_3 wn_27_3 mop3 mon3 vdd vbsyn gsyn
X_28_3 a_xp28 a_xn28 wp_28_3 wn_28_3 mop3 mon3 vdd vbsyn gsyn
X_29_3 a_xp29 a_xn29 wp_29_3 wn_29_3 mop3 mon3 vdd vbsyn gsyn
X_30_3 a_xp30 a_xn30 wp_30_3 wn_30_3 mop3 mon3 vdd vbsyn gsyn
X_31_3 a_xp31 a_xn31 wp_31_3 wn_31_3 mop3 mon3 vdd vbsyn gsyn
X_32_3 a_xp32 a_xn32 wp_32_3 wn_32_3 mop3 mon3 vdd vbsyn gsyn
X_33_3 a_xp33 a_xn33 wp_33_3 wn_33_3 mop3 mon3 vdd vbsyn gsyn
X_34_3 a_xp34 a_xn34 wp_34_3 wn_34_3 mop3 mon3 vdd vbsyn gsyn
X_35_3 a_xp35 a_xn35 wp_35_3 wn_35_3 mop3 mon3 vdd vbsyn gsyn
X_36_3 a_xp36 a_xn36 wp_36_3 wn_36_3 mop3 mon3 vdd vbsyn gsyn
X_37_3 a_xp37 a_xn37 wp_37_3 wn_37_3 mop3 mon3 vdd vbsyn gsyn
X_38_3 a_xp38 a_xn38 wp_38_3 wn_38_3 mop3 mon3 vdd vbsyn gsyn
X_39_3 a_xp39 a_xn39 wp_39_3 wn_39_3 mop3 mon3 vdd vbsyn gsyn
X_40_3 a_xp40 a_xn40 wp_40_3 wn_40_3 mop3 mon3 vdd vbsyn gsyn
X_41_3 a_xp41 a_xn41 wp_41_3 wn_41_3 mop3 mon3 vdd vbsyn gsyn
X_42_3 a_xp42 a_xn42 wp_42_3 wn_42_3 mop3 mon3 vdd vbsyn gsyn
X_43_3 a_xp43 a_xn43 wp_43_3 wn_43_3 mop3 mon3 vdd vbsyn gsyn
X_44_3 a_xp44 a_xn44 wp_44_3 wn_44_3 mop3 mon3 vdd vbsyn gsyn
X_45_3 a_xp45 a_xn45 wp_45_3 wn_45_3 mop3 mon3 vdd vbsyn gsyn
X_46_3 a_xp46 a_xn46 wp_46_3 wn_46_3 mop3 mon3 vdd vbsyn gsyn
X_47_3 a_xp47 a_xn47 wp_47_3 wn_47_3 mop3 mon3 vdd vbsyn gsyn
X_48_3 a_xp48 a_xn48 wp_48_3 wn_48_3 mop3 mon3 vdd vbsyn gsyn
X_49_3 a_xp49 a_xn49 wp_49_3 wn_49_3 mop3 mon3 vdd vbsyn gsyn
X_50_3 a_xp50 a_xn50 wp_50_3 wn_50_3 mop3 mon3 vdd vbsyn gsyn
X_51_3 a_xp51 a_xn51 wp_51_3 wn_51_3 mop3 mon3 vdd vbsyn gsyn
X_52_3 a_xp52 a_xn52 wp_52_3 wn_52_3 mop3 mon3 vdd vbsyn gsyn
X_53_3 a_xp53 a_xn53 wp_53_3 wn_53_3 mop3 mon3 vdd vbsyn gsyn
X_54_3 a_xp54 a_xn54 wp_54_3 wn_54_3 mop3 mon3 vdd vbsyn gsyn
X_55_3 a_xp55 a_xn55 wp_55_3 wn_55_3 mop3 mon3 vdd vbsyn gsyn
X_56_3 a_xp56 a_xn56 wp_56_3 wn_56_3 mop3 mon3 vdd vbsyn gsyn
X_57_3 a_xp57 a_xn57 wp_57_3 wn_57_3 mop3 mon3 vdd vbsyn gsyn
X_58_3 a_xp58 a_xn58 wp_58_3 wn_58_3 mop3 mon3 vdd vbsyn gsyn
X_59_3 a_xp59 a_xn59 wp_59_3 wn_59_3 mop3 mon3 vdd vbsyn gsyn
X_60_3 a_xp60 a_xn60 wp_60_3 wn_60_3 mop3 mon3 vdd vbsyn gsyn
X_61_3 a_xp61 a_xn61 wp_61_3 wn_61_3 mop3 mon3 vdd vbsyn gsyn
X_62_3 a_xp62 a_xn62 wp_62_3 wn_62_3 mop3 mon3 vdd vbsyn gsyn
X_63_3 a_xp63 a_xn63 wp_63_3 wn_63_3 mop3 mon3 vdd vbsyn gsyn
Xcm_mo4 mop4 mon4 vdd cmld
Rnd_mo4 mop4 mon4 20k
X_0_4 a_xp0 a_xn0 wp_0_4 wn_0_4 mop4 mon4 vdd vbsyn gsyn
X_1_4 a_xp1 a_xn1 wp_1_4 wn_1_4 mop4 mon4 vdd vbsyn gsyn
X_2_4 a_xp2 a_xn2 wp_2_4 wn_2_4 mop4 mon4 vdd vbsyn gsyn
X_3_4 a_xp3 a_xn3 wp_3_4 wn_3_4 mop4 mon4 vdd vbsyn gsyn
X_4_4 a_xp4 a_xn4 wp_4_4 wn_4_4 mop4 mon4 vdd vbsyn gsyn
X_5_4 a_xp5 a_xn5 wp_5_4 wn_5_4 mop4 mon4 vdd vbsyn gsyn
X_6_4 a_xp6 a_xn6 wp_6_4 wn_6_4 mop4 mon4 vdd vbsyn gsyn
X_7_4 a_xp7 a_xn7 wp_7_4 wn_7_4 mop4 mon4 vdd vbsyn gsyn
X_8_4 a_xp8 a_xn8 wp_8_4 wn_8_4 mop4 mon4 vdd vbsyn gsyn
X_9_4 a_xp9 a_xn9 wp_9_4 wn_9_4 mop4 mon4 vdd vbsyn gsyn
X_10_4 a_xp10 a_xn10 wp_10_4 wn_10_4 mop4 mon4 vdd vbsyn gsyn
X_11_4 a_xp11 a_xn11 wp_11_4 wn_11_4 mop4 mon4 vdd vbsyn gsyn
X_12_4 a_xp12 a_xn12 wp_12_4 wn_12_4 mop4 mon4 vdd vbsyn gsyn
X_13_4 a_xp13 a_xn13 wp_13_4 wn_13_4 mop4 mon4 vdd vbsyn gsyn
X_14_4 a_xp14 a_xn14 wp_14_4 wn_14_4 mop4 mon4 vdd vbsyn gsyn
X_15_4 a_xp15 a_xn15 wp_15_4 wn_15_4 mop4 mon4 vdd vbsyn gsyn
X_16_4 a_xp16 a_xn16 wp_16_4 wn_16_4 mop4 mon4 vdd vbsyn gsyn
X_17_4 a_xp17 a_xn17 wp_17_4 wn_17_4 mop4 mon4 vdd vbsyn gsyn
X_18_4 a_xp18 a_xn18 wp_18_4 wn_18_4 mop4 mon4 vdd vbsyn gsyn
X_19_4 a_xp19 a_xn19 wp_19_4 wn_19_4 mop4 mon4 vdd vbsyn gsyn
X_20_4 a_xp20 a_xn20 wp_20_4 wn_20_4 mop4 mon4 vdd vbsyn gsyn
X_21_4 a_xp21 a_xn21 wp_21_4 wn_21_4 mop4 mon4 vdd vbsyn gsyn
X_22_4 a_xp22 a_xn22 wp_22_4 wn_22_4 mop4 mon4 vdd vbsyn gsyn
X_23_4 a_xp23 a_xn23 wp_23_4 wn_23_4 mop4 mon4 vdd vbsyn gsyn
X_24_4 a_xp24 a_xn24 wp_24_4 wn_24_4 mop4 mon4 vdd vbsyn gsyn
X_25_4 a_xp25 a_xn25 wp_25_4 wn_25_4 mop4 mon4 vdd vbsyn gsyn
X_26_4 a_xp26 a_xn26 wp_26_4 wn_26_4 mop4 mon4 vdd vbsyn gsyn
X_27_4 a_xp27 a_xn27 wp_27_4 wn_27_4 mop4 mon4 vdd vbsyn gsyn
X_28_4 a_xp28 a_xn28 wp_28_4 wn_28_4 mop4 mon4 vdd vbsyn gsyn
X_29_4 a_xp29 a_xn29 wp_29_4 wn_29_4 mop4 mon4 vdd vbsyn gsyn
X_30_4 a_xp30 a_xn30 wp_30_4 wn_30_4 mop4 mon4 vdd vbsyn gsyn
X_31_4 a_xp31 a_xn31 wp_31_4 wn_31_4 mop4 mon4 vdd vbsyn gsyn
X_32_4 a_xp32 a_xn32 wp_32_4 wn_32_4 mop4 mon4 vdd vbsyn gsyn
X_33_4 a_xp33 a_xn33 wp_33_4 wn_33_4 mop4 mon4 vdd vbsyn gsyn
X_34_4 a_xp34 a_xn34 wp_34_4 wn_34_4 mop4 mon4 vdd vbsyn gsyn
X_35_4 a_xp35 a_xn35 wp_35_4 wn_35_4 mop4 mon4 vdd vbsyn gsyn
X_36_4 a_xp36 a_xn36 wp_36_4 wn_36_4 mop4 mon4 vdd vbsyn gsyn
X_37_4 a_xp37 a_xn37 wp_37_4 wn_37_4 mop4 mon4 vdd vbsyn gsyn
X_38_4 a_xp38 a_xn38 wp_38_4 wn_38_4 mop4 mon4 vdd vbsyn gsyn
X_39_4 a_xp39 a_xn39 wp_39_4 wn_39_4 mop4 mon4 vdd vbsyn gsyn
X_40_4 a_xp40 a_xn40 wp_40_4 wn_40_4 mop4 mon4 vdd vbsyn gsyn
X_41_4 a_xp41 a_xn41 wp_41_4 wn_41_4 mop4 mon4 vdd vbsyn gsyn
X_42_4 a_xp42 a_xn42 wp_42_4 wn_42_4 mop4 mon4 vdd vbsyn gsyn
X_43_4 a_xp43 a_xn43 wp_43_4 wn_43_4 mop4 mon4 vdd vbsyn gsyn
X_44_4 a_xp44 a_xn44 wp_44_4 wn_44_4 mop4 mon4 vdd vbsyn gsyn
X_45_4 a_xp45 a_xn45 wp_45_4 wn_45_4 mop4 mon4 vdd vbsyn gsyn
X_46_4 a_xp46 a_xn46 wp_46_4 wn_46_4 mop4 mon4 vdd vbsyn gsyn
X_47_4 a_xp47 a_xn47 wp_47_4 wn_47_4 mop4 mon4 vdd vbsyn gsyn
X_48_4 a_xp48 a_xn48 wp_48_4 wn_48_4 mop4 mon4 vdd vbsyn gsyn
X_49_4 a_xp49 a_xn49 wp_49_4 wn_49_4 mop4 mon4 vdd vbsyn gsyn
X_50_4 a_xp50 a_xn50 wp_50_4 wn_50_4 mop4 mon4 vdd vbsyn gsyn
X_51_4 a_xp51 a_xn51 wp_51_4 wn_51_4 mop4 mon4 vdd vbsyn gsyn
X_52_4 a_xp52 a_xn52 wp_52_4 wn_52_4 mop4 mon4 vdd vbsyn gsyn
X_53_4 a_xp53 a_xn53 wp_53_4 wn_53_4 mop4 mon4 vdd vbsyn gsyn
X_54_4 a_xp54 a_xn54 wp_54_4 wn_54_4 mop4 mon4 vdd vbsyn gsyn
X_55_4 a_xp55 a_xn55 wp_55_4 wn_55_4 mop4 mon4 vdd vbsyn gsyn
X_56_4 a_xp56 a_xn56 wp_56_4 wn_56_4 mop4 mon4 vdd vbsyn gsyn
X_57_4 a_xp57 a_xn57 wp_57_4 wn_57_4 mop4 mon4 vdd vbsyn gsyn
X_58_4 a_xp58 a_xn58 wp_58_4 wn_58_4 mop4 mon4 vdd vbsyn gsyn
X_59_4 a_xp59 a_xn59 wp_59_4 wn_59_4 mop4 mon4 vdd vbsyn gsyn
X_60_4 a_xp60 a_xn60 wp_60_4 wn_60_4 mop4 mon4 vdd vbsyn gsyn
X_61_4 a_xp61 a_xn61 wp_61_4 wn_61_4 mop4 mon4 vdd vbsyn gsyn
X_62_4 a_xp62 a_xn62 wp_62_4 wn_62_4 mop4 mon4 vdd vbsyn gsyn
X_63_4 a_xp63 a_xn63 wp_63_4 wn_63_4 mop4 mon4 vdd vbsyn gsyn
.options gmin=1e-10
.end
