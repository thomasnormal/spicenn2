* Analog delta-rule learner: generated by competition/make_baseline.py
* Weight = capacitor voltage; update current depends on error and input.
* Based on the DIRECT path of experiments/gen_mc.py.
Ma0 n_neg0 n_neg0 0 0 nch W=20u L=1u
Mb0 out0 n_neg0 0 0 nch W=20u L=1u
Mc0 n_pos0 n_pos0 0 0 nch W=20u L=1u
Md0 n_mirror0 n_pos0 0 0 nch W=20u L=1u
Me0 n_mirror0 n_mirror0 vdd vdd pch W=60u L=1u
Mf0 out0 n_mirror0 vdd vdd pch W=60u L=1u
Mep0 n_error0 n_mirror0 vdd vdd pch W=60u L=1u
Men0 n_error0 n_neg0 0 0 nch W=20u L=1u
Moff0 n_error0 voffset vdd vdd pch W=10u L=1u
Mtarget0 n_error0 target0 0 0 nch W=10u L=1u
Rscore0 out0 vref 7k
Rerror0 n_error0 verror 7k
* Synapse class=0, input=in0; n_w0_0 stores the learned weight.
Cw0_0 n_w0_0 0 1.67e-06
Mreset0_0 vweight reset n_w0_0 0 syn W=1000u L=1u
Mpos0_0 in0 n_w0_0 n_pos0 0 syn W=10u L=1u
Mneg0_0 in0 vweight n_neg0 0 syn W=10u L=1u
Menable0_0 n_gate0_0 learn 0 0 nch W=1000u L=1u
Mtail0_0 n_tail0_0 in0 n_gate0_0 0 nch W=20u L=1u
Mu1_0_0 n_up0_0 verror n_tail0_0 0 nch W=20u L=1u
Mu2_0_0 n_w0_0 n_error0 n_tail0_0 0 nch W=20u L=1u
Mu3_0_0 n_up0_0 n_up0_0 vdd vdd pch W=60u L=1u
Mu4_0_0 n_w0_0 n_up0_0 vdd vdd pch W=60u L=1u
* Synapse class=0, input=in1; n_w0_1 stores the learned weight.
Cw0_1 n_w0_1 0 1.67e-06
Mreset0_1 vweight reset n_w0_1 0 syn W=1000u L=1u
Mpos0_1 in1 n_w0_1 n_pos0 0 syn W=10u L=1u
Mneg0_1 in1 vweight n_neg0 0 syn W=10u L=1u
Menable0_1 n_gate0_1 learn 0 0 nch W=1000u L=1u
Mtail0_1 n_tail0_1 in1 n_gate0_1 0 nch W=20u L=1u
Mu1_0_1 n_up0_1 verror n_tail0_1 0 nch W=20u L=1u
Mu2_0_1 n_w0_1 n_error0 n_tail0_1 0 nch W=20u L=1u
Mu3_0_1 n_up0_1 n_up0_1 vdd vdd pch W=60u L=1u
Mu4_0_1 n_w0_1 n_up0_1 vdd vdd pch W=60u L=1u
* Synapse class=0, input=in2; n_w0_2 stores the learned weight.
Cw0_2 n_w0_2 0 1.67e-06
Mreset0_2 vweight reset n_w0_2 0 syn W=1000u L=1u
Mpos0_2 in2 n_w0_2 n_pos0 0 syn W=10u L=1u
Mneg0_2 in2 vweight n_neg0 0 syn W=10u L=1u
Menable0_2 n_gate0_2 learn 0 0 nch W=1000u L=1u
Mtail0_2 n_tail0_2 in2 n_gate0_2 0 nch W=20u L=1u
Mu1_0_2 n_up0_2 verror n_tail0_2 0 nch W=20u L=1u
Mu2_0_2 n_w0_2 n_error0 n_tail0_2 0 nch W=20u L=1u
Mu3_0_2 n_up0_2 n_up0_2 vdd vdd pch W=60u L=1u
Mu4_0_2 n_w0_2 n_up0_2 vdd vdd pch W=60u L=1u
* Synapse class=0, input=in3; n_w0_3 stores the learned weight.
Cw0_3 n_w0_3 0 1.67e-06
Mreset0_3 vweight reset n_w0_3 0 syn W=1000u L=1u
Mpos0_3 in3 n_w0_3 n_pos0 0 syn W=10u L=1u
Mneg0_3 in3 vweight n_neg0 0 syn W=10u L=1u
Menable0_3 n_gate0_3 learn 0 0 nch W=1000u L=1u
Mtail0_3 n_tail0_3 in3 n_gate0_3 0 nch W=20u L=1u
Mu1_0_3 n_up0_3 verror n_tail0_3 0 nch W=20u L=1u
Mu2_0_3 n_w0_3 n_error0 n_tail0_3 0 nch W=20u L=1u
Mu3_0_3 n_up0_3 n_up0_3 vdd vdd pch W=60u L=1u
Mu4_0_3 n_w0_3 n_up0_3 vdd vdd pch W=60u L=1u
* Synapse class=0, input=in4; n_w0_4 stores the learned weight.
Cw0_4 n_w0_4 0 1.67e-06
Mreset0_4 vweight reset n_w0_4 0 syn W=1000u L=1u
Mpos0_4 in4 n_w0_4 n_pos0 0 syn W=10u L=1u
Mneg0_4 in4 vweight n_neg0 0 syn W=10u L=1u
Menable0_4 n_gate0_4 learn 0 0 nch W=1000u L=1u
Mtail0_4 n_tail0_4 in4 n_gate0_4 0 nch W=20u L=1u
Mu1_0_4 n_up0_4 verror n_tail0_4 0 nch W=20u L=1u
Mu2_0_4 n_w0_4 n_error0 n_tail0_4 0 nch W=20u L=1u
Mu3_0_4 n_up0_4 n_up0_4 vdd vdd pch W=60u L=1u
Mu4_0_4 n_w0_4 n_up0_4 vdd vdd pch W=60u L=1u
* Synapse class=0, input=in5; n_w0_5 stores the learned weight.
Cw0_5 n_w0_5 0 1.67e-06
Mreset0_5 vweight reset n_w0_5 0 syn W=1000u L=1u
Mpos0_5 in5 n_w0_5 n_pos0 0 syn W=10u L=1u
Mneg0_5 in5 vweight n_neg0 0 syn W=10u L=1u
Menable0_5 n_gate0_5 learn 0 0 nch W=1000u L=1u
Mtail0_5 n_tail0_5 in5 n_gate0_5 0 nch W=20u L=1u
Mu1_0_5 n_up0_5 verror n_tail0_5 0 nch W=20u L=1u
Mu2_0_5 n_w0_5 n_error0 n_tail0_5 0 nch W=20u L=1u
Mu3_0_5 n_up0_5 n_up0_5 vdd vdd pch W=60u L=1u
Mu4_0_5 n_w0_5 n_up0_5 vdd vdd pch W=60u L=1u
* Synapse class=0, input=in6; n_w0_6 stores the learned weight.
Cw0_6 n_w0_6 0 1.67e-06
Mreset0_6 vweight reset n_w0_6 0 syn W=1000u L=1u
Mpos0_6 in6 n_w0_6 n_pos0 0 syn W=10u L=1u
Mneg0_6 in6 vweight n_neg0 0 syn W=10u L=1u
Menable0_6 n_gate0_6 learn 0 0 nch W=1000u L=1u
Mtail0_6 n_tail0_6 in6 n_gate0_6 0 nch W=20u L=1u
Mu1_0_6 n_up0_6 verror n_tail0_6 0 nch W=20u L=1u
Mu2_0_6 n_w0_6 n_error0 n_tail0_6 0 nch W=20u L=1u
Mu3_0_6 n_up0_6 n_up0_6 vdd vdd pch W=60u L=1u
Mu4_0_6 n_w0_6 n_up0_6 vdd vdd pch W=60u L=1u
* Synapse class=0, input=in7; n_w0_7 stores the learned weight.
Cw0_7 n_w0_7 0 1.67e-06
Mreset0_7 vweight reset n_w0_7 0 syn W=1000u L=1u
Mpos0_7 in7 n_w0_7 n_pos0 0 syn W=10u L=1u
Mneg0_7 in7 vweight n_neg0 0 syn W=10u L=1u
Menable0_7 n_gate0_7 learn 0 0 nch W=1000u L=1u
Mtail0_7 n_tail0_7 in7 n_gate0_7 0 nch W=20u L=1u
Mu1_0_7 n_up0_7 verror n_tail0_7 0 nch W=20u L=1u
Mu2_0_7 n_w0_7 n_error0 n_tail0_7 0 nch W=20u L=1u
Mu3_0_7 n_up0_7 n_up0_7 vdd vdd pch W=60u L=1u
Mu4_0_7 n_w0_7 n_up0_7 vdd vdd pch W=60u L=1u
* Synapse class=0, input=in8; n_w0_8 stores the learned weight.
Cw0_8 n_w0_8 0 1.67e-06
Mreset0_8 vweight reset n_w0_8 0 syn W=1000u L=1u
Mpos0_8 in8 n_w0_8 n_pos0 0 syn W=10u L=1u
Mneg0_8 in8 vweight n_neg0 0 syn W=10u L=1u
Menable0_8 n_gate0_8 learn 0 0 nch W=1000u L=1u
Mtail0_8 n_tail0_8 in8 n_gate0_8 0 nch W=20u L=1u
Mu1_0_8 n_up0_8 verror n_tail0_8 0 nch W=20u L=1u
Mu2_0_8 n_w0_8 n_error0 n_tail0_8 0 nch W=20u L=1u
Mu3_0_8 n_up0_8 n_up0_8 vdd vdd pch W=60u L=1u
Mu4_0_8 n_w0_8 n_up0_8 vdd vdd pch W=60u L=1u
* Synapse class=0, input=in9; n_w0_9 stores the learned weight.
Cw0_9 n_w0_9 0 1.67e-06
Mreset0_9 vweight reset n_w0_9 0 syn W=1000u L=1u
Mpos0_9 in9 n_w0_9 n_pos0 0 syn W=10u L=1u
Mneg0_9 in9 vweight n_neg0 0 syn W=10u L=1u
Menable0_9 n_gate0_9 learn 0 0 nch W=1000u L=1u
Mtail0_9 n_tail0_9 in9 n_gate0_9 0 nch W=20u L=1u
Mu1_0_9 n_up0_9 verror n_tail0_9 0 nch W=20u L=1u
Mu2_0_9 n_w0_9 n_error0 n_tail0_9 0 nch W=20u L=1u
Mu3_0_9 n_up0_9 n_up0_9 vdd vdd pch W=60u L=1u
Mu4_0_9 n_w0_9 n_up0_9 vdd vdd pch W=60u L=1u
* Synapse class=0, input=in10; n_w0_10 stores the learned weight.
Cw0_10 n_w0_10 0 1.67e-06
Mreset0_10 vweight reset n_w0_10 0 syn W=1000u L=1u
Mpos0_10 in10 n_w0_10 n_pos0 0 syn W=10u L=1u
Mneg0_10 in10 vweight n_neg0 0 syn W=10u L=1u
Menable0_10 n_gate0_10 learn 0 0 nch W=1000u L=1u
Mtail0_10 n_tail0_10 in10 n_gate0_10 0 nch W=20u L=1u
Mu1_0_10 n_up0_10 verror n_tail0_10 0 nch W=20u L=1u
Mu2_0_10 n_w0_10 n_error0 n_tail0_10 0 nch W=20u L=1u
Mu3_0_10 n_up0_10 n_up0_10 vdd vdd pch W=60u L=1u
Mu4_0_10 n_w0_10 n_up0_10 vdd vdd pch W=60u L=1u
* Synapse class=0, input=in11; n_w0_11 stores the learned weight.
Cw0_11 n_w0_11 0 1.67e-06
Mreset0_11 vweight reset n_w0_11 0 syn W=1000u L=1u
Mpos0_11 in11 n_w0_11 n_pos0 0 syn W=10u L=1u
Mneg0_11 in11 vweight n_neg0 0 syn W=10u L=1u
Menable0_11 n_gate0_11 learn 0 0 nch W=1000u L=1u
Mtail0_11 n_tail0_11 in11 n_gate0_11 0 nch W=20u L=1u
Mu1_0_11 n_up0_11 verror n_tail0_11 0 nch W=20u L=1u
Mu2_0_11 n_w0_11 n_error0 n_tail0_11 0 nch W=20u L=1u
Mu3_0_11 n_up0_11 n_up0_11 vdd vdd pch W=60u L=1u
Mu4_0_11 n_w0_11 n_up0_11 vdd vdd pch W=60u L=1u
* Synapse class=0, input=in12; n_w0_12 stores the learned weight.
Cw0_12 n_w0_12 0 1.67e-06
Mreset0_12 vweight reset n_w0_12 0 syn W=1000u L=1u
Mpos0_12 in12 n_w0_12 n_pos0 0 syn W=10u L=1u
Mneg0_12 in12 vweight n_neg0 0 syn W=10u L=1u
Menable0_12 n_gate0_12 learn 0 0 nch W=1000u L=1u
Mtail0_12 n_tail0_12 in12 n_gate0_12 0 nch W=20u L=1u
Mu1_0_12 n_up0_12 verror n_tail0_12 0 nch W=20u L=1u
Mu2_0_12 n_w0_12 n_error0 n_tail0_12 0 nch W=20u L=1u
Mu3_0_12 n_up0_12 n_up0_12 vdd vdd pch W=60u L=1u
Mu4_0_12 n_w0_12 n_up0_12 vdd vdd pch W=60u L=1u
* Synapse class=0, input=in13; n_w0_13 stores the learned weight.
Cw0_13 n_w0_13 0 1.67e-06
Mreset0_13 vweight reset n_w0_13 0 syn W=1000u L=1u
Mpos0_13 in13 n_w0_13 n_pos0 0 syn W=10u L=1u
Mneg0_13 in13 vweight n_neg0 0 syn W=10u L=1u
Menable0_13 n_gate0_13 learn 0 0 nch W=1000u L=1u
Mtail0_13 n_tail0_13 in13 n_gate0_13 0 nch W=20u L=1u
Mu1_0_13 n_up0_13 verror n_tail0_13 0 nch W=20u L=1u
Mu2_0_13 n_w0_13 n_error0 n_tail0_13 0 nch W=20u L=1u
Mu3_0_13 n_up0_13 n_up0_13 vdd vdd pch W=60u L=1u
Mu4_0_13 n_w0_13 n_up0_13 vdd vdd pch W=60u L=1u
* Synapse class=0, input=in14; n_w0_14 stores the learned weight.
Cw0_14 n_w0_14 0 1.67e-06
Mreset0_14 vweight reset n_w0_14 0 syn W=1000u L=1u
Mpos0_14 in14 n_w0_14 n_pos0 0 syn W=10u L=1u
Mneg0_14 in14 vweight n_neg0 0 syn W=10u L=1u
Menable0_14 n_gate0_14 learn 0 0 nch W=1000u L=1u
Mtail0_14 n_tail0_14 in14 n_gate0_14 0 nch W=20u L=1u
Mu1_0_14 n_up0_14 verror n_tail0_14 0 nch W=20u L=1u
Mu2_0_14 n_w0_14 n_error0 n_tail0_14 0 nch W=20u L=1u
Mu3_0_14 n_up0_14 n_up0_14 vdd vdd pch W=60u L=1u
Mu4_0_14 n_w0_14 n_up0_14 vdd vdd pch W=60u L=1u
* Synapse class=0, input=in15; n_w0_15 stores the learned weight.
Cw0_15 n_w0_15 0 1.67e-06
Mreset0_15 vweight reset n_w0_15 0 syn W=1000u L=1u
Mpos0_15 in15 n_w0_15 n_pos0 0 syn W=10u L=1u
Mneg0_15 in15 vweight n_neg0 0 syn W=10u L=1u
Menable0_15 n_gate0_15 learn 0 0 nch W=1000u L=1u
Mtail0_15 n_tail0_15 in15 n_gate0_15 0 nch W=20u L=1u
Mu1_0_15 n_up0_15 verror n_tail0_15 0 nch W=20u L=1u
Mu2_0_15 n_w0_15 n_error0 n_tail0_15 0 nch W=20u L=1u
Mu3_0_15 n_up0_15 n_up0_15 vdd vdd pch W=60u L=1u
Mu4_0_15 n_w0_15 n_up0_15 vdd vdd pch W=60u L=1u
* Synapse class=0, input=vbias; n_w0_16 stores the learned weight.
Cw0_16 n_w0_16 0 1.67e-06
Mreset0_16 vweight reset n_w0_16 0 syn W=1000u L=1u
Mpos0_16 vbias n_w0_16 n_pos0 0 syn W=10u L=1u
Mneg0_16 vbias vweight n_neg0 0 syn W=10u L=1u
Menable0_16 n_gate0_16 learn 0 0 nch W=1000u L=1u
Mtail0_16 n_tail0_16 vbias n_gate0_16 0 nch W=20u L=1u
Mu1_0_16 n_up0_16 verror n_tail0_16 0 nch W=20u L=1u
Mu2_0_16 n_w0_16 n_error0 n_tail0_16 0 nch W=20u L=1u
Mu3_0_16 n_up0_16 n_up0_16 vdd vdd pch W=60u L=1u
Mu4_0_16 n_w0_16 n_up0_16 vdd vdd pch W=60u L=1u
Ma1 n_neg1 n_neg1 0 0 nch W=20u L=1u
Mb1 out1 n_neg1 0 0 nch W=20u L=1u
Mc1 n_pos1 n_pos1 0 0 nch W=20u L=1u
Md1 n_mirror1 n_pos1 0 0 nch W=20u L=1u
Me1 n_mirror1 n_mirror1 vdd vdd pch W=60u L=1u
Mf1 out1 n_mirror1 vdd vdd pch W=60u L=1u
Mep1 n_error1 n_mirror1 vdd vdd pch W=60u L=1u
Men1 n_error1 n_neg1 0 0 nch W=20u L=1u
Moff1 n_error1 voffset vdd vdd pch W=10u L=1u
Mtarget1 n_error1 target1 0 0 nch W=10u L=1u
Rscore1 out1 vref 7k
Rerror1 n_error1 verror 7k
* Synapse class=1, input=in0; n_w1_0 stores the learned weight.
Cw1_0 n_w1_0 0 1.67e-06
Mreset1_0 vweight reset n_w1_0 0 syn W=1000u L=1u
Mpos1_0 in0 n_w1_0 n_pos1 0 syn W=10u L=1u
Mneg1_0 in0 vweight n_neg1 0 syn W=10u L=1u
Menable1_0 n_gate1_0 learn 0 0 nch W=1000u L=1u
Mtail1_0 n_tail1_0 in0 n_gate1_0 0 nch W=20u L=1u
Mu1_1_0 n_up1_0 verror n_tail1_0 0 nch W=20u L=1u
Mu2_1_0 n_w1_0 n_error1 n_tail1_0 0 nch W=20u L=1u
Mu3_1_0 n_up1_0 n_up1_0 vdd vdd pch W=60u L=1u
Mu4_1_0 n_w1_0 n_up1_0 vdd vdd pch W=60u L=1u
* Synapse class=1, input=in1; n_w1_1 stores the learned weight.
Cw1_1 n_w1_1 0 1.67e-06
Mreset1_1 vweight reset n_w1_1 0 syn W=1000u L=1u
Mpos1_1 in1 n_w1_1 n_pos1 0 syn W=10u L=1u
Mneg1_1 in1 vweight n_neg1 0 syn W=10u L=1u
Menable1_1 n_gate1_1 learn 0 0 nch W=1000u L=1u
Mtail1_1 n_tail1_1 in1 n_gate1_1 0 nch W=20u L=1u
Mu1_1_1 n_up1_1 verror n_tail1_1 0 nch W=20u L=1u
Mu2_1_1 n_w1_1 n_error1 n_tail1_1 0 nch W=20u L=1u
Mu3_1_1 n_up1_1 n_up1_1 vdd vdd pch W=60u L=1u
Mu4_1_1 n_w1_1 n_up1_1 vdd vdd pch W=60u L=1u
* Synapse class=1, input=in2; n_w1_2 stores the learned weight.
Cw1_2 n_w1_2 0 1.67e-06
Mreset1_2 vweight reset n_w1_2 0 syn W=1000u L=1u
Mpos1_2 in2 n_w1_2 n_pos1 0 syn W=10u L=1u
Mneg1_2 in2 vweight n_neg1 0 syn W=10u L=1u
Menable1_2 n_gate1_2 learn 0 0 nch W=1000u L=1u
Mtail1_2 n_tail1_2 in2 n_gate1_2 0 nch W=20u L=1u
Mu1_1_2 n_up1_2 verror n_tail1_2 0 nch W=20u L=1u
Mu2_1_2 n_w1_2 n_error1 n_tail1_2 0 nch W=20u L=1u
Mu3_1_2 n_up1_2 n_up1_2 vdd vdd pch W=60u L=1u
Mu4_1_2 n_w1_2 n_up1_2 vdd vdd pch W=60u L=1u
* Synapse class=1, input=in3; n_w1_3 stores the learned weight.
Cw1_3 n_w1_3 0 1.67e-06
Mreset1_3 vweight reset n_w1_3 0 syn W=1000u L=1u
Mpos1_3 in3 n_w1_3 n_pos1 0 syn W=10u L=1u
Mneg1_3 in3 vweight n_neg1 0 syn W=10u L=1u
Menable1_3 n_gate1_3 learn 0 0 nch W=1000u L=1u
Mtail1_3 n_tail1_3 in3 n_gate1_3 0 nch W=20u L=1u
Mu1_1_3 n_up1_3 verror n_tail1_3 0 nch W=20u L=1u
Mu2_1_3 n_w1_3 n_error1 n_tail1_3 0 nch W=20u L=1u
Mu3_1_3 n_up1_3 n_up1_3 vdd vdd pch W=60u L=1u
Mu4_1_3 n_w1_3 n_up1_3 vdd vdd pch W=60u L=1u
* Synapse class=1, input=in4; n_w1_4 stores the learned weight.
Cw1_4 n_w1_4 0 1.67e-06
Mreset1_4 vweight reset n_w1_4 0 syn W=1000u L=1u
Mpos1_4 in4 n_w1_4 n_pos1 0 syn W=10u L=1u
Mneg1_4 in4 vweight n_neg1 0 syn W=10u L=1u
Menable1_4 n_gate1_4 learn 0 0 nch W=1000u L=1u
Mtail1_4 n_tail1_4 in4 n_gate1_4 0 nch W=20u L=1u
Mu1_1_4 n_up1_4 verror n_tail1_4 0 nch W=20u L=1u
Mu2_1_4 n_w1_4 n_error1 n_tail1_4 0 nch W=20u L=1u
Mu3_1_4 n_up1_4 n_up1_4 vdd vdd pch W=60u L=1u
Mu4_1_4 n_w1_4 n_up1_4 vdd vdd pch W=60u L=1u
* Synapse class=1, input=in5; n_w1_5 stores the learned weight.
Cw1_5 n_w1_5 0 1.67e-06
Mreset1_5 vweight reset n_w1_5 0 syn W=1000u L=1u
Mpos1_5 in5 n_w1_5 n_pos1 0 syn W=10u L=1u
Mneg1_5 in5 vweight n_neg1 0 syn W=10u L=1u
Menable1_5 n_gate1_5 learn 0 0 nch W=1000u L=1u
Mtail1_5 n_tail1_5 in5 n_gate1_5 0 nch W=20u L=1u
Mu1_1_5 n_up1_5 verror n_tail1_5 0 nch W=20u L=1u
Mu2_1_5 n_w1_5 n_error1 n_tail1_5 0 nch W=20u L=1u
Mu3_1_5 n_up1_5 n_up1_5 vdd vdd pch W=60u L=1u
Mu4_1_5 n_w1_5 n_up1_5 vdd vdd pch W=60u L=1u
* Synapse class=1, input=in6; n_w1_6 stores the learned weight.
Cw1_6 n_w1_6 0 1.67e-06
Mreset1_6 vweight reset n_w1_6 0 syn W=1000u L=1u
Mpos1_6 in6 n_w1_6 n_pos1 0 syn W=10u L=1u
Mneg1_6 in6 vweight n_neg1 0 syn W=10u L=1u
Menable1_6 n_gate1_6 learn 0 0 nch W=1000u L=1u
Mtail1_6 n_tail1_6 in6 n_gate1_6 0 nch W=20u L=1u
Mu1_1_6 n_up1_6 verror n_tail1_6 0 nch W=20u L=1u
Mu2_1_6 n_w1_6 n_error1 n_tail1_6 0 nch W=20u L=1u
Mu3_1_6 n_up1_6 n_up1_6 vdd vdd pch W=60u L=1u
Mu4_1_6 n_w1_6 n_up1_6 vdd vdd pch W=60u L=1u
* Synapse class=1, input=in7; n_w1_7 stores the learned weight.
Cw1_7 n_w1_7 0 1.67e-06
Mreset1_7 vweight reset n_w1_7 0 syn W=1000u L=1u
Mpos1_7 in7 n_w1_7 n_pos1 0 syn W=10u L=1u
Mneg1_7 in7 vweight n_neg1 0 syn W=10u L=1u
Menable1_7 n_gate1_7 learn 0 0 nch W=1000u L=1u
Mtail1_7 n_tail1_7 in7 n_gate1_7 0 nch W=20u L=1u
Mu1_1_7 n_up1_7 verror n_tail1_7 0 nch W=20u L=1u
Mu2_1_7 n_w1_7 n_error1 n_tail1_7 0 nch W=20u L=1u
Mu3_1_7 n_up1_7 n_up1_7 vdd vdd pch W=60u L=1u
Mu4_1_7 n_w1_7 n_up1_7 vdd vdd pch W=60u L=1u
* Synapse class=1, input=in8; n_w1_8 stores the learned weight.
Cw1_8 n_w1_8 0 1.67e-06
Mreset1_8 vweight reset n_w1_8 0 syn W=1000u L=1u
Mpos1_8 in8 n_w1_8 n_pos1 0 syn W=10u L=1u
Mneg1_8 in8 vweight n_neg1 0 syn W=10u L=1u
Menable1_8 n_gate1_8 learn 0 0 nch W=1000u L=1u
Mtail1_8 n_tail1_8 in8 n_gate1_8 0 nch W=20u L=1u
Mu1_1_8 n_up1_8 verror n_tail1_8 0 nch W=20u L=1u
Mu2_1_8 n_w1_8 n_error1 n_tail1_8 0 nch W=20u L=1u
Mu3_1_8 n_up1_8 n_up1_8 vdd vdd pch W=60u L=1u
Mu4_1_8 n_w1_8 n_up1_8 vdd vdd pch W=60u L=1u
* Synapse class=1, input=in9; n_w1_9 stores the learned weight.
Cw1_9 n_w1_9 0 1.67e-06
Mreset1_9 vweight reset n_w1_9 0 syn W=1000u L=1u
Mpos1_9 in9 n_w1_9 n_pos1 0 syn W=10u L=1u
Mneg1_9 in9 vweight n_neg1 0 syn W=10u L=1u
Menable1_9 n_gate1_9 learn 0 0 nch W=1000u L=1u
Mtail1_9 n_tail1_9 in9 n_gate1_9 0 nch W=20u L=1u
Mu1_1_9 n_up1_9 verror n_tail1_9 0 nch W=20u L=1u
Mu2_1_9 n_w1_9 n_error1 n_tail1_9 0 nch W=20u L=1u
Mu3_1_9 n_up1_9 n_up1_9 vdd vdd pch W=60u L=1u
Mu4_1_9 n_w1_9 n_up1_9 vdd vdd pch W=60u L=1u
* Synapse class=1, input=in10; n_w1_10 stores the learned weight.
Cw1_10 n_w1_10 0 1.67e-06
Mreset1_10 vweight reset n_w1_10 0 syn W=1000u L=1u
Mpos1_10 in10 n_w1_10 n_pos1 0 syn W=10u L=1u
Mneg1_10 in10 vweight n_neg1 0 syn W=10u L=1u
Menable1_10 n_gate1_10 learn 0 0 nch W=1000u L=1u
Mtail1_10 n_tail1_10 in10 n_gate1_10 0 nch W=20u L=1u
Mu1_1_10 n_up1_10 verror n_tail1_10 0 nch W=20u L=1u
Mu2_1_10 n_w1_10 n_error1 n_tail1_10 0 nch W=20u L=1u
Mu3_1_10 n_up1_10 n_up1_10 vdd vdd pch W=60u L=1u
Mu4_1_10 n_w1_10 n_up1_10 vdd vdd pch W=60u L=1u
* Synapse class=1, input=in11; n_w1_11 stores the learned weight.
Cw1_11 n_w1_11 0 1.67e-06
Mreset1_11 vweight reset n_w1_11 0 syn W=1000u L=1u
Mpos1_11 in11 n_w1_11 n_pos1 0 syn W=10u L=1u
Mneg1_11 in11 vweight n_neg1 0 syn W=10u L=1u
Menable1_11 n_gate1_11 learn 0 0 nch W=1000u L=1u
Mtail1_11 n_tail1_11 in11 n_gate1_11 0 nch W=20u L=1u
Mu1_1_11 n_up1_11 verror n_tail1_11 0 nch W=20u L=1u
Mu2_1_11 n_w1_11 n_error1 n_tail1_11 0 nch W=20u L=1u
Mu3_1_11 n_up1_11 n_up1_11 vdd vdd pch W=60u L=1u
Mu4_1_11 n_w1_11 n_up1_11 vdd vdd pch W=60u L=1u
* Synapse class=1, input=in12; n_w1_12 stores the learned weight.
Cw1_12 n_w1_12 0 1.67e-06
Mreset1_12 vweight reset n_w1_12 0 syn W=1000u L=1u
Mpos1_12 in12 n_w1_12 n_pos1 0 syn W=10u L=1u
Mneg1_12 in12 vweight n_neg1 0 syn W=10u L=1u
Menable1_12 n_gate1_12 learn 0 0 nch W=1000u L=1u
Mtail1_12 n_tail1_12 in12 n_gate1_12 0 nch W=20u L=1u
Mu1_1_12 n_up1_12 verror n_tail1_12 0 nch W=20u L=1u
Mu2_1_12 n_w1_12 n_error1 n_tail1_12 0 nch W=20u L=1u
Mu3_1_12 n_up1_12 n_up1_12 vdd vdd pch W=60u L=1u
Mu4_1_12 n_w1_12 n_up1_12 vdd vdd pch W=60u L=1u
* Synapse class=1, input=in13; n_w1_13 stores the learned weight.
Cw1_13 n_w1_13 0 1.67e-06
Mreset1_13 vweight reset n_w1_13 0 syn W=1000u L=1u
Mpos1_13 in13 n_w1_13 n_pos1 0 syn W=10u L=1u
Mneg1_13 in13 vweight n_neg1 0 syn W=10u L=1u
Menable1_13 n_gate1_13 learn 0 0 nch W=1000u L=1u
Mtail1_13 n_tail1_13 in13 n_gate1_13 0 nch W=20u L=1u
Mu1_1_13 n_up1_13 verror n_tail1_13 0 nch W=20u L=1u
Mu2_1_13 n_w1_13 n_error1 n_tail1_13 0 nch W=20u L=1u
Mu3_1_13 n_up1_13 n_up1_13 vdd vdd pch W=60u L=1u
Mu4_1_13 n_w1_13 n_up1_13 vdd vdd pch W=60u L=1u
* Synapse class=1, input=in14; n_w1_14 stores the learned weight.
Cw1_14 n_w1_14 0 1.67e-06
Mreset1_14 vweight reset n_w1_14 0 syn W=1000u L=1u
Mpos1_14 in14 n_w1_14 n_pos1 0 syn W=10u L=1u
Mneg1_14 in14 vweight n_neg1 0 syn W=10u L=1u
Menable1_14 n_gate1_14 learn 0 0 nch W=1000u L=1u
Mtail1_14 n_tail1_14 in14 n_gate1_14 0 nch W=20u L=1u
Mu1_1_14 n_up1_14 verror n_tail1_14 0 nch W=20u L=1u
Mu2_1_14 n_w1_14 n_error1 n_tail1_14 0 nch W=20u L=1u
Mu3_1_14 n_up1_14 n_up1_14 vdd vdd pch W=60u L=1u
Mu4_1_14 n_w1_14 n_up1_14 vdd vdd pch W=60u L=1u
* Synapse class=1, input=in15; n_w1_15 stores the learned weight.
Cw1_15 n_w1_15 0 1.67e-06
Mreset1_15 vweight reset n_w1_15 0 syn W=1000u L=1u
Mpos1_15 in15 n_w1_15 n_pos1 0 syn W=10u L=1u
Mneg1_15 in15 vweight n_neg1 0 syn W=10u L=1u
Menable1_15 n_gate1_15 learn 0 0 nch W=1000u L=1u
Mtail1_15 n_tail1_15 in15 n_gate1_15 0 nch W=20u L=1u
Mu1_1_15 n_up1_15 verror n_tail1_15 0 nch W=20u L=1u
Mu2_1_15 n_w1_15 n_error1 n_tail1_15 0 nch W=20u L=1u
Mu3_1_15 n_up1_15 n_up1_15 vdd vdd pch W=60u L=1u
Mu4_1_15 n_w1_15 n_up1_15 vdd vdd pch W=60u L=1u
* Synapse class=1, input=vbias; n_w1_16 stores the learned weight.
Cw1_16 n_w1_16 0 1.67e-06
Mreset1_16 vweight reset n_w1_16 0 syn W=1000u L=1u
Mpos1_16 vbias n_w1_16 n_pos1 0 syn W=10u L=1u
Mneg1_16 vbias vweight n_neg1 0 syn W=10u L=1u
Menable1_16 n_gate1_16 learn 0 0 nch W=1000u L=1u
Mtail1_16 n_tail1_16 vbias n_gate1_16 0 nch W=20u L=1u
Mu1_1_16 n_up1_16 verror n_tail1_16 0 nch W=20u L=1u
Mu2_1_16 n_w1_16 n_error1 n_tail1_16 0 nch W=20u L=1u
Mu3_1_16 n_up1_16 n_up1_16 vdd vdd pch W=60u L=1u
Mu4_1_16 n_w1_16 n_up1_16 vdd vdd pch W=60u L=1u
Ma7 n_neg7 n_neg7 0 0 nch W=20u L=1u
Mb7 out7 n_neg7 0 0 nch W=20u L=1u
Mc7 n_pos7 n_pos7 0 0 nch W=20u L=1u
Md7 n_mirror7 n_pos7 0 0 nch W=20u L=1u
Me7 n_mirror7 n_mirror7 vdd vdd pch W=60u L=1u
Mf7 out7 n_mirror7 vdd vdd pch W=60u L=1u
Mep7 n_error7 n_mirror7 vdd vdd pch W=60u L=1u
Men7 n_error7 n_neg7 0 0 nch W=20u L=1u
Moff7 n_error7 voffset vdd vdd pch W=10u L=1u
Mtarget7 n_error7 target7 0 0 nch W=10u L=1u
Rscore7 out7 vref 7k
Rerror7 n_error7 verror 7k
* Synapse class=7, input=in0; n_w7_0 stores the learned weight.
Cw7_0 n_w7_0 0 1.67e-06
Mreset7_0 vweight reset n_w7_0 0 syn W=1000u L=1u
Mpos7_0 in0 n_w7_0 n_pos7 0 syn W=10u L=1u
Mneg7_0 in0 vweight n_neg7 0 syn W=10u L=1u
Menable7_0 n_gate7_0 learn 0 0 nch W=1000u L=1u
Mtail7_0 n_tail7_0 in0 n_gate7_0 0 nch W=20u L=1u
Mu1_7_0 n_up7_0 verror n_tail7_0 0 nch W=20u L=1u
Mu2_7_0 n_w7_0 n_error7 n_tail7_0 0 nch W=20u L=1u
Mu3_7_0 n_up7_0 n_up7_0 vdd vdd pch W=60u L=1u
Mu4_7_0 n_w7_0 n_up7_0 vdd vdd pch W=60u L=1u
* Synapse class=7, input=in1; n_w7_1 stores the learned weight.
Cw7_1 n_w7_1 0 1.67e-06
Mreset7_1 vweight reset n_w7_1 0 syn W=1000u L=1u
Mpos7_1 in1 n_w7_1 n_pos7 0 syn W=10u L=1u
Mneg7_1 in1 vweight n_neg7 0 syn W=10u L=1u
Menable7_1 n_gate7_1 learn 0 0 nch W=1000u L=1u
Mtail7_1 n_tail7_1 in1 n_gate7_1 0 nch W=20u L=1u
Mu1_7_1 n_up7_1 verror n_tail7_1 0 nch W=20u L=1u
Mu2_7_1 n_w7_1 n_error7 n_tail7_1 0 nch W=20u L=1u
Mu3_7_1 n_up7_1 n_up7_1 vdd vdd pch W=60u L=1u
Mu4_7_1 n_w7_1 n_up7_1 vdd vdd pch W=60u L=1u
* Synapse class=7, input=in2; n_w7_2 stores the learned weight.
Cw7_2 n_w7_2 0 1.67e-06
Mreset7_2 vweight reset n_w7_2 0 syn W=1000u L=1u
Mpos7_2 in2 n_w7_2 n_pos7 0 syn W=10u L=1u
Mneg7_2 in2 vweight n_neg7 0 syn W=10u L=1u
Menable7_2 n_gate7_2 learn 0 0 nch W=1000u L=1u
Mtail7_2 n_tail7_2 in2 n_gate7_2 0 nch W=20u L=1u
Mu1_7_2 n_up7_2 verror n_tail7_2 0 nch W=20u L=1u
Mu2_7_2 n_w7_2 n_error7 n_tail7_2 0 nch W=20u L=1u
Mu3_7_2 n_up7_2 n_up7_2 vdd vdd pch W=60u L=1u
Mu4_7_2 n_w7_2 n_up7_2 vdd vdd pch W=60u L=1u
* Synapse class=7, input=in3; n_w7_3 stores the learned weight.
Cw7_3 n_w7_3 0 1.67e-06
Mreset7_3 vweight reset n_w7_3 0 syn W=1000u L=1u
Mpos7_3 in3 n_w7_3 n_pos7 0 syn W=10u L=1u
Mneg7_3 in3 vweight n_neg7 0 syn W=10u L=1u
Menable7_3 n_gate7_3 learn 0 0 nch W=1000u L=1u
Mtail7_3 n_tail7_3 in3 n_gate7_3 0 nch W=20u L=1u
Mu1_7_3 n_up7_3 verror n_tail7_3 0 nch W=20u L=1u
Mu2_7_3 n_w7_3 n_error7 n_tail7_3 0 nch W=20u L=1u
Mu3_7_3 n_up7_3 n_up7_3 vdd vdd pch W=60u L=1u
Mu4_7_3 n_w7_3 n_up7_3 vdd vdd pch W=60u L=1u
* Synapse class=7, input=in4; n_w7_4 stores the learned weight.
Cw7_4 n_w7_4 0 1.67e-06
Mreset7_4 vweight reset n_w7_4 0 syn W=1000u L=1u
Mpos7_4 in4 n_w7_4 n_pos7 0 syn W=10u L=1u
Mneg7_4 in4 vweight n_neg7 0 syn W=10u L=1u
Menable7_4 n_gate7_4 learn 0 0 nch W=1000u L=1u
Mtail7_4 n_tail7_4 in4 n_gate7_4 0 nch W=20u L=1u
Mu1_7_4 n_up7_4 verror n_tail7_4 0 nch W=20u L=1u
Mu2_7_4 n_w7_4 n_error7 n_tail7_4 0 nch W=20u L=1u
Mu3_7_4 n_up7_4 n_up7_4 vdd vdd pch W=60u L=1u
Mu4_7_4 n_w7_4 n_up7_4 vdd vdd pch W=60u L=1u
* Synapse class=7, input=in5; n_w7_5 stores the learned weight.
Cw7_5 n_w7_5 0 1.67e-06
Mreset7_5 vweight reset n_w7_5 0 syn W=1000u L=1u
Mpos7_5 in5 n_w7_5 n_pos7 0 syn W=10u L=1u
Mneg7_5 in5 vweight n_neg7 0 syn W=10u L=1u
Menable7_5 n_gate7_5 learn 0 0 nch W=1000u L=1u
Mtail7_5 n_tail7_5 in5 n_gate7_5 0 nch W=20u L=1u
Mu1_7_5 n_up7_5 verror n_tail7_5 0 nch W=20u L=1u
Mu2_7_5 n_w7_5 n_error7 n_tail7_5 0 nch W=20u L=1u
Mu3_7_5 n_up7_5 n_up7_5 vdd vdd pch W=60u L=1u
Mu4_7_5 n_w7_5 n_up7_5 vdd vdd pch W=60u L=1u
* Synapse class=7, input=in6; n_w7_6 stores the learned weight.
Cw7_6 n_w7_6 0 1.67e-06
Mreset7_6 vweight reset n_w7_6 0 syn W=1000u L=1u
Mpos7_6 in6 n_w7_6 n_pos7 0 syn W=10u L=1u
Mneg7_6 in6 vweight n_neg7 0 syn W=10u L=1u
Menable7_6 n_gate7_6 learn 0 0 nch W=1000u L=1u
Mtail7_6 n_tail7_6 in6 n_gate7_6 0 nch W=20u L=1u
Mu1_7_6 n_up7_6 verror n_tail7_6 0 nch W=20u L=1u
Mu2_7_6 n_w7_6 n_error7 n_tail7_6 0 nch W=20u L=1u
Mu3_7_6 n_up7_6 n_up7_6 vdd vdd pch W=60u L=1u
Mu4_7_6 n_w7_6 n_up7_6 vdd vdd pch W=60u L=1u
* Synapse class=7, input=in7; n_w7_7 stores the learned weight.
Cw7_7 n_w7_7 0 1.67e-06
Mreset7_7 vweight reset n_w7_7 0 syn W=1000u L=1u
Mpos7_7 in7 n_w7_7 n_pos7 0 syn W=10u L=1u
Mneg7_7 in7 vweight n_neg7 0 syn W=10u L=1u
Menable7_7 n_gate7_7 learn 0 0 nch W=1000u L=1u
Mtail7_7 n_tail7_7 in7 n_gate7_7 0 nch W=20u L=1u
Mu1_7_7 n_up7_7 verror n_tail7_7 0 nch W=20u L=1u
Mu2_7_7 n_w7_7 n_error7 n_tail7_7 0 nch W=20u L=1u
Mu3_7_7 n_up7_7 n_up7_7 vdd vdd pch W=60u L=1u
Mu4_7_7 n_w7_7 n_up7_7 vdd vdd pch W=60u L=1u
* Synapse class=7, input=in8; n_w7_8 stores the learned weight.
Cw7_8 n_w7_8 0 1.67e-06
Mreset7_8 vweight reset n_w7_8 0 syn W=1000u L=1u
Mpos7_8 in8 n_w7_8 n_pos7 0 syn W=10u L=1u
Mneg7_8 in8 vweight n_neg7 0 syn W=10u L=1u
Menable7_8 n_gate7_8 learn 0 0 nch W=1000u L=1u
Mtail7_8 n_tail7_8 in8 n_gate7_8 0 nch W=20u L=1u
Mu1_7_8 n_up7_8 verror n_tail7_8 0 nch W=20u L=1u
Mu2_7_8 n_w7_8 n_error7 n_tail7_8 0 nch W=20u L=1u
Mu3_7_8 n_up7_8 n_up7_8 vdd vdd pch W=60u L=1u
Mu4_7_8 n_w7_8 n_up7_8 vdd vdd pch W=60u L=1u
* Synapse class=7, input=in9; n_w7_9 stores the learned weight.
Cw7_9 n_w7_9 0 1.67e-06
Mreset7_9 vweight reset n_w7_9 0 syn W=1000u L=1u
Mpos7_9 in9 n_w7_9 n_pos7 0 syn W=10u L=1u
Mneg7_9 in9 vweight n_neg7 0 syn W=10u L=1u
Menable7_9 n_gate7_9 learn 0 0 nch W=1000u L=1u
Mtail7_9 n_tail7_9 in9 n_gate7_9 0 nch W=20u L=1u
Mu1_7_9 n_up7_9 verror n_tail7_9 0 nch W=20u L=1u
Mu2_7_9 n_w7_9 n_error7 n_tail7_9 0 nch W=20u L=1u
Mu3_7_9 n_up7_9 n_up7_9 vdd vdd pch W=60u L=1u
Mu4_7_9 n_w7_9 n_up7_9 vdd vdd pch W=60u L=1u
* Synapse class=7, input=in10; n_w7_10 stores the learned weight.
Cw7_10 n_w7_10 0 1.67e-06
Mreset7_10 vweight reset n_w7_10 0 syn W=1000u L=1u
Mpos7_10 in10 n_w7_10 n_pos7 0 syn W=10u L=1u
Mneg7_10 in10 vweight n_neg7 0 syn W=10u L=1u
Menable7_10 n_gate7_10 learn 0 0 nch W=1000u L=1u
Mtail7_10 n_tail7_10 in10 n_gate7_10 0 nch W=20u L=1u
Mu1_7_10 n_up7_10 verror n_tail7_10 0 nch W=20u L=1u
Mu2_7_10 n_w7_10 n_error7 n_tail7_10 0 nch W=20u L=1u
Mu3_7_10 n_up7_10 n_up7_10 vdd vdd pch W=60u L=1u
Mu4_7_10 n_w7_10 n_up7_10 vdd vdd pch W=60u L=1u
* Synapse class=7, input=in11; n_w7_11 stores the learned weight.
Cw7_11 n_w7_11 0 1.67e-06
Mreset7_11 vweight reset n_w7_11 0 syn W=1000u L=1u
Mpos7_11 in11 n_w7_11 n_pos7 0 syn W=10u L=1u
Mneg7_11 in11 vweight n_neg7 0 syn W=10u L=1u
Menable7_11 n_gate7_11 learn 0 0 nch W=1000u L=1u
Mtail7_11 n_tail7_11 in11 n_gate7_11 0 nch W=20u L=1u
Mu1_7_11 n_up7_11 verror n_tail7_11 0 nch W=20u L=1u
Mu2_7_11 n_w7_11 n_error7 n_tail7_11 0 nch W=20u L=1u
Mu3_7_11 n_up7_11 n_up7_11 vdd vdd pch W=60u L=1u
Mu4_7_11 n_w7_11 n_up7_11 vdd vdd pch W=60u L=1u
* Synapse class=7, input=in12; n_w7_12 stores the learned weight.
Cw7_12 n_w7_12 0 1.67e-06
Mreset7_12 vweight reset n_w7_12 0 syn W=1000u L=1u
Mpos7_12 in12 n_w7_12 n_pos7 0 syn W=10u L=1u
Mneg7_12 in12 vweight n_neg7 0 syn W=10u L=1u
Menable7_12 n_gate7_12 learn 0 0 nch W=1000u L=1u
Mtail7_12 n_tail7_12 in12 n_gate7_12 0 nch W=20u L=1u
Mu1_7_12 n_up7_12 verror n_tail7_12 0 nch W=20u L=1u
Mu2_7_12 n_w7_12 n_error7 n_tail7_12 0 nch W=20u L=1u
Mu3_7_12 n_up7_12 n_up7_12 vdd vdd pch W=60u L=1u
Mu4_7_12 n_w7_12 n_up7_12 vdd vdd pch W=60u L=1u
* Synapse class=7, input=in13; n_w7_13 stores the learned weight.
Cw7_13 n_w7_13 0 1.67e-06
Mreset7_13 vweight reset n_w7_13 0 syn W=1000u L=1u
Mpos7_13 in13 n_w7_13 n_pos7 0 syn W=10u L=1u
Mneg7_13 in13 vweight n_neg7 0 syn W=10u L=1u
Menable7_13 n_gate7_13 learn 0 0 nch W=1000u L=1u
Mtail7_13 n_tail7_13 in13 n_gate7_13 0 nch W=20u L=1u
Mu1_7_13 n_up7_13 verror n_tail7_13 0 nch W=20u L=1u
Mu2_7_13 n_w7_13 n_error7 n_tail7_13 0 nch W=20u L=1u
Mu3_7_13 n_up7_13 n_up7_13 vdd vdd pch W=60u L=1u
Mu4_7_13 n_w7_13 n_up7_13 vdd vdd pch W=60u L=1u
* Synapse class=7, input=in14; n_w7_14 stores the learned weight.
Cw7_14 n_w7_14 0 1.67e-06
Mreset7_14 vweight reset n_w7_14 0 syn W=1000u L=1u
Mpos7_14 in14 n_w7_14 n_pos7 0 syn W=10u L=1u
Mneg7_14 in14 vweight n_neg7 0 syn W=10u L=1u
Menable7_14 n_gate7_14 learn 0 0 nch W=1000u L=1u
Mtail7_14 n_tail7_14 in14 n_gate7_14 0 nch W=20u L=1u
Mu1_7_14 n_up7_14 verror n_tail7_14 0 nch W=20u L=1u
Mu2_7_14 n_w7_14 n_error7 n_tail7_14 0 nch W=20u L=1u
Mu3_7_14 n_up7_14 n_up7_14 vdd vdd pch W=60u L=1u
Mu4_7_14 n_w7_14 n_up7_14 vdd vdd pch W=60u L=1u
* Synapse class=7, input=in15; n_w7_15 stores the learned weight.
Cw7_15 n_w7_15 0 1.67e-06
Mreset7_15 vweight reset n_w7_15 0 syn W=1000u L=1u
Mpos7_15 in15 n_w7_15 n_pos7 0 syn W=10u L=1u
Mneg7_15 in15 vweight n_neg7 0 syn W=10u L=1u
Menable7_15 n_gate7_15 learn 0 0 nch W=1000u L=1u
Mtail7_15 n_tail7_15 in15 n_gate7_15 0 nch W=20u L=1u
Mu1_7_15 n_up7_15 verror n_tail7_15 0 nch W=20u L=1u
Mu2_7_15 n_w7_15 n_error7 n_tail7_15 0 nch W=20u L=1u
Mu3_7_15 n_up7_15 n_up7_15 vdd vdd pch W=60u L=1u
Mu4_7_15 n_w7_15 n_up7_15 vdd vdd pch W=60u L=1u
* Synapse class=7, input=vbias; n_w7_16 stores the learned weight.
Cw7_16 n_w7_16 0 1.67e-06
Mreset7_16 vweight reset n_w7_16 0 syn W=1000u L=1u
Mpos7_16 vbias n_w7_16 n_pos7 0 syn W=10u L=1u
Mneg7_16 vbias vweight n_neg7 0 syn W=10u L=1u
Menable7_16 n_gate7_16 learn 0 0 nch W=1000u L=1u
Mtail7_16 n_tail7_16 vbias n_gate7_16 0 nch W=20u L=1u
Mu1_7_16 n_up7_16 verror n_tail7_16 0 nch W=20u L=1u
Mu2_7_16 n_w7_16 n_error7 n_tail7_16 0 nch W=20u L=1u
Mu3_7_16 n_up7_16 n_up7_16 vdd vdd pch W=60u L=1u
Mu4_7_16 n_w7_16 n_up7_16 vdd vdd pch W=60u L=1u
