* Analog delta-rule learner: generated by competition/make_baseline.py
* Weight = capacitor voltage; update current depends on error and input.
* Based on the DIRECT path of experiments/gen_mc.py.
Ma0 n_neg0 n_neg0 0 0 nch W=20u L=1u
Mb0 out0 n_neg0 0 0 nch W=20u L=1u
Mc0 n_pos0 n_pos0 0 0 nch W=20u L=1u
Md0 n_mirror0 n_pos0 0 0 nch W=20u L=1u
Me0 n_mirror0 n_mirror0 vdd vdd pch W=60u L=1u
Mf0 out0 n_mirror0 vdd vdd pch W=60u L=1u
Mep0 n_error0 n_mirror0 vdd vdd pch W=60u L=1u
Men0 n_error0 n_neg0 0 0 nch W=20u L=1u
Moff0 n_error0 voffset vdd vdd pch W=10u L=1u
Mtarget0 n_error0 target0 0 0 nch W=10u L=1u
Rscore0 out0 vref 7k
Rerror0 n_error0 verror 7k
* Synapse class=0, input=in0; n_w0_0 stores the learned weight.
Cw0_0 n_w0_0 0 1.67e-06
Mreset0_0 vweight reset n_w0_0 0 syn W=1000u L=1u
Mpos0_0 in0 n_w0_0 n_pos0 0 syn W=10u L=1u
Mneg0_0 in0 vweight n_neg0 0 syn W=10u L=1u
Menable0_0 n_gate0_0 learn 0 0 nch W=1000u L=1u
Mtail0_0 n_tail0_0 in0 n_gate0_0 0 nch W=20u L=1u
Mu1_0_0 n_up0_0 verror n_tail0_0 0 nch W=20u L=1u
Mu2_0_0 n_w0_0 n_error0 n_tail0_0 0 nch W=20u L=1u
Mu3_0_0 n_up0_0 n_up0_0 vdd vdd pch W=60u L=1u
Mu4_0_0 n_w0_0 n_up0_0 vdd vdd pch W=60u L=1u
* Synapse class=0, input=in1; n_w0_1 stores the learned weight.
Cw0_1 n_w0_1 0 1.67e-06
Mreset0_1 vweight reset n_w0_1 0 syn W=1000u L=1u
Mpos0_1 in1 n_w0_1 n_pos0 0 syn W=10u L=1u
Mneg0_1 in1 vweight n_neg0 0 syn W=10u L=1u
Menable0_1 n_gate0_1 learn 0 0 nch W=1000u L=1u
Mtail0_1 n_tail0_1 in1 n_gate0_1 0 nch W=20u L=1u
Mu1_0_1 n_up0_1 verror n_tail0_1 0 nch W=20u L=1u
Mu2_0_1 n_w0_1 n_error0 n_tail0_1 0 nch W=20u L=1u
Mu3_0_1 n_up0_1 n_up0_1 vdd vdd pch W=60u L=1u
Mu4_0_1 n_w0_1 n_up0_1 vdd vdd pch W=60u L=1u
* Synapse class=0, input=vbias; n_w0_2 stores the learned weight.
Cw0_2 n_w0_2 0 1.67e-06
Mreset0_2 vweight reset n_w0_2 0 syn W=1000u L=1u
Mpos0_2 vbias n_w0_2 n_pos0 0 syn W=10u L=1u
Mneg0_2 vbias vweight n_neg0 0 syn W=10u L=1u
Menable0_2 n_gate0_2 learn 0 0 nch W=1000u L=1u
Mtail0_2 n_tail0_2 vbias n_gate0_2 0 nch W=20u L=1u
Mu1_0_2 n_up0_2 verror n_tail0_2 0 nch W=20u L=1u
Mu2_0_2 n_w0_2 n_error0 n_tail0_2 0 nch W=20u L=1u
Mu3_0_2 n_up0_2 n_up0_2 vdd vdd pch W=60u L=1u
Mu4_0_2 n_w0_2 n_up0_2 vdd vdd pch W=60u L=1u
Ma1 n_neg1 n_neg1 0 0 nch W=20u L=1u
Mb1 out1 n_neg1 0 0 nch W=20u L=1u
Mc1 n_pos1 n_pos1 0 0 nch W=20u L=1u
Md1 n_mirror1 n_pos1 0 0 nch W=20u L=1u
Me1 n_mirror1 n_mirror1 vdd vdd pch W=60u L=1u
Mf1 out1 n_mirror1 vdd vdd pch W=60u L=1u
Mep1 n_error1 n_mirror1 vdd vdd pch W=60u L=1u
Men1 n_error1 n_neg1 0 0 nch W=20u L=1u
Moff1 n_error1 voffset vdd vdd pch W=10u L=1u
Mtarget1 n_error1 target1 0 0 nch W=10u L=1u
Rscore1 out1 vref 7k
Rerror1 n_error1 verror 7k
* Synapse class=1, input=in0; n_w1_0 stores the learned weight.
Cw1_0 n_w1_0 0 1.67e-06
Mreset1_0 vweight reset n_w1_0 0 syn W=1000u L=1u
Mpos1_0 in0 n_w1_0 n_pos1 0 syn W=10u L=1u
Mneg1_0 in0 vweight n_neg1 0 syn W=10u L=1u
Menable1_0 n_gate1_0 learn 0 0 nch W=1000u L=1u
Mtail1_0 n_tail1_0 in0 n_gate1_0 0 nch W=20u L=1u
Mu1_1_0 n_up1_0 verror n_tail1_0 0 nch W=20u L=1u
Mu2_1_0 n_w1_0 n_error1 n_tail1_0 0 nch W=20u L=1u
Mu3_1_0 n_up1_0 n_up1_0 vdd vdd pch W=60u L=1u
Mu4_1_0 n_w1_0 n_up1_0 vdd vdd pch W=60u L=1u
* Synapse class=1, input=in1; n_w1_1 stores the learned weight.
Cw1_1 n_w1_1 0 1.67e-06
Mreset1_1 vweight reset n_w1_1 0 syn W=1000u L=1u
Mpos1_1 in1 n_w1_1 n_pos1 0 syn W=10u L=1u
Mneg1_1 in1 vweight n_neg1 0 syn W=10u L=1u
Menable1_1 n_gate1_1 learn 0 0 nch W=1000u L=1u
Mtail1_1 n_tail1_1 in1 n_gate1_1 0 nch W=20u L=1u
Mu1_1_1 n_up1_1 verror n_tail1_1 0 nch W=20u L=1u
Mu2_1_1 n_w1_1 n_error1 n_tail1_1 0 nch W=20u L=1u
Mu3_1_1 n_up1_1 n_up1_1 vdd vdd pch W=60u L=1u
Mu4_1_1 n_w1_1 n_up1_1 vdd vdd pch W=60u L=1u
* Synapse class=1, input=vbias; n_w1_2 stores the learned weight.
Cw1_2 n_w1_2 0 1.67e-06
Mreset1_2 vweight reset n_w1_2 0 syn W=1000u L=1u
Mpos1_2 vbias n_w1_2 n_pos1 0 syn W=10u L=1u
Mneg1_2 vbias vweight n_neg1 0 syn W=10u L=1u
Menable1_2 n_gate1_2 learn 0 0 nch W=1000u L=1u
Mtail1_2 n_tail1_2 vbias n_gate1_2 0 nch W=20u L=1u
Mu1_1_2 n_up1_2 verror n_tail1_2 0 nch W=20u L=1u
Mu2_1_2 n_w1_2 n_error1 n_tail1_2 0 nch W=20u L=1u
Mu3_1_2 n_up1_2 n_up1_2 vdd vdd pch W=60u L=1u
Mu4_1_2 n_w1_2 n_up1_2 vdd vdd pch W=60u L=1u
