* Analog delta-rule learner: generated by competition/make_baseline.py
* Weight = capacitor voltage; update current depends on error and input.
* Based on the DIRECT path of experiments/gen_mc.py.
Ma0 n_neg0 n_neg0 0 0 nch W=20u L=1u
Mb0 out0 n_neg0 0 0 nch W=20u L=1u
Mc0 n_pos0 n_pos0 0 0 nch W=20u L=1u
Md0 n_mirror0 n_pos0 0 0 nch W=20u L=1u
Me0 n_mirror0 n_mirror0 vdd vdd pch W=60u L=1u
Mf0 out0 n_mirror0 vdd vdd pch W=60u L=1u
Mep0 n_error0 n_mirror0 vdd vdd pch W=60u L=1u
Men0 n_error0 n_neg0 0 0 nch W=20u L=1u
Moff0 n_error0 voffset vdd vdd pch W=10u L=1u
Mtarget0 n_error0 target0 0 0 nch W=10u L=1u
Rscore0 out0 vref 7k
Rerror0 n_error0 verror 7k
* Synapse class=0, input=in0; n_w0_0 stores the learned weight.
Cw0_0 n_w0_0 0 1.67e-06
Mreset0_0 vweight reset n_w0_0 0 syn W=1000u L=1u
Mpos0_0 in0 n_w0_0 n_pos0 0 syn W=10u L=1u
Mneg0_0 in0 vweight n_neg0 0 syn W=10u L=1u
Menable0_0 n_gate0_0 learn 0 0 nch W=1000u L=1u
Mtail0_0 n_tail0_0 in0 n_gate0_0 0 nch W=20u L=1u
Mu1_0_0 n_up0_0 verror n_tail0_0 0 nch W=20u L=1u
Mu2_0_0 n_w0_0 n_error0 n_tail0_0 0 nch W=20u L=1u
Mu3_0_0 n_up0_0 n_up0_0 vdd vdd pch W=60u L=1u
Mu4_0_0 n_w0_0 n_up0_0 vdd vdd pch W=60u L=1u
* Synapse class=0, input=in1; n_w0_1 stores the learned weight.
Cw0_1 n_w0_1 0 1.67e-06
Mreset0_1 vweight reset n_w0_1 0 syn W=1000u L=1u
Mpos0_1 in1 n_w0_1 n_pos0 0 syn W=10u L=1u
Mneg0_1 in1 vweight n_neg0 0 syn W=10u L=1u
Menable0_1 n_gate0_1 learn 0 0 nch W=1000u L=1u
Mtail0_1 n_tail0_1 in1 n_gate0_1 0 nch W=20u L=1u
Mu1_0_1 n_up0_1 verror n_tail0_1 0 nch W=20u L=1u
Mu2_0_1 n_w0_1 n_error0 n_tail0_1 0 nch W=20u L=1u
Mu3_0_1 n_up0_1 n_up0_1 vdd vdd pch W=60u L=1u
Mu4_0_1 n_w0_1 n_up0_1 vdd vdd pch W=60u L=1u
* Synapse class=0, input=in2; n_w0_2 stores the learned weight.
Cw0_2 n_w0_2 0 1.67e-06
Mreset0_2 vweight reset n_w0_2 0 syn W=1000u L=1u
Mpos0_2 in2 n_w0_2 n_pos0 0 syn W=10u L=1u
Mneg0_2 in2 vweight n_neg0 0 syn W=10u L=1u
Menable0_2 n_gate0_2 learn 0 0 nch W=1000u L=1u
Mtail0_2 n_tail0_2 in2 n_gate0_2 0 nch W=20u L=1u
Mu1_0_2 n_up0_2 verror n_tail0_2 0 nch W=20u L=1u
Mu2_0_2 n_w0_2 n_error0 n_tail0_2 0 nch W=20u L=1u
Mu3_0_2 n_up0_2 n_up0_2 vdd vdd pch W=60u L=1u
Mu4_0_2 n_w0_2 n_up0_2 vdd vdd pch W=60u L=1u
* Synapse class=0, input=in3; n_w0_3 stores the learned weight.
Cw0_3 n_w0_3 0 1.67e-06
Mreset0_3 vweight reset n_w0_3 0 syn W=1000u L=1u
Mpos0_3 in3 n_w0_3 n_pos0 0 syn W=10u L=1u
Mneg0_3 in3 vweight n_neg0 0 syn W=10u L=1u
Menable0_3 n_gate0_3 learn 0 0 nch W=1000u L=1u
Mtail0_3 n_tail0_3 in3 n_gate0_3 0 nch W=20u L=1u
Mu1_0_3 n_up0_3 verror n_tail0_3 0 nch W=20u L=1u
Mu2_0_3 n_w0_3 n_error0 n_tail0_3 0 nch W=20u L=1u
Mu3_0_3 n_up0_3 n_up0_3 vdd vdd pch W=60u L=1u
Mu4_0_3 n_w0_3 n_up0_3 vdd vdd pch W=60u L=1u
* Synapse class=0, input=in4; n_w0_4 stores the learned weight.
Cw0_4 n_w0_4 0 1.67e-06
Mreset0_4 vweight reset n_w0_4 0 syn W=1000u L=1u
Mpos0_4 in4 n_w0_4 n_pos0 0 syn W=10u L=1u
Mneg0_4 in4 vweight n_neg0 0 syn W=10u L=1u
Menable0_4 n_gate0_4 learn 0 0 nch W=1000u L=1u
Mtail0_4 n_tail0_4 in4 n_gate0_4 0 nch W=20u L=1u
Mu1_0_4 n_up0_4 verror n_tail0_4 0 nch W=20u L=1u
Mu2_0_4 n_w0_4 n_error0 n_tail0_4 0 nch W=20u L=1u
Mu3_0_4 n_up0_4 n_up0_4 vdd vdd pch W=60u L=1u
Mu4_0_4 n_w0_4 n_up0_4 vdd vdd pch W=60u L=1u
* Synapse class=0, input=in5; n_w0_5 stores the learned weight.
Cw0_5 n_w0_5 0 1.67e-06
Mreset0_5 vweight reset n_w0_5 0 syn W=1000u L=1u
Mpos0_5 in5 n_w0_5 n_pos0 0 syn W=10u L=1u
Mneg0_5 in5 vweight n_neg0 0 syn W=10u L=1u
Menable0_5 n_gate0_5 learn 0 0 nch W=1000u L=1u
Mtail0_5 n_tail0_5 in5 n_gate0_5 0 nch W=20u L=1u
Mu1_0_5 n_up0_5 verror n_tail0_5 0 nch W=20u L=1u
Mu2_0_5 n_w0_5 n_error0 n_tail0_5 0 nch W=20u L=1u
Mu3_0_5 n_up0_5 n_up0_5 vdd vdd pch W=60u L=1u
Mu4_0_5 n_w0_5 n_up0_5 vdd vdd pch W=60u L=1u
* Synapse class=0, input=in6; n_w0_6 stores the learned weight.
Cw0_6 n_w0_6 0 1.67e-06
Mreset0_6 vweight reset n_w0_6 0 syn W=1000u L=1u
Mpos0_6 in6 n_w0_6 n_pos0 0 syn W=10u L=1u
Mneg0_6 in6 vweight n_neg0 0 syn W=10u L=1u
Menable0_6 n_gate0_6 learn 0 0 nch W=1000u L=1u
Mtail0_6 n_tail0_6 in6 n_gate0_6 0 nch W=20u L=1u
Mu1_0_6 n_up0_6 verror n_tail0_6 0 nch W=20u L=1u
Mu2_0_6 n_w0_6 n_error0 n_tail0_6 0 nch W=20u L=1u
Mu3_0_6 n_up0_6 n_up0_6 vdd vdd pch W=60u L=1u
Mu4_0_6 n_w0_6 n_up0_6 vdd vdd pch W=60u L=1u
* Synapse class=0, input=in7; n_w0_7 stores the learned weight.
Cw0_7 n_w0_7 0 1.67e-06
Mreset0_7 vweight reset n_w0_7 0 syn W=1000u L=1u
Mpos0_7 in7 n_w0_7 n_pos0 0 syn W=10u L=1u
Mneg0_7 in7 vweight n_neg0 0 syn W=10u L=1u
Menable0_7 n_gate0_7 learn 0 0 nch W=1000u L=1u
Mtail0_7 n_tail0_7 in7 n_gate0_7 0 nch W=20u L=1u
Mu1_0_7 n_up0_7 verror n_tail0_7 0 nch W=20u L=1u
Mu2_0_7 n_w0_7 n_error0 n_tail0_7 0 nch W=20u L=1u
Mu3_0_7 n_up0_7 n_up0_7 vdd vdd pch W=60u L=1u
Mu4_0_7 n_w0_7 n_up0_7 vdd vdd pch W=60u L=1u
* Synapse class=0, input=in8; n_w0_8 stores the learned weight.
Cw0_8 n_w0_8 0 1.67e-06
Mreset0_8 vweight reset n_w0_8 0 syn W=1000u L=1u
Mpos0_8 in8 n_w0_8 n_pos0 0 syn W=10u L=1u
Mneg0_8 in8 vweight n_neg0 0 syn W=10u L=1u
Menable0_8 n_gate0_8 learn 0 0 nch W=1000u L=1u
Mtail0_8 n_tail0_8 in8 n_gate0_8 0 nch W=20u L=1u
Mu1_0_8 n_up0_8 verror n_tail0_8 0 nch W=20u L=1u
Mu2_0_8 n_w0_8 n_error0 n_tail0_8 0 nch W=20u L=1u
Mu3_0_8 n_up0_8 n_up0_8 vdd vdd pch W=60u L=1u
Mu4_0_8 n_w0_8 n_up0_8 vdd vdd pch W=60u L=1u
* Synapse class=0, input=in9; n_w0_9 stores the learned weight.
Cw0_9 n_w0_9 0 1.67e-06
Mreset0_9 vweight reset n_w0_9 0 syn W=1000u L=1u
Mpos0_9 in9 n_w0_9 n_pos0 0 syn W=10u L=1u
Mneg0_9 in9 vweight n_neg0 0 syn W=10u L=1u
Menable0_9 n_gate0_9 learn 0 0 nch W=1000u L=1u
Mtail0_9 n_tail0_9 in9 n_gate0_9 0 nch W=20u L=1u
Mu1_0_9 n_up0_9 verror n_tail0_9 0 nch W=20u L=1u
Mu2_0_9 n_w0_9 n_error0 n_tail0_9 0 nch W=20u L=1u
Mu3_0_9 n_up0_9 n_up0_9 vdd vdd pch W=60u L=1u
Mu4_0_9 n_w0_9 n_up0_9 vdd vdd pch W=60u L=1u
* Synapse class=0, input=in10; n_w0_10 stores the learned weight.
Cw0_10 n_w0_10 0 1.67e-06
Mreset0_10 vweight reset n_w0_10 0 syn W=1000u L=1u
Mpos0_10 in10 n_w0_10 n_pos0 0 syn W=10u L=1u
Mneg0_10 in10 vweight n_neg0 0 syn W=10u L=1u
Menable0_10 n_gate0_10 learn 0 0 nch W=1000u L=1u
Mtail0_10 n_tail0_10 in10 n_gate0_10 0 nch W=20u L=1u
Mu1_0_10 n_up0_10 verror n_tail0_10 0 nch W=20u L=1u
Mu2_0_10 n_w0_10 n_error0 n_tail0_10 0 nch W=20u L=1u
Mu3_0_10 n_up0_10 n_up0_10 vdd vdd pch W=60u L=1u
Mu4_0_10 n_w0_10 n_up0_10 vdd vdd pch W=60u L=1u
* Synapse class=0, input=in11; n_w0_11 stores the learned weight.
Cw0_11 n_w0_11 0 1.67e-06
Mreset0_11 vweight reset n_w0_11 0 syn W=1000u L=1u
Mpos0_11 in11 n_w0_11 n_pos0 0 syn W=10u L=1u
Mneg0_11 in11 vweight n_neg0 0 syn W=10u L=1u
Menable0_11 n_gate0_11 learn 0 0 nch W=1000u L=1u
Mtail0_11 n_tail0_11 in11 n_gate0_11 0 nch W=20u L=1u
Mu1_0_11 n_up0_11 verror n_tail0_11 0 nch W=20u L=1u
Mu2_0_11 n_w0_11 n_error0 n_tail0_11 0 nch W=20u L=1u
Mu3_0_11 n_up0_11 n_up0_11 vdd vdd pch W=60u L=1u
Mu4_0_11 n_w0_11 n_up0_11 vdd vdd pch W=60u L=1u
* Synapse class=0, input=in12; n_w0_12 stores the learned weight.
Cw0_12 n_w0_12 0 1.67e-06
Mreset0_12 vweight reset n_w0_12 0 syn W=1000u L=1u
Mpos0_12 in12 n_w0_12 n_pos0 0 syn W=10u L=1u
Mneg0_12 in12 vweight n_neg0 0 syn W=10u L=1u
Menable0_12 n_gate0_12 learn 0 0 nch W=1000u L=1u
Mtail0_12 n_tail0_12 in12 n_gate0_12 0 nch W=20u L=1u
Mu1_0_12 n_up0_12 verror n_tail0_12 0 nch W=20u L=1u
Mu2_0_12 n_w0_12 n_error0 n_tail0_12 0 nch W=20u L=1u
Mu3_0_12 n_up0_12 n_up0_12 vdd vdd pch W=60u L=1u
Mu4_0_12 n_w0_12 n_up0_12 vdd vdd pch W=60u L=1u
* Synapse class=0, input=in13; n_w0_13 stores the learned weight.
Cw0_13 n_w0_13 0 1.67e-06
Mreset0_13 vweight reset n_w0_13 0 syn W=1000u L=1u
Mpos0_13 in13 n_w0_13 n_pos0 0 syn W=10u L=1u
Mneg0_13 in13 vweight n_neg0 0 syn W=10u L=1u
Menable0_13 n_gate0_13 learn 0 0 nch W=1000u L=1u
Mtail0_13 n_tail0_13 in13 n_gate0_13 0 nch W=20u L=1u
Mu1_0_13 n_up0_13 verror n_tail0_13 0 nch W=20u L=1u
Mu2_0_13 n_w0_13 n_error0 n_tail0_13 0 nch W=20u L=1u
Mu3_0_13 n_up0_13 n_up0_13 vdd vdd pch W=60u L=1u
Mu4_0_13 n_w0_13 n_up0_13 vdd vdd pch W=60u L=1u
* Synapse class=0, input=in14; n_w0_14 stores the learned weight.
Cw0_14 n_w0_14 0 1.67e-06
Mreset0_14 vweight reset n_w0_14 0 syn W=1000u L=1u
Mpos0_14 in14 n_w0_14 n_pos0 0 syn W=10u L=1u
Mneg0_14 in14 vweight n_neg0 0 syn W=10u L=1u
Menable0_14 n_gate0_14 learn 0 0 nch W=1000u L=1u
Mtail0_14 n_tail0_14 in14 n_gate0_14 0 nch W=20u L=1u
Mu1_0_14 n_up0_14 verror n_tail0_14 0 nch W=20u L=1u
Mu2_0_14 n_w0_14 n_error0 n_tail0_14 0 nch W=20u L=1u
Mu3_0_14 n_up0_14 n_up0_14 vdd vdd pch W=60u L=1u
Mu4_0_14 n_w0_14 n_up0_14 vdd vdd pch W=60u L=1u
* Synapse class=0, input=in15; n_w0_15 stores the learned weight.
Cw0_15 n_w0_15 0 1.67e-06
Mreset0_15 vweight reset n_w0_15 0 syn W=1000u L=1u
Mpos0_15 in15 n_w0_15 n_pos0 0 syn W=10u L=1u
Mneg0_15 in15 vweight n_neg0 0 syn W=10u L=1u
Menable0_15 n_gate0_15 learn 0 0 nch W=1000u L=1u
Mtail0_15 n_tail0_15 in15 n_gate0_15 0 nch W=20u L=1u
Mu1_0_15 n_up0_15 verror n_tail0_15 0 nch W=20u L=1u
Mu2_0_15 n_w0_15 n_error0 n_tail0_15 0 nch W=20u L=1u
Mu3_0_15 n_up0_15 n_up0_15 vdd vdd pch W=60u L=1u
Mu4_0_15 n_w0_15 n_up0_15 vdd vdd pch W=60u L=1u
* Synapse class=0, input=vbias; n_w0_16 stores the learned weight.
Cw0_16 n_w0_16 0 1.67e-06
Mreset0_16 vweight reset n_w0_16 0 syn W=1000u L=1u
Mpos0_16 vbias n_w0_16 n_pos0 0 syn W=10u L=1u
Mneg0_16 vbias vweight n_neg0 0 syn W=10u L=1u
Menable0_16 n_gate0_16 learn 0 0 nch W=1000u L=1u
Mtail0_16 n_tail0_16 vbias n_gate0_16 0 nch W=20u L=1u
Mu1_0_16 n_up0_16 verror n_tail0_16 0 nch W=20u L=1u
Mu2_0_16 n_w0_16 n_error0 n_tail0_16 0 nch W=20u L=1u
Mu3_0_16 n_up0_16 n_up0_16 vdd vdd pch W=60u L=1u
Mu4_0_16 n_w0_16 n_up0_16 vdd vdd pch W=60u L=1u
Ma1 n_neg1 n_neg1 0 0 nch W=20u L=1u
Mb1 out1 n_neg1 0 0 nch W=20u L=1u
Mc1 n_pos1 n_pos1 0 0 nch W=20u L=1u
Md1 n_mirror1 n_pos1 0 0 nch W=20u L=1u
Me1 n_mirror1 n_mirror1 vdd vdd pch W=60u L=1u
Mf1 out1 n_mirror1 vdd vdd pch W=60u L=1u
Mep1 n_error1 n_mirror1 vdd vdd pch W=60u L=1u
Men1 n_error1 n_neg1 0 0 nch W=20u L=1u
Moff1 n_error1 voffset vdd vdd pch W=10u L=1u
Mtarget1 n_error1 target1 0 0 nch W=10u L=1u
Rscore1 out1 vref 7k
Rerror1 n_error1 verror 7k
* Synapse class=1, input=in0; n_w1_0 stores the learned weight.
Cw1_0 n_w1_0 0 1.67e-06
Mreset1_0 vweight reset n_w1_0 0 syn W=1000u L=1u
Mpos1_0 in0 n_w1_0 n_pos1 0 syn W=10u L=1u
Mneg1_0 in0 vweight n_neg1 0 syn W=10u L=1u
Menable1_0 n_gate1_0 learn 0 0 nch W=1000u L=1u
Mtail1_0 n_tail1_0 in0 n_gate1_0 0 nch W=20u L=1u
Mu1_1_0 n_up1_0 verror n_tail1_0 0 nch W=20u L=1u
Mu2_1_0 n_w1_0 n_error1 n_tail1_0 0 nch W=20u L=1u
Mu3_1_0 n_up1_0 n_up1_0 vdd vdd pch W=60u L=1u
Mu4_1_0 n_w1_0 n_up1_0 vdd vdd pch W=60u L=1u
* Synapse class=1, input=in1; n_w1_1 stores the learned weight.
Cw1_1 n_w1_1 0 1.67e-06
Mreset1_1 vweight reset n_w1_1 0 syn W=1000u L=1u
Mpos1_1 in1 n_w1_1 n_pos1 0 syn W=10u L=1u
Mneg1_1 in1 vweight n_neg1 0 syn W=10u L=1u
Menable1_1 n_gate1_1 learn 0 0 nch W=1000u L=1u
Mtail1_1 n_tail1_1 in1 n_gate1_1 0 nch W=20u L=1u
Mu1_1_1 n_up1_1 verror n_tail1_1 0 nch W=20u L=1u
Mu2_1_1 n_w1_1 n_error1 n_tail1_1 0 nch W=20u L=1u
Mu3_1_1 n_up1_1 n_up1_1 vdd vdd pch W=60u L=1u
Mu4_1_1 n_w1_1 n_up1_1 vdd vdd pch W=60u L=1u
* Synapse class=1, input=in2; n_w1_2 stores the learned weight.
Cw1_2 n_w1_2 0 1.67e-06
Mreset1_2 vweight reset n_w1_2 0 syn W=1000u L=1u
Mpos1_2 in2 n_w1_2 n_pos1 0 syn W=10u L=1u
Mneg1_2 in2 vweight n_neg1 0 syn W=10u L=1u
Menable1_2 n_gate1_2 learn 0 0 nch W=1000u L=1u
Mtail1_2 n_tail1_2 in2 n_gate1_2 0 nch W=20u L=1u
Mu1_1_2 n_up1_2 verror n_tail1_2 0 nch W=20u L=1u
Mu2_1_2 n_w1_2 n_error1 n_tail1_2 0 nch W=20u L=1u
Mu3_1_2 n_up1_2 n_up1_2 vdd vdd pch W=60u L=1u
Mu4_1_2 n_w1_2 n_up1_2 vdd vdd pch W=60u L=1u
* Synapse class=1, input=in3; n_w1_3 stores the learned weight.
Cw1_3 n_w1_3 0 1.67e-06
Mreset1_3 vweight reset n_w1_3 0 syn W=1000u L=1u
Mpos1_3 in3 n_w1_3 n_pos1 0 syn W=10u L=1u
Mneg1_3 in3 vweight n_neg1 0 syn W=10u L=1u
Menable1_3 n_gate1_3 learn 0 0 nch W=1000u L=1u
Mtail1_3 n_tail1_3 in3 n_gate1_3 0 nch W=20u L=1u
Mu1_1_3 n_up1_3 verror n_tail1_3 0 nch W=20u L=1u
Mu2_1_3 n_w1_3 n_error1 n_tail1_3 0 nch W=20u L=1u
Mu3_1_3 n_up1_3 n_up1_3 vdd vdd pch W=60u L=1u
Mu4_1_3 n_w1_3 n_up1_3 vdd vdd pch W=60u L=1u
* Synapse class=1, input=in4; n_w1_4 stores the learned weight.
Cw1_4 n_w1_4 0 1.67e-06
Mreset1_4 vweight reset n_w1_4 0 syn W=1000u L=1u
Mpos1_4 in4 n_w1_4 n_pos1 0 syn W=10u L=1u
Mneg1_4 in4 vweight n_neg1 0 syn W=10u L=1u
Menable1_4 n_gate1_4 learn 0 0 nch W=1000u L=1u
Mtail1_4 n_tail1_4 in4 n_gate1_4 0 nch W=20u L=1u
Mu1_1_4 n_up1_4 verror n_tail1_4 0 nch W=20u L=1u
Mu2_1_4 n_w1_4 n_error1 n_tail1_4 0 nch W=20u L=1u
Mu3_1_4 n_up1_4 n_up1_4 vdd vdd pch W=60u L=1u
Mu4_1_4 n_w1_4 n_up1_4 vdd vdd pch W=60u L=1u
* Synapse class=1, input=in5; n_w1_5 stores the learned weight.
Cw1_5 n_w1_5 0 1.67e-06
Mreset1_5 vweight reset n_w1_5 0 syn W=1000u L=1u
Mpos1_5 in5 n_w1_5 n_pos1 0 syn W=10u L=1u
Mneg1_5 in5 vweight n_neg1 0 syn W=10u L=1u
Menable1_5 n_gate1_5 learn 0 0 nch W=1000u L=1u
Mtail1_5 n_tail1_5 in5 n_gate1_5 0 nch W=20u L=1u
Mu1_1_5 n_up1_5 verror n_tail1_5 0 nch W=20u L=1u
Mu2_1_5 n_w1_5 n_error1 n_tail1_5 0 nch W=20u L=1u
Mu3_1_5 n_up1_5 n_up1_5 vdd vdd pch W=60u L=1u
Mu4_1_5 n_w1_5 n_up1_5 vdd vdd pch W=60u L=1u
* Synapse class=1, input=in6; n_w1_6 stores the learned weight.
Cw1_6 n_w1_6 0 1.67e-06
Mreset1_6 vweight reset n_w1_6 0 syn W=1000u L=1u
Mpos1_6 in6 n_w1_6 n_pos1 0 syn W=10u L=1u
Mneg1_6 in6 vweight n_neg1 0 syn W=10u L=1u
Menable1_6 n_gate1_6 learn 0 0 nch W=1000u L=1u
Mtail1_6 n_tail1_6 in6 n_gate1_6 0 nch W=20u L=1u
Mu1_1_6 n_up1_6 verror n_tail1_6 0 nch W=20u L=1u
Mu2_1_6 n_w1_6 n_error1 n_tail1_6 0 nch W=20u L=1u
Mu3_1_6 n_up1_6 n_up1_6 vdd vdd pch W=60u L=1u
Mu4_1_6 n_w1_6 n_up1_6 vdd vdd pch W=60u L=1u
* Synapse class=1, input=in7; n_w1_7 stores the learned weight.
Cw1_7 n_w1_7 0 1.67e-06
Mreset1_7 vweight reset n_w1_7 0 syn W=1000u L=1u
Mpos1_7 in7 n_w1_7 n_pos1 0 syn W=10u L=1u
Mneg1_7 in7 vweight n_neg1 0 syn W=10u L=1u
Menable1_7 n_gate1_7 learn 0 0 nch W=1000u L=1u
Mtail1_7 n_tail1_7 in7 n_gate1_7 0 nch W=20u L=1u
Mu1_1_7 n_up1_7 verror n_tail1_7 0 nch W=20u L=1u
Mu2_1_7 n_w1_7 n_error1 n_tail1_7 0 nch W=20u L=1u
Mu3_1_7 n_up1_7 n_up1_7 vdd vdd pch W=60u L=1u
Mu4_1_7 n_w1_7 n_up1_7 vdd vdd pch W=60u L=1u
* Synapse class=1, input=in8; n_w1_8 stores the learned weight.
Cw1_8 n_w1_8 0 1.67e-06
Mreset1_8 vweight reset n_w1_8 0 syn W=1000u L=1u
Mpos1_8 in8 n_w1_8 n_pos1 0 syn W=10u L=1u
Mneg1_8 in8 vweight n_neg1 0 syn W=10u L=1u
Menable1_8 n_gate1_8 learn 0 0 nch W=1000u L=1u
Mtail1_8 n_tail1_8 in8 n_gate1_8 0 nch W=20u L=1u
Mu1_1_8 n_up1_8 verror n_tail1_8 0 nch W=20u L=1u
Mu2_1_8 n_w1_8 n_error1 n_tail1_8 0 nch W=20u L=1u
Mu3_1_8 n_up1_8 n_up1_8 vdd vdd pch W=60u L=1u
Mu4_1_8 n_w1_8 n_up1_8 vdd vdd pch W=60u L=1u
* Synapse class=1, input=in9; n_w1_9 stores the learned weight.
Cw1_9 n_w1_9 0 1.67e-06
Mreset1_9 vweight reset n_w1_9 0 syn W=1000u L=1u
Mpos1_9 in9 n_w1_9 n_pos1 0 syn W=10u L=1u
Mneg1_9 in9 vweight n_neg1 0 syn W=10u L=1u
Menable1_9 n_gate1_9 learn 0 0 nch W=1000u L=1u
Mtail1_9 n_tail1_9 in9 n_gate1_9 0 nch W=20u L=1u
Mu1_1_9 n_up1_9 verror n_tail1_9 0 nch W=20u L=1u
Mu2_1_9 n_w1_9 n_error1 n_tail1_9 0 nch W=20u L=1u
Mu3_1_9 n_up1_9 n_up1_9 vdd vdd pch W=60u L=1u
Mu4_1_9 n_w1_9 n_up1_9 vdd vdd pch W=60u L=1u
* Synapse class=1, input=in10; n_w1_10 stores the learned weight.
Cw1_10 n_w1_10 0 1.67e-06
Mreset1_10 vweight reset n_w1_10 0 syn W=1000u L=1u
Mpos1_10 in10 n_w1_10 n_pos1 0 syn W=10u L=1u
Mneg1_10 in10 vweight n_neg1 0 syn W=10u L=1u
Menable1_10 n_gate1_10 learn 0 0 nch W=1000u L=1u
Mtail1_10 n_tail1_10 in10 n_gate1_10 0 nch W=20u L=1u
Mu1_1_10 n_up1_10 verror n_tail1_10 0 nch W=20u L=1u
Mu2_1_10 n_w1_10 n_error1 n_tail1_10 0 nch W=20u L=1u
Mu3_1_10 n_up1_10 n_up1_10 vdd vdd pch W=60u L=1u
Mu4_1_10 n_w1_10 n_up1_10 vdd vdd pch W=60u L=1u
* Synapse class=1, input=in11; n_w1_11 stores the learned weight.
Cw1_11 n_w1_11 0 1.67e-06
Mreset1_11 vweight reset n_w1_11 0 syn W=1000u L=1u
Mpos1_11 in11 n_w1_11 n_pos1 0 syn W=10u L=1u
Mneg1_11 in11 vweight n_neg1 0 syn W=10u L=1u
Menable1_11 n_gate1_11 learn 0 0 nch W=1000u L=1u
Mtail1_11 n_tail1_11 in11 n_gate1_11 0 nch W=20u L=1u
Mu1_1_11 n_up1_11 verror n_tail1_11 0 nch W=20u L=1u
Mu2_1_11 n_w1_11 n_error1 n_tail1_11 0 nch W=20u L=1u
Mu3_1_11 n_up1_11 n_up1_11 vdd vdd pch W=60u L=1u
Mu4_1_11 n_w1_11 n_up1_11 vdd vdd pch W=60u L=1u
* Synapse class=1, input=in12; n_w1_12 stores the learned weight.
Cw1_12 n_w1_12 0 1.67e-06
Mreset1_12 vweight reset n_w1_12 0 syn W=1000u L=1u
Mpos1_12 in12 n_w1_12 n_pos1 0 syn W=10u L=1u
Mneg1_12 in12 vweight n_neg1 0 syn W=10u L=1u
Menable1_12 n_gate1_12 learn 0 0 nch W=1000u L=1u
Mtail1_12 n_tail1_12 in12 n_gate1_12 0 nch W=20u L=1u
Mu1_1_12 n_up1_12 verror n_tail1_12 0 nch W=20u L=1u
Mu2_1_12 n_w1_12 n_error1 n_tail1_12 0 nch W=20u L=1u
Mu3_1_12 n_up1_12 n_up1_12 vdd vdd pch W=60u L=1u
Mu4_1_12 n_w1_12 n_up1_12 vdd vdd pch W=60u L=1u
* Synapse class=1, input=in13; n_w1_13 stores the learned weight.
Cw1_13 n_w1_13 0 1.67e-06
Mreset1_13 vweight reset n_w1_13 0 syn W=1000u L=1u
Mpos1_13 in13 n_w1_13 n_pos1 0 syn W=10u L=1u
Mneg1_13 in13 vweight n_neg1 0 syn W=10u L=1u
Menable1_13 n_gate1_13 learn 0 0 nch W=1000u L=1u
Mtail1_13 n_tail1_13 in13 n_gate1_13 0 nch W=20u L=1u
Mu1_1_13 n_up1_13 verror n_tail1_13 0 nch W=20u L=1u
Mu2_1_13 n_w1_13 n_error1 n_tail1_13 0 nch W=20u L=1u
Mu3_1_13 n_up1_13 n_up1_13 vdd vdd pch W=60u L=1u
Mu4_1_13 n_w1_13 n_up1_13 vdd vdd pch W=60u L=1u
* Synapse class=1, input=in14; n_w1_14 stores the learned weight.
Cw1_14 n_w1_14 0 1.67e-06
Mreset1_14 vweight reset n_w1_14 0 syn W=1000u L=1u
Mpos1_14 in14 n_w1_14 n_pos1 0 syn W=10u L=1u
Mneg1_14 in14 vweight n_neg1 0 syn W=10u L=1u
Menable1_14 n_gate1_14 learn 0 0 nch W=1000u L=1u
Mtail1_14 n_tail1_14 in14 n_gate1_14 0 nch W=20u L=1u
Mu1_1_14 n_up1_14 verror n_tail1_14 0 nch W=20u L=1u
Mu2_1_14 n_w1_14 n_error1 n_tail1_14 0 nch W=20u L=1u
Mu3_1_14 n_up1_14 n_up1_14 vdd vdd pch W=60u L=1u
Mu4_1_14 n_w1_14 n_up1_14 vdd vdd pch W=60u L=1u
* Synapse class=1, input=in15; n_w1_15 stores the learned weight.
Cw1_15 n_w1_15 0 1.67e-06
Mreset1_15 vweight reset n_w1_15 0 syn W=1000u L=1u
Mpos1_15 in15 n_w1_15 n_pos1 0 syn W=10u L=1u
Mneg1_15 in15 vweight n_neg1 0 syn W=10u L=1u
Menable1_15 n_gate1_15 learn 0 0 nch W=1000u L=1u
Mtail1_15 n_tail1_15 in15 n_gate1_15 0 nch W=20u L=1u
Mu1_1_15 n_up1_15 verror n_tail1_15 0 nch W=20u L=1u
Mu2_1_15 n_w1_15 n_error1 n_tail1_15 0 nch W=20u L=1u
Mu3_1_15 n_up1_15 n_up1_15 vdd vdd pch W=60u L=1u
Mu4_1_15 n_w1_15 n_up1_15 vdd vdd pch W=60u L=1u
* Synapse class=1, input=vbias; n_w1_16 stores the learned weight.
Cw1_16 n_w1_16 0 1.67e-06
Mreset1_16 vweight reset n_w1_16 0 syn W=1000u L=1u
Mpos1_16 vbias n_w1_16 n_pos1 0 syn W=10u L=1u
Mneg1_16 vbias vweight n_neg1 0 syn W=10u L=1u
Menable1_16 n_gate1_16 learn 0 0 nch W=1000u L=1u
Mtail1_16 n_tail1_16 vbias n_gate1_16 0 nch W=20u L=1u
Mu1_1_16 n_up1_16 verror n_tail1_16 0 nch W=20u L=1u
Mu2_1_16 n_w1_16 n_error1 n_tail1_16 0 nch W=20u L=1u
Mu3_1_16 n_up1_16 n_up1_16 vdd vdd pch W=60u L=1u
Mu4_1_16 n_w1_16 n_up1_16 vdd vdd pch W=60u L=1u
Ma2 n_neg2 n_neg2 0 0 nch W=20u L=1u
Mb2 out2 n_neg2 0 0 nch W=20u L=1u
Mc2 n_pos2 n_pos2 0 0 nch W=20u L=1u
Md2 n_mirror2 n_pos2 0 0 nch W=20u L=1u
Me2 n_mirror2 n_mirror2 vdd vdd pch W=60u L=1u
Mf2 out2 n_mirror2 vdd vdd pch W=60u L=1u
Mep2 n_error2 n_mirror2 vdd vdd pch W=60u L=1u
Men2 n_error2 n_neg2 0 0 nch W=20u L=1u
Moff2 n_error2 voffset vdd vdd pch W=10u L=1u
Mtarget2 n_error2 target2 0 0 nch W=10u L=1u
Rscore2 out2 vref 7k
Rerror2 n_error2 verror 7k
* Synapse class=2, input=in0; n_w2_0 stores the learned weight.
Cw2_0 n_w2_0 0 1.67e-06
Mreset2_0 vweight reset n_w2_0 0 syn W=1000u L=1u
Mpos2_0 in0 n_w2_0 n_pos2 0 syn W=10u L=1u
Mneg2_0 in0 vweight n_neg2 0 syn W=10u L=1u
Menable2_0 n_gate2_0 learn 0 0 nch W=1000u L=1u
Mtail2_0 n_tail2_0 in0 n_gate2_0 0 nch W=20u L=1u
Mu1_2_0 n_up2_0 verror n_tail2_0 0 nch W=20u L=1u
Mu2_2_0 n_w2_0 n_error2 n_tail2_0 0 nch W=20u L=1u
Mu3_2_0 n_up2_0 n_up2_0 vdd vdd pch W=60u L=1u
Mu4_2_0 n_w2_0 n_up2_0 vdd vdd pch W=60u L=1u
* Synapse class=2, input=in1; n_w2_1 stores the learned weight.
Cw2_1 n_w2_1 0 1.67e-06
Mreset2_1 vweight reset n_w2_1 0 syn W=1000u L=1u
Mpos2_1 in1 n_w2_1 n_pos2 0 syn W=10u L=1u
Mneg2_1 in1 vweight n_neg2 0 syn W=10u L=1u
Menable2_1 n_gate2_1 learn 0 0 nch W=1000u L=1u
Mtail2_1 n_tail2_1 in1 n_gate2_1 0 nch W=20u L=1u
Mu1_2_1 n_up2_1 verror n_tail2_1 0 nch W=20u L=1u
Mu2_2_1 n_w2_1 n_error2 n_tail2_1 0 nch W=20u L=1u
Mu3_2_1 n_up2_1 n_up2_1 vdd vdd pch W=60u L=1u
Mu4_2_1 n_w2_1 n_up2_1 vdd vdd pch W=60u L=1u
* Synapse class=2, input=in2; n_w2_2 stores the learned weight.
Cw2_2 n_w2_2 0 1.67e-06
Mreset2_2 vweight reset n_w2_2 0 syn W=1000u L=1u
Mpos2_2 in2 n_w2_2 n_pos2 0 syn W=10u L=1u
Mneg2_2 in2 vweight n_neg2 0 syn W=10u L=1u
Menable2_2 n_gate2_2 learn 0 0 nch W=1000u L=1u
Mtail2_2 n_tail2_2 in2 n_gate2_2 0 nch W=20u L=1u
Mu1_2_2 n_up2_2 verror n_tail2_2 0 nch W=20u L=1u
Mu2_2_2 n_w2_2 n_error2 n_tail2_2 0 nch W=20u L=1u
Mu3_2_2 n_up2_2 n_up2_2 vdd vdd pch W=60u L=1u
Mu4_2_2 n_w2_2 n_up2_2 vdd vdd pch W=60u L=1u
* Synapse class=2, input=in3; n_w2_3 stores the learned weight.
Cw2_3 n_w2_3 0 1.67e-06
Mreset2_3 vweight reset n_w2_3 0 syn W=1000u L=1u
Mpos2_3 in3 n_w2_3 n_pos2 0 syn W=10u L=1u
Mneg2_3 in3 vweight n_neg2 0 syn W=10u L=1u
Menable2_3 n_gate2_3 learn 0 0 nch W=1000u L=1u
Mtail2_3 n_tail2_3 in3 n_gate2_3 0 nch W=20u L=1u
Mu1_2_3 n_up2_3 verror n_tail2_3 0 nch W=20u L=1u
Mu2_2_3 n_w2_3 n_error2 n_tail2_3 0 nch W=20u L=1u
Mu3_2_3 n_up2_3 n_up2_3 vdd vdd pch W=60u L=1u
Mu4_2_3 n_w2_3 n_up2_3 vdd vdd pch W=60u L=1u
* Synapse class=2, input=in4; n_w2_4 stores the learned weight.
Cw2_4 n_w2_4 0 1.67e-06
Mreset2_4 vweight reset n_w2_4 0 syn W=1000u L=1u
Mpos2_4 in4 n_w2_4 n_pos2 0 syn W=10u L=1u
Mneg2_4 in4 vweight n_neg2 0 syn W=10u L=1u
Menable2_4 n_gate2_4 learn 0 0 nch W=1000u L=1u
Mtail2_4 n_tail2_4 in4 n_gate2_4 0 nch W=20u L=1u
Mu1_2_4 n_up2_4 verror n_tail2_4 0 nch W=20u L=1u
Mu2_2_4 n_w2_4 n_error2 n_tail2_4 0 nch W=20u L=1u
Mu3_2_4 n_up2_4 n_up2_4 vdd vdd pch W=60u L=1u
Mu4_2_4 n_w2_4 n_up2_4 vdd vdd pch W=60u L=1u
* Synapse class=2, input=in5; n_w2_5 stores the learned weight.
Cw2_5 n_w2_5 0 1.67e-06
Mreset2_5 vweight reset n_w2_5 0 syn W=1000u L=1u
Mpos2_5 in5 n_w2_5 n_pos2 0 syn W=10u L=1u
Mneg2_5 in5 vweight n_neg2 0 syn W=10u L=1u
Menable2_5 n_gate2_5 learn 0 0 nch W=1000u L=1u
Mtail2_5 n_tail2_5 in5 n_gate2_5 0 nch W=20u L=1u
Mu1_2_5 n_up2_5 verror n_tail2_5 0 nch W=20u L=1u
Mu2_2_5 n_w2_5 n_error2 n_tail2_5 0 nch W=20u L=1u
Mu3_2_5 n_up2_5 n_up2_5 vdd vdd pch W=60u L=1u
Mu4_2_5 n_w2_5 n_up2_5 vdd vdd pch W=60u L=1u
* Synapse class=2, input=in6; n_w2_6 stores the learned weight.
Cw2_6 n_w2_6 0 1.67e-06
Mreset2_6 vweight reset n_w2_6 0 syn W=1000u L=1u
Mpos2_6 in6 n_w2_6 n_pos2 0 syn W=10u L=1u
Mneg2_6 in6 vweight n_neg2 0 syn W=10u L=1u
Menable2_6 n_gate2_6 learn 0 0 nch W=1000u L=1u
Mtail2_6 n_tail2_6 in6 n_gate2_6 0 nch W=20u L=1u
Mu1_2_6 n_up2_6 verror n_tail2_6 0 nch W=20u L=1u
Mu2_2_6 n_w2_6 n_error2 n_tail2_6 0 nch W=20u L=1u
Mu3_2_6 n_up2_6 n_up2_6 vdd vdd pch W=60u L=1u
Mu4_2_6 n_w2_6 n_up2_6 vdd vdd pch W=60u L=1u
* Synapse class=2, input=in7; n_w2_7 stores the learned weight.
Cw2_7 n_w2_7 0 1.67e-06
Mreset2_7 vweight reset n_w2_7 0 syn W=1000u L=1u
Mpos2_7 in7 n_w2_7 n_pos2 0 syn W=10u L=1u
Mneg2_7 in7 vweight n_neg2 0 syn W=10u L=1u
Menable2_7 n_gate2_7 learn 0 0 nch W=1000u L=1u
Mtail2_7 n_tail2_7 in7 n_gate2_7 0 nch W=20u L=1u
Mu1_2_7 n_up2_7 verror n_tail2_7 0 nch W=20u L=1u
Mu2_2_7 n_w2_7 n_error2 n_tail2_7 0 nch W=20u L=1u
Mu3_2_7 n_up2_7 n_up2_7 vdd vdd pch W=60u L=1u
Mu4_2_7 n_w2_7 n_up2_7 vdd vdd pch W=60u L=1u
* Synapse class=2, input=in8; n_w2_8 stores the learned weight.
Cw2_8 n_w2_8 0 1.67e-06
Mreset2_8 vweight reset n_w2_8 0 syn W=1000u L=1u
Mpos2_8 in8 n_w2_8 n_pos2 0 syn W=10u L=1u
Mneg2_8 in8 vweight n_neg2 0 syn W=10u L=1u
Menable2_8 n_gate2_8 learn 0 0 nch W=1000u L=1u
Mtail2_8 n_tail2_8 in8 n_gate2_8 0 nch W=20u L=1u
Mu1_2_8 n_up2_8 verror n_tail2_8 0 nch W=20u L=1u
Mu2_2_8 n_w2_8 n_error2 n_tail2_8 0 nch W=20u L=1u
Mu3_2_8 n_up2_8 n_up2_8 vdd vdd pch W=60u L=1u
Mu4_2_8 n_w2_8 n_up2_8 vdd vdd pch W=60u L=1u
* Synapse class=2, input=in9; n_w2_9 stores the learned weight.
Cw2_9 n_w2_9 0 1.67e-06
Mreset2_9 vweight reset n_w2_9 0 syn W=1000u L=1u
Mpos2_9 in9 n_w2_9 n_pos2 0 syn W=10u L=1u
Mneg2_9 in9 vweight n_neg2 0 syn W=10u L=1u
Menable2_9 n_gate2_9 learn 0 0 nch W=1000u L=1u
Mtail2_9 n_tail2_9 in9 n_gate2_9 0 nch W=20u L=1u
Mu1_2_9 n_up2_9 verror n_tail2_9 0 nch W=20u L=1u
Mu2_2_9 n_w2_9 n_error2 n_tail2_9 0 nch W=20u L=1u
Mu3_2_9 n_up2_9 n_up2_9 vdd vdd pch W=60u L=1u
Mu4_2_9 n_w2_9 n_up2_9 vdd vdd pch W=60u L=1u
* Synapse class=2, input=in10; n_w2_10 stores the learned weight.
Cw2_10 n_w2_10 0 1.67e-06
Mreset2_10 vweight reset n_w2_10 0 syn W=1000u L=1u
Mpos2_10 in10 n_w2_10 n_pos2 0 syn W=10u L=1u
Mneg2_10 in10 vweight n_neg2 0 syn W=10u L=1u
Menable2_10 n_gate2_10 learn 0 0 nch W=1000u L=1u
Mtail2_10 n_tail2_10 in10 n_gate2_10 0 nch W=20u L=1u
Mu1_2_10 n_up2_10 verror n_tail2_10 0 nch W=20u L=1u
Mu2_2_10 n_w2_10 n_error2 n_tail2_10 0 nch W=20u L=1u
Mu3_2_10 n_up2_10 n_up2_10 vdd vdd pch W=60u L=1u
Mu4_2_10 n_w2_10 n_up2_10 vdd vdd pch W=60u L=1u
* Synapse class=2, input=in11; n_w2_11 stores the learned weight.
Cw2_11 n_w2_11 0 1.67e-06
Mreset2_11 vweight reset n_w2_11 0 syn W=1000u L=1u
Mpos2_11 in11 n_w2_11 n_pos2 0 syn W=10u L=1u
Mneg2_11 in11 vweight n_neg2 0 syn W=10u L=1u
Menable2_11 n_gate2_11 learn 0 0 nch W=1000u L=1u
Mtail2_11 n_tail2_11 in11 n_gate2_11 0 nch W=20u L=1u
Mu1_2_11 n_up2_11 verror n_tail2_11 0 nch W=20u L=1u
Mu2_2_11 n_w2_11 n_error2 n_tail2_11 0 nch W=20u L=1u
Mu3_2_11 n_up2_11 n_up2_11 vdd vdd pch W=60u L=1u
Mu4_2_11 n_w2_11 n_up2_11 vdd vdd pch W=60u L=1u
* Synapse class=2, input=in12; n_w2_12 stores the learned weight.
Cw2_12 n_w2_12 0 1.67e-06
Mreset2_12 vweight reset n_w2_12 0 syn W=1000u L=1u
Mpos2_12 in12 n_w2_12 n_pos2 0 syn W=10u L=1u
Mneg2_12 in12 vweight n_neg2 0 syn W=10u L=1u
Menable2_12 n_gate2_12 learn 0 0 nch W=1000u L=1u
Mtail2_12 n_tail2_12 in12 n_gate2_12 0 nch W=20u L=1u
Mu1_2_12 n_up2_12 verror n_tail2_12 0 nch W=20u L=1u
Mu2_2_12 n_w2_12 n_error2 n_tail2_12 0 nch W=20u L=1u
Mu3_2_12 n_up2_12 n_up2_12 vdd vdd pch W=60u L=1u
Mu4_2_12 n_w2_12 n_up2_12 vdd vdd pch W=60u L=1u
* Synapse class=2, input=in13; n_w2_13 stores the learned weight.
Cw2_13 n_w2_13 0 1.67e-06
Mreset2_13 vweight reset n_w2_13 0 syn W=1000u L=1u
Mpos2_13 in13 n_w2_13 n_pos2 0 syn W=10u L=1u
Mneg2_13 in13 vweight n_neg2 0 syn W=10u L=1u
Menable2_13 n_gate2_13 learn 0 0 nch W=1000u L=1u
Mtail2_13 n_tail2_13 in13 n_gate2_13 0 nch W=20u L=1u
Mu1_2_13 n_up2_13 verror n_tail2_13 0 nch W=20u L=1u
Mu2_2_13 n_w2_13 n_error2 n_tail2_13 0 nch W=20u L=1u
Mu3_2_13 n_up2_13 n_up2_13 vdd vdd pch W=60u L=1u
Mu4_2_13 n_w2_13 n_up2_13 vdd vdd pch W=60u L=1u
* Synapse class=2, input=in14; n_w2_14 stores the learned weight.
Cw2_14 n_w2_14 0 1.67e-06
Mreset2_14 vweight reset n_w2_14 0 syn W=1000u L=1u
Mpos2_14 in14 n_w2_14 n_pos2 0 syn W=10u L=1u
Mneg2_14 in14 vweight n_neg2 0 syn W=10u L=1u
Menable2_14 n_gate2_14 learn 0 0 nch W=1000u L=1u
Mtail2_14 n_tail2_14 in14 n_gate2_14 0 nch W=20u L=1u
Mu1_2_14 n_up2_14 verror n_tail2_14 0 nch W=20u L=1u
Mu2_2_14 n_w2_14 n_error2 n_tail2_14 0 nch W=20u L=1u
Mu3_2_14 n_up2_14 n_up2_14 vdd vdd pch W=60u L=1u
Mu4_2_14 n_w2_14 n_up2_14 vdd vdd pch W=60u L=1u
* Synapse class=2, input=in15; n_w2_15 stores the learned weight.
Cw2_15 n_w2_15 0 1.67e-06
Mreset2_15 vweight reset n_w2_15 0 syn W=1000u L=1u
Mpos2_15 in15 n_w2_15 n_pos2 0 syn W=10u L=1u
Mneg2_15 in15 vweight n_neg2 0 syn W=10u L=1u
Menable2_15 n_gate2_15 learn 0 0 nch W=1000u L=1u
Mtail2_15 n_tail2_15 in15 n_gate2_15 0 nch W=20u L=1u
Mu1_2_15 n_up2_15 verror n_tail2_15 0 nch W=20u L=1u
Mu2_2_15 n_w2_15 n_error2 n_tail2_15 0 nch W=20u L=1u
Mu3_2_15 n_up2_15 n_up2_15 vdd vdd pch W=60u L=1u
Mu4_2_15 n_w2_15 n_up2_15 vdd vdd pch W=60u L=1u
* Synapse class=2, input=vbias; n_w2_16 stores the learned weight.
Cw2_16 n_w2_16 0 1.67e-06
Mreset2_16 vweight reset n_w2_16 0 syn W=1000u L=1u
Mpos2_16 vbias n_w2_16 n_pos2 0 syn W=10u L=1u
Mneg2_16 vbias vweight n_neg2 0 syn W=10u L=1u
Menable2_16 n_gate2_16 learn 0 0 nch W=1000u L=1u
Mtail2_16 n_tail2_16 vbias n_gate2_16 0 nch W=20u L=1u
Mu1_2_16 n_up2_16 verror n_tail2_16 0 nch W=20u L=1u
Mu2_2_16 n_w2_16 n_error2 n_tail2_16 0 nch W=20u L=1u
Mu3_2_16 n_up2_16 n_up2_16 vdd vdd pch W=60u L=1u
Mu4_2_16 n_w2_16 n_up2_16 vdd vdd pch W=60u L=1u
Ma3 n_neg3 n_neg3 0 0 nch W=20u L=1u
Mb3 out3 n_neg3 0 0 nch W=20u L=1u
Mc3 n_pos3 n_pos3 0 0 nch W=20u L=1u
Md3 n_mirror3 n_pos3 0 0 nch W=20u L=1u
Me3 n_mirror3 n_mirror3 vdd vdd pch W=60u L=1u
Mf3 out3 n_mirror3 vdd vdd pch W=60u L=1u
Mep3 n_error3 n_mirror3 vdd vdd pch W=60u L=1u
Men3 n_error3 n_neg3 0 0 nch W=20u L=1u
Moff3 n_error3 voffset vdd vdd pch W=10u L=1u
Mtarget3 n_error3 target3 0 0 nch W=10u L=1u
Rscore3 out3 vref 7k
Rerror3 n_error3 verror 7k
* Synapse class=3, input=in0; n_w3_0 stores the learned weight.
Cw3_0 n_w3_0 0 1.67e-06
Mreset3_0 vweight reset n_w3_0 0 syn W=1000u L=1u
Mpos3_0 in0 n_w3_0 n_pos3 0 syn W=10u L=1u
Mneg3_0 in0 vweight n_neg3 0 syn W=10u L=1u
Menable3_0 n_gate3_0 learn 0 0 nch W=1000u L=1u
Mtail3_0 n_tail3_0 in0 n_gate3_0 0 nch W=20u L=1u
Mu1_3_0 n_up3_0 verror n_tail3_0 0 nch W=20u L=1u
Mu2_3_0 n_w3_0 n_error3 n_tail3_0 0 nch W=20u L=1u
Mu3_3_0 n_up3_0 n_up3_0 vdd vdd pch W=60u L=1u
Mu4_3_0 n_w3_0 n_up3_0 vdd vdd pch W=60u L=1u
* Synapse class=3, input=in1; n_w3_1 stores the learned weight.
Cw3_1 n_w3_1 0 1.67e-06
Mreset3_1 vweight reset n_w3_1 0 syn W=1000u L=1u
Mpos3_1 in1 n_w3_1 n_pos3 0 syn W=10u L=1u
Mneg3_1 in1 vweight n_neg3 0 syn W=10u L=1u
Menable3_1 n_gate3_1 learn 0 0 nch W=1000u L=1u
Mtail3_1 n_tail3_1 in1 n_gate3_1 0 nch W=20u L=1u
Mu1_3_1 n_up3_1 verror n_tail3_1 0 nch W=20u L=1u
Mu2_3_1 n_w3_1 n_error3 n_tail3_1 0 nch W=20u L=1u
Mu3_3_1 n_up3_1 n_up3_1 vdd vdd pch W=60u L=1u
Mu4_3_1 n_w3_1 n_up3_1 vdd vdd pch W=60u L=1u
* Synapse class=3, input=in2; n_w3_2 stores the learned weight.
Cw3_2 n_w3_2 0 1.67e-06
Mreset3_2 vweight reset n_w3_2 0 syn W=1000u L=1u
Mpos3_2 in2 n_w3_2 n_pos3 0 syn W=10u L=1u
Mneg3_2 in2 vweight n_neg3 0 syn W=10u L=1u
Menable3_2 n_gate3_2 learn 0 0 nch W=1000u L=1u
Mtail3_2 n_tail3_2 in2 n_gate3_2 0 nch W=20u L=1u
Mu1_3_2 n_up3_2 verror n_tail3_2 0 nch W=20u L=1u
Mu2_3_2 n_w3_2 n_error3 n_tail3_2 0 nch W=20u L=1u
Mu3_3_2 n_up3_2 n_up3_2 vdd vdd pch W=60u L=1u
Mu4_3_2 n_w3_2 n_up3_2 vdd vdd pch W=60u L=1u
* Synapse class=3, input=in3; n_w3_3 stores the learned weight.
Cw3_3 n_w3_3 0 1.67e-06
Mreset3_3 vweight reset n_w3_3 0 syn W=1000u L=1u
Mpos3_3 in3 n_w3_3 n_pos3 0 syn W=10u L=1u
Mneg3_3 in3 vweight n_neg3 0 syn W=10u L=1u
Menable3_3 n_gate3_3 learn 0 0 nch W=1000u L=1u
Mtail3_3 n_tail3_3 in3 n_gate3_3 0 nch W=20u L=1u
Mu1_3_3 n_up3_3 verror n_tail3_3 0 nch W=20u L=1u
Mu2_3_3 n_w3_3 n_error3 n_tail3_3 0 nch W=20u L=1u
Mu3_3_3 n_up3_3 n_up3_3 vdd vdd pch W=60u L=1u
Mu4_3_3 n_w3_3 n_up3_3 vdd vdd pch W=60u L=1u
* Synapse class=3, input=in4; n_w3_4 stores the learned weight.
Cw3_4 n_w3_4 0 1.67e-06
Mreset3_4 vweight reset n_w3_4 0 syn W=1000u L=1u
Mpos3_4 in4 n_w3_4 n_pos3 0 syn W=10u L=1u
Mneg3_4 in4 vweight n_neg3 0 syn W=10u L=1u
Menable3_4 n_gate3_4 learn 0 0 nch W=1000u L=1u
Mtail3_4 n_tail3_4 in4 n_gate3_4 0 nch W=20u L=1u
Mu1_3_4 n_up3_4 verror n_tail3_4 0 nch W=20u L=1u
Mu2_3_4 n_w3_4 n_error3 n_tail3_4 0 nch W=20u L=1u
Mu3_3_4 n_up3_4 n_up3_4 vdd vdd pch W=60u L=1u
Mu4_3_4 n_w3_4 n_up3_4 vdd vdd pch W=60u L=1u
* Synapse class=3, input=in5; n_w3_5 stores the learned weight.
Cw3_5 n_w3_5 0 1.67e-06
Mreset3_5 vweight reset n_w3_5 0 syn W=1000u L=1u
Mpos3_5 in5 n_w3_5 n_pos3 0 syn W=10u L=1u
Mneg3_5 in5 vweight n_neg3 0 syn W=10u L=1u
Menable3_5 n_gate3_5 learn 0 0 nch W=1000u L=1u
Mtail3_5 n_tail3_5 in5 n_gate3_5 0 nch W=20u L=1u
Mu1_3_5 n_up3_5 verror n_tail3_5 0 nch W=20u L=1u
Mu2_3_5 n_w3_5 n_error3 n_tail3_5 0 nch W=20u L=1u
Mu3_3_5 n_up3_5 n_up3_5 vdd vdd pch W=60u L=1u
Mu4_3_5 n_w3_5 n_up3_5 vdd vdd pch W=60u L=1u
* Synapse class=3, input=in6; n_w3_6 stores the learned weight.
Cw3_6 n_w3_6 0 1.67e-06
Mreset3_6 vweight reset n_w3_6 0 syn W=1000u L=1u
Mpos3_6 in6 n_w3_6 n_pos3 0 syn W=10u L=1u
Mneg3_6 in6 vweight n_neg3 0 syn W=10u L=1u
Menable3_6 n_gate3_6 learn 0 0 nch W=1000u L=1u
Mtail3_6 n_tail3_6 in6 n_gate3_6 0 nch W=20u L=1u
Mu1_3_6 n_up3_6 verror n_tail3_6 0 nch W=20u L=1u
Mu2_3_6 n_w3_6 n_error3 n_tail3_6 0 nch W=20u L=1u
Mu3_3_6 n_up3_6 n_up3_6 vdd vdd pch W=60u L=1u
Mu4_3_6 n_w3_6 n_up3_6 vdd vdd pch W=60u L=1u
* Synapse class=3, input=in7; n_w3_7 stores the learned weight.
Cw3_7 n_w3_7 0 1.67e-06
Mreset3_7 vweight reset n_w3_7 0 syn W=1000u L=1u
Mpos3_7 in7 n_w3_7 n_pos3 0 syn W=10u L=1u
Mneg3_7 in7 vweight n_neg3 0 syn W=10u L=1u
Menable3_7 n_gate3_7 learn 0 0 nch W=1000u L=1u
Mtail3_7 n_tail3_7 in7 n_gate3_7 0 nch W=20u L=1u
Mu1_3_7 n_up3_7 verror n_tail3_7 0 nch W=20u L=1u
Mu2_3_7 n_w3_7 n_error3 n_tail3_7 0 nch W=20u L=1u
Mu3_3_7 n_up3_7 n_up3_7 vdd vdd pch W=60u L=1u
Mu4_3_7 n_w3_7 n_up3_7 vdd vdd pch W=60u L=1u
* Synapse class=3, input=in8; n_w3_8 stores the learned weight.
Cw3_8 n_w3_8 0 1.67e-06
Mreset3_8 vweight reset n_w3_8 0 syn W=1000u L=1u
Mpos3_8 in8 n_w3_8 n_pos3 0 syn W=10u L=1u
Mneg3_8 in8 vweight n_neg3 0 syn W=10u L=1u
Menable3_8 n_gate3_8 learn 0 0 nch W=1000u L=1u
Mtail3_8 n_tail3_8 in8 n_gate3_8 0 nch W=20u L=1u
Mu1_3_8 n_up3_8 verror n_tail3_8 0 nch W=20u L=1u
Mu2_3_8 n_w3_8 n_error3 n_tail3_8 0 nch W=20u L=1u
Mu3_3_8 n_up3_8 n_up3_8 vdd vdd pch W=60u L=1u
Mu4_3_8 n_w3_8 n_up3_8 vdd vdd pch W=60u L=1u
* Synapse class=3, input=in9; n_w3_9 stores the learned weight.
Cw3_9 n_w3_9 0 1.67e-06
Mreset3_9 vweight reset n_w3_9 0 syn W=1000u L=1u
Mpos3_9 in9 n_w3_9 n_pos3 0 syn W=10u L=1u
Mneg3_9 in9 vweight n_neg3 0 syn W=10u L=1u
Menable3_9 n_gate3_9 learn 0 0 nch W=1000u L=1u
Mtail3_9 n_tail3_9 in9 n_gate3_9 0 nch W=20u L=1u
Mu1_3_9 n_up3_9 verror n_tail3_9 0 nch W=20u L=1u
Mu2_3_9 n_w3_9 n_error3 n_tail3_9 0 nch W=20u L=1u
Mu3_3_9 n_up3_9 n_up3_9 vdd vdd pch W=60u L=1u
Mu4_3_9 n_w3_9 n_up3_9 vdd vdd pch W=60u L=1u
* Synapse class=3, input=in10; n_w3_10 stores the learned weight.
Cw3_10 n_w3_10 0 1.67e-06
Mreset3_10 vweight reset n_w3_10 0 syn W=1000u L=1u
Mpos3_10 in10 n_w3_10 n_pos3 0 syn W=10u L=1u
Mneg3_10 in10 vweight n_neg3 0 syn W=10u L=1u
Menable3_10 n_gate3_10 learn 0 0 nch W=1000u L=1u
Mtail3_10 n_tail3_10 in10 n_gate3_10 0 nch W=20u L=1u
Mu1_3_10 n_up3_10 verror n_tail3_10 0 nch W=20u L=1u
Mu2_3_10 n_w3_10 n_error3 n_tail3_10 0 nch W=20u L=1u
Mu3_3_10 n_up3_10 n_up3_10 vdd vdd pch W=60u L=1u
Mu4_3_10 n_w3_10 n_up3_10 vdd vdd pch W=60u L=1u
* Synapse class=3, input=in11; n_w3_11 stores the learned weight.
Cw3_11 n_w3_11 0 1.67e-06
Mreset3_11 vweight reset n_w3_11 0 syn W=1000u L=1u
Mpos3_11 in11 n_w3_11 n_pos3 0 syn W=10u L=1u
Mneg3_11 in11 vweight n_neg3 0 syn W=10u L=1u
Menable3_11 n_gate3_11 learn 0 0 nch W=1000u L=1u
Mtail3_11 n_tail3_11 in11 n_gate3_11 0 nch W=20u L=1u
Mu1_3_11 n_up3_11 verror n_tail3_11 0 nch W=20u L=1u
Mu2_3_11 n_w3_11 n_error3 n_tail3_11 0 nch W=20u L=1u
Mu3_3_11 n_up3_11 n_up3_11 vdd vdd pch W=60u L=1u
Mu4_3_11 n_w3_11 n_up3_11 vdd vdd pch W=60u L=1u
* Synapse class=3, input=in12; n_w3_12 stores the learned weight.
Cw3_12 n_w3_12 0 1.67e-06
Mreset3_12 vweight reset n_w3_12 0 syn W=1000u L=1u
Mpos3_12 in12 n_w3_12 n_pos3 0 syn W=10u L=1u
Mneg3_12 in12 vweight n_neg3 0 syn W=10u L=1u
Menable3_12 n_gate3_12 learn 0 0 nch W=1000u L=1u
Mtail3_12 n_tail3_12 in12 n_gate3_12 0 nch W=20u L=1u
Mu1_3_12 n_up3_12 verror n_tail3_12 0 nch W=20u L=1u
Mu2_3_12 n_w3_12 n_error3 n_tail3_12 0 nch W=20u L=1u
Mu3_3_12 n_up3_12 n_up3_12 vdd vdd pch W=60u L=1u
Mu4_3_12 n_w3_12 n_up3_12 vdd vdd pch W=60u L=1u
* Synapse class=3, input=in13; n_w3_13 stores the learned weight.
Cw3_13 n_w3_13 0 1.67e-06
Mreset3_13 vweight reset n_w3_13 0 syn W=1000u L=1u
Mpos3_13 in13 n_w3_13 n_pos3 0 syn W=10u L=1u
Mneg3_13 in13 vweight n_neg3 0 syn W=10u L=1u
Menable3_13 n_gate3_13 learn 0 0 nch W=1000u L=1u
Mtail3_13 n_tail3_13 in13 n_gate3_13 0 nch W=20u L=1u
Mu1_3_13 n_up3_13 verror n_tail3_13 0 nch W=20u L=1u
Mu2_3_13 n_w3_13 n_error3 n_tail3_13 0 nch W=20u L=1u
Mu3_3_13 n_up3_13 n_up3_13 vdd vdd pch W=60u L=1u
Mu4_3_13 n_w3_13 n_up3_13 vdd vdd pch W=60u L=1u
* Synapse class=3, input=in14; n_w3_14 stores the learned weight.
Cw3_14 n_w3_14 0 1.67e-06
Mreset3_14 vweight reset n_w3_14 0 syn W=1000u L=1u
Mpos3_14 in14 n_w3_14 n_pos3 0 syn W=10u L=1u
Mneg3_14 in14 vweight n_neg3 0 syn W=10u L=1u
Menable3_14 n_gate3_14 learn 0 0 nch W=1000u L=1u
Mtail3_14 n_tail3_14 in14 n_gate3_14 0 nch W=20u L=1u
Mu1_3_14 n_up3_14 verror n_tail3_14 0 nch W=20u L=1u
Mu2_3_14 n_w3_14 n_error3 n_tail3_14 0 nch W=20u L=1u
Mu3_3_14 n_up3_14 n_up3_14 vdd vdd pch W=60u L=1u
Mu4_3_14 n_w3_14 n_up3_14 vdd vdd pch W=60u L=1u
* Synapse class=3, input=in15; n_w3_15 stores the learned weight.
Cw3_15 n_w3_15 0 1.67e-06
Mreset3_15 vweight reset n_w3_15 0 syn W=1000u L=1u
Mpos3_15 in15 n_w3_15 n_pos3 0 syn W=10u L=1u
Mneg3_15 in15 vweight n_neg3 0 syn W=10u L=1u
Menable3_15 n_gate3_15 learn 0 0 nch W=1000u L=1u
Mtail3_15 n_tail3_15 in15 n_gate3_15 0 nch W=20u L=1u
Mu1_3_15 n_up3_15 verror n_tail3_15 0 nch W=20u L=1u
Mu2_3_15 n_w3_15 n_error3 n_tail3_15 0 nch W=20u L=1u
Mu3_3_15 n_up3_15 n_up3_15 vdd vdd pch W=60u L=1u
Mu4_3_15 n_w3_15 n_up3_15 vdd vdd pch W=60u L=1u
* Synapse class=3, input=vbias; n_w3_16 stores the learned weight.
Cw3_16 n_w3_16 0 1.67e-06
Mreset3_16 vweight reset n_w3_16 0 syn W=1000u L=1u
Mpos3_16 vbias n_w3_16 n_pos3 0 syn W=10u L=1u
Mneg3_16 vbias vweight n_neg3 0 syn W=10u L=1u
Menable3_16 n_gate3_16 learn 0 0 nch W=1000u L=1u
Mtail3_16 n_tail3_16 vbias n_gate3_16 0 nch W=20u L=1u
Mu1_3_16 n_up3_16 verror n_tail3_16 0 nch W=20u L=1u
Mu2_3_16 n_w3_16 n_error3 n_tail3_16 0 nch W=20u L=1u
Mu3_3_16 n_up3_16 n_up3_16 vdd vdd pch W=60u L=1u
Mu4_3_16 n_w3_16 n_up3_16 vdd vdd pch W=60u L=1u
Ma4 n_neg4 n_neg4 0 0 nch W=20u L=1u
Mb4 out4 n_neg4 0 0 nch W=20u L=1u
Mc4 n_pos4 n_pos4 0 0 nch W=20u L=1u
Md4 n_mirror4 n_pos4 0 0 nch W=20u L=1u
Me4 n_mirror4 n_mirror4 vdd vdd pch W=60u L=1u
Mf4 out4 n_mirror4 vdd vdd pch W=60u L=1u
Mep4 n_error4 n_mirror4 vdd vdd pch W=60u L=1u
Men4 n_error4 n_neg4 0 0 nch W=20u L=1u
Moff4 n_error4 voffset vdd vdd pch W=10u L=1u
Mtarget4 n_error4 target4 0 0 nch W=10u L=1u
Rscore4 out4 vref 7k
Rerror4 n_error4 verror 7k
* Synapse class=4, input=in0; n_w4_0 stores the learned weight.
Cw4_0 n_w4_0 0 1.67e-06
Mreset4_0 vweight reset n_w4_0 0 syn W=1000u L=1u
Mpos4_0 in0 n_w4_0 n_pos4 0 syn W=10u L=1u
Mneg4_0 in0 vweight n_neg4 0 syn W=10u L=1u
Menable4_0 n_gate4_0 learn 0 0 nch W=1000u L=1u
Mtail4_0 n_tail4_0 in0 n_gate4_0 0 nch W=20u L=1u
Mu1_4_0 n_up4_0 verror n_tail4_0 0 nch W=20u L=1u
Mu2_4_0 n_w4_0 n_error4 n_tail4_0 0 nch W=20u L=1u
Mu3_4_0 n_up4_0 n_up4_0 vdd vdd pch W=60u L=1u
Mu4_4_0 n_w4_0 n_up4_0 vdd vdd pch W=60u L=1u
* Synapse class=4, input=in1; n_w4_1 stores the learned weight.
Cw4_1 n_w4_1 0 1.67e-06
Mreset4_1 vweight reset n_w4_1 0 syn W=1000u L=1u
Mpos4_1 in1 n_w4_1 n_pos4 0 syn W=10u L=1u
Mneg4_1 in1 vweight n_neg4 0 syn W=10u L=1u
Menable4_1 n_gate4_1 learn 0 0 nch W=1000u L=1u
Mtail4_1 n_tail4_1 in1 n_gate4_1 0 nch W=20u L=1u
Mu1_4_1 n_up4_1 verror n_tail4_1 0 nch W=20u L=1u
Mu2_4_1 n_w4_1 n_error4 n_tail4_1 0 nch W=20u L=1u
Mu3_4_1 n_up4_1 n_up4_1 vdd vdd pch W=60u L=1u
Mu4_4_1 n_w4_1 n_up4_1 vdd vdd pch W=60u L=1u
* Synapse class=4, input=in2; n_w4_2 stores the learned weight.
Cw4_2 n_w4_2 0 1.67e-06
Mreset4_2 vweight reset n_w4_2 0 syn W=1000u L=1u
Mpos4_2 in2 n_w4_2 n_pos4 0 syn W=10u L=1u
Mneg4_2 in2 vweight n_neg4 0 syn W=10u L=1u
Menable4_2 n_gate4_2 learn 0 0 nch W=1000u L=1u
Mtail4_2 n_tail4_2 in2 n_gate4_2 0 nch W=20u L=1u
Mu1_4_2 n_up4_2 verror n_tail4_2 0 nch W=20u L=1u
Mu2_4_2 n_w4_2 n_error4 n_tail4_2 0 nch W=20u L=1u
Mu3_4_2 n_up4_2 n_up4_2 vdd vdd pch W=60u L=1u
Mu4_4_2 n_w4_2 n_up4_2 vdd vdd pch W=60u L=1u
* Synapse class=4, input=in3; n_w4_3 stores the learned weight.
Cw4_3 n_w4_3 0 1.67e-06
Mreset4_3 vweight reset n_w4_3 0 syn W=1000u L=1u
Mpos4_3 in3 n_w4_3 n_pos4 0 syn W=10u L=1u
Mneg4_3 in3 vweight n_neg4 0 syn W=10u L=1u
Menable4_3 n_gate4_3 learn 0 0 nch W=1000u L=1u
Mtail4_3 n_tail4_3 in3 n_gate4_3 0 nch W=20u L=1u
Mu1_4_3 n_up4_3 verror n_tail4_3 0 nch W=20u L=1u
Mu2_4_3 n_w4_3 n_error4 n_tail4_3 0 nch W=20u L=1u
Mu3_4_3 n_up4_3 n_up4_3 vdd vdd pch W=60u L=1u
Mu4_4_3 n_w4_3 n_up4_3 vdd vdd pch W=60u L=1u
* Synapse class=4, input=in4; n_w4_4 stores the learned weight.
Cw4_4 n_w4_4 0 1.67e-06
Mreset4_4 vweight reset n_w4_4 0 syn W=1000u L=1u
Mpos4_4 in4 n_w4_4 n_pos4 0 syn W=10u L=1u
Mneg4_4 in4 vweight n_neg4 0 syn W=10u L=1u
Menable4_4 n_gate4_4 learn 0 0 nch W=1000u L=1u
Mtail4_4 n_tail4_4 in4 n_gate4_4 0 nch W=20u L=1u
Mu1_4_4 n_up4_4 verror n_tail4_4 0 nch W=20u L=1u
Mu2_4_4 n_w4_4 n_error4 n_tail4_4 0 nch W=20u L=1u
Mu3_4_4 n_up4_4 n_up4_4 vdd vdd pch W=60u L=1u
Mu4_4_4 n_w4_4 n_up4_4 vdd vdd pch W=60u L=1u
* Synapse class=4, input=in5; n_w4_5 stores the learned weight.
Cw4_5 n_w4_5 0 1.67e-06
Mreset4_5 vweight reset n_w4_5 0 syn W=1000u L=1u
Mpos4_5 in5 n_w4_5 n_pos4 0 syn W=10u L=1u
Mneg4_5 in5 vweight n_neg4 0 syn W=10u L=1u
Menable4_5 n_gate4_5 learn 0 0 nch W=1000u L=1u
Mtail4_5 n_tail4_5 in5 n_gate4_5 0 nch W=20u L=1u
Mu1_4_5 n_up4_5 verror n_tail4_5 0 nch W=20u L=1u
Mu2_4_5 n_w4_5 n_error4 n_tail4_5 0 nch W=20u L=1u
Mu3_4_5 n_up4_5 n_up4_5 vdd vdd pch W=60u L=1u
Mu4_4_5 n_w4_5 n_up4_5 vdd vdd pch W=60u L=1u
* Synapse class=4, input=in6; n_w4_6 stores the learned weight.
Cw4_6 n_w4_6 0 1.67e-06
Mreset4_6 vweight reset n_w4_6 0 syn W=1000u L=1u
Mpos4_6 in6 n_w4_6 n_pos4 0 syn W=10u L=1u
Mneg4_6 in6 vweight n_neg4 0 syn W=10u L=1u
Menable4_6 n_gate4_6 learn 0 0 nch W=1000u L=1u
Mtail4_6 n_tail4_6 in6 n_gate4_6 0 nch W=20u L=1u
Mu1_4_6 n_up4_6 verror n_tail4_6 0 nch W=20u L=1u
Mu2_4_6 n_w4_6 n_error4 n_tail4_6 0 nch W=20u L=1u
Mu3_4_6 n_up4_6 n_up4_6 vdd vdd pch W=60u L=1u
Mu4_4_6 n_w4_6 n_up4_6 vdd vdd pch W=60u L=1u
* Synapse class=4, input=in7; n_w4_7 stores the learned weight.
Cw4_7 n_w4_7 0 1.67e-06
Mreset4_7 vweight reset n_w4_7 0 syn W=1000u L=1u
Mpos4_7 in7 n_w4_7 n_pos4 0 syn W=10u L=1u
Mneg4_7 in7 vweight n_neg4 0 syn W=10u L=1u
Menable4_7 n_gate4_7 learn 0 0 nch W=1000u L=1u
Mtail4_7 n_tail4_7 in7 n_gate4_7 0 nch W=20u L=1u
Mu1_4_7 n_up4_7 verror n_tail4_7 0 nch W=20u L=1u
Mu2_4_7 n_w4_7 n_error4 n_tail4_7 0 nch W=20u L=1u
Mu3_4_7 n_up4_7 n_up4_7 vdd vdd pch W=60u L=1u
Mu4_4_7 n_w4_7 n_up4_7 vdd vdd pch W=60u L=1u
* Synapse class=4, input=in8; n_w4_8 stores the learned weight.
Cw4_8 n_w4_8 0 1.67e-06
Mreset4_8 vweight reset n_w4_8 0 syn W=1000u L=1u
Mpos4_8 in8 n_w4_8 n_pos4 0 syn W=10u L=1u
Mneg4_8 in8 vweight n_neg4 0 syn W=10u L=1u
Menable4_8 n_gate4_8 learn 0 0 nch W=1000u L=1u
Mtail4_8 n_tail4_8 in8 n_gate4_8 0 nch W=20u L=1u
Mu1_4_8 n_up4_8 verror n_tail4_8 0 nch W=20u L=1u
Mu2_4_8 n_w4_8 n_error4 n_tail4_8 0 nch W=20u L=1u
Mu3_4_8 n_up4_8 n_up4_8 vdd vdd pch W=60u L=1u
Mu4_4_8 n_w4_8 n_up4_8 vdd vdd pch W=60u L=1u
* Synapse class=4, input=in9; n_w4_9 stores the learned weight.
Cw4_9 n_w4_9 0 1.67e-06
Mreset4_9 vweight reset n_w4_9 0 syn W=1000u L=1u
Mpos4_9 in9 n_w4_9 n_pos4 0 syn W=10u L=1u
Mneg4_9 in9 vweight n_neg4 0 syn W=10u L=1u
Menable4_9 n_gate4_9 learn 0 0 nch W=1000u L=1u
Mtail4_9 n_tail4_9 in9 n_gate4_9 0 nch W=20u L=1u
Mu1_4_9 n_up4_9 verror n_tail4_9 0 nch W=20u L=1u
Mu2_4_9 n_w4_9 n_error4 n_tail4_9 0 nch W=20u L=1u
Mu3_4_9 n_up4_9 n_up4_9 vdd vdd pch W=60u L=1u
Mu4_4_9 n_w4_9 n_up4_9 vdd vdd pch W=60u L=1u
* Synapse class=4, input=in10; n_w4_10 stores the learned weight.
Cw4_10 n_w4_10 0 1.67e-06
Mreset4_10 vweight reset n_w4_10 0 syn W=1000u L=1u
Mpos4_10 in10 n_w4_10 n_pos4 0 syn W=10u L=1u
Mneg4_10 in10 vweight n_neg4 0 syn W=10u L=1u
Menable4_10 n_gate4_10 learn 0 0 nch W=1000u L=1u
Mtail4_10 n_tail4_10 in10 n_gate4_10 0 nch W=20u L=1u
Mu1_4_10 n_up4_10 verror n_tail4_10 0 nch W=20u L=1u
Mu2_4_10 n_w4_10 n_error4 n_tail4_10 0 nch W=20u L=1u
Mu3_4_10 n_up4_10 n_up4_10 vdd vdd pch W=60u L=1u
Mu4_4_10 n_w4_10 n_up4_10 vdd vdd pch W=60u L=1u
* Synapse class=4, input=in11; n_w4_11 stores the learned weight.
Cw4_11 n_w4_11 0 1.67e-06
Mreset4_11 vweight reset n_w4_11 0 syn W=1000u L=1u
Mpos4_11 in11 n_w4_11 n_pos4 0 syn W=10u L=1u
Mneg4_11 in11 vweight n_neg4 0 syn W=10u L=1u
Menable4_11 n_gate4_11 learn 0 0 nch W=1000u L=1u
Mtail4_11 n_tail4_11 in11 n_gate4_11 0 nch W=20u L=1u
Mu1_4_11 n_up4_11 verror n_tail4_11 0 nch W=20u L=1u
Mu2_4_11 n_w4_11 n_error4 n_tail4_11 0 nch W=20u L=1u
Mu3_4_11 n_up4_11 n_up4_11 vdd vdd pch W=60u L=1u
Mu4_4_11 n_w4_11 n_up4_11 vdd vdd pch W=60u L=1u
* Synapse class=4, input=in12; n_w4_12 stores the learned weight.
Cw4_12 n_w4_12 0 1.67e-06
Mreset4_12 vweight reset n_w4_12 0 syn W=1000u L=1u
Mpos4_12 in12 n_w4_12 n_pos4 0 syn W=10u L=1u
Mneg4_12 in12 vweight n_neg4 0 syn W=10u L=1u
Menable4_12 n_gate4_12 learn 0 0 nch W=1000u L=1u
Mtail4_12 n_tail4_12 in12 n_gate4_12 0 nch W=20u L=1u
Mu1_4_12 n_up4_12 verror n_tail4_12 0 nch W=20u L=1u
Mu2_4_12 n_w4_12 n_error4 n_tail4_12 0 nch W=20u L=1u
Mu3_4_12 n_up4_12 n_up4_12 vdd vdd pch W=60u L=1u
Mu4_4_12 n_w4_12 n_up4_12 vdd vdd pch W=60u L=1u
* Synapse class=4, input=in13; n_w4_13 stores the learned weight.
Cw4_13 n_w4_13 0 1.67e-06
Mreset4_13 vweight reset n_w4_13 0 syn W=1000u L=1u
Mpos4_13 in13 n_w4_13 n_pos4 0 syn W=10u L=1u
Mneg4_13 in13 vweight n_neg4 0 syn W=10u L=1u
Menable4_13 n_gate4_13 learn 0 0 nch W=1000u L=1u
Mtail4_13 n_tail4_13 in13 n_gate4_13 0 nch W=20u L=1u
Mu1_4_13 n_up4_13 verror n_tail4_13 0 nch W=20u L=1u
Mu2_4_13 n_w4_13 n_error4 n_tail4_13 0 nch W=20u L=1u
Mu3_4_13 n_up4_13 n_up4_13 vdd vdd pch W=60u L=1u
Mu4_4_13 n_w4_13 n_up4_13 vdd vdd pch W=60u L=1u
* Synapse class=4, input=in14; n_w4_14 stores the learned weight.
Cw4_14 n_w4_14 0 1.67e-06
Mreset4_14 vweight reset n_w4_14 0 syn W=1000u L=1u
Mpos4_14 in14 n_w4_14 n_pos4 0 syn W=10u L=1u
Mneg4_14 in14 vweight n_neg4 0 syn W=10u L=1u
Menable4_14 n_gate4_14 learn 0 0 nch W=1000u L=1u
Mtail4_14 n_tail4_14 in14 n_gate4_14 0 nch W=20u L=1u
Mu1_4_14 n_up4_14 verror n_tail4_14 0 nch W=20u L=1u
Mu2_4_14 n_w4_14 n_error4 n_tail4_14 0 nch W=20u L=1u
Mu3_4_14 n_up4_14 n_up4_14 vdd vdd pch W=60u L=1u
Mu4_4_14 n_w4_14 n_up4_14 vdd vdd pch W=60u L=1u
* Synapse class=4, input=in15; n_w4_15 stores the learned weight.
Cw4_15 n_w4_15 0 1.67e-06
Mreset4_15 vweight reset n_w4_15 0 syn W=1000u L=1u
Mpos4_15 in15 n_w4_15 n_pos4 0 syn W=10u L=1u
Mneg4_15 in15 vweight n_neg4 0 syn W=10u L=1u
Menable4_15 n_gate4_15 learn 0 0 nch W=1000u L=1u
Mtail4_15 n_tail4_15 in15 n_gate4_15 0 nch W=20u L=1u
Mu1_4_15 n_up4_15 verror n_tail4_15 0 nch W=20u L=1u
Mu2_4_15 n_w4_15 n_error4 n_tail4_15 0 nch W=20u L=1u
Mu3_4_15 n_up4_15 n_up4_15 vdd vdd pch W=60u L=1u
Mu4_4_15 n_w4_15 n_up4_15 vdd vdd pch W=60u L=1u
* Synapse class=4, input=vbias; n_w4_16 stores the learned weight.
Cw4_16 n_w4_16 0 1.67e-06
Mreset4_16 vweight reset n_w4_16 0 syn W=1000u L=1u
Mpos4_16 vbias n_w4_16 n_pos4 0 syn W=10u L=1u
Mneg4_16 vbias vweight n_neg4 0 syn W=10u L=1u
Menable4_16 n_gate4_16 learn 0 0 nch W=1000u L=1u
Mtail4_16 n_tail4_16 vbias n_gate4_16 0 nch W=20u L=1u
Mu1_4_16 n_up4_16 verror n_tail4_16 0 nch W=20u L=1u
Mu2_4_16 n_w4_16 n_error4 n_tail4_16 0 nch W=20u L=1u
Mu3_4_16 n_up4_16 n_up4_16 vdd vdd pch W=60u L=1u
Mu4_4_16 n_w4_16 n_up4_16 vdd vdd pch W=60u L=1u
Ma5 n_neg5 n_neg5 0 0 nch W=20u L=1u
Mb5 out5 n_neg5 0 0 nch W=20u L=1u
Mc5 n_pos5 n_pos5 0 0 nch W=20u L=1u
Md5 n_mirror5 n_pos5 0 0 nch W=20u L=1u
Me5 n_mirror5 n_mirror5 vdd vdd pch W=60u L=1u
Mf5 out5 n_mirror5 vdd vdd pch W=60u L=1u
Mep5 n_error5 n_mirror5 vdd vdd pch W=60u L=1u
Men5 n_error5 n_neg5 0 0 nch W=20u L=1u
Moff5 n_error5 voffset vdd vdd pch W=10u L=1u
Mtarget5 n_error5 target5 0 0 nch W=10u L=1u
Rscore5 out5 vref 7k
Rerror5 n_error5 verror 7k
* Synapse class=5, input=in0; n_w5_0 stores the learned weight.
Cw5_0 n_w5_0 0 1.67e-06
Mreset5_0 vweight reset n_w5_0 0 syn W=1000u L=1u
Mpos5_0 in0 n_w5_0 n_pos5 0 syn W=10u L=1u
Mneg5_0 in0 vweight n_neg5 0 syn W=10u L=1u
Menable5_0 n_gate5_0 learn 0 0 nch W=1000u L=1u
Mtail5_0 n_tail5_0 in0 n_gate5_0 0 nch W=20u L=1u
Mu1_5_0 n_up5_0 verror n_tail5_0 0 nch W=20u L=1u
Mu2_5_0 n_w5_0 n_error5 n_tail5_0 0 nch W=20u L=1u
Mu3_5_0 n_up5_0 n_up5_0 vdd vdd pch W=60u L=1u
Mu4_5_0 n_w5_0 n_up5_0 vdd vdd pch W=60u L=1u
* Synapse class=5, input=in1; n_w5_1 stores the learned weight.
Cw5_1 n_w5_1 0 1.67e-06
Mreset5_1 vweight reset n_w5_1 0 syn W=1000u L=1u
Mpos5_1 in1 n_w5_1 n_pos5 0 syn W=10u L=1u
Mneg5_1 in1 vweight n_neg5 0 syn W=10u L=1u
Menable5_1 n_gate5_1 learn 0 0 nch W=1000u L=1u
Mtail5_1 n_tail5_1 in1 n_gate5_1 0 nch W=20u L=1u
Mu1_5_1 n_up5_1 verror n_tail5_1 0 nch W=20u L=1u
Mu2_5_1 n_w5_1 n_error5 n_tail5_1 0 nch W=20u L=1u
Mu3_5_1 n_up5_1 n_up5_1 vdd vdd pch W=60u L=1u
Mu4_5_1 n_w5_1 n_up5_1 vdd vdd pch W=60u L=1u
* Synapse class=5, input=in2; n_w5_2 stores the learned weight.
Cw5_2 n_w5_2 0 1.67e-06
Mreset5_2 vweight reset n_w5_2 0 syn W=1000u L=1u
Mpos5_2 in2 n_w5_2 n_pos5 0 syn W=10u L=1u
Mneg5_2 in2 vweight n_neg5 0 syn W=10u L=1u
Menable5_2 n_gate5_2 learn 0 0 nch W=1000u L=1u
Mtail5_2 n_tail5_2 in2 n_gate5_2 0 nch W=20u L=1u
Mu1_5_2 n_up5_2 verror n_tail5_2 0 nch W=20u L=1u
Mu2_5_2 n_w5_2 n_error5 n_tail5_2 0 nch W=20u L=1u
Mu3_5_2 n_up5_2 n_up5_2 vdd vdd pch W=60u L=1u
Mu4_5_2 n_w5_2 n_up5_2 vdd vdd pch W=60u L=1u
* Synapse class=5, input=in3; n_w5_3 stores the learned weight.
Cw5_3 n_w5_3 0 1.67e-06
Mreset5_3 vweight reset n_w5_3 0 syn W=1000u L=1u
Mpos5_3 in3 n_w5_3 n_pos5 0 syn W=10u L=1u
Mneg5_3 in3 vweight n_neg5 0 syn W=10u L=1u
Menable5_3 n_gate5_3 learn 0 0 nch W=1000u L=1u
Mtail5_3 n_tail5_3 in3 n_gate5_3 0 nch W=20u L=1u
Mu1_5_3 n_up5_3 verror n_tail5_3 0 nch W=20u L=1u
Mu2_5_3 n_w5_3 n_error5 n_tail5_3 0 nch W=20u L=1u
Mu3_5_3 n_up5_3 n_up5_3 vdd vdd pch W=60u L=1u
Mu4_5_3 n_w5_3 n_up5_3 vdd vdd pch W=60u L=1u
* Synapse class=5, input=in4; n_w5_4 stores the learned weight.
Cw5_4 n_w5_4 0 1.67e-06
Mreset5_4 vweight reset n_w5_4 0 syn W=1000u L=1u
Mpos5_4 in4 n_w5_4 n_pos5 0 syn W=10u L=1u
Mneg5_4 in4 vweight n_neg5 0 syn W=10u L=1u
Menable5_4 n_gate5_4 learn 0 0 nch W=1000u L=1u
Mtail5_4 n_tail5_4 in4 n_gate5_4 0 nch W=20u L=1u
Mu1_5_4 n_up5_4 verror n_tail5_4 0 nch W=20u L=1u
Mu2_5_4 n_w5_4 n_error5 n_tail5_4 0 nch W=20u L=1u
Mu3_5_4 n_up5_4 n_up5_4 vdd vdd pch W=60u L=1u
Mu4_5_4 n_w5_4 n_up5_4 vdd vdd pch W=60u L=1u
* Synapse class=5, input=in5; n_w5_5 stores the learned weight.
Cw5_5 n_w5_5 0 1.67e-06
Mreset5_5 vweight reset n_w5_5 0 syn W=1000u L=1u
Mpos5_5 in5 n_w5_5 n_pos5 0 syn W=10u L=1u
Mneg5_5 in5 vweight n_neg5 0 syn W=10u L=1u
Menable5_5 n_gate5_5 learn 0 0 nch W=1000u L=1u
Mtail5_5 n_tail5_5 in5 n_gate5_5 0 nch W=20u L=1u
Mu1_5_5 n_up5_5 verror n_tail5_5 0 nch W=20u L=1u
Mu2_5_5 n_w5_5 n_error5 n_tail5_5 0 nch W=20u L=1u
Mu3_5_5 n_up5_5 n_up5_5 vdd vdd pch W=60u L=1u
Mu4_5_5 n_w5_5 n_up5_5 vdd vdd pch W=60u L=1u
* Synapse class=5, input=in6; n_w5_6 stores the learned weight.
Cw5_6 n_w5_6 0 1.67e-06
Mreset5_6 vweight reset n_w5_6 0 syn W=1000u L=1u
Mpos5_6 in6 n_w5_6 n_pos5 0 syn W=10u L=1u
Mneg5_6 in6 vweight n_neg5 0 syn W=10u L=1u
Menable5_6 n_gate5_6 learn 0 0 nch W=1000u L=1u
Mtail5_6 n_tail5_6 in6 n_gate5_6 0 nch W=20u L=1u
Mu1_5_6 n_up5_6 verror n_tail5_6 0 nch W=20u L=1u
Mu2_5_6 n_w5_6 n_error5 n_tail5_6 0 nch W=20u L=1u
Mu3_5_6 n_up5_6 n_up5_6 vdd vdd pch W=60u L=1u
Mu4_5_6 n_w5_6 n_up5_6 vdd vdd pch W=60u L=1u
* Synapse class=5, input=in7; n_w5_7 stores the learned weight.
Cw5_7 n_w5_7 0 1.67e-06
Mreset5_7 vweight reset n_w5_7 0 syn W=1000u L=1u
Mpos5_7 in7 n_w5_7 n_pos5 0 syn W=10u L=1u
Mneg5_7 in7 vweight n_neg5 0 syn W=10u L=1u
Menable5_7 n_gate5_7 learn 0 0 nch W=1000u L=1u
Mtail5_7 n_tail5_7 in7 n_gate5_7 0 nch W=20u L=1u
Mu1_5_7 n_up5_7 verror n_tail5_7 0 nch W=20u L=1u
Mu2_5_7 n_w5_7 n_error5 n_tail5_7 0 nch W=20u L=1u
Mu3_5_7 n_up5_7 n_up5_7 vdd vdd pch W=60u L=1u
Mu4_5_7 n_w5_7 n_up5_7 vdd vdd pch W=60u L=1u
* Synapse class=5, input=in8; n_w5_8 stores the learned weight.
Cw5_8 n_w5_8 0 1.67e-06
Mreset5_8 vweight reset n_w5_8 0 syn W=1000u L=1u
Mpos5_8 in8 n_w5_8 n_pos5 0 syn W=10u L=1u
Mneg5_8 in8 vweight n_neg5 0 syn W=10u L=1u
Menable5_8 n_gate5_8 learn 0 0 nch W=1000u L=1u
Mtail5_8 n_tail5_8 in8 n_gate5_8 0 nch W=20u L=1u
Mu1_5_8 n_up5_8 verror n_tail5_8 0 nch W=20u L=1u
Mu2_5_8 n_w5_8 n_error5 n_tail5_8 0 nch W=20u L=1u
Mu3_5_8 n_up5_8 n_up5_8 vdd vdd pch W=60u L=1u
Mu4_5_8 n_w5_8 n_up5_8 vdd vdd pch W=60u L=1u
* Synapse class=5, input=in9; n_w5_9 stores the learned weight.
Cw5_9 n_w5_9 0 1.67e-06
Mreset5_9 vweight reset n_w5_9 0 syn W=1000u L=1u
Mpos5_9 in9 n_w5_9 n_pos5 0 syn W=10u L=1u
Mneg5_9 in9 vweight n_neg5 0 syn W=10u L=1u
Menable5_9 n_gate5_9 learn 0 0 nch W=1000u L=1u
Mtail5_9 n_tail5_9 in9 n_gate5_9 0 nch W=20u L=1u
Mu1_5_9 n_up5_9 verror n_tail5_9 0 nch W=20u L=1u
Mu2_5_9 n_w5_9 n_error5 n_tail5_9 0 nch W=20u L=1u
Mu3_5_9 n_up5_9 n_up5_9 vdd vdd pch W=60u L=1u
Mu4_5_9 n_w5_9 n_up5_9 vdd vdd pch W=60u L=1u
* Synapse class=5, input=in10; n_w5_10 stores the learned weight.
Cw5_10 n_w5_10 0 1.67e-06
Mreset5_10 vweight reset n_w5_10 0 syn W=1000u L=1u
Mpos5_10 in10 n_w5_10 n_pos5 0 syn W=10u L=1u
Mneg5_10 in10 vweight n_neg5 0 syn W=10u L=1u
Menable5_10 n_gate5_10 learn 0 0 nch W=1000u L=1u
Mtail5_10 n_tail5_10 in10 n_gate5_10 0 nch W=20u L=1u
Mu1_5_10 n_up5_10 verror n_tail5_10 0 nch W=20u L=1u
Mu2_5_10 n_w5_10 n_error5 n_tail5_10 0 nch W=20u L=1u
Mu3_5_10 n_up5_10 n_up5_10 vdd vdd pch W=60u L=1u
Mu4_5_10 n_w5_10 n_up5_10 vdd vdd pch W=60u L=1u
* Synapse class=5, input=in11; n_w5_11 stores the learned weight.
Cw5_11 n_w5_11 0 1.67e-06
Mreset5_11 vweight reset n_w5_11 0 syn W=1000u L=1u
Mpos5_11 in11 n_w5_11 n_pos5 0 syn W=10u L=1u
Mneg5_11 in11 vweight n_neg5 0 syn W=10u L=1u
Menable5_11 n_gate5_11 learn 0 0 nch W=1000u L=1u
Mtail5_11 n_tail5_11 in11 n_gate5_11 0 nch W=20u L=1u
Mu1_5_11 n_up5_11 verror n_tail5_11 0 nch W=20u L=1u
Mu2_5_11 n_w5_11 n_error5 n_tail5_11 0 nch W=20u L=1u
Mu3_5_11 n_up5_11 n_up5_11 vdd vdd pch W=60u L=1u
Mu4_5_11 n_w5_11 n_up5_11 vdd vdd pch W=60u L=1u
* Synapse class=5, input=in12; n_w5_12 stores the learned weight.
Cw5_12 n_w5_12 0 1.67e-06
Mreset5_12 vweight reset n_w5_12 0 syn W=1000u L=1u
Mpos5_12 in12 n_w5_12 n_pos5 0 syn W=10u L=1u
Mneg5_12 in12 vweight n_neg5 0 syn W=10u L=1u
Menable5_12 n_gate5_12 learn 0 0 nch W=1000u L=1u
Mtail5_12 n_tail5_12 in12 n_gate5_12 0 nch W=20u L=1u
Mu1_5_12 n_up5_12 verror n_tail5_12 0 nch W=20u L=1u
Mu2_5_12 n_w5_12 n_error5 n_tail5_12 0 nch W=20u L=1u
Mu3_5_12 n_up5_12 n_up5_12 vdd vdd pch W=60u L=1u
Mu4_5_12 n_w5_12 n_up5_12 vdd vdd pch W=60u L=1u
* Synapse class=5, input=in13; n_w5_13 stores the learned weight.
Cw5_13 n_w5_13 0 1.67e-06
Mreset5_13 vweight reset n_w5_13 0 syn W=1000u L=1u
Mpos5_13 in13 n_w5_13 n_pos5 0 syn W=10u L=1u
Mneg5_13 in13 vweight n_neg5 0 syn W=10u L=1u
Menable5_13 n_gate5_13 learn 0 0 nch W=1000u L=1u
Mtail5_13 n_tail5_13 in13 n_gate5_13 0 nch W=20u L=1u
Mu1_5_13 n_up5_13 verror n_tail5_13 0 nch W=20u L=1u
Mu2_5_13 n_w5_13 n_error5 n_tail5_13 0 nch W=20u L=1u
Mu3_5_13 n_up5_13 n_up5_13 vdd vdd pch W=60u L=1u
Mu4_5_13 n_w5_13 n_up5_13 vdd vdd pch W=60u L=1u
* Synapse class=5, input=in14; n_w5_14 stores the learned weight.
Cw5_14 n_w5_14 0 1.67e-06
Mreset5_14 vweight reset n_w5_14 0 syn W=1000u L=1u
Mpos5_14 in14 n_w5_14 n_pos5 0 syn W=10u L=1u
Mneg5_14 in14 vweight n_neg5 0 syn W=10u L=1u
Menable5_14 n_gate5_14 learn 0 0 nch W=1000u L=1u
Mtail5_14 n_tail5_14 in14 n_gate5_14 0 nch W=20u L=1u
Mu1_5_14 n_up5_14 verror n_tail5_14 0 nch W=20u L=1u
Mu2_5_14 n_w5_14 n_error5 n_tail5_14 0 nch W=20u L=1u
Mu3_5_14 n_up5_14 n_up5_14 vdd vdd pch W=60u L=1u
Mu4_5_14 n_w5_14 n_up5_14 vdd vdd pch W=60u L=1u
* Synapse class=5, input=in15; n_w5_15 stores the learned weight.
Cw5_15 n_w5_15 0 1.67e-06
Mreset5_15 vweight reset n_w5_15 0 syn W=1000u L=1u
Mpos5_15 in15 n_w5_15 n_pos5 0 syn W=10u L=1u
Mneg5_15 in15 vweight n_neg5 0 syn W=10u L=1u
Menable5_15 n_gate5_15 learn 0 0 nch W=1000u L=1u
Mtail5_15 n_tail5_15 in15 n_gate5_15 0 nch W=20u L=1u
Mu1_5_15 n_up5_15 verror n_tail5_15 0 nch W=20u L=1u
Mu2_5_15 n_w5_15 n_error5 n_tail5_15 0 nch W=20u L=1u
Mu3_5_15 n_up5_15 n_up5_15 vdd vdd pch W=60u L=1u
Mu4_5_15 n_w5_15 n_up5_15 vdd vdd pch W=60u L=1u
* Synapse class=5, input=vbias; n_w5_16 stores the learned weight.
Cw5_16 n_w5_16 0 1.67e-06
Mreset5_16 vweight reset n_w5_16 0 syn W=1000u L=1u
Mpos5_16 vbias n_w5_16 n_pos5 0 syn W=10u L=1u
Mneg5_16 vbias vweight n_neg5 0 syn W=10u L=1u
Menable5_16 n_gate5_16 learn 0 0 nch W=1000u L=1u
Mtail5_16 n_tail5_16 vbias n_gate5_16 0 nch W=20u L=1u
Mu1_5_16 n_up5_16 verror n_tail5_16 0 nch W=20u L=1u
Mu2_5_16 n_w5_16 n_error5 n_tail5_16 0 nch W=20u L=1u
Mu3_5_16 n_up5_16 n_up5_16 vdd vdd pch W=60u L=1u
Mu4_5_16 n_w5_16 n_up5_16 vdd vdd pch W=60u L=1u
Ma6 n_neg6 n_neg6 0 0 nch W=20u L=1u
Mb6 out6 n_neg6 0 0 nch W=20u L=1u
Mc6 n_pos6 n_pos6 0 0 nch W=20u L=1u
Md6 n_mirror6 n_pos6 0 0 nch W=20u L=1u
Me6 n_mirror6 n_mirror6 vdd vdd pch W=60u L=1u
Mf6 out6 n_mirror6 vdd vdd pch W=60u L=1u
Mep6 n_error6 n_mirror6 vdd vdd pch W=60u L=1u
Men6 n_error6 n_neg6 0 0 nch W=20u L=1u
Moff6 n_error6 voffset vdd vdd pch W=10u L=1u
Mtarget6 n_error6 target6 0 0 nch W=10u L=1u
Rscore6 out6 vref 7k
Rerror6 n_error6 verror 7k
* Synapse class=6, input=in0; n_w6_0 stores the learned weight.
Cw6_0 n_w6_0 0 1.67e-06
Mreset6_0 vweight reset n_w6_0 0 syn W=1000u L=1u
Mpos6_0 in0 n_w6_0 n_pos6 0 syn W=10u L=1u
Mneg6_0 in0 vweight n_neg6 0 syn W=10u L=1u
Menable6_0 n_gate6_0 learn 0 0 nch W=1000u L=1u
Mtail6_0 n_tail6_0 in0 n_gate6_0 0 nch W=20u L=1u
Mu1_6_0 n_up6_0 verror n_tail6_0 0 nch W=20u L=1u
Mu2_6_0 n_w6_0 n_error6 n_tail6_0 0 nch W=20u L=1u
Mu3_6_0 n_up6_0 n_up6_0 vdd vdd pch W=60u L=1u
Mu4_6_0 n_w6_0 n_up6_0 vdd vdd pch W=60u L=1u
* Synapse class=6, input=in1; n_w6_1 stores the learned weight.
Cw6_1 n_w6_1 0 1.67e-06
Mreset6_1 vweight reset n_w6_1 0 syn W=1000u L=1u
Mpos6_1 in1 n_w6_1 n_pos6 0 syn W=10u L=1u
Mneg6_1 in1 vweight n_neg6 0 syn W=10u L=1u
Menable6_1 n_gate6_1 learn 0 0 nch W=1000u L=1u
Mtail6_1 n_tail6_1 in1 n_gate6_1 0 nch W=20u L=1u
Mu1_6_1 n_up6_1 verror n_tail6_1 0 nch W=20u L=1u
Mu2_6_1 n_w6_1 n_error6 n_tail6_1 0 nch W=20u L=1u
Mu3_6_1 n_up6_1 n_up6_1 vdd vdd pch W=60u L=1u
Mu4_6_1 n_w6_1 n_up6_1 vdd vdd pch W=60u L=1u
* Synapse class=6, input=in2; n_w6_2 stores the learned weight.
Cw6_2 n_w6_2 0 1.67e-06
Mreset6_2 vweight reset n_w6_2 0 syn W=1000u L=1u
Mpos6_2 in2 n_w6_2 n_pos6 0 syn W=10u L=1u
Mneg6_2 in2 vweight n_neg6 0 syn W=10u L=1u
Menable6_2 n_gate6_2 learn 0 0 nch W=1000u L=1u
Mtail6_2 n_tail6_2 in2 n_gate6_2 0 nch W=20u L=1u
Mu1_6_2 n_up6_2 verror n_tail6_2 0 nch W=20u L=1u
Mu2_6_2 n_w6_2 n_error6 n_tail6_2 0 nch W=20u L=1u
Mu3_6_2 n_up6_2 n_up6_2 vdd vdd pch W=60u L=1u
Mu4_6_2 n_w6_2 n_up6_2 vdd vdd pch W=60u L=1u
* Synapse class=6, input=in3; n_w6_3 stores the learned weight.
Cw6_3 n_w6_3 0 1.67e-06
Mreset6_3 vweight reset n_w6_3 0 syn W=1000u L=1u
Mpos6_3 in3 n_w6_3 n_pos6 0 syn W=10u L=1u
Mneg6_3 in3 vweight n_neg6 0 syn W=10u L=1u
Menable6_3 n_gate6_3 learn 0 0 nch W=1000u L=1u
Mtail6_3 n_tail6_3 in3 n_gate6_3 0 nch W=20u L=1u
Mu1_6_3 n_up6_3 verror n_tail6_3 0 nch W=20u L=1u
Mu2_6_3 n_w6_3 n_error6 n_tail6_3 0 nch W=20u L=1u
Mu3_6_3 n_up6_3 n_up6_3 vdd vdd pch W=60u L=1u
Mu4_6_3 n_w6_3 n_up6_3 vdd vdd pch W=60u L=1u
* Synapse class=6, input=in4; n_w6_4 stores the learned weight.
Cw6_4 n_w6_4 0 1.67e-06
Mreset6_4 vweight reset n_w6_4 0 syn W=1000u L=1u
Mpos6_4 in4 n_w6_4 n_pos6 0 syn W=10u L=1u
Mneg6_4 in4 vweight n_neg6 0 syn W=10u L=1u
Menable6_4 n_gate6_4 learn 0 0 nch W=1000u L=1u
Mtail6_4 n_tail6_4 in4 n_gate6_4 0 nch W=20u L=1u
Mu1_6_4 n_up6_4 verror n_tail6_4 0 nch W=20u L=1u
Mu2_6_4 n_w6_4 n_error6 n_tail6_4 0 nch W=20u L=1u
Mu3_6_4 n_up6_4 n_up6_4 vdd vdd pch W=60u L=1u
Mu4_6_4 n_w6_4 n_up6_4 vdd vdd pch W=60u L=1u
* Synapse class=6, input=in5; n_w6_5 stores the learned weight.
Cw6_5 n_w6_5 0 1.67e-06
Mreset6_5 vweight reset n_w6_5 0 syn W=1000u L=1u
Mpos6_5 in5 n_w6_5 n_pos6 0 syn W=10u L=1u
Mneg6_5 in5 vweight n_neg6 0 syn W=10u L=1u
Menable6_5 n_gate6_5 learn 0 0 nch W=1000u L=1u
Mtail6_5 n_tail6_5 in5 n_gate6_5 0 nch W=20u L=1u
Mu1_6_5 n_up6_5 verror n_tail6_5 0 nch W=20u L=1u
Mu2_6_5 n_w6_5 n_error6 n_tail6_5 0 nch W=20u L=1u
Mu3_6_5 n_up6_5 n_up6_5 vdd vdd pch W=60u L=1u
Mu4_6_5 n_w6_5 n_up6_5 vdd vdd pch W=60u L=1u
* Synapse class=6, input=in6; n_w6_6 stores the learned weight.
Cw6_6 n_w6_6 0 1.67e-06
Mreset6_6 vweight reset n_w6_6 0 syn W=1000u L=1u
Mpos6_6 in6 n_w6_6 n_pos6 0 syn W=10u L=1u
Mneg6_6 in6 vweight n_neg6 0 syn W=10u L=1u
Menable6_6 n_gate6_6 learn 0 0 nch W=1000u L=1u
Mtail6_6 n_tail6_6 in6 n_gate6_6 0 nch W=20u L=1u
Mu1_6_6 n_up6_6 verror n_tail6_6 0 nch W=20u L=1u
Mu2_6_6 n_w6_6 n_error6 n_tail6_6 0 nch W=20u L=1u
Mu3_6_6 n_up6_6 n_up6_6 vdd vdd pch W=60u L=1u
Mu4_6_6 n_w6_6 n_up6_6 vdd vdd pch W=60u L=1u
* Synapse class=6, input=in7; n_w6_7 stores the learned weight.
Cw6_7 n_w6_7 0 1.67e-06
Mreset6_7 vweight reset n_w6_7 0 syn W=1000u L=1u
Mpos6_7 in7 n_w6_7 n_pos6 0 syn W=10u L=1u
Mneg6_7 in7 vweight n_neg6 0 syn W=10u L=1u
Menable6_7 n_gate6_7 learn 0 0 nch W=1000u L=1u
Mtail6_7 n_tail6_7 in7 n_gate6_7 0 nch W=20u L=1u
Mu1_6_7 n_up6_7 verror n_tail6_7 0 nch W=20u L=1u
Mu2_6_7 n_w6_7 n_error6 n_tail6_7 0 nch W=20u L=1u
Mu3_6_7 n_up6_7 n_up6_7 vdd vdd pch W=60u L=1u
Mu4_6_7 n_w6_7 n_up6_7 vdd vdd pch W=60u L=1u
* Synapse class=6, input=in8; n_w6_8 stores the learned weight.
Cw6_8 n_w6_8 0 1.67e-06
Mreset6_8 vweight reset n_w6_8 0 syn W=1000u L=1u
Mpos6_8 in8 n_w6_8 n_pos6 0 syn W=10u L=1u
Mneg6_8 in8 vweight n_neg6 0 syn W=10u L=1u
Menable6_8 n_gate6_8 learn 0 0 nch W=1000u L=1u
Mtail6_8 n_tail6_8 in8 n_gate6_8 0 nch W=20u L=1u
Mu1_6_8 n_up6_8 verror n_tail6_8 0 nch W=20u L=1u
Mu2_6_8 n_w6_8 n_error6 n_tail6_8 0 nch W=20u L=1u
Mu3_6_8 n_up6_8 n_up6_8 vdd vdd pch W=60u L=1u
Mu4_6_8 n_w6_8 n_up6_8 vdd vdd pch W=60u L=1u
* Synapse class=6, input=in9; n_w6_9 stores the learned weight.
Cw6_9 n_w6_9 0 1.67e-06
Mreset6_9 vweight reset n_w6_9 0 syn W=1000u L=1u
Mpos6_9 in9 n_w6_9 n_pos6 0 syn W=10u L=1u
Mneg6_9 in9 vweight n_neg6 0 syn W=10u L=1u
Menable6_9 n_gate6_9 learn 0 0 nch W=1000u L=1u
Mtail6_9 n_tail6_9 in9 n_gate6_9 0 nch W=20u L=1u
Mu1_6_9 n_up6_9 verror n_tail6_9 0 nch W=20u L=1u
Mu2_6_9 n_w6_9 n_error6 n_tail6_9 0 nch W=20u L=1u
Mu3_6_9 n_up6_9 n_up6_9 vdd vdd pch W=60u L=1u
Mu4_6_9 n_w6_9 n_up6_9 vdd vdd pch W=60u L=1u
* Synapse class=6, input=in10; n_w6_10 stores the learned weight.
Cw6_10 n_w6_10 0 1.67e-06
Mreset6_10 vweight reset n_w6_10 0 syn W=1000u L=1u
Mpos6_10 in10 n_w6_10 n_pos6 0 syn W=10u L=1u
Mneg6_10 in10 vweight n_neg6 0 syn W=10u L=1u
Menable6_10 n_gate6_10 learn 0 0 nch W=1000u L=1u
Mtail6_10 n_tail6_10 in10 n_gate6_10 0 nch W=20u L=1u
Mu1_6_10 n_up6_10 verror n_tail6_10 0 nch W=20u L=1u
Mu2_6_10 n_w6_10 n_error6 n_tail6_10 0 nch W=20u L=1u
Mu3_6_10 n_up6_10 n_up6_10 vdd vdd pch W=60u L=1u
Mu4_6_10 n_w6_10 n_up6_10 vdd vdd pch W=60u L=1u
* Synapse class=6, input=in11; n_w6_11 stores the learned weight.
Cw6_11 n_w6_11 0 1.67e-06
Mreset6_11 vweight reset n_w6_11 0 syn W=1000u L=1u
Mpos6_11 in11 n_w6_11 n_pos6 0 syn W=10u L=1u
Mneg6_11 in11 vweight n_neg6 0 syn W=10u L=1u
Menable6_11 n_gate6_11 learn 0 0 nch W=1000u L=1u
Mtail6_11 n_tail6_11 in11 n_gate6_11 0 nch W=20u L=1u
Mu1_6_11 n_up6_11 verror n_tail6_11 0 nch W=20u L=1u
Mu2_6_11 n_w6_11 n_error6 n_tail6_11 0 nch W=20u L=1u
Mu3_6_11 n_up6_11 n_up6_11 vdd vdd pch W=60u L=1u
Mu4_6_11 n_w6_11 n_up6_11 vdd vdd pch W=60u L=1u
* Synapse class=6, input=in12; n_w6_12 stores the learned weight.
Cw6_12 n_w6_12 0 1.67e-06
Mreset6_12 vweight reset n_w6_12 0 syn W=1000u L=1u
Mpos6_12 in12 n_w6_12 n_pos6 0 syn W=10u L=1u
Mneg6_12 in12 vweight n_neg6 0 syn W=10u L=1u
Menable6_12 n_gate6_12 learn 0 0 nch W=1000u L=1u
Mtail6_12 n_tail6_12 in12 n_gate6_12 0 nch W=20u L=1u
Mu1_6_12 n_up6_12 verror n_tail6_12 0 nch W=20u L=1u
Mu2_6_12 n_w6_12 n_error6 n_tail6_12 0 nch W=20u L=1u
Mu3_6_12 n_up6_12 n_up6_12 vdd vdd pch W=60u L=1u
Mu4_6_12 n_w6_12 n_up6_12 vdd vdd pch W=60u L=1u
* Synapse class=6, input=in13; n_w6_13 stores the learned weight.
Cw6_13 n_w6_13 0 1.67e-06
Mreset6_13 vweight reset n_w6_13 0 syn W=1000u L=1u
Mpos6_13 in13 n_w6_13 n_pos6 0 syn W=10u L=1u
Mneg6_13 in13 vweight n_neg6 0 syn W=10u L=1u
Menable6_13 n_gate6_13 learn 0 0 nch W=1000u L=1u
Mtail6_13 n_tail6_13 in13 n_gate6_13 0 nch W=20u L=1u
Mu1_6_13 n_up6_13 verror n_tail6_13 0 nch W=20u L=1u
Mu2_6_13 n_w6_13 n_error6 n_tail6_13 0 nch W=20u L=1u
Mu3_6_13 n_up6_13 n_up6_13 vdd vdd pch W=60u L=1u
Mu4_6_13 n_w6_13 n_up6_13 vdd vdd pch W=60u L=1u
* Synapse class=6, input=in14; n_w6_14 stores the learned weight.
Cw6_14 n_w6_14 0 1.67e-06
Mreset6_14 vweight reset n_w6_14 0 syn W=1000u L=1u
Mpos6_14 in14 n_w6_14 n_pos6 0 syn W=10u L=1u
Mneg6_14 in14 vweight n_neg6 0 syn W=10u L=1u
Menable6_14 n_gate6_14 learn 0 0 nch W=1000u L=1u
Mtail6_14 n_tail6_14 in14 n_gate6_14 0 nch W=20u L=1u
Mu1_6_14 n_up6_14 verror n_tail6_14 0 nch W=20u L=1u
Mu2_6_14 n_w6_14 n_error6 n_tail6_14 0 nch W=20u L=1u
Mu3_6_14 n_up6_14 n_up6_14 vdd vdd pch W=60u L=1u
Mu4_6_14 n_w6_14 n_up6_14 vdd vdd pch W=60u L=1u
* Synapse class=6, input=in15; n_w6_15 stores the learned weight.
Cw6_15 n_w6_15 0 1.67e-06
Mreset6_15 vweight reset n_w6_15 0 syn W=1000u L=1u
Mpos6_15 in15 n_w6_15 n_pos6 0 syn W=10u L=1u
Mneg6_15 in15 vweight n_neg6 0 syn W=10u L=1u
Menable6_15 n_gate6_15 learn 0 0 nch W=1000u L=1u
Mtail6_15 n_tail6_15 in15 n_gate6_15 0 nch W=20u L=1u
Mu1_6_15 n_up6_15 verror n_tail6_15 0 nch W=20u L=1u
Mu2_6_15 n_w6_15 n_error6 n_tail6_15 0 nch W=20u L=1u
Mu3_6_15 n_up6_15 n_up6_15 vdd vdd pch W=60u L=1u
Mu4_6_15 n_w6_15 n_up6_15 vdd vdd pch W=60u L=1u
* Synapse class=6, input=vbias; n_w6_16 stores the learned weight.
Cw6_16 n_w6_16 0 1.67e-06
Mreset6_16 vweight reset n_w6_16 0 syn W=1000u L=1u
Mpos6_16 vbias n_w6_16 n_pos6 0 syn W=10u L=1u
Mneg6_16 vbias vweight n_neg6 0 syn W=10u L=1u
Menable6_16 n_gate6_16 learn 0 0 nch W=1000u L=1u
Mtail6_16 n_tail6_16 vbias n_gate6_16 0 nch W=20u L=1u
Mu1_6_16 n_up6_16 verror n_tail6_16 0 nch W=20u L=1u
Mu2_6_16 n_w6_16 n_error6 n_tail6_16 0 nch W=20u L=1u
Mu3_6_16 n_up6_16 n_up6_16 vdd vdd pch W=60u L=1u
Mu4_6_16 n_w6_16 n_up6_16 vdd vdd pch W=60u L=1u
Ma7 n_neg7 n_neg7 0 0 nch W=20u L=1u
Mb7 out7 n_neg7 0 0 nch W=20u L=1u
Mc7 n_pos7 n_pos7 0 0 nch W=20u L=1u
Md7 n_mirror7 n_pos7 0 0 nch W=20u L=1u
Me7 n_mirror7 n_mirror7 vdd vdd pch W=60u L=1u
Mf7 out7 n_mirror7 vdd vdd pch W=60u L=1u
Mep7 n_error7 n_mirror7 vdd vdd pch W=60u L=1u
Men7 n_error7 n_neg7 0 0 nch W=20u L=1u
Moff7 n_error7 voffset vdd vdd pch W=10u L=1u
Mtarget7 n_error7 target7 0 0 nch W=10u L=1u
Rscore7 out7 vref 7k
Rerror7 n_error7 verror 7k
* Synapse class=7, input=in0; n_w7_0 stores the learned weight.
Cw7_0 n_w7_0 0 1.67e-06
Mreset7_0 vweight reset n_w7_0 0 syn W=1000u L=1u
Mpos7_0 in0 n_w7_0 n_pos7 0 syn W=10u L=1u
Mneg7_0 in0 vweight n_neg7 0 syn W=10u L=1u
Menable7_0 n_gate7_0 learn 0 0 nch W=1000u L=1u
Mtail7_0 n_tail7_0 in0 n_gate7_0 0 nch W=20u L=1u
Mu1_7_0 n_up7_0 verror n_tail7_0 0 nch W=20u L=1u
Mu2_7_0 n_w7_0 n_error7 n_tail7_0 0 nch W=20u L=1u
Mu3_7_0 n_up7_0 n_up7_0 vdd vdd pch W=60u L=1u
Mu4_7_0 n_w7_0 n_up7_0 vdd vdd pch W=60u L=1u
* Synapse class=7, input=in1; n_w7_1 stores the learned weight.
Cw7_1 n_w7_1 0 1.67e-06
Mreset7_1 vweight reset n_w7_1 0 syn W=1000u L=1u
Mpos7_1 in1 n_w7_1 n_pos7 0 syn W=10u L=1u
Mneg7_1 in1 vweight n_neg7 0 syn W=10u L=1u
Menable7_1 n_gate7_1 learn 0 0 nch W=1000u L=1u
Mtail7_1 n_tail7_1 in1 n_gate7_1 0 nch W=20u L=1u
Mu1_7_1 n_up7_1 verror n_tail7_1 0 nch W=20u L=1u
Mu2_7_1 n_w7_1 n_error7 n_tail7_1 0 nch W=20u L=1u
Mu3_7_1 n_up7_1 n_up7_1 vdd vdd pch W=60u L=1u
Mu4_7_1 n_w7_1 n_up7_1 vdd vdd pch W=60u L=1u
* Synapse class=7, input=in2; n_w7_2 stores the learned weight.
Cw7_2 n_w7_2 0 1.67e-06
Mreset7_2 vweight reset n_w7_2 0 syn W=1000u L=1u
Mpos7_2 in2 n_w7_2 n_pos7 0 syn W=10u L=1u
Mneg7_2 in2 vweight n_neg7 0 syn W=10u L=1u
Menable7_2 n_gate7_2 learn 0 0 nch W=1000u L=1u
Mtail7_2 n_tail7_2 in2 n_gate7_2 0 nch W=20u L=1u
Mu1_7_2 n_up7_2 verror n_tail7_2 0 nch W=20u L=1u
Mu2_7_2 n_w7_2 n_error7 n_tail7_2 0 nch W=20u L=1u
Mu3_7_2 n_up7_2 n_up7_2 vdd vdd pch W=60u L=1u
Mu4_7_2 n_w7_2 n_up7_2 vdd vdd pch W=60u L=1u
* Synapse class=7, input=in3; n_w7_3 stores the learned weight.
Cw7_3 n_w7_3 0 1.67e-06
Mreset7_3 vweight reset n_w7_3 0 syn W=1000u L=1u
Mpos7_3 in3 n_w7_3 n_pos7 0 syn W=10u L=1u
Mneg7_3 in3 vweight n_neg7 0 syn W=10u L=1u
Menable7_3 n_gate7_3 learn 0 0 nch W=1000u L=1u
Mtail7_3 n_tail7_3 in3 n_gate7_3 0 nch W=20u L=1u
Mu1_7_3 n_up7_3 verror n_tail7_3 0 nch W=20u L=1u
Mu2_7_3 n_w7_3 n_error7 n_tail7_3 0 nch W=20u L=1u
Mu3_7_3 n_up7_3 n_up7_3 vdd vdd pch W=60u L=1u
Mu4_7_3 n_w7_3 n_up7_3 vdd vdd pch W=60u L=1u
* Synapse class=7, input=in4; n_w7_4 stores the learned weight.
Cw7_4 n_w7_4 0 1.67e-06
Mreset7_4 vweight reset n_w7_4 0 syn W=1000u L=1u
Mpos7_4 in4 n_w7_4 n_pos7 0 syn W=10u L=1u
Mneg7_4 in4 vweight n_neg7 0 syn W=10u L=1u
Menable7_4 n_gate7_4 learn 0 0 nch W=1000u L=1u
Mtail7_4 n_tail7_4 in4 n_gate7_4 0 nch W=20u L=1u
Mu1_7_4 n_up7_4 verror n_tail7_4 0 nch W=20u L=1u
Mu2_7_4 n_w7_4 n_error7 n_tail7_4 0 nch W=20u L=1u
Mu3_7_4 n_up7_4 n_up7_4 vdd vdd pch W=60u L=1u
Mu4_7_4 n_w7_4 n_up7_4 vdd vdd pch W=60u L=1u
* Synapse class=7, input=in5; n_w7_5 stores the learned weight.
Cw7_5 n_w7_5 0 1.67e-06
Mreset7_5 vweight reset n_w7_5 0 syn W=1000u L=1u
Mpos7_5 in5 n_w7_5 n_pos7 0 syn W=10u L=1u
Mneg7_5 in5 vweight n_neg7 0 syn W=10u L=1u
Menable7_5 n_gate7_5 learn 0 0 nch W=1000u L=1u
Mtail7_5 n_tail7_5 in5 n_gate7_5 0 nch W=20u L=1u
Mu1_7_5 n_up7_5 verror n_tail7_5 0 nch W=20u L=1u
Mu2_7_5 n_w7_5 n_error7 n_tail7_5 0 nch W=20u L=1u
Mu3_7_5 n_up7_5 n_up7_5 vdd vdd pch W=60u L=1u
Mu4_7_5 n_w7_5 n_up7_5 vdd vdd pch W=60u L=1u
* Synapse class=7, input=in6; n_w7_6 stores the learned weight.
Cw7_6 n_w7_6 0 1.67e-06
Mreset7_6 vweight reset n_w7_6 0 syn W=1000u L=1u
Mpos7_6 in6 n_w7_6 n_pos7 0 syn W=10u L=1u
Mneg7_6 in6 vweight n_neg7 0 syn W=10u L=1u
Menable7_6 n_gate7_6 learn 0 0 nch W=1000u L=1u
Mtail7_6 n_tail7_6 in6 n_gate7_6 0 nch W=20u L=1u
Mu1_7_6 n_up7_6 verror n_tail7_6 0 nch W=20u L=1u
Mu2_7_6 n_w7_6 n_error7 n_tail7_6 0 nch W=20u L=1u
Mu3_7_6 n_up7_6 n_up7_6 vdd vdd pch W=60u L=1u
Mu4_7_6 n_w7_6 n_up7_6 vdd vdd pch W=60u L=1u
* Synapse class=7, input=in7; n_w7_7 stores the learned weight.
Cw7_7 n_w7_7 0 1.67e-06
Mreset7_7 vweight reset n_w7_7 0 syn W=1000u L=1u
Mpos7_7 in7 n_w7_7 n_pos7 0 syn W=10u L=1u
Mneg7_7 in7 vweight n_neg7 0 syn W=10u L=1u
Menable7_7 n_gate7_7 learn 0 0 nch W=1000u L=1u
Mtail7_7 n_tail7_7 in7 n_gate7_7 0 nch W=20u L=1u
Mu1_7_7 n_up7_7 verror n_tail7_7 0 nch W=20u L=1u
Mu2_7_7 n_w7_7 n_error7 n_tail7_7 0 nch W=20u L=1u
Mu3_7_7 n_up7_7 n_up7_7 vdd vdd pch W=60u L=1u
Mu4_7_7 n_w7_7 n_up7_7 vdd vdd pch W=60u L=1u
* Synapse class=7, input=in8; n_w7_8 stores the learned weight.
Cw7_8 n_w7_8 0 1.67e-06
Mreset7_8 vweight reset n_w7_8 0 syn W=1000u L=1u
Mpos7_8 in8 n_w7_8 n_pos7 0 syn W=10u L=1u
Mneg7_8 in8 vweight n_neg7 0 syn W=10u L=1u
Menable7_8 n_gate7_8 learn 0 0 nch W=1000u L=1u
Mtail7_8 n_tail7_8 in8 n_gate7_8 0 nch W=20u L=1u
Mu1_7_8 n_up7_8 verror n_tail7_8 0 nch W=20u L=1u
Mu2_7_8 n_w7_8 n_error7 n_tail7_8 0 nch W=20u L=1u
Mu3_7_8 n_up7_8 n_up7_8 vdd vdd pch W=60u L=1u
Mu4_7_8 n_w7_8 n_up7_8 vdd vdd pch W=60u L=1u
* Synapse class=7, input=in9; n_w7_9 stores the learned weight.
Cw7_9 n_w7_9 0 1.67e-06
Mreset7_9 vweight reset n_w7_9 0 syn W=1000u L=1u
Mpos7_9 in9 n_w7_9 n_pos7 0 syn W=10u L=1u
Mneg7_9 in9 vweight n_neg7 0 syn W=10u L=1u
Menable7_9 n_gate7_9 learn 0 0 nch W=1000u L=1u
Mtail7_9 n_tail7_9 in9 n_gate7_9 0 nch W=20u L=1u
Mu1_7_9 n_up7_9 verror n_tail7_9 0 nch W=20u L=1u
Mu2_7_9 n_w7_9 n_error7 n_tail7_9 0 nch W=20u L=1u
Mu3_7_9 n_up7_9 n_up7_9 vdd vdd pch W=60u L=1u
Mu4_7_9 n_w7_9 n_up7_9 vdd vdd pch W=60u L=1u
* Synapse class=7, input=in10; n_w7_10 stores the learned weight.
Cw7_10 n_w7_10 0 1.67e-06
Mreset7_10 vweight reset n_w7_10 0 syn W=1000u L=1u
Mpos7_10 in10 n_w7_10 n_pos7 0 syn W=10u L=1u
Mneg7_10 in10 vweight n_neg7 0 syn W=10u L=1u
Menable7_10 n_gate7_10 learn 0 0 nch W=1000u L=1u
Mtail7_10 n_tail7_10 in10 n_gate7_10 0 nch W=20u L=1u
Mu1_7_10 n_up7_10 verror n_tail7_10 0 nch W=20u L=1u
Mu2_7_10 n_w7_10 n_error7 n_tail7_10 0 nch W=20u L=1u
Mu3_7_10 n_up7_10 n_up7_10 vdd vdd pch W=60u L=1u
Mu4_7_10 n_w7_10 n_up7_10 vdd vdd pch W=60u L=1u
* Synapse class=7, input=in11; n_w7_11 stores the learned weight.
Cw7_11 n_w7_11 0 1.67e-06
Mreset7_11 vweight reset n_w7_11 0 syn W=1000u L=1u
Mpos7_11 in11 n_w7_11 n_pos7 0 syn W=10u L=1u
Mneg7_11 in11 vweight n_neg7 0 syn W=10u L=1u
Menable7_11 n_gate7_11 learn 0 0 nch W=1000u L=1u
Mtail7_11 n_tail7_11 in11 n_gate7_11 0 nch W=20u L=1u
Mu1_7_11 n_up7_11 verror n_tail7_11 0 nch W=20u L=1u
Mu2_7_11 n_w7_11 n_error7 n_tail7_11 0 nch W=20u L=1u
Mu3_7_11 n_up7_11 n_up7_11 vdd vdd pch W=60u L=1u
Mu4_7_11 n_w7_11 n_up7_11 vdd vdd pch W=60u L=1u
* Synapse class=7, input=in12; n_w7_12 stores the learned weight.
Cw7_12 n_w7_12 0 1.67e-06
Mreset7_12 vweight reset n_w7_12 0 syn W=1000u L=1u
Mpos7_12 in12 n_w7_12 n_pos7 0 syn W=10u L=1u
Mneg7_12 in12 vweight n_neg7 0 syn W=10u L=1u
Menable7_12 n_gate7_12 learn 0 0 nch W=1000u L=1u
Mtail7_12 n_tail7_12 in12 n_gate7_12 0 nch W=20u L=1u
Mu1_7_12 n_up7_12 verror n_tail7_12 0 nch W=20u L=1u
Mu2_7_12 n_w7_12 n_error7 n_tail7_12 0 nch W=20u L=1u
Mu3_7_12 n_up7_12 n_up7_12 vdd vdd pch W=60u L=1u
Mu4_7_12 n_w7_12 n_up7_12 vdd vdd pch W=60u L=1u
* Synapse class=7, input=in13; n_w7_13 stores the learned weight.
Cw7_13 n_w7_13 0 1.67e-06
Mreset7_13 vweight reset n_w7_13 0 syn W=1000u L=1u
Mpos7_13 in13 n_w7_13 n_pos7 0 syn W=10u L=1u
Mneg7_13 in13 vweight n_neg7 0 syn W=10u L=1u
Menable7_13 n_gate7_13 learn 0 0 nch W=1000u L=1u
Mtail7_13 n_tail7_13 in13 n_gate7_13 0 nch W=20u L=1u
Mu1_7_13 n_up7_13 verror n_tail7_13 0 nch W=20u L=1u
Mu2_7_13 n_w7_13 n_error7 n_tail7_13 0 nch W=20u L=1u
Mu3_7_13 n_up7_13 n_up7_13 vdd vdd pch W=60u L=1u
Mu4_7_13 n_w7_13 n_up7_13 vdd vdd pch W=60u L=1u
* Synapse class=7, input=in14; n_w7_14 stores the learned weight.
Cw7_14 n_w7_14 0 1.67e-06
Mreset7_14 vweight reset n_w7_14 0 syn W=1000u L=1u
Mpos7_14 in14 n_w7_14 n_pos7 0 syn W=10u L=1u
Mneg7_14 in14 vweight n_neg7 0 syn W=10u L=1u
Menable7_14 n_gate7_14 learn 0 0 nch W=1000u L=1u
Mtail7_14 n_tail7_14 in14 n_gate7_14 0 nch W=20u L=1u
Mu1_7_14 n_up7_14 verror n_tail7_14 0 nch W=20u L=1u
Mu2_7_14 n_w7_14 n_error7 n_tail7_14 0 nch W=20u L=1u
Mu3_7_14 n_up7_14 n_up7_14 vdd vdd pch W=60u L=1u
Mu4_7_14 n_w7_14 n_up7_14 vdd vdd pch W=60u L=1u
* Synapse class=7, input=in15; n_w7_15 stores the learned weight.
Cw7_15 n_w7_15 0 1.67e-06
Mreset7_15 vweight reset n_w7_15 0 syn W=1000u L=1u
Mpos7_15 in15 n_w7_15 n_pos7 0 syn W=10u L=1u
Mneg7_15 in15 vweight n_neg7 0 syn W=10u L=1u
Menable7_15 n_gate7_15 learn 0 0 nch W=1000u L=1u
Mtail7_15 n_tail7_15 in15 n_gate7_15 0 nch W=20u L=1u
Mu1_7_15 n_up7_15 verror n_tail7_15 0 nch W=20u L=1u
Mu2_7_15 n_w7_15 n_error7 n_tail7_15 0 nch W=20u L=1u
Mu3_7_15 n_up7_15 n_up7_15 vdd vdd pch W=60u L=1u
Mu4_7_15 n_w7_15 n_up7_15 vdd vdd pch W=60u L=1u
* Synapse class=7, input=vbias; n_w7_16 stores the learned weight.
Cw7_16 n_w7_16 0 1.67e-06
Mreset7_16 vweight reset n_w7_16 0 syn W=1000u L=1u
Mpos7_16 vbias n_w7_16 n_pos7 0 syn W=10u L=1u
Mneg7_16 vbias vweight n_neg7 0 syn W=10u L=1u
Menable7_16 n_gate7_16 learn 0 0 nch W=1000u L=1u
Mtail7_16 n_tail7_16 vbias n_gate7_16 0 nch W=20u L=1u
Mu1_7_16 n_up7_16 verror n_tail7_16 0 nch W=20u L=1u
Mu2_7_16 n_w7_16 n_error7 n_tail7_16 0 nch W=20u L=1u
Mu3_7_16 n_up7_16 n_up7_16 vdd vdd pch W=60u L=1u
Mu4_7_16 n_w7_16 n_up7_16 vdd vdd pch W=60u L=1u
Ma8 n_neg8 n_neg8 0 0 nch W=20u L=1u
Mb8 out8 n_neg8 0 0 nch W=20u L=1u
Mc8 n_pos8 n_pos8 0 0 nch W=20u L=1u
Md8 n_mirror8 n_pos8 0 0 nch W=20u L=1u
Me8 n_mirror8 n_mirror8 vdd vdd pch W=60u L=1u
Mf8 out8 n_mirror8 vdd vdd pch W=60u L=1u
Mep8 n_error8 n_mirror8 vdd vdd pch W=60u L=1u
Men8 n_error8 n_neg8 0 0 nch W=20u L=1u
Moff8 n_error8 voffset vdd vdd pch W=10u L=1u
Mtarget8 n_error8 target8 0 0 nch W=10u L=1u
Rscore8 out8 vref 7k
Rerror8 n_error8 verror 7k
* Synapse class=8, input=in0; n_w8_0 stores the learned weight.
Cw8_0 n_w8_0 0 1.67e-06
Mreset8_0 vweight reset n_w8_0 0 syn W=1000u L=1u
Mpos8_0 in0 n_w8_0 n_pos8 0 syn W=10u L=1u
Mneg8_0 in0 vweight n_neg8 0 syn W=10u L=1u
Menable8_0 n_gate8_0 learn 0 0 nch W=1000u L=1u
Mtail8_0 n_tail8_0 in0 n_gate8_0 0 nch W=20u L=1u
Mu1_8_0 n_up8_0 verror n_tail8_0 0 nch W=20u L=1u
Mu2_8_0 n_w8_0 n_error8 n_tail8_0 0 nch W=20u L=1u
Mu3_8_0 n_up8_0 n_up8_0 vdd vdd pch W=60u L=1u
Mu4_8_0 n_w8_0 n_up8_0 vdd vdd pch W=60u L=1u
* Synapse class=8, input=in1; n_w8_1 stores the learned weight.
Cw8_1 n_w8_1 0 1.67e-06
Mreset8_1 vweight reset n_w8_1 0 syn W=1000u L=1u
Mpos8_1 in1 n_w8_1 n_pos8 0 syn W=10u L=1u
Mneg8_1 in1 vweight n_neg8 0 syn W=10u L=1u
Menable8_1 n_gate8_1 learn 0 0 nch W=1000u L=1u
Mtail8_1 n_tail8_1 in1 n_gate8_1 0 nch W=20u L=1u
Mu1_8_1 n_up8_1 verror n_tail8_1 0 nch W=20u L=1u
Mu2_8_1 n_w8_1 n_error8 n_tail8_1 0 nch W=20u L=1u
Mu3_8_1 n_up8_1 n_up8_1 vdd vdd pch W=60u L=1u
Mu4_8_1 n_w8_1 n_up8_1 vdd vdd pch W=60u L=1u
* Synapse class=8, input=in2; n_w8_2 stores the learned weight.
Cw8_2 n_w8_2 0 1.67e-06
Mreset8_2 vweight reset n_w8_2 0 syn W=1000u L=1u
Mpos8_2 in2 n_w8_2 n_pos8 0 syn W=10u L=1u
Mneg8_2 in2 vweight n_neg8 0 syn W=10u L=1u
Menable8_2 n_gate8_2 learn 0 0 nch W=1000u L=1u
Mtail8_2 n_tail8_2 in2 n_gate8_2 0 nch W=20u L=1u
Mu1_8_2 n_up8_2 verror n_tail8_2 0 nch W=20u L=1u
Mu2_8_2 n_w8_2 n_error8 n_tail8_2 0 nch W=20u L=1u
Mu3_8_2 n_up8_2 n_up8_2 vdd vdd pch W=60u L=1u
Mu4_8_2 n_w8_2 n_up8_2 vdd vdd pch W=60u L=1u
* Synapse class=8, input=in3; n_w8_3 stores the learned weight.
Cw8_3 n_w8_3 0 1.67e-06
Mreset8_3 vweight reset n_w8_3 0 syn W=1000u L=1u
Mpos8_3 in3 n_w8_3 n_pos8 0 syn W=10u L=1u
Mneg8_3 in3 vweight n_neg8 0 syn W=10u L=1u
Menable8_3 n_gate8_3 learn 0 0 nch W=1000u L=1u
Mtail8_3 n_tail8_3 in3 n_gate8_3 0 nch W=20u L=1u
Mu1_8_3 n_up8_3 verror n_tail8_3 0 nch W=20u L=1u
Mu2_8_3 n_w8_3 n_error8 n_tail8_3 0 nch W=20u L=1u
Mu3_8_3 n_up8_3 n_up8_3 vdd vdd pch W=60u L=1u
Mu4_8_3 n_w8_3 n_up8_3 vdd vdd pch W=60u L=1u
* Synapse class=8, input=in4; n_w8_4 stores the learned weight.
Cw8_4 n_w8_4 0 1.67e-06
Mreset8_4 vweight reset n_w8_4 0 syn W=1000u L=1u
Mpos8_4 in4 n_w8_4 n_pos8 0 syn W=10u L=1u
Mneg8_4 in4 vweight n_neg8 0 syn W=10u L=1u
Menable8_4 n_gate8_4 learn 0 0 nch W=1000u L=1u
Mtail8_4 n_tail8_4 in4 n_gate8_4 0 nch W=20u L=1u
Mu1_8_4 n_up8_4 verror n_tail8_4 0 nch W=20u L=1u
Mu2_8_4 n_w8_4 n_error8 n_tail8_4 0 nch W=20u L=1u
Mu3_8_4 n_up8_4 n_up8_4 vdd vdd pch W=60u L=1u
Mu4_8_4 n_w8_4 n_up8_4 vdd vdd pch W=60u L=1u
* Synapse class=8, input=in5; n_w8_5 stores the learned weight.
Cw8_5 n_w8_5 0 1.67e-06
Mreset8_5 vweight reset n_w8_5 0 syn W=1000u L=1u
Mpos8_5 in5 n_w8_5 n_pos8 0 syn W=10u L=1u
Mneg8_5 in5 vweight n_neg8 0 syn W=10u L=1u
Menable8_5 n_gate8_5 learn 0 0 nch W=1000u L=1u
Mtail8_5 n_tail8_5 in5 n_gate8_5 0 nch W=20u L=1u
Mu1_8_5 n_up8_5 verror n_tail8_5 0 nch W=20u L=1u
Mu2_8_5 n_w8_5 n_error8 n_tail8_5 0 nch W=20u L=1u
Mu3_8_5 n_up8_5 n_up8_5 vdd vdd pch W=60u L=1u
Mu4_8_5 n_w8_5 n_up8_5 vdd vdd pch W=60u L=1u
* Synapse class=8, input=in6; n_w8_6 stores the learned weight.
Cw8_6 n_w8_6 0 1.67e-06
Mreset8_6 vweight reset n_w8_6 0 syn W=1000u L=1u
Mpos8_6 in6 n_w8_6 n_pos8 0 syn W=10u L=1u
Mneg8_6 in6 vweight n_neg8 0 syn W=10u L=1u
Menable8_6 n_gate8_6 learn 0 0 nch W=1000u L=1u
Mtail8_6 n_tail8_6 in6 n_gate8_6 0 nch W=20u L=1u
Mu1_8_6 n_up8_6 verror n_tail8_6 0 nch W=20u L=1u
Mu2_8_6 n_w8_6 n_error8 n_tail8_6 0 nch W=20u L=1u
Mu3_8_6 n_up8_6 n_up8_6 vdd vdd pch W=60u L=1u
Mu4_8_6 n_w8_6 n_up8_6 vdd vdd pch W=60u L=1u
* Synapse class=8, input=in7; n_w8_7 stores the learned weight.
Cw8_7 n_w8_7 0 1.67e-06
Mreset8_7 vweight reset n_w8_7 0 syn W=1000u L=1u
Mpos8_7 in7 n_w8_7 n_pos8 0 syn W=10u L=1u
Mneg8_7 in7 vweight n_neg8 0 syn W=10u L=1u
Menable8_7 n_gate8_7 learn 0 0 nch W=1000u L=1u
Mtail8_7 n_tail8_7 in7 n_gate8_7 0 nch W=20u L=1u
Mu1_8_7 n_up8_7 verror n_tail8_7 0 nch W=20u L=1u
Mu2_8_7 n_w8_7 n_error8 n_tail8_7 0 nch W=20u L=1u
Mu3_8_7 n_up8_7 n_up8_7 vdd vdd pch W=60u L=1u
Mu4_8_7 n_w8_7 n_up8_7 vdd vdd pch W=60u L=1u
* Synapse class=8, input=in8; n_w8_8 stores the learned weight.
Cw8_8 n_w8_8 0 1.67e-06
Mreset8_8 vweight reset n_w8_8 0 syn W=1000u L=1u
Mpos8_8 in8 n_w8_8 n_pos8 0 syn W=10u L=1u
Mneg8_8 in8 vweight n_neg8 0 syn W=10u L=1u
Menable8_8 n_gate8_8 learn 0 0 nch W=1000u L=1u
Mtail8_8 n_tail8_8 in8 n_gate8_8 0 nch W=20u L=1u
Mu1_8_8 n_up8_8 verror n_tail8_8 0 nch W=20u L=1u
Mu2_8_8 n_w8_8 n_error8 n_tail8_8 0 nch W=20u L=1u
Mu3_8_8 n_up8_8 n_up8_8 vdd vdd pch W=60u L=1u
Mu4_8_8 n_w8_8 n_up8_8 vdd vdd pch W=60u L=1u
* Synapse class=8, input=in9; n_w8_9 stores the learned weight.
Cw8_9 n_w8_9 0 1.67e-06
Mreset8_9 vweight reset n_w8_9 0 syn W=1000u L=1u
Mpos8_9 in9 n_w8_9 n_pos8 0 syn W=10u L=1u
Mneg8_9 in9 vweight n_neg8 0 syn W=10u L=1u
Menable8_9 n_gate8_9 learn 0 0 nch W=1000u L=1u
Mtail8_9 n_tail8_9 in9 n_gate8_9 0 nch W=20u L=1u
Mu1_8_9 n_up8_9 verror n_tail8_9 0 nch W=20u L=1u
Mu2_8_9 n_w8_9 n_error8 n_tail8_9 0 nch W=20u L=1u
Mu3_8_9 n_up8_9 n_up8_9 vdd vdd pch W=60u L=1u
Mu4_8_9 n_w8_9 n_up8_9 vdd vdd pch W=60u L=1u
* Synapse class=8, input=in10; n_w8_10 stores the learned weight.
Cw8_10 n_w8_10 0 1.67e-06
Mreset8_10 vweight reset n_w8_10 0 syn W=1000u L=1u
Mpos8_10 in10 n_w8_10 n_pos8 0 syn W=10u L=1u
Mneg8_10 in10 vweight n_neg8 0 syn W=10u L=1u
Menable8_10 n_gate8_10 learn 0 0 nch W=1000u L=1u
Mtail8_10 n_tail8_10 in10 n_gate8_10 0 nch W=20u L=1u
Mu1_8_10 n_up8_10 verror n_tail8_10 0 nch W=20u L=1u
Mu2_8_10 n_w8_10 n_error8 n_tail8_10 0 nch W=20u L=1u
Mu3_8_10 n_up8_10 n_up8_10 vdd vdd pch W=60u L=1u
Mu4_8_10 n_w8_10 n_up8_10 vdd vdd pch W=60u L=1u
* Synapse class=8, input=in11; n_w8_11 stores the learned weight.
Cw8_11 n_w8_11 0 1.67e-06
Mreset8_11 vweight reset n_w8_11 0 syn W=1000u L=1u
Mpos8_11 in11 n_w8_11 n_pos8 0 syn W=10u L=1u
Mneg8_11 in11 vweight n_neg8 0 syn W=10u L=1u
Menable8_11 n_gate8_11 learn 0 0 nch W=1000u L=1u
Mtail8_11 n_tail8_11 in11 n_gate8_11 0 nch W=20u L=1u
Mu1_8_11 n_up8_11 verror n_tail8_11 0 nch W=20u L=1u
Mu2_8_11 n_w8_11 n_error8 n_tail8_11 0 nch W=20u L=1u
Mu3_8_11 n_up8_11 n_up8_11 vdd vdd pch W=60u L=1u
Mu4_8_11 n_w8_11 n_up8_11 vdd vdd pch W=60u L=1u
* Synapse class=8, input=in12; n_w8_12 stores the learned weight.
Cw8_12 n_w8_12 0 1.67e-06
Mreset8_12 vweight reset n_w8_12 0 syn W=1000u L=1u
Mpos8_12 in12 n_w8_12 n_pos8 0 syn W=10u L=1u
Mneg8_12 in12 vweight n_neg8 0 syn W=10u L=1u
Menable8_12 n_gate8_12 learn 0 0 nch W=1000u L=1u
Mtail8_12 n_tail8_12 in12 n_gate8_12 0 nch W=20u L=1u
Mu1_8_12 n_up8_12 verror n_tail8_12 0 nch W=20u L=1u
Mu2_8_12 n_w8_12 n_error8 n_tail8_12 0 nch W=20u L=1u
Mu3_8_12 n_up8_12 n_up8_12 vdd vdd pch W=60u L=1u
Mu4_8_12 n_w8_12 n_up8_12 vdd vdd pch W=60u L=1u
* Synapse class=8, input=in13; n_w8_13 stores the learned weight.
Cw8_13 n_w8_13 0 1.67e-06
Mreset8_13 vweight reset n_w8_13 0 syn W=1000u L=1u
Mpos8_13 in13 n_w8_13 n_pos8 0 syn W=10u L=1u
Mneg8_13 in13 vweight n_neg8 0 syn W=10u L=1u
Menable8_13 n_gate8_13 learn 0 0 nch W=1000u L=1u
Mtail8_13 n_tail8_13 in13 n_gate8_13 0 nch W=20u L=1u
Mu1_8_13 n_up8_13 verror n_tail8_13 0 nch W=20u L=1u
Mu2_8_13 n_w8_13 n_error8 n_tail8_13 0 nch W=20u L=1u
Mu3_8_13 n_up8_13 n_up8_13 vdd vdd pch W=60u L=1u
Mu4_8_13 n_w8_13 n_up8_13 vdd vdd pch W=60u L=1u
* Synapse class=8, input=in14; n_w8_14 stores the learned weight.
Cw8_14 n_w8_14 0 1.67e-06
Mreset8_14 vweight reset n_w8_14 0 syn W=1000u L=1u
Mpos8_14 in14 n_w8_14 n_pos8 0 syn W=10u L=1u
Mneg8_14 in14 vweight n_neg8 0 syn W=10u L=1u
Menable8_14 n_gate8_14 learn 0 0 nch W=1000u L=1u
Mtail8_14 n_tail8_14 in14 n_gate8_14 0 nch W=20u L=1u
Mu1_8_14 n_up8_14 verror n_tail8_14 0 nch W=20u L=1u
Mu2_8_14 n_w8_14 n_error8 n_tail8_14 0 nch W=20u L=1u
Mu3_8_14 n_up8_14 n_up8_14 vdd vdd pch W=60u L=1u
Mu4_8_14 n_w8_14 n_up8_14 vdd vdd pch W=60u L=1u
* Synapse class=8, input=in15; n_w8_15 stores the learned weight.
Cw8_15 n_w8_15 0 1.67e-06
Mreset8_15 vweight reset n_w8_15 0 syn W=1000u L=1u
Mpos8_15 in15 n_w8_15 n_pos8 0 syn W=10u L=1u
Mneg8_15 in15 vweight n_neg8 0 syn W=10u L=1u
Menable8_15 n_gate8_15 learn 0 0 nch W=1000u L=1u
Mtail8_15 n_tail8_15 in15 n_gate8_15 0 nch W=20u L=1u
Mu1_8_15 n_up8_15 verror n_tail8_15 0 nch W=20u L=1u
Mu2_8_15 n_w8_15 n_error8 n_tail8_15 0 nch W=20u L=1u
Mu3_8_15 n_up8_15 n_up8_15 vdd vdd pch W=60u L=1u
Mu4_8_15 n_w8_15 n_up8_15 vdd vdd pch W=60u L=1u
* Synapse class=8, input=vbias; n_w8_16 stores the learned weight.
Cw8_16 n_w8_16 0 1.67e-06
Mreset8_16 vweight reset n_w8_16 0 syn W=1000u L=1u
Mpos8_16 vbias n_w8_16 n_pos8 0 syn W=10u L=1u
Mneg8_16 vbias vweight n_neg8 0 syn W=10u L=1u
Menable8_16 n_gate8_16 learn 0 0 nch W=1000u L=1u
Mtail8_16 n_tail8_16 vbias n_gate8_16 0 nch W=20u L=1u
Mu1_8_16 n_up8_16 verror n_tail8_16 0 nch W=20u L=1u
Mu2_8_16 n_w8_16 n_error8 n_tail8_16 0 nch W=20u L=1u
Mu3_8_16 n_up8_16 n_up8_16 vdd vdd pch W=60u L=1u
Mu4_8_16 n_w8_16 n_up8_16 vdd vdd pch W=60u L=1u
Ma9 n_neg9 n_neg9 0 0 nch W=20u L=1u
Mb9 out9 n_neg9 0 0 nch W=20u L=1u
Mc9 n_pos9 n_pos9 0 0 nch W=20u L=1u
Md9 n_mirror9 n_pos9 0 0 nch W=20u L=1u
Me9 n_mirror9 n_mirror9 vdd vdd pch W=60u L=1u
Mf9 out9 n_mirror9 vdd vdd pch W=60u L=1u
Mep9 n_error9 n_mirror9 vdd vdd pch W=60u L=1u
Men9 n_error9 n_neg9 0 0 nch W=20u L=1u
Moff9 n_error9 voffset vdd vdd pch W=10u L=1u
Mtarget9 n_error9 target9 0 0 nch W=10u L=1u
Rscore9 out9 vref 7k
Rerror9 n_error9 verror 7k
* Synapse class=9, input=in0; n_w9_0 stores the learned weight.
Cw9_0 n_w9_0 0 1.67e-06
Mreset9_0 vweight reset n_w9_0 0 syn W=1000u L=1u
Mpos9_0 in0 n_w9_0 n_pos9 0 syn W=10u L=1u
Mneg9_0 in0 vweight n_neg9 0 syn W=10u L=1u
Menable9_0 n_gate9_0 learn 0 0 nch W=1000u L=1u
Mtail9_0 n_tail9_0 in0 n_gate9_0 0 nch W=20u L=1u
Mu1_9_0 n_up9_0 verror n_tail9_0 0 nch W=20u L=1u
Mu2_9_0 n_w9_0 n_error9 n_tail9_0 0 nch W=20u L=1u
Mu3_9_0 n_up9_0 n_up9_0 vdd vdd pch W=60u L=1u
Mu4_9_0 n_w9_0 n_up9_0 vdd vdd pch W=60u L=1u
* Synapse class=9, input=in1; n_w9_1 stores the learned weight.
Cw9_1 n_w9_1 0 1.67e-06
Mreset9_1 vweight reset n_w9_1 0 syn W=1000u L=1u
Mpos9_1 in1 n_w9_1 n_pos9 0 syn W=10u L=1u
Mneg9_1 in1 vweight n_neg9 0 syn W=10u L=1u
Menable9_1 n_gate9_1 learn 0 0 nch W=1000u L=1u
Mtail9_1 n_tail9_1 in1 n_gate9_1 0 nch W=20u L=1u
Mu1_9_1 n_up9_1 verror n_tail9_1 0 nch W=20u L=1u
Mu2_9_1 n_w9_1 n_error9 n_tail9_1 0 nch W=20u L=1u
Mu3_9_1 n_up9_1 n_up9_1 vdd vdd pch W=60u L=1u
Mu4_9_1 n_w9_1 n_up9_1 vdd vdd pch W=60u L=1u
* Synapse class=9, input=in2; n_w9_2 stores the learned weight.
Cw9_2 n_w9_2 0 1.67e-06
Mreset9_2 vweight reset n_w9_2 0 syn W=1000u L=1u
Mpos9_2 in2 n_w9_2 n_pos9 0 syn W=10u L=1u
Mneg9_2 in2 vweight n_neg9 0 syn W=10u L=1u
Menable9_2 n_gate9_2 learn 0 0 nch W=1000u L=1u
Mtail9_2 n_tail9_2 in2 n_gate9_2 0 nch W=20u L=1u
Mu1_9_2 n_up9_2 verror n_tail9_2 0 nch W=20u L=1u
Mu2_9_2 n_w9_2 n_error9 n_tail9_2 0 nch W=20u L=1u
Mu3_9_2 n_up9_2 n_up9_2 vdd vdd pch W=60u L=1u
Mu4_9_2 n_w9_2 n_up9_2 vdd vdd pch W=60u L=1u
* Synapse class=9, input=in3; n_w9_3 stores the learned weight.
Cw9_3 n_w9_3 0 1.67e-06
Mreset9_3 vweight reset n_w9_3 0 syn W=1000u L=1u
Mpos9_3 in3 n_w9_3 n_pos9 0 syn W=10u L=1u
Mneg9_3 in3 vweight n_neg9 0 syn W=10u L=1u
Menable9_3 n_gate9_3 learn 0 0 nch W=1000u L=1u
Mtail9_3 n_tail9_3 in3 n_gate9_3 0 nch W=20u L=1u
Mu1_9_3 n_up9_3 verror n_tail9_3 0 nch W=20u L=1u
Mu2_9_3 n_w9_3 n_error9 n_tail9_3 0 nch W=20u L=1u
Mu3_9_3 n_up9_3 n_up9_3 vdd vdd pch W=60u L=1u
Mu4_9_3 n_w9_3 n_up9_3 vdd vdd pch W=60u L=1u
* Synapse class=9, input=in4; n_w9_4 stores the learned weight.
Cw9_4 n_w9_4 0 1.67e-06
Mreset9_4 vweight reset n_w9_4 0 syn W=1000u L=1u
Mpos9_4 in4 n_w9_4 n_pos9 0 syn W=10u L=1u
Mneg9_4 in4 vweight n_neg9 0 syn W=10u L=1u
Menable9_4 n_gate9_4 learn 0 0 nch W=1000u L=1u
Mtail9_4 n_tail9_4 in4 n_gate9_4 0 nch W=20u L=1u
Mu1_9_4 n_up9_4 verror n_tail9_4 0 nch W=20u L=1u
Mu2_9_4 n_w9_4 n_error9 n_tail9_4 0 nch W=20u L=1u
Mu3_9_4 n_up9_4 n_up9_4 vdd vdd pch W=60u L=1u
Mu4_9_4 n_w9_4 n_up9_4 vdd vdd pch W=60u L=1u
* Synapse class=9, input=in5; n_w9_5 stores the learned weight.
Cw9_5 n_w9_5 0 1.67e-06
Mreset9_5 vweight reset n_w9_5 0 syn W=1000u L=1u
Mpos9_5 in5 n_w9_5 n_pos9 0 syn W=10u L=1u
Mneg9_5 in5 vweight n_neg9 0 syn W=10u L=1u
Menable9_5 n_gate9_5 learn 0 0 nch W=1000u L=1u
Mtail9_5 n_tail9_5 in5 n_gate9_5 0 nch W=20u L=1u
Mu1_9_5 n_up9_5 verror n_tail9_5 0 nch W=20u L=1u
Mu2_9_5 n_w9_5 n_error9 n_tail9_5 0 nch W=20u L=1u
Mu3_9_5 n_up9_5 n_up9_5 vdd vdd pch W=60u L=1u
Mu4_9_5 n_w9_5 n_up9_5 vdd vdd pch W=60u L=1u
* Synapse class=9, input=in6; n_w9_6 stores the learned weight.
Cw9_6 n_w9_6 0 1.67e-06
Mreset9_6 vweight reset n_w9_6 0 syn W=1000u L=1u
Mpos9_6 in6 n_w9_6 n_pos9 0 syn W=10u L=1u
Mneg9_6 in6 vweight n_neg9 0 syn W=10u L=1u
Menable9_6 n_gate9_6 learn 0 0 nch W=1000u L=1u
Mtail9_6 n_tail9_6 in6 n_gate9_6 0 nch W=20u L=1u
Mu1_9_6 n_up9_6 verror n_tail9_6 0 nch W=20u L=1u
Mu2_9_6 n_w9_6 n_error9 n_tail9_6 0 nch W=20u L=1u
Mu3_9_6 n_up9_6 n_up9_6 vdd vdd pch W=60u L=1u
Mu4_9_6 n_w9_6 n_up9_6 vdd vdd pch W=60u L=1u
* Synapse class=9, input=in7; n_w9_7 stores the learned weight.
Cw9_7 n_w9_7 0 1.67e-06
Mreset9_7 vweight reset n_w9_7 0 syn W=1000u L=1u
Mpos9_7 in7 n_w9_7 n_pos9 0 syn W=10u L=1u
Mneg9_7 in7 vweight n_neg9 0 syn W=10u L=1u
Menable9_7 n_gate9_7 learn 0 0 nch W=1000u L=1u
Mtail9_7 n_tail9_7 in7 n_gate9_7 0 nch W=20u L=1u
Mu1_9_7 n_up9_7 verror n_tail9_7 0 nch W=20u L=1u
Mu2_9_7 n_w9_7 n_error9 n_tail9_7 0 nch W=20u L=1u
Mu3_9_7 n_up9_7 n_up9_7 vdd vdd pch W=60u L=1u
Mu4_9_7 n_w9_7 n_up9_7 vdd vdd pch W=60u L=1u
* Synapse class=9, input=in8; n_w9_8 stores the learned weight.
Cw9_8 n_w9_8 0 1.67e-06
Mreset9_8 vweight reset n_w9_8 0 syn W=1000u L=1u
Mpos9_8 in8 n_w9_8 n_pos9 0 syn W=10u L=1u
Mneg9_8 in8 vweight n_neg9 0 syn W=10u L=1u
Menable9_8 n_gate9_8 learn 0 0 nch W=1000u L=1u
Mtail9_8 n_tail9_8 in8 n_gate9_8 0 nch W=20u L=1u
Mu1_9_8 n_up9_8 verror n_tail9_8 0 nch W=20u L=1u
Mu2_9_8 n_w9_8 n_error9 n_tail9_8 0 nch W=20u L=1u
Mu3_9_8 n_up9_8 n_up9_8 vdd vdd pch W=60u L=1u
Mu4_9_8 n_w9_8 n_up9_8 vdd vdd pch W=60u L=1u
* Synapse class=9, input=in9; n_w9_9 stores the learned weight.
Cw9_9 n_w9_9 0 1.67e-06
Mreset9_9 vweight reset n_w9_9 0 syn W=1000u L=1u
Mpos9_9 in9 n_w9_9 n_pos9 0 syn W=10u L=1u
Mneg9_9 in9 vweight n_neg9 0 syn W=10u L=1u
Menable9_9 n_gate9_9 learn 0 0 nch W=1000u L=1u
Mtail9_9 n_tail9_9 in9 n_gate9_9 0 nch W=20u L=1u
Mu1_9_9 n_up9_9 verror n_tail9_9 0 nch W=20u L=1u
Mu2_9_9 n_w9_9 n_error9 n_tail9_9 0 nch W=20u L=1u
Mu3_9_9 n_up9_9 n_up9_9 vdd vdd pch W=60u L=1u
Mu4_9_9 n_w9_9 n_up9_9 vdd vdd pch W=60u L=1u
* Synapse class=9, input=in10; n_w9_10 stores the learned weight.
Cw9_10 n_w9_10 0 1.67e-06
Mreset9_10 vweight reset n_w9_10 0 syn W=1000u L=1u
Mpos9_10 in10 n_w9_10 n_pos9 0 syn W=10u L=1u
Mneg9_10 in10 vweight n_neg9 0 syn W=10u L=1u
Menable9_10 n_gate9_10 learn 0 0 nch W=1000u L=1u
Mtail9_10 n_tail9_10 in10 n_gate9_10 0 nch W=20u L=1u
Mu1_9_10 n_up9_10 verror n_tail9_10 0 nch W=20u L=1u
Mu2_9_10 n_w9_10 n_error9 n_tail9_10 0 nch W=20u L=1u
Mu3_9_10 n_up9_10 n_up9_10 vdd vdd pch W=60u L=1u
Mu4_9_10 n_w9_10 n_up9_10 vdd vdd pch W=60u L=1u
* Synapse class=9, input=in11; n_w9_11 stores the learned weight.
Cw9_11 n_w9_11 0 1.67e-06
Mreset9_11 vweight reset n_w9_11 0 syn W=1000u L=1u
Mpos9_11 in11 n_w9_11 n_pos9 0 syn W=10u L=1u
Mneg9_11 in11 vweight n_neg9 0 syn W=10u L=1u
Menable9_11 n_gate9_11 learn 0 0 nch W=1000u L=1u
Mtail9_11 n_tail9_11 in11 n_gate9_11 0 nch W=20u L=1u
Mu1_9_11 n_up9_11 verror n_tail9_11 0 nch W=20u L=1u
Mu2_9_11 n_w9_11 n_error9 n_tail9_11 0 nch W=20u L=1u
Mu3_9_11 n_up9_11 n_up9_11 vdd vdd pch W=60u L=1u
Mu4_9_11 n_w9_11 n_up9_11 vdd vdd pch W=60u L=1u
* Synapse class=9, input=in12; n_w9_12 stores the learned weight.
Cw9_12 n_w9_12 0 1.67e-06
Mreset9_12 vweight reset n_w9_12 0 syn W=1000u L=1u
Mpos9_12 in12 n_w9_12 n_pos9 0 syn W=10u L=1u
Mneg9_12 in12 vweight n_neg9 0 syn W=10u L=1u
Menable9_12 n_gate9_12 learn 0 0 nch W=1000u L=1u
Mtail9_12 n_tail9_12 in12 n_gate9_12 0 nch W=20u L=1u
Mu1_9_12 n_up9_12 verror n_tail9_12 0 nch W=20u L=1u
Mu2_9_12 n_w9_12 n_error9 n_tail9_12 0 nch W=20u L=1u
Mu3_9_12 n_up9_12 n_up9_12 vdd vdd pch W=60u L=1u
Mu4_9_12 n_w9_12 n_up9_12 vdd vdd pch W=60u L=1u
* Synapse class=9, input=in13; n_w9_13 stores the learned weight.
Cw9_13 n_w9_13 0 1.67e-06
Mreset9_13 vweight reset n_w9_13 0 syn W=1000u L=1u
Mpos9_13 in13 n_w9_13 n_pos9 0 syn W=10u L=1u
Mneg9_13 in13 vweight n_neg9 0 syn W=10u L=1u
Menable9_13 n_gate9_13 learn 0 0 nch W=1000u L=1u
Mtail9_13 n_tail9_13 in13 n_gate9_13 0 nch W=20u L=1u
Mu1_9_13 n_up9_13 verror n_tail9_13 0 nch W=20u L=1u
Mu2_9_13 n_w9_13 n_error9 n_tail9_13 0 nch W=20u L=1u
Mu3_9_13 n_up9_13 n_up9_13 vdd vdd pch W=60u L=1u
Mu4_9_13 n_w9_13 n_up9_13 vdd vdd pch W=60u L=1u
* Synapse class=9, input=in14; n_w9_14 stores the learned weight.
Cw9_14 n_w9_14 0 1.67e-06
Mreset9_14 vweight reset n_w9_14 0 syn W=1000u L=1u
Mpos9_14 in14 n_w9_14 n_pos9 0 syn W=10u L=1u
Mneg9_14 in14 vweight n_neg9 0 syn W=10u L=1u
Menable9_14 n_gate9_14 learn 0 0 nch W=1000u L=1u
Mtail9_14 n_tail9_14 in14 n_gate9_14 0 nch W=20u L=1u
Mu1_9_14 n_up9_14 verror n_tail9_14 0 nch W=20u L=1u
Mu2_9_14 n_w9_14 n_error9 n_tail9_14 0 nch W=20u L=1u
Mu3_9_14 n_up9_14 n_up9_14 vdd vdd pch W=60u L=1u
Mu4_9_14 n_w9_14 n_up9_14 vdd vdd pch W=60u L=1u
* Synapse class=9, input=in15; n_w9_15 stores the learned weight.
Cw9_15 n_w9_15 0 1.67e-06
Mreset9_15 vweight reset n_w9_15 0 syn W=1000u L=1u
Mpos9_15 in15 n_w9_15 n_pos9 0 syn W=10u L=1u
Mneg9_15 in15 vweight n_neg9 0 syn W=10u L=1u
Menable9_15 n_gate9_15 learn 0 0 nch W=1000u L=1u
Mtail9_15 n_tail9_15 in15 n_gate9_15 0 nch W=20u L=1u
Mu1_9_15 n_up9_15 verror n_tail9_15 0 nch W=20u L=1u
Mu2_9_15 n_w9_15 n_error9 n_tail9_15 0 nch W=20u L=1u
Mu3_9_15 n_up9_15 n_up9_15 vdd vdd pch W=60u L=1u
Mu4_9_15 n_w9_15 n_up9_15 vdd vdd pch W=60u L=1u
* Synapse class=9, input=vbias; n_w9_16 stores the learned weight.
Cw9_16 n_w9_16 0 1.67e-06
Mreset9_16 vweight reset n_w9_16 0 syn W=1000u L=1u
Mpos9_16 vbias n_w9_16 n_pos9 0 syn W=10u L=1u
Mneg9_16 vbias vweight n_neg9 0 syn W=10u L=1u
Menable9_16 n_gate9_16 learn 0 0 nch W=1000u L=1u
Mtail9_16 n_tail9_16 vbias n_gate9_16 0 nch W=20u L=1u
Mu1_9_16 n_up9_16 verror n_tail9_16 0 nch W=20u L=1u
Mu2_9_16 n_w9_16 n_error9 n_tail9_16 0 nch W=20u L=1u
Mu3_9_16 n_up9_16 n_up9_16 vdd vdd pch W=60u L=1u
Mu4_9_16 n_w9_16 n_up9_16 vdd vdd pch W=60u L=1u
