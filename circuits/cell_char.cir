* gsyn characterization
.model NNR NMOS (LEVEL=1 VTO=0.2 KP=120u LAMBDA=0.02 GAMMA=0 PHI=0.7)
.subckt gsyn inp inn wp wn outp outn vdd vbn
Mtail nt vbn 0 0 NNR W=400u L=100u
M5 na wp s5 0 NNR W=200u L=100u
Rd5 s5 nt 200k
M6 nb wn s6 0 NNR W=200u L=100u
Rd6 s6 nt 200k
M1 outp inp s1 0 NNR W=200u L=100u
Rd1 s1 na 200k
M2 outn inn s2 0 NNR W=200u L=100u
Rd2 s2 na 200k
M3 outn inp s3 0 NNR W=200u L=100u
Rd3 s3 nb 200k
M4 outp inn s4 0 NNR W=200u L=100u
Rd4 s4 nb 200k
.ends
Vdd vdd 0 1.0
Vbsyn vbsyn 0 0.45
Vinp inp 0 PWL(0 0.475000 4.8e-08 0.475000 5e-08 0.506250 9.8e-08 0.506250 1e-07 0.537500 1.48e-07 0.537500 1.5e-07 0.568750 1.98e-07 0.568750 2e-07 0.600000 2.48e-07 0.600000 2.5e-07 0.631250 2.98e-07 0.631250 3e-07 0.662500 3.48e-07 0.662500 3.5e-07 0.693750 3.98e-07 0.693750 4e-07 0.725000 4.48e-07 0.725000 4.5e-07 0.475000 4.98e-07 0.475000 5e-07 0.506250 5.48e-07 0.506250 5.5e-07 0.537500 5.98e-07 0.537500 6e-07 0.568750 6.48e-07 0.568750 6.5e-07 0.600000 6.98e-07 0.600000 7e-07 0.631250 7.48e-07 0.631250 7.5e-07 0.662500 7.98e-07 0.662500 8e-07 0.693750 8.48e-07 0.693750 8.5e-07 0.725000 8.98e-07 0.725000 9e-07 0.475000 9.48e-07 0.475000 9.5e-07 0.506250 9.98e-07 0.506250 1e-06 0.537500 1.048e-06 0.537500 1.05e-06 0.568750 1.098e-06 0.568750 1.1e-06 0.600000 1.148e-06 0.600000 1.15e-06 0.631250 1.198e-06 0.631250 1.2e-06 0.662500 1.248e-06 0.662500 1.25e-06 0.693750 1.298e-06 0.693750 1.3e-06 0.725000 1.348e-06 0.725000 1.35e-06 0.475000 1.398e-06 0.475000 1.4e-06 0.506250 1.448e-06 0.506250 1.45e-06 0.537500 1.498e-06 0.537500 1.5e-06 0.568750 1.548e-06 0.568750 1.55e-06 0.600000 1.598e-06 0.600000 1.6e-06 0.631250 1.648e-06 0.631250 1.65e-06 0.662500 1.698e-06 0.662500 1.7e-06 0.693750 1.748e-06 0.693750 1.75e-06 0.725000 1.798e-06 0.725000 1.8e-06 0.475000 1.848e-06 0.475000 1.85e-06 0.506250 1.898e-06 0.506250 1.9e-06 0.537500 1.948e-06 0.537500 1.95e-06 0.568750 1.998e-06 0.568750 2e-06 0.600000 2.048e-06 0.600000 2.05e-06 0.631250 2.098e-06 0.631250 2.1e-06 0.662500 2.148e-06 0.662500 2.15e-06 0.693750 2.198e-06 0.693750 2.2e-06 0.725000 2.248e-06 0.725000 2.25e-06 0.475000 2.298e-06 0.475000 2.3e-06 0.506250 2.348e-06 0.506250 2.35e-06 0.537500 2.398e-06 0.537500 2.4e-06 0.568750 2.448e-06 0.568750 2.45e-06 0.600000 2.498e-06 0.600000 2.5e-06 0.631250 2.548e-06 0.631250 2.55e-06 0.662500 2.598e-06 0.662500 2.6e-06 0.693750 2.648e-06 0.693750 2.65e-06 0.725000 2.698e-06 0.725000 2.7e-06 0.475000 2.748e-06 0.475000 2.75e-06 0.506250 2.798e-06 0.506250 2.8e-06 0.537500 2.848e-06 0.537500 2.85e-06 0.568750 2.898e-06 0.568750 2.9e-06 0.600000 2.948e-06 0.600000 2.95e-06 0.631250 2.998e-06 0.631250 3e-06 0.662500 3.048e-06 0.662500 3.05e-06 0.693750 3.098e-06 0.693750 3.1e-06 0.725000 3.148e-06 0.725000 3.15e-06 0.475000 3.198e-06 0.475000 3.2e-06 0.506250 3.248e-06 0.506250 3.25e-06 0.537500 3.298e-06 0.537500 3.3e-06 0.568750 3.348e-06 0.568750 3.35e-06 0.600000 3.398e-06 0.600000 3.4e-06 0.631250 3.448e-06 0.631250 3.45e-06 0.662500 3.498e-06 0.662500 3.5e-06 0.693750 3.548e-06 0.693750 3.55e-06 0.725000 3.598e-06 0.725000 3.6e-06 0.475000 3.648e-06 0.475000 3.65e-06 0.506250 3.698e-06 0.506250 3.7e-06 0.537500 3.748e-06 0.537500 3.75e-06 0.568750 3.798e-06 0.568750 3.8e-06 0.600000 3.848e-06 0.600000 3.85e-06 0.631250 3.898e-06 0.631250 3.9e-06 0.662500 3.948e-06 0.662500 3.95e-06 0.693750 3.998e-06 0.693750 4e-06 0.725000 4.048e-06 0.725000 4.05e-06 0.725000)
Vinn inn 0 PWL(0 0.725000 4.8e-08 0.725000 5e-08 0.693750 9.8e-08 0.693750 1e-07 0.662500 1.48e-07 0.662500 1.5e-07 0.631250 1.98e-07 0.631250 2e-07 0.600000 2.48e-07 0.600000 2.5e-07 0.568750 2.98e-07 0.568750 3e-07 0.537500 3.48e-07 0.537500 3.5e-07 0.506250 3.98e-07 0.506250 4e-07 0.475000 4.48e-07 0.475000 4.5e-07 0.725000 4.98e-07 0.725000 5e-07 0.693750 5.48e-07 0.693750 5.5e-07 0.662500 5.98e-07 0.662500 6e-07 0.631250 6.48e-07 0.631250 6.5e-07 0.600000 6.98e-07 0.600000 7e-07 0.568750 7.48e-07 0.568750 7.5e-07 0.537500 7.98e-07 0.537500 8e-07 0.506250 8.48e-07 0.506250 8.5e-07 0.475000 8.98e-07 0.475000 9e-07 0.725000 9.48e-07 0.725000 9.5e-07 0.693750 9.98e-07 0.693750 1e-06 0.662500 1.048e-06 0.662500 1.05e-06 0.631250 1.098e-06 0.631250 1.1e-06 0.600000 1.148e-06 0.600000 1.15e-06 0.568750 1.198e-06 0.568750 1.2e-06 0.537500 1.248e-06 0.537500 1.25e-06 0.506250 1.298e-06 0.506250 1.3e-06 0.475000 1.348e-06 0.475000 1.35e-06 0.725000 1.398e-06 0.725000 1.4e-06 0.693750 1.448e-06 0.693750 1.45e-06 0.662500 1.498e-06 0.662500 1.5e-06 0.631250 1.548e-06 0.631250 1.55e-06 0.600000 1.598e-06 0.600000 1.6e-06 0.568750 1.648e-06 0.568750 1.65e-06 0.537500 1.698e-06 0.537500 1.7e-06 0.506250 1.748e-06 0.506250 1.75e-06 0.475000 1.798e-06 0.475000 1.8e-06 0.725000 1.848e-06 0.725000 1.85e-06 0.693750 1.898e-06 0.693750 1.9e-06 0.662500 1.948e-06 0.662500 1.95e-06 0.631250 1.998e-06 0.631250 2e-06 0.600000 2.048e-06 0.600000 2.05e-06 0.568750 2.098e-06 0.568750 2.1e-06 0.537500 2.148e-06 0.537500 2.15e-06 0.506250 2.198e-06 0.506250 2.2e-06 0.475000 2.248e-06 0.475000 2.25e-06 0.725000 2.298e-06 0.725000 2.3e-06 0.693750 2.348e-06 0.693750 2.35e-06 0.662500 2.398e-06 0.662500 2.4e-06 0.631250 2.448e-06 0.631250 2.45e-06 0.600000 2.498e-06 0.600000 2.5e-06 0.568750 2.548e-06 0.568750 2.55e-06 0.537500 2.598e-06 0.537500 2.6e-06 0.506250 2.648e-06 0.506250 2.65e-06 0.475000 2.698e-06 0.475000 2.7e-06 0.725000 2.748e-06 0.725000 2.75e-06 0.693750 2.798e-06 0.693750 2.8e-06 0.662500 2.848e-06 0.662500 2.85e-06 0.631250 2.898e-06 0.631250 2.9e-06 0.600000 2.948e-06 0.600000 2.95e-06 0.568750 2.998e-06 0.568750 3e-06 0.537500 3.048e-06 0.537500 3.05e-06 0.506250 3.098e-06 0.506250 3.1e-06 0.475000 3.148e-06 0.475000 3.15e-06 0.725000 3.198e-06 0.725000 3.2e-06 0.693750 3.248e-06 0.693750 3.25e-06 0.662500 3.298e-06 0.662500 3.3e-06 0.631250 3.348e-06 0.631250 3.35e-06 0.600000 3.398e-06 0.600000 3.4e-06 0.568750 3.448e-06 0.568750 3.45e-06 0.537500 3.498e-06 0.537500 3.5e-06 0.506250 3.548e-06 0.506250 3.55e-06 0.475000 3.598e-06 0.475000 3.6e-06 0.725000 3.648e-06 0.725000 3.65e-06 0.693750 3.698e-06 0.693750 3.7e-06 0.662500 3.748e-06 0.662500 3.75e-06 0.631250 3.798e-06 0.631250 3.8e-06 0.600000 3.848e-06 0.600000 3.85e-06 0.568750 3.898e-06 0.568750 3.9e-06 0.537500 3.948e-06 0.537500 3.95e-06 0.506250 3.998e-06 0.506250 4e-06 0.475000 4.048e-06 0.475000 4.05e-06 0.475000)
Vwp wp 0 PWL(0 0.375000 4.8e-08 0.375000 5e-08 0.375000 9.8e-08 0.375000 1e-07 0.375000 1.48e-07 0.375000 1.5e-07 0.375000 1.98e-07 0.375000 2e-07 0.375000 2.48e-07 0.375000 2.5e-07 0.375000 2.98e-07 0.375000 3e-07 0.375000 3.48e-07 0.375000 3.5e-07 0.375000 3.98e-07 0.375000 4e-07 0.375000 4.48e-07 0.375000 4.5e-07 0.406250 4.98e-07 0.406250 5e-07 0.406250 5.48e-07 0.406250 5.5e-07 0.406250 5.98e-07 0.406250 6e-07 0.406250 6.48e-07 0.406250 6.5e-07 0.406250 6.98e-07 0.406250 7e-07 0.406250 7.48e-07 0.406250 7.5e-07 0.406250 7.98e-07 0.406250 8e-07 0.406250 8.48e-07 0.406250 8.5e-07 0.406250 8.98e-07 0.406250 9e-07 0.437500 9.48e-07 0.437500 9.5e-07 0.437500 9.98e-07 0.437500 1e-06 0.437500 1.048e-06 0.437500 1.05e-06 0.437500 1.098e-06 0.437500 1.1e-06 0.437500 1.148e-06 0.437500 1.15e-06 0.437500 1.198e-06 0.437500 1.2e-06 0.437500 1.248e-06 0.437500 1.25e-06 0.437500 1.298e-06 0.437500 1.3e-06 0.437500 1.348e-06 0.437500 1.35e-06 0.468750 1.398e-06 0.468750 1.4e-06 0.468750 1.448e-06 0.468750 1.45e-06 0.468750 1.498e-06 0.468750 1.5e-06 0.468750 1.548e-06 0.468750 1.55e-06 0.468750 1.598e-06 0.468750 1.6e-06 0.468750 1.648e-06 0.468750 1.65e-06 0.468750 1.698e-06 0.468750 1.7e-06 0.468750 1.748e-06 0.468750 1.75e-06 0.468750 1.798e-06 0.468750 1.8e-06 0.500000 1.848e-06 0.500000 1.85e-06 0.500000 1.898e-06 0.500000 1.9e-06 0.500000 1.948e-06 0.500000 1.95e-06 0.500000 1.998e-06 0.500000 2e-06 0.500000 2.048e-06 0.500000 2.05e-06 0.500000 2.098e-06 0.500000 2.1e-06 0.500000 2.148e-06 0.500000 2.15e-06 0.500000 2.198e-06 0.500000 2.2e-06 0.500000 2.248e-06 0.500000 2.25e-06 0.531250 2.298e-06 0.531250 2.3e-06 0.531250 2.348e-06 0.531250 2.35e-06 0.531250 2.398e-06 0.531250 2.4e-06 0.531250 2.448e-06 0.531250 2.45e-06 0.531250 2.498e-06 0.531250 2.5e-06 0.531250 2.548e-06 0.531250 2.55e-06 0.531250 2.598e-06 0.531250 2.6e-06 0.531250 2.648e-06 0.531250 2.65e-06 0.531250 2.698e-06 0.531250 2.7e-06 0.562500 2.748e-06 0.562500 2.75e-06 0.562500 2.798e-06 0.562500 2.8e-06 0.562500 2.848e-06 0.562500 2.85e-06 0.562500 2.898e-06 0.562500 2.9e-06 0.562500 2.948e-06 0.562500 2.95e-06 0.562500 2.998e-06 0.562500 3e-06 0.562500 3.048e-06 0.562500 3.05e-06 0.562500 3.098e-06 0.562500 3.1e-06 0.562500 3.148e-06 0.562500 3.15e-06 0.593750 3.198e-06 0.593750 3.2e-06 0.593750 3.248e-06 0.593750 3.25e-06 0.593750 3.298e-06 0.593750 3.3e-06 0.593750 3.348e-06 0.593750 3.35e-06 0.593750 3.398e-06 0.593750 3.4e-06 0.593750 3.448e-06 0.593750 3.45e-06 0.593750 3.498e-06 0.593750 3.5e-06 0.593750 3.548e-06 0.593750 3.55e-06 0.593750 3.598e-06 0.593750 3.6e-06 0.625000 3.648e-06 0.625000 3.65e-06 0.625000 3.698e-06 0.625000 3.7e-06 0.625000 3.748e-06 0.625000 3.75e-06 0.625000 3.798e-06 0.625000 3.8e-06 0.625000 3.848e-06 0.625000 3.85e-06 0.625000 3.898e-06 0.625000 3.9e-06 0.625000 3.948e-06 0.625000 3.95e-06 0.625000 3.998e-06 0.625000 4e-06 0.625000 4.048e-06 0.625000 4.05e-06 0.625000)
Vwn wn 0 PWL(0 0.625000 4.8e-08 0.625000 5e-08 0.625000 9.8e-08 0.625000 1e-07 0.625000 1.48e-07 0.625000 1.5e-07 0.625000 1.98e-07 0.625000 2e-07 0.625000 2.48e-07 0.625000 2.5e-07 0.625000 2.98e-07 0.625000 3e-07 0.625000 3.48e-07 0.625000 3.5e-07 0.625000 3.98e-07 0.625000 4e-07 0.625000 4.48e-07 0.625000 4.5e-07 0.593750 4.98e-07 0.593750 5e-07 0.593750 5.48e-07 0.593750 5.5e-07 0.593750 5.98e-07 0.593750 6e-07 0.593750 6.48e-07 0.593750 6.5e-07 0.593750 6.98e-07 0.593750 7e-07 0.593750 7.48e-07 0.593750 7.5e-07 0.593750 7.98e-07 0.593750 8e-07 0.593750 8.48e-07 0.593750 8.5e-07 0.593750 8.98e-07 0.593750 9e-07 0.562500 9.48e-07 0.562500 9.5e-07 0.562500 9.98e-07 0.562500 1e-06 0.562500 1.048e-06 0.562500 1.05e-06 0.562500 1.098e-06 0.562500 1.1e-06 0.562500 1.148e-06 0.562500 1.15e-06 0.562500 1.198e-06 0.562500 1.2e-06 0.562500 1.248e-06 0.562500 1.25e-06 0.562500 1.298e-06 0.562500 1.3e-06 0.562500 1.348e-06 0.562500 1.35e-06 0.531250 1.398e-06 0.531250 1.4e-06 0.531250 1.448e-06 0.531250 1.45e-06 0.531250 1.498e-06 0.531250 1.5e-06 0.531250 1.548e-06 0.531250 1.55e-06 0.531250 1.598e-06 0.531250 1.6e-06 0.531250 1.648e-06 0.531250 1.65e-06 0.531250 1.698e-06 0.531250 1.7e-06 0.531250 1.748e-06 0.531250 1.75e-06 0.531250 1.798e-06 0.531250 1.8e-06 0.500000 1.848e-06 0.500000 1.85e-06 0.500000 1.898e-06 0.500000 1.9e-06 0.500000 1.948e-06 0.500000 1.95e-06 0.500000 1.998e-06 0.500000 2e-06 0.500000 2.048e-06 0.500000 2.05e-06 0.500000 2.098e-06 0.500000 2.1e-06 0.500000 2.148e-06 0.500000 2.15e-06 0.500000 2.198e-06 0.500000 2.2e-06 0.500000 2.248e-06 0.500000 2.25e-06 0.468750 2.298e-06 0.468750 2.3e-06 0.468750 2.348e-06 0.468750 2.35e-06 0.468750 2.398e-06 0.468750 2.4e-06 0.468750 2.448e-06 0.468750 2.45e-06 0.468750 2.498e-06 0.468750 2.5e-06 0.468750 2.548e-06 0.468750 2.55e-06 0.468750 2.598e-06 0.468750 2.6e-06 0.468750 2.648e-06 0.468750 2.65e-06 0.468750 2.698e-06 0.468750 2.7e-06 0.437500 2.748e-06 0.437500 2.75e-06 0.437500 2.798e-06 0.437500 2.8e-06 0.437500 2.848e-06 0.437500 2.85e-06 0.437500 2.898e-06 0.437500 2.9e-06 0.437500 2.948e-06 0.437500 2.95e-06 0.437500 2.998e-06 0.437500 3e-06 0.437500 3.048e-06 0.437500 3.05e-06 0.437500 3.098e-06 0.437500 3.1e-06 0.437500 3.148e-06 0.437500 3.15e-06 0.406250 3.198e-06 0.406250 3.2e-06 0.406250 3.248e-06 0.406250 3.25e-06 0.406250 3.298e-06 0.406250 3.3e-06 0.406250 3.348e-06 0.406250 3.35e-06 0.406250 3.398e-06 0.406250 3.4e-06 0.406250 3.448e-06 0.406250 3.45e-06 0.406250 3.498e-06 0.406250 3.5e-06 0.406250 3.548e-06 0.406250 3.55e-06 0.406250 3.598e-06 0.406250 3.6e-06 0.375000 3.648e-06 0.375000 3.65e-06 0.375000 3.698e-06 0.375000 3.7e-06 0.375000 3.748e-06 0.375000 3.75e-06 0.375000 3.798e-06 0.375000 3.8e-06 0.375000 3.848e-06 0.375000 3.85e-06 0.375000 3.898e-06 0.375000 3.9e-06 0.375000 3.948e-06 0.375000 3.95e-06 0.375000 3.998e-06 0.375000 4e-06 0.375000 4.048e-06 0.375000 4.05e-06 0.375000)
Vop outp 0 0.7
Von outn 0 0.7
Xs inp inn wp wn outp outn vdd vbsyn gsyn
.control
tran 2e-09 4.05e-06 uic
wrdata cell_char.txt i(Vop) i(Von)
echo CHAR_OK
.endc
.end
