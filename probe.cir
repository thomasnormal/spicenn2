* pipe probe rc
Va a 0 dc 0.2
R1 a b 10k
C1 b 0 200p
.end
