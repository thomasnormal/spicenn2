pc1
.model NNR NMOS (LEVEL=1 VTO=0.2 KP=120u LAMBDA=0.02 GAMMA=0 PHI=0.7)
.model PNR PMOS (LEVEL=1 VTO=-0.2 KP=40u LAMBDA=0.02 GAMMA=0 PHI=0.7)
.subckt gsyn inp inn wp wn outp outn vdd vbn
Mtail nt vbn 0 0 NNR W=400u L=100u
M5 na wp nt 0 NNR W=200u L=100u
M6 nb wn nt 0 NNR W=200u L=100u
M1 outp inp na 0 NNR W=200u L=100u
M2 outn inn na 0 NNR W=200u L=100u
M3 outn inp nb 0 NNR W=200u L=100u
M4 outp inn nb 0 NNR W=200u L=100u
.ends
.subckt cmld p n vdd
Rcs1 p cmx 300k
Rcs2 n cmx 300k
MLp p cmx vdd vdd PNR W=1000u L=100u
MLn n cmx vdd vdd PNR W=1000u L=100u
.ends
Vdd vdd 0 1.0
Vbsyn vbsyn 0 0.45
Vxp0 a_xp0 0 0.5
Vxn0 a_xn0 0 0.5
Vxp1 a_xp1 0 0.5
Vxn1 a_xn1 0 0.5
Vxp2 a_xp2 0 0.5
Vxn2 a_xn2 0 0.5
Vxp3 a_xp3 0 0.5
Vxn3 a_xn3 0 0.5
Vxp4 a_xp4 0 0.5
Vxn4 a_xn4 0 0.5
Vxp5 a_xp5 0 0.5
Vxn5 a_xn5 0 0.5
Vxp6 a_xp6 0 0.5
Vxn6 a_xn6 0 0.5
Vxp7 a_xp7 0 0.5
Vxn7 a_xn7 0 0.5
Vxp8 a_xp8 0 0.5
Vxn8 a_xn8 0 0.5
Vxp9 a_xp9 0 0.5
Vxn9 a_xn9 0 0.5
Vxp10 a_xp10 0 0.5
Vxn10 a_xn10 0 0.5
Vxp11 a_xp11 0 0.5
Vxn11 a_xn11 0 0.5
Vxp12 a_xp12 0 0.5
Vxn12 a_xn12 0 0.5
Vxp13 a_xp13 0 0.5
Vxn13 a_xn13 0 0.5
Vxp14 a_xp14 0 0.5
Vxn14 a_xn14 0 0.5
Vxp15 a_xp15 0 0.5
Vxn15 a_xn15 0 0.5
Vxp16 a_xp16 0 0.5
Vxn16 a_xn16 0 0.5
Vxp17 a_xp17 0 0.5
Vxn17 a_xn17 0 0.5
Vxp18 a_xp18 0 0.5
Vxn18 a_xn18 0 0.5
Vxp19 a_xp19 0 0.5
Vxn19 a_xn19 0 0.5
Vxp20 a_xp20 0 0.5
Vxn20 a_xn20 0 0.5
Vxp21 a_xp21 0 0.5
Vxn21 a_xn21 0 0.5
Vxp22 a_xp22 0 0.5
Vxn22 a_xn22 0 0.5
Vxp23 a_xp23 0 0.5
Vxn23 a_xn23 0 0.5
Vxp24 a_xp24 0 0.5
Vxn24 a_xn24 0 0.5
Vxp25 a_xp25 0 0.5
Vxn25 a_xn25 0 0.5
Vxp26 a_xp26 0 0.5
Vxn26 a_xn26 0 0.5
Vxp27 a_xp27 0 0.5
Vxn27 a_xn27 0 0.5
Vxp28 a_xp28 0 0.5
Vxn28 a_xn28 0 0.5
Vxp29 a_xp29 0 0.5
Vxn29 a_xn29 0 0.5
Vxp30 a_xp30 0 0.5
Vxn30 a_xn30 0 0.5
Vxp31 a_xp31 0 0.5
Vxn31 a_xn31 0 0.5
Vxp32 a_xp32 0 0.5
Vxn32 a_xn32 0 0.5
Vxp33 a_xp33 0 0.5
Vxn33 a_xn33 0 0.5
Vxp34 a_xp34 0 0.5
Vxn34 a_xn34 0 0.5
Vxp35 a_xp35 0 0.5
Vxn35 a_xn35 0 0.5
Vxp36 a_xp36 0 0.5
Vxn36 a_xn36 0 0.5
Vxp37 a_xp37 0 0.5
Vxn37 a_xn37 0 0.5
Vxp38 a_xp38 0 0.5
Vxn38 a_xn38 0 0.5
Vxp39 a_xp39 0 0.5
Vxn39 a_xn39 0 0.5
Vxp40 a_xp40 0 0.5
Vxn40 a_xn40 0 0.5
Vxp41 a_xp41 0 0.5
Vxn41 a_xn41 0 0.5
Vxp42 a_xp42 0 0.5
Vxn42 a_xn42 0 0.5
Vxp43 a_xp43 0 0.5
Vxn43 a_xn43 0 0.5
Vxp44 a_xp44 0 0.5
Vxn44 a_xn44 0 0.5
Vxp45 a_xp45 0 0.5
Vxn45 a_xn45 0 0.5
Vxp46 a_xp46 0 0.5
Vxn46 a_xn46 0 0.5
Vxp47 a_xp47 0 0.5
Vxn47 a_xn47 0 0.5
Vxp48 a_xp48 0 0.5
Vxn48 a_xn48 0 0.5
Vxp49 a_xp49 0 0.5
Vxn49 a_xn49 0 0.5
Vxp50 a_xp50 0 0.5
Vxn50 a_xn50 0 0.5
Vxp51 a_xp51 0 0.5
Vxn51 a_xn51 0 0.5
Vxp52 a_xp52 0 0.5
Vxn52 a_xn52 0 0.5
Vxp53 a_xp53 0 0.5
Vxn53 a_xn53 0 0.5
Vxp54 a_xp54 0 0.5
Vxn54 a_xn54 0 0.5
Vxp55 a_xp55 0 0.5
Vxn55 a_xn55 0 0.5
Vxp56 a_xp56 0 0.5
Vxn56 a_xn56 0 0.5
Vxp57 a_xp57 0 0.5
Vxn57 a_xn57 0 0.5
Vxp58 a_xp58 0 0.5
Vxn58 a_xn58 0 0.5
Vxp59 a_xp59 0 0.5
Vxn59 a_xn59 0 0.5
Vxp60 a_xp60 0 0.5
Vxn60 a_xn60 0 0.5
Vxp61 a_xp61 0 0.5
Vxn61 a_xn61 0 0.5
Vxp62 a_xp62 0 0.5
Vxn62 a_xn62 0 0.5
Vxp63 a_xp63 0 0.5
Vxn63 a_xn63 0 0.5
Vwp_0_0 wp_0_0 0 0.5099880939265242
Vwn_0_0 wn_0_0 0 0.4900119060734757
Vwp_1_0 wp_1_0 0 0.5043867959918309
Vwn_1_0 wn_1_0 0 0.4956132040081691
Vwp_2_0 wp_2_0 0 0.4858143279754948
Vwn_2_0 wn_2_0 0 0.5141856720245053
Vwp_3_0 wp_3_0 0 0.5079422834905264
Vwn_3_0 wn_3_0 0 0.4920577165094736
Vwp_4_0 wp_4_0 0 0.52278917661516
Vwn_4_0 wn_4_0 0 0.47721082338484
Vwp_5_0 wp_5_0 0 0.4807637328509909
Vwn_5_0 wn_5_0 0 0.5192362671490091
Vwp_6_0 wp_6_0 0 0.5009188369226311
Vwn_6_0 wn_6_0 0 0.499081163077369
Vwp_7_0 wp_7_0 0 0.529649770212991
Vwn_7_0 wn_7_0 0 0.470350229787009
Vwp_8_0 wp_8_0 0 0.5091673983357263
Vwn_8_0 wn_8_0 0 0.4908326016642737
Vwp_9_0 wp_9_0 0 0.5122007768615103
Vwn_9_0 wn_9_0 0 0.48779922313848967
Vwp_10_0 wp_10_0 0 0.4969977099424977
Vwn_10_0 wn_10_0 0 0.5030022900575023
Vwp_11_0 wp_11_0 0 0.48803054365793574
Vwn_11_0 wn_11_0 0 0.5119694563420643
Vwp_12_0 wp_12_0 0 0.5171505754231605
Vwn_12_0 wn_12_0 0 0.48284942457683955
Vwp_13_0 wp_13_0 0 0.5098058741624305
Vwn_13_0 wn_13_0 0 0.49019412583756955
Vwp_14_0 wp_14_0 0 0.49922715222147196
Vwn_14_0 wn_14_0 0 0.500772847778528
Vwp_15_0 wp_15_0 0 0.49301996412765003
Vwn_15_0 wn_15_0 0 0.50698003587235
Vwp_16_0 wp_16_0 0 0.4737841215737133
Vwn_16_0 wn_16_0 0 0.5262158784262867
Vwp_17_0 wp_17_0 0 0.5023385934367851
Vwn_17_0 wn_17_0 0 0.4976614065632149
Vwp_18_0 wp_18_0 0 0.48962430853154376
Vwn_18_0 wn_18_0 0 0.5103756914684563
Vwp_19_0 wp_19_0 0 0.49802218597428427
Vwn_19_0 wn_19_0 0 0.5019778140257157
Vwp_20_0 wp_20_0 0 0.5100646307638013
Vwn_20_0 wn_20_0 0 0.48993536923619874
Vwp_21_0 wp_21_0 0 0.5123000405855541
Vwn_21_0 wn_21_0 0 0.4876999594144459
Vwp_22_0 wp_22_0 0 0.5107850145356887
Vwn_22_0 wn_22_0 0 0.48921498546431125
Vwp_23_0 wp_23_0 0 0.5338259649830791
Vwn_23_0 wn_23_0 0 0.4661740350169209
Vwp_24_0 wp_24_0 0 0.5174767779377022
Vwn_24_0 wn_24_0 0 0.48252322206229775
Vwp_25_0 wp_25_0 0 0.48880882736340947
Vwn_25_0 wn_25_0 0 0.5111911726365905
Vwp_26_0 wp_26_0 0 0.4877254711467893
Vwn_26_0 wn_26_0 0 0.5122745288532107
Vwp_27_0 wp_27_0 0 0.5349222608688348
Vwn_27_0 wn_27_0 0 0.46507773913116524
Vwp_28_0 wp_28_0 0 0.49005010762560625
Vwn_28_0 wn_28_0 0 0.5099498923743938
Vwp_29_0 wp_29_0 0 0.4993379698620025
Vwn_29_0 wn_29_0 0 0.5006620301379975
Vwp_30_0 wp_30_0 0 0.5261728863163454
Vwn_30_0 wn_30_0 0 0.4738271136836546
Vwp_31_0 wp_31_0 0 0.525729738117434
Vwn_31_0 wn_31_0 0 0.4742702618825661
Vwp_32_0 wp_32_0 0 0.4991805195625599
Vwn_32_0 wn_32_0 0 0.5008194804374402
Vwp_33_0 wp_33_0 0 0.5036291462230832
Vwn_33_0 wn_33_0 0 0.4963708537769168
Vwp_34_0 wp_34_0 0 0.47547336046878996
Vwn_34_0 wn_34_0 0 0.52452663953121
Vwp_35_0 wp_35_0 0 0.4863747694921687
Vwn_35_0 wn_35_0 0 0.5136252305078313
Vwp_36_0 wp_36_0 0 0.49452111304835483
Vwn_36_0 wn_36_0 0 0.5054788869516452
Vwp_37_0 wp_37_0 0 0.49991509745767
Vwn_37_0 wn_37_0 0 0.5000849025423301
Vwp_38_0 wp_38_0 0 0.4951501928591438
Vwn_38_0 wn_38_0 0 0.5048498071408561
Vwp_39_0 wp_39_0 0 0.502284409723636
Vwn_39_0 wn_39_0 0 0.49771559027636403
Vwp_40_0 wp_40_0 0 0.5328905227084312
Vwn_40_0 wn_40_0 0 0.46710947729156876
Vwp_41_0 wp_41_0 0 0.5069651129134854
Vwn_41_0 wn_41_0 0 0.49303488708651455
Vwp_42_0 wp_42_0 0 0.5046306078163216
Vwn_42_0 wn_42_0 0 0.49536939218367837
Vwp_43_0 wp_43_0 0 0.5000273953383713
Vwn_43_0 wn_43_0 0 0.49997260466162874
Vwp_44_0 wp_44_0 0 0.4974213859250034
Vwn_44_0 wn_44_0 0 0.5025786140749966
Vwp_45_0 wp_45_0 0 0.5184941690031463
Vwn_45_0 wn_45_0 0 0.48150583099685373
Vwp_46_0 wp_46_0 0 0.48513107853926757
Vwn_46_0 wn_46_0 0 0.5148689214607324
Vwp_47_0 wp_47_0 0 0.4981163071240091
Vwn_47_0 wn_47_0 0 0.5018836928759909
Vwp_48_0 wp_48_0 0 0.48356334153373376
Vwn_48_0 wn_48_0 0 0.5164366584662662
Vwp_49_0 wp_49_0 0 0.5013069455288509
Vwn_49_0 wn_49_0 0 0.4986930544711491
Vwp_50_0 wp_50_0 0 0.5017857548335044
Vwn_50_0 wn_50_0 0 0.49821424516649554
Vwp_51_0 wp_51_0 0 0.513807597621696
Vwn_51_0 wn_51_0 0 0.48619240237830397
Vwp_52_0 wp_52_0 0 0.5179649243122473
Vwn_52_0 wn_52_0 0 0.4820350756877527
Vwp_53_0 wp_53_0 0 0.5099459649995024
Vwn_53_0 wn_53_0 0 0.4900540350004976
Vwp_54_0 wp_54_0 0 0.5243338893063554
Vwn_54_0 wn_54_0 0 0.4756661106936447
Vwp_55_0 wp_55_0 0 0.5238275490195922
Vwn_55_0 wn_55_0 0 0.47617245098040784
Vwp_56_0 wp_56_0 0 0.504730380320827
Vwn_56_0 wn_56_0 0 0.495269619679173
Vwp_57_0 wp_57_0 0 0.50560020293938
Vwn_57_0 wn_57_0 0 0.49439979706062
Vwp_58_0 wp_58_0 0 0.470955774624473
Vwn_58_0 wn_58_0 0 0.529044225375527
Vwp_59_0 wp_59_0 0 0.5048036480709133
Vwn_59_0 wn_59_0 0 0.4951963519290867
Vwp_60_0 wp_60_0 0 0.4999236266918323
Vwn_60_0 wn_60_0 0 0.5000763733081677
Vwp_61_0 wp_61_0 0 0.4746725718217476
Vwn_61_0 wn_61_0 0 0.5253274281782524
Vwp_62_0 wp_62_0 0 0.493529209522373
Vwn_62_0 wn_62_0 0 0.506470790477627
Vwp_63_0 wp_63_0 0 0.5143613595015812
Vwn_63_0 wn_63_0 0 0.48563864049841876
Vwp_0_1 wp_0_1 0 0.4814183851052475
Vwn_0_1 wn_0_1 0 0.5185816148947525
Vwp_1_1 wp_1_1 0 0.5193942674702706
Vwn_1_1 wn_1_1 0 0.4806057325297294
Vwp_2_1 wp_2_1 0 0.5071219897810697
Vwn_2_1 wn_2_1 0 0.4928780102189303
Vwp_3_1 wp_3_1 0 0.49657417864634684
Vwn_3_1 wn_3_1 0 0.5034258213536532
Vwp_4_1 wp_4_1 0 0.4978650906923192
Vwn_4_1 wn_4_1 0 0.5021349093076808
Vwp_5_1 wp_5_1 0 0.5124489065637432
Vwn_5_1 wn_5_1 0 0.48755109343625674
Vwp_6_1 wp_6_1 0 0.47852908580734044
Vwn_6_1 wn_6_1 0 0.5214709141926596
Vwp_7_1 wp_7_1 0 0.5306114290984542
Vwn_7_1 wn_7_1 0 0.46938857090154584
Vwp_8_1 wp_8_1 0 0.4877987070569828
Vwn_8_1 wn_8_1 0 0.5122012929430172
Vwp_9_1 wp_9_1 0 0.48852075137079365
Vwn_9_1 wn_9_1 0 0.5114792486292064
Vwp_10_1 wp_10_1 0 0.5183115229578392
Vwn_10_1 wn_10_1 0 0.4816884770421607
Vwp_11_1 wp_11_1 0 0.5118507850251759
Vwn_11_1 wn_11_1 0 0.48814921497482405
Vwp_12_1 wp_12_1 0 0.5198808754347471
Vwn_12_1 wn_12_1 0 0.48011912456525285
Vwp_13_1 wp_13_1 0 0.5156897161079672
Vwn_13_1 wn_13_1 0 0.4843102838920328
Vwp_14_1 wp_14_1 0 0.5056459389319717
Vwn_14_1 wn_14_1 0 0.49435406106802826
Vwp_15_1 wp_15_1 0 0.48085423780065367
Vwn_15_1 wn_15_1 0 0.5191457621993464
Vwp_16_1 wp_16_1 0 0.49290740134941996
Vwn_16_1 wn_16_1 0 0.50709259865058
Vwp_17_1 wp_17_1 0 0.5029765904693259
Vwn_17_1 wn_17_1 0 0.4970234095306741
Vwp_18_1 wp_18_1 0 0.49974226144309486
Vwn_18_1 wn_18_1 0 0.5002577385569051
Vwp_19_1 wp_19_1 0 0.46920825768976065
Vwn_19_1 wn_19_1 0 0.5307917423102393
Vwp_20_1 wp_20_1 0 0.5156660803903248
Vwn_20_1 wn_20_1 0 0.4843339196096752
Vwp_21_1 wp_21_1 0 0.5259671369295719
Vwn_21_1 wn_21_1 0 0.4740328630704281
Vwp_22_1 wp_22_1 0 0.5219614279803794
Vwn_22_1 wn_22_1 0 0.47803857201962063
Vwp_23_1 wp_23_1 0 0.48473210560284685
Vwn_23_1 wn_23_1 0 0.5152678943971531
Vwp_24_1 wp_24_1 0 0.5065395016960782
Vwn_24_1 wn_24_1 0 0.49346049830392186
Vwp_25_1 wp_25_1 0 0.46810252873122615
Vwn_25_1 wn_25_1 0 0.5318974712687738
Vwp_26_1 wp_26_1 0 0.5253502721297456
Vwn_26_1 wn_26_1 0 0.4746497278702544
Vwp_27_1 wp_27_1 0 0.47090184635331783
Vwn_27_1 wn_27_1 0 0.5290981536466822
Vwp_28_1 wp_28_1 0 0.5061576314487081
Vwn_28_1 wn_28_1 0 0.49384236855129193
Vwp_29_1 wp_29_1 0 0.5174386953293466
Vwn_29_1 wn_29_1 0 0.4825613046706534
Vwp_30_1 wp_30_1 0 0.5193698259639611
Vwn_30_1 wn_30_1 0 0.48063017403603897
Vwp_31_1 wp_31_1 0 0.5051595577206937
Vwn_31_1 wn_31_1 0 0.49484044227930635
Vwp_32_1 wp_32_1 0 0.4786152492633989
Vwn_32_1 wn_32_1 0 0.5213847507366012
Vwp_33_1 wp_33_1 0 0.4984823631043357
Vwn_33_1 wn_33_1 0 0.5015176368956643
Vwp_34_1 wp_34_1 0 0.4959752228872258
Vwn_34_1 wn_34_1 0 0.5040247771127743
Vwp_35_1 wp_35_1 0 0.5055253873857042
Vwn_35_1 wn_35_1 0 0.49447461261429576
Vwp_36_1 wp_36_1 0 0.5148161897602362
Vwn_36_1 wn_36_1 0 0.48518381023976376
Vwp_37_1 wp_37_1 0 0.5099306132346244
Vwn_37_1 wn_37_1 0 0.4900693867653756
Vwp_38_1 wp_38_1 0 0.531824248365043
Vwn_38_1 wn_38_1 0 0.46817575163495695
Vwp_39_1 wp_39_1 0 0.5099157628268333
Vwn_39_1 wn_39_1 0 0.49008423717316674
Vwp_40_1 wp_40_1 0 0.49416773737541175
Vwn_40_1 wn_40_1 0 0.5058322626245882
Vwp_41_1 wp_41_1 0 0.5244496932824028
Vwn_41_1 wn_41_1 0 0.4755503067175973
Vwp_42_1 wp_42_1 0 0.49528207902583005
Vwn_42_1 wn_42_1 0 0.5047179209741699
Vwp_43_1 wp_43_1 0 0.5042279526643159
Vwn_43_1 wn_43_1 0 0.4957720473356842
Vwp_44_1 wp_44_1 0 0.502711668895454
Vwn_44_1 wn_44_1 0 0.49728833110454596
Vwp_45_1 wp_45_1 0 0.4656015296253464
Vwn_45_1 wn_45_1 0 0.5343984703746536
Vwp_46_1 wp_46_1 0 0.5041522993013643
Vwn_46_1 wn_46_1 0 0.49584770069863576
Vwp_47_1 wp_47_1 0 0.5043415993025089
Vwn_47_1 wn_47_1 0 0.4956584006974911
Vwp_48_1 wp_48_1 0 0.49685442417541426
Vwn_48_1 wn_48_1 0 0.5031455758245857
Vwp_49_1 wp_49_1 0 0.49788069537111207
Vwn_49_1 wn_49_1 0 0.502119304628888
Vwp_50_1 wp_50_1 0 0.4807339475971723
Vwn_50_1 wn_50_1 0 0.5192660524028277
Vwp_51_1 wp_51_1 0 0.50123694963257
Vwn_51_1 wn_51_1 0 0.49876305036742996
Vwp_52_1 wp_52_1 0 0.5225438822960279
Vwn_52_1 wn_52_1 0 0.47745611770397206
Vwp_53_1 wp_53_1 0 0.49734095647983523
Vwn_53_1 wn_53_1 0 0.5026590435201648
Vwp_54_1 wp_54_1 0 0.49216811372771646
Vwn_54_1 wn_54_1 0 0.5078318862722836
Vwp_55_1 wp_55_1 0 0.4908840665778485
Vwn_55_1 wn_55_1 0 0.5091159334221516
Vwp_56_1 wp_56_1 0 0.53025631862281
Vwn_56_1 wn_56_1 0 0.46974368137719
Vwp_57_1 wp_57_1 0 0.47967134766684405
Vwn_57_1 wn_57_1 0 0.520328652333156
Vwp_58_1 wp_58_1 0 0.5126742465100529
Vwn_58_1 wn_58_1 0 0.4873257534899471
Vwp_59_1 wp_59_1 0 0.5016711770772002
Vwn_59_1 wn_59_1 0 0.4983288229227998
Vwp_60_1 wp_60_1 0 0.5288134463518548
Vwn_60_1 wn_60_1 0 0.4711865536481452
Vwp_61_1 wp_61_1 0 0.5196689813132606
Vwn_61_1 wn_61_1 0 0.48033101868673944
Vwp_62_1 wp_62_1 0 0.4986752296105698
Vwn_62_1 wn_62_1 0 0.5013247703894302
Vwp_63_1 wp_63_1 0 0.4768779704363573
Vwn_63_1 wn_63_1 0 0.5231220295636426
Vwp_0_2 wp_0_2 0 0.5214445976490787
Vwn_0_2 wn_0_2 0 0.47855540235092137
Vwp_1_2 wp_1_2 0 0.5218706550146653
Vwn_1_2 wn_1_2 0 0.47812934498533466
Vwp_2_2 wp_2_2 0 0.4834264700822231
Vwn_2_2 wn_2_2 0 0.5165735299177769
Vwp_3_2 wp_3_2 0 0.5111785024580769
Vwn_3_2 wn_3_2 0 0.48882149754192306
Vwp_4_2 wp_4_2 0 0.487988501767109
Vwn_4_2 wn_4_2 0 0.5120114982328909
Vwp_5_2 wp_5_2 0 0.4883571454045309
Vwn_5_2 wn_5_2 0 0.5116428545954691
Vwp_6_2 wp_6_2 0 0.47586029870845936
Vwn_6_2 wn_6_2 0 0.5241397012915406
Vwp_7_2 wp_7_2 0 0.5139935784124897
Vwn_7_2 wn_7_2 0 0.48600642158751034
Vwp_8_2 wp_8_2 0 0.5040669263914896
Vwn_8_2 wn_8_2 0 0.49593307360851036
Vwp_9_2 wp_9_2 0 0.5074174959606248
Vwn_9_2 wn_9_2 0 0.49258250403937515
Vwp_10_2 wp_10_2 0 0.5217871240509013
Vwn_10_2 wn_10_2 0 0.47821287594909867
Vwp_11_2 wp_11_2 0 0.5100293695489023
Vwn_11_2 wn_11_2 0 0.48997063045109773
Vwp_12_2 wp_12_2 0 0.5087684413525421
Vwn_12_2 wn_12_2 0 0.49123155864745793
Vwp_13_2 wp_13_2 0 0.5112391081859999
Vwn_13_2 wn_13_2 0 0.48876089181400006
Vwp_14_2 wp_14_2 0 0.48403142233691937
Vwn_14_2 wn_14_2 0 0.5159685776630807
Vwp_15_2 wp_15_2 0 0.49948302298076463
Vwn_15_2 wn_15_2 0 0.5005169770192354
Vwp_16_2 wp_16_2 0 0.4819060766803062
Vwn_16_2 wn_16_2 0 0.5180939233196937
Vwp_17_2 wp_17_2 0 0.4865013033408776
Vwn_17_2 wn_17_2 0 0.5134986966591224
Vwp_18_2 wp_18_2 0 0.4986227524775898
Vwn_18_2 wn_18_2 0 0.5013772475224102
Vwp_19_2 wp_19_2 0 0.5159283142726203
Vwn_19_2 wn_19_2 0 0.4840716857273797
Vwp_20_2 wp_20_2 0 0.5308732102084843
Vwn_20_2 wn_20_2 0 0.4691267897915156
Vwp_21_2 wp_21_2 0 0.4837221025566121
Vwn_21_2 wn_21_2 0 0.5162778974433879
Vwp_22_2 wp_22_2 0 0.5025999562453772
Vwn_22_2 wn_22_2 0 0.49740004375462277
Vwp_23_2 wp_23_2 0 0.4989363434569079
Vwn_23_2 wn_23_2 0 0.501063656543092
Vwp_24_2 wp_24_2 0 0.5079085343363434
Vwn_24_2 wn_24_2 0 0.49209146566365664
Vwp_25_2 wp_25_2 0 0.5087361482346345
Vwn_25_2 wn_25_2 0 0.49126385176536547
Vwp_26_2 wp_26_2 0 0.505436317464439
Vwn_26_2 wn_26_2 0 0.49456368253556104
Vwp_27_2 wp_27_2 0 0.4854923518632878
Vwn_27_2 wn_27_2 0 0.5145076481367121
Vwp_28_2 wp_28_2 0 0.5059201313442924
Vwn_28_2 wn_28_2 0 0.4940798686557076
Vwp_29_2 wp_29_2 0 0.5133849006961666
Vwn_29_2 wn_29_2 0 0.4866150993038334
Vwp_30_2 wp_30_2 0 0.49229913751330245
Vwn_30_2 wn_30_2 0 0.5077008624866975
Vwp_31_2 wp_31_2 0 0.5296724738538581
Vwn_31_2 wn_31_2 0 0.4703275261461419
Vwp_32_2 wp_32_2 0 0.4964763022707964
Vwn_32_2 wn_32_2 0 0.5035236977292036
Vwp_33_2 wp_33_2 0 0.4904920970330811
Vwn_33_2 wn_33_2 0 0.5095079029669188
Vwp_34_2 wp_34_2 0 0.504445685576119
Vwn_34_2 wn_34_2 0 0.49555431442388104
Vwp_35_2 wp_35_2 0 0.49613615773790604
Vwn_35_2 wn_35_2 0 0.5038638422620939
Vwp_36_2 wp_36_2 0 0.47949240778841773
Vwn_36_2 wn_36_2 0 0.5205075922115823
Vwp_37_2 wp_37_2 0 0.4996076482021555
Vwn_37_2 wn_37_2 0 0.5003923517978446
Vwp_38_2 wp_38_2 0 0.5239355366134761
Vwn_38_2 wn_38_2 0 0.4760644633865239
Vwp_39_2 wp_39_2 0 0.5300379847615976
Vwn_39_2 wn_39_2 0 0.4699620152384025
Vwp_40_2 wp_40_2 0 0.4914943780926392
Vwn_40_2 wn_40_2 0 0.5085056219073608
Vwp_41_2 wp_41_2 0 0.5135791190546273
Vwn_41_2 wn_41_2 0 0.4864208809453728
Vwp_42_2 wp_42_2 0 0.5019879418227963
Vwn_42_2 wn_42_2 0 0.4980120581772038
Vwp_43_2 wp_43_2 0 0.5042582994447846
Vwn_43_2 wn_43_2 0 0.49574170055521544
Vwp_44_2 wp_44_2 0 0.5190105681982061
Vwn_44_2 wn_44_2 0 0.4809894318017939
Vwp_45_2 wp_45_2 0 0.5127810729243356
Vwn_45_2 wn_45_2 0 0.4872189270756644
Vwp_46_2 wp_46_2 0 0.5023148062364223
Vwn_46_2 wn_46_2 0 0.4976851937635776
Vwp_47_2 wp_47_2 0 0.4860688357147165
Vwn_47_2 wn_47_2 0 0.5139311642852835
Vwp_48_2 wp_48_2 0 0.4831402873765122
Vwn_48_2 wn_48_2 0 0.5168597126234877
Vwp_49_2 wp_49_2 0 0.4990397283432903
Vwn_49_2 wn_49_2 0 0.5009602716567098
Vwp_50_2 wp_50_2 0 0.5048541999120032
Vwn_50_2 wn_50_2 0 0.49514580008799675
Vwp_51_2 wp_51_2 0 0.5075475783838861
Vwn_51_2 wn_51_2 0 0.49245242161611386
Vwp_52_2 wp_52_2 0 0.5117295403006348
Vwn_52_2 wn_52_2 0 0.48827045969936517
Vwp_53_2 wp_53_2 0 0.5146937769319714
Vwn_53_2 wn_53_2 0 0.4853062230680286
Vwp_54_2 wp_54_2 0 0.4639538495486814
Vwn_54_2 wn_54_2 0 0.5360461504513185
Vwp_55_2 wp_55_2 0 0.5135516049954445
Vwn_55_2 wn_55_2 0 0.48644839500455556
Vwp_56_2 wp_56_2 0 0.48428828335129215
Vwn_56_2 wn_56_2 0 0.5157117166487079
Vwp_57_2 wp_57_2 0 0.5167110286213545
Vwn_57_2 wn_57_2 0 0.4832889713786454
Vwp_58_2 wp_58_2 0 0.5050496649191345
Vwn_58_2 wn_58_2 0 0.4949503350808655
Vwp_59_2 wp_59_2 0 0.5094583972668055
Vwn_59_2 wn_59_2 0 0.49054160273319447
Vwp_60_2 wp_60_2 0 0.49188611377693886
Vwn_60_2 wn_60_2 0 0.5081138862230612
Vwp_61_2 wp_61_2 0 0.5042397698204906
Vwn_61_2 wn_61_2 0 0.49576023017950943
Vwp_62_2 wp_62_2 0 0.4719918113091455
Vwn_62_2 wn_62_2 0 0.5280081886908545
Vwp_63_2 wp_63_2 0 0.5164286992505687
Vwn_63_2 wn_63_2 0 0.4835713007494314
Vwp_0_3 wp_0_3 0 0.4950374189203878
Vwn_0_3 wn_0_3 0 0.5049625810796122
Vwp_1_3 wp_1_3 0 0.46116379557754567
Vwn_1_3 wn_1_3 0 0.5388362044224544
Vwp_2_3 wp_2_3 0 0.5159222533048884
Vwn_2_3 wn_2_3 0 0.4840777466951116
Vwp_3_3 wp_3_3 0 0.5251516058997858
Vwn_3_3 wn_3_3 0 0.4748483941002142
Vwp_4_3 wp_4_3 0 0.4868580572539398
Vwn_4_3 wn_4_3 0 0.5131419427460602
Vwp_5_3 wp_5_3 0 0.5181906482868912
Vwn_5_3 wn_5_3 0 0.48180935171310874
Vwp_6_3 wp_6_3 0 0.4887536682333141
Vwn_6_3 wn_6_3 0 0.5112463317666859
Vwp_7_3 wp_7_3 0 0.46600219055100933
Vwn_7_3 wn_7_3 0 0.5339978094489907
Vwp_8_3 wp_8_3 0 0.4946316128858101
Vwn_8_3 wn_8_3 0 0.5053683871141899
Vwp_9_3 wp_9_3 0 0.504892046779894
Vwn_9_3 wn_9_3 0 0.495107953220106
Vwp_10_3 wp_10_3 0 0.502003266940667
Vwn_10_3 wn_10_3 0 0.49799673305933295
Vwp_11_3 wp_11_3 0 0.5015539692424196
Vwn_11_3 wn_11_3 0 0.49844603075758037
Vwp_12_3 wp_12_3 0 0.5044463428664347
Vwn_12_3 wn_12_3 0 0.49555365713356525
Vwp_13_3 wp_13_3 0 0.5032483349543434
Vwn_13_3 wn_13_3 0 0.49675166504565665
Vwp_14_3 wp_14_3 0 0.49675942544813206
Vwn_14_3 wn_14_3 0 0.5032405745518679
Vwp_15_3 wp_15_3 0 0.4909792794027004
Vwn_15_3 wn_15_3 0 0.5090207205972996
Vwp_16_3 wp_16_3 0 0.4960129872867992
Vwn_16_3 wn_16_3 0 0.5039870127132008
Vwp_17_3 wp_17_3 0 0.4947249115076296
Vwn_17_3 wn_17_3 0 0.5052750884923705
Vwp_18_3 wp_18_3 0 0.4954561606484764
Vwn_18_3 wn_18_3 0 0.5045438393515236
Vwp_19_3 wp_19_3 0 0.4834556985307182
Vwn_19_3 wn_19_3 0 0.5165443014692819
Vwp_20_3 wp_20_3 0 0.4918610842322424
Vwn_20_3 wn_20_3 0 0.5081389157677576
Vwp_21_3 wp_21_3 0 0.5012333928317767
Vwn_21_3 wn_21_3 0 0.4987666071682233
Vwp_22_3 wp_22_3 0 0.5046412836565459
Vwn_22_3 wn_22_3 0 0.49535871634345413
Vwp_23_3 wp_23_3 0 0.49903956578721975
Vwn_23_3 wn_23_3 0 0.5009604342127802
Vwp_24_3 wp_24_3 0 0.49724510128647
Vwn_24_3 wn_24_3 0 0.50275489871353
Vwp_25_3 wp_25_3 0 0.5080167481035824
Vwn_25_3 wn_25_3 0 0.49198325189641756
Vwp_26_3 wp_26_3 0 0.5122170299092257
Vwn_26_3 wn_26_3 0 0.48778297009077437
Vwp_27_3 wp_27_3 0 0.5102011981805072
Vwn_27_3 wn_27_3 0 0.48979880181949276
Vwp_28_3 wp_28_3 0 0.4737513637185666
Vwn_28_3 wn_28_3 0 0.5262486362814334
Vwp_29_3 wp_29_3 0 0.4931689236311845
Vwn_29_3 wn_29_3 0 0.5068310763688155
Vwp_30_3 wp_30_3 0 0.5105848188055299
Vwn_30_3 wn_30_3 0 0.48941518119447014
Vwp_31_3 wp_31_3 0 0.507730959855156
Vwn_31_3 wn_31_3 0 0.49226904014484396
Vwp_32_3 wp_32_3 0 0.5101971590195712
Vwn_32_3 wn_32_3 0 0.48980284098042887
Vwp_33_3 wp_33_3 0 0.5047152726202914
Vwn_33_3 wn_33_3 0 0.49528472737970863
Vwp_34_3 wp_34_3 0 0.4871969479653286
Vwn_34_3 wn_34_3 0 0.5128030520346714
Vwp_35_3 wp_35_3 0 0.5183384679851121
Vwn_35_3 wn_35_3 0 0.48166153201488787
Vwp_36_3 wp_36_3 0 0.47960616688680097
Vwn_36_3 wn_36_3 0 0.5203938331131991
Vwp_37_3 wp_37_3 0 0.514786366886356
Vwn_37_3 wn_37_3 0 0.4852136331136439
Vwp_38_3 wp_38_3 0 0.49975437303139103
Vwn_38_3 wn_38_3 0 0.500245626968609
Vwp_39_3 wp_39_3 0 0.47791018663570006
Vwn_39_3 wn_39_3 0 0.5220898133642999
Vwp_40_3 wp_40_3 0 0.49405761799169556
Vwn_40_3 wn_40_3 0 0.5059423820083044
Vwp_41_3 wp_41_3 0 0.518056276197756
Vwn_41_3 wn_41_3 0 0.481943723802244
Vwp_42_3 wp_42_3 0 0.4911739749525424
Vwn_42_3 wn_42_3 0 0.5088260250474577
Vwp_43_3 wp_43_3 0 0.4818409640477851
Vwn_43_3 wn_43_3 0 0.5181590359522149
Vwp_44_3 wp_44_3 0 0.49566814574361795
Vwn_44_3 wn_44_3 0 0.504331854256382
Vwp_45_3 wp_45_3 0 0.48772887562187667
Vwn_45_3 wn_45_3 0 0.5122711243781234
Vwp_46_3 wp_46_3 0 0.48124100031157113
Vwn_46_3 wn_46_3 0 0.5187589996884289
Vwp_47_3 wp_47_3 0 0.5065630662834045
Vwn_47_3 wn_47_3 0 0.4934369337165954
Vwp_48_3 wp_48_3 0 0.5119725846139671
Vwn_48_3 wn_48_3 0 0.4880274153860329
Vwp_49_3 wp_49_3 0 0.49172402874213317
Vwn_49_3 wn_49_3 0 0.5082759712578668
Vwp_50_3 wp_50_3 0 0.5078543438546733
Vwn_50_3 wn_50_3 0 0.49214565614532674
Vwp_51_3 wp_51_3 0 0.49419459477620714
Vwn_51_3 wn_51_3 0 0.5058054052237928
Vwp_52_3 wp_52_3 0 0.4985042880626477
Vwn_52_3 wn_52_3 0 0.5014957119373523
Vwp_53_3 wp_53_3 0 0.5018510361648886
Vwn_53_3 wn_53_3 0 0.4981489638351115
Vwp_54_3 wp_54_3 0 0.5223992531208802
Vwn_54_3 wn_54_3 0 0.47760074687911974
Vwp_55_3 wp_55_3 0 0.5076133829775804
Vwn_55_3 wn_55_3 0 0.4923866170224196
Vwp_56_3 wp_56_3 0 0.4850133033719017
Vwn_56_3 wn_56_3 0 0.5149866966280983
Vwp_57_3 wp_57_3 0 0.50773743853625
Vwn_57_3 wn_57_3 0 0.49226256146375
Vwp_58_3 wp_58_3 0 0.49668217594644903
Vwn_58_3 wn_58_3 0 0.503317824053551
Vwp_59_3 wp_59_3 0 0.49300459386638584
Vwn_59_3 wn_59_3 0 0.5069954061336142
Vwp_60_3 wp_60_3 0 0.48740357963720016
Vwn_60_3 wn_60_3 0 0.5125964203627998
Vwp_61_3 wp_61_3 0 0.4996060960616537
Vwn_61_3 wn_61_3 0 0.5003939039383464
Vwp_62_3 wp_62_3 0 0.49909801347069976
Vwn_62_3 wn_62_3 0 0.5009019865293003
Vwp_63_3 wp_63_3 0 0.4939672645318328
Vwn_63_3 wn_63_3 0 0.5060327354681672
Vwp_0_4 wp_0_4 0 0.47913278983852603
Vwn_0_4 wn_0_4 0 0.520867210161474
Vwp_1_4 wp_1_4 0 0.4743924156039572
Vwn_1_4 wn_1_4 0 0.5256075843960428
Vwp_2_4 wp_2_4 0 0.5019197673802198
Vwn_2_4 wn_2_4 0 0.4980802326197802
Vwp_3_4 wp_3_4 0 0.5026730713018438
Vwn_3_4 wn_3_4 0 0.49732692869815626
Vwp_4_4 wp_4_4 0 0.5327469303102806
Vwn_4_4 wn_4_4 0 0.4672530696897194
Vwp_5_4 wp_5_4 0 0.49732005485955355
Vwn_5_4 wn_5_4 0 0.5026799451404464
Vwp_6_4 wp_6_4 0 0.5153213611875742
Vwn_6_4 wn_6_4 0 0.4846786388124258
Vwp_7_4 wp_7_4 0 0.5179280558347884
Vwn_7_4 wn_7_4 0 0.4820719441652116
Vwp_8_4 wp_8_4 0 0.49908399866913133
Vwn_8_4 wn_8_4 0 0.5009160013308687
Vwp_9_4 wp_9_4 0 0.5011520150515637
Vwn_9_4 wn_9_4 0 0.49884798494843635
Vwp_10_4 wp_10_4 0 0.4935523439408336
Vwn_10_4 wn_10_4 0 0.5064476560591664
Vwp_11_4 wp_11_4 0 0.5266273881617645
Vwn_11_4 wn_11_4 0 0.4733726118382355
Vwp_12_4 wp_12_4 0 0.4773735174311662
Vwn_12_4 wn_12_4 0 0.5226264825688338
Vwp_13_4 wp_13_4 0 0.49940530777043446
Vwn_13_4 wn_13_4 0 0.5005946922295655
Vwp_14_4 wp_14_4 0 0.5207618449115547
Vwn_14_4 wn_14_4 0 0.47923815508844525
Vwp_15_4 wp_15_4 0 0.4983847990499964
Vwn_15_4 wn_15_4 0 0.5016152009500036
Vwp_16_4 wp_16_4 0 0.4914359375033205
Vwn_16_4 wn_16_4 0 0.5085640624966795
Vwp_17_4 wp_17_4 0 0.503493239554178
Vwn_17_4 wn_17_4 0 0.496506760445822
Vwp_18_4 wp_18_4 0 0.5079048201902385
Vwn_18_4 wn_18_4 0 0.49209517980976153
Vwp_19_4 wp_19_4 0 0.5085116461052972
Vwn_19_4 wn_19_4 0 0.4914883538947028
Vwp_20_4 wp_20_4 0 0.5042246497240318
Vwn_20_4 wn_20_4 0 0.49577535027596814
Vwp_21_4 wp_21_4 0 0.5112513667954661
Vwn_21_4 wn_21_4 0 0.48874863320453393
Vwp_22_4 wp_22_4 0 0.5141855158399801
Vwn_22_4 wn_22_4 0 0.48581448416002
Vwp_23_4 wp_23_4 0 0.48339675631431267
Vwn_23_4 wn_23_4 0 0.5166032436856873
Vwp_24_4 wp_24_4 0 0.49431662262128523
Vwn_24_4 wn_24_4 0 0.5056833773787147
Vwp_25_4 wp_25_4 0 0.5130453698936804
Vwn_25_4 wn_25_4 0 0.48695463010631956
Vwp_26_4 wp_26_4 0 0.5073293003672084
Vwn_26_4 wn_26_4 0 0.4926706996327916
Vwp_27_4 wp_27_4 0 0.5035190016252252
Vwn_27_4 wn_27_4 0 0.4964809983747748
Vwp_28_4 wp_28_4 0 0.5100871833817736
Vwn_28_4 wn_28_4 0 0.48991281661822644
Vwp_29_4 wp_29_4 0 0.514282306020513
Vwn_29_4 wn_29_4 0 0.4857176939794871
Vwp_30_4 wp_30_4 0 0.48712929411399825
Vwn_30_4 wn_30_4 0 0.5128707058860017
Vwp_31_4 wp_31_4 0 0.4815958338178434
Vwn_31_4 wn_31_4 0 0.5184041661821567
Vwp_32_4 wp_32_4 0 0.4826947780897284
Vwn_32_4 wn_32_4 0 0.5173052219102716
Vwp_33_4 wp_33_4 0 0.5278801119370429
Vwn_33_4 wn_33_4 0 0.4721198880629571
Vwp_34_4 wp_34_4 0 0.48418351140128085
Vwn_34_4 wn_34_4 0 0.5158164885987191
Vwp_35_4 wp_35_4 0 0.49648119316182493
Vwn_35_4 wn_35_4 0 0.5035188068381751
Vwp_36_4 wp_36_4 0 0.49721782551372773
Vwn_36_4 wn_36_4 0 0.5027821744862723
Vwp_37_4 wp_37_4 0 0.5154659024781356
Vwn_37_4 wn_37_4 0 0.4845340975218644
Vwp_38_4 wp_38_4 0 0.4739251835164854
Vwn_38_4 wn_38_4 0 0.5260748164835146
Vwp_39_4 wp_39_4 0 0.4994109768356989
Vwn_39_4 wn_39_4 0 0.5005890231643011
Vwp_40_4 wp_40_4 0 0.5182158252027304
Vwn_40_4 wn_40_4 0 0.48178417479726965
Vwp_41_4 wp_41_4 0 0.516723496432859
Vwn_41_4 wn_41_4 0 0.48327650356714097
Vwp_42_4 wp_42_4 0 0.5061396799165475
Vwn_42_4 wn_42_4 0 0.49386032008345254
Vwp_43_4 wp_43_4 0 0.49608591368930094
Vwn_43_4 wn_43_4 0 0.503914086310699
Vwp_44_4 wp_44_4 0 0.5263652516995253
Vwn_44_4 wn_44_4 0 0.47363474830047475
Vwp_45_4 wp_45_4 0 0.47492079235221485
Vwn_45_4 wn_45_4 0 0.5250792076477852
Vwp_46_4 wp_46_4 0 0.5147147791281778
Vwn_46_4 wn_46_4 0 0.48528522087182224
Vwp_47_4 wp_47_4 0 0.5076226683296879
Vwn_47_4 wn_47_4 0 0.49237733167031206
Vwp_48_4 wp_48_4 0 0.5088655502661151
Vwn_48_4 wn_48_4 0 0.49113444973388487
Vwp_49_4 wp_49_4 0 0.5039871324536171
Vwn_49_4 wn_49_4 0 0.4960128675463828
Vwp_50_4 wp_50_4 0 0.503077702211705
Vwn_50_4 wn_50_4 0 0.496922297788295
Vwp_51_4 wp_51_4 0 0.5139618199370333
Vwn_51_4 wn_51_4 0 0.48603818006296673
Vwp_52_4 wp_52_4 0 0.48270432817024067
Vwn_52_4 wn_52_4 0 0.5172956718297593
Vwp_53_4 wp_53_4 0 0.48130172081682304
Vwn_53_4 wn_53_4 0 0.518698279183177
Vwp_54_4 wp_54_4 0 0.5024367985301573
Vwn_54_4 wn_54_4 0 0.4975632014698427
Vwp_55_4 wp_55_4 0 0.5007822618752337
Vwn_55_4 wn_55_4 0 0.49921773812476633
Vwp_56_4 wp_56_4 0 0.5024549024350956
Vwn_56_4 wn_56_4 0 0.4975450975649044
Vwp_57_4 wp_57_4 0 0.523856494752578
Vwn_57_4 wn_57_4 0 0.476143505247422
Vwp_58_4 wp_58_4 0 0.49131035969660536
Vwn_58_4 wn_58_4 0 0.5086896403033946
Vwp_59_4 wp_59_4 0 0.5112697814171114
Vwn_59_4 wn_59_4 0 0.4887302185828885
Vwp_60_4 wp_60_4 0 0.5057667155561026
Vwn_60_4 wn_60_4 0 0.49423328444389736
Vwp_61_4 wp_61_4 0 0.5354984360351073
Vwn_61_4 wn_61_4 0 0.4645015639648927
Vwp_62_4 wp_62_4 0 0.47896720022751615
Vwn_62_4 wn_62_4 0 0.5210327997724838
Vwp_63_4 wp_63_4 0 0.4918098932250238
Vwn_63_4 wn_63_4 0 0.5081901067749762
Vwp_0_5 wp_0_5 0 0.49314814948950736
Vwn_0_5 wn_0_5 0 0.5068518505104926
Vwp_1_5 wp_1_5 0 0.519809043449062
Vwn_1_5 wn_1_5 0 0.48019095655093796
Vwp_2_5 wp_2_5 0 0.48770122143746175
Vwn_2_5 wn_2_5 0 0.5122987785625382
Vwp_3_5 wp_3_5 0 0.5248691449927451
Vwn_3_5 wn_3_5 0 0.475130855007255
Vwp_4_5 wp_4_5 0 0.5239716246970203
Vwn_4_5 wn_4_5 0 0.4760283753029797
Vwp_5_5 wp_5_5 0 0.5129841897634091
Vwn_5_5 wn_5_5 0 0.48701581023659096
Vwp_6_5 wp_6_5 0 0.5065606406034048
Vwn_6_5 wn_6_5 0 0.49343935939659517
Vwp_7_5 wp_7_5 0 0.47665732716595094
Vwn_7_5 wn_7_5 0 0.5233426728340491
Vwp_8_5 wp_8_5 0 0.5027322426031752
Vwn_8_5 wn_8_5 0 0.4972677573968249
Vwp_9_5 wp_9_5 0 0.47853992511892457
Vwn_9_5 wn_9_5 0 0.5214600748810754
Vwp_10_5 wp_10_5 0 0.4945606041558274
Vwn_10_5 wn_10_5 0 0.5054393958441726
Vwp_11_5 wp_11_5 0 0.5030465109994454
Vwn_11_5 wn_11_5 0 0.4969534890005545
Vwp_12_5 wp_12_5 0 0.495366929315462
Vwn_12_5 wn_12_5 0 0.504633070684538
Vwp_13_5 wp_13_5 0 0.5142620843331366
Vwn_13_5 wn_13_5 0 0.48573791566686336
Vwp_14_5 wp_14_5 0 0.4980623577930552
Vwn_14_5 wn_14_5 0 0.5019376422069448
Vwp_15_5 wp_15_5 0 0.47677126669593234
Vwn_15_5 wn_15_5 0 0.5232287333040676
Vwp_16_5 wp_16_5 0 0.48409914160953965
Vwn_16_5 wn_16_5 0 0.5159008583904603
Vwp_17_5 wp_17_5 0 0.480891374148251
Vwn_17_5 wn_17_5 0 0.519108625851749
Vwp_18_5 wp_18_5 0 0.49525354433351093
Vwn_18_5 wn_18_5 0 0.504746455666489
Vwp_19_5 wp_19_5 0 0.5187137728552969
Vwn_19_5 wn_19_5 0 0.4812862271447032
Vwp_20_5 wp_20_5 0 0.5075861907221992
Vwn_20_5 wn_20_5 0 0.4924138092778008
Vwp_21_5 wp_21_5 0 0.5050926420736955
Vwn_21_5 wn_21_5 0 0.49490735792630447
Vwp_22_5 wp_22_5 0 0.48071927910271023
Vwn_22_5 wn_22_5 0 0.5192807208972898
Vwp_23_5 wp_23_5 0 0.535537457794853
Vwn_23_5 wn_23_5 0 0.46446254220514704
Vwp_24_5 wp_24_5 0 0.49957605256717375
Vwn_24_5 wn_24_5 0 0.5004239474328263
Vwp_25_5 wp_25_5 0 0.5362536900474826
Vwn_25_5 wn_25_5 0 0.4637463099525175
Vwp_26_5 wp_26_5 0 0.4869886783054625
Vwn_26_5 wn_26_5 0 0.5130113216945376
Vwp_27_5 wp_27_5 0 0.4914823027919597
Vwn_27_5 wn_27_5 0 0.5085176972080403
Vwp_28_5 wp_28_5 0 0.538994922354005
Vwn_28_5 wn_28_5 0 0.46100507764599497
Vwp_29_5 wp_29_5 0 0.48387509031116394
Vwn_29_5 wn_29_5 0 0.5161249096888361
Vwp_30_5 wp_30_5 0 0.5062805873103782
Vwn_30_5 wn_30_5 0 0.49371941268962183
Vwp_31_5 wp_31_5 0 0.4949269208828291
Vwn_31_5 wn_31_5 0 0.5050730791171709
Vwp_32_5 wp_32_5 0 0.48779881490463484
Vwn_32_5 wn_32_5 0 0.5122011850953652
Vwp_33_5 wp_33_5 0 0.5324161939492693
Vwn_33_5 wn_33_5 0 0.46758380605073063
Vwp_34_5 wp_34_5 0 0.4849380342378405
Vwn_34_5 wn_34_5 0 0.5150619657621596
Vwp_35_5 wp_35_5 0 0.5134615250239589
Vwn_35_5 wn_35_5 0 0.486538474976041
Vwp_36_5 wp_36_5 0 0.5165646889622572
Vwn_36_5 wn_36_5 0 0.48343531103774284
Vwp_37_5 wp_37_5 0 0.48482297816786785
Vwn_37_5 wn_37_5 0 0.5151770218321321
Vwp_38_5 wp_38_5 0 0.4715416206371846
Vwn_38_5 wn_38_5 0 0.5284583793628154
Vwp_39_5 wp_39_5 0 0.4732904015410444
Vwn_39_5 wn_39_5 0 0.5267095984589556
Vwp_40_5 wp_40_5 0 0.4880062479828843
Vwn_40_5 wn_40_5 0 0.5119937520171157
Vwp_41_5 wp_41_5 0 0.5033399700312876
Vwn_41_5 wn_41_5 0 0.49666002996871234
Vwp_42_5 wp_42_5 0 0.5050316319575572
Vwn_42_5 wn_42_5 0 0.4949683680424428
Vwp_43_5 wp_43_5 0 0.49716430138750506
Vwn_43_5 wn_43_5 0 0.5028356986124949
Vwp_44_5 wp_44_5 0 0.49842040123023806
Vwn_44_5 wn_44_5 0 0.5015795987697619
Vwp_45_5 wp_45_5 0 0.5146107103756988
Vwn_45_5 wn_45_5 0 0.48538928962430117
Vwp_46_5 wp_46_5 0 0.5115222946760476
Vwn_46_5 wn_46_5 0 0.48847770532395235
Vwp_47_5 wp_47_5 0 0.5056813133771252
Vwn_47_5 wn_47_5 0 0.4943186866228748
Vwp_48_5 wp_48_5 0 0.49074549322839695
Vwn_48_5 wn_48_5 0 0.5092545067716031
Vwp_49_5 wp_49_5 0 0.5116635916842497
Vwn_49_5 wn_49_5 0 0.4883364083157503
Vwp_50_5 wp_50_5 0 0.5027181451613248
Vwn_50_5 wn_50_5 0 0.49728185483867515
Vwp_51_5 wp_51_5 0 0.48878247279183634
Vwn_51_5 wn_51_5 0 0.5112175272081636
Vwp_52_5 wp_52_5 0 0.4913465618443196
Vwn_52_5 wn_52_5 0 0.5086534381556804
Vwp_53_5 wp_53_5 0 0.5184297163765581
Vwn_53_5 wn_53_5 0 0.4815702836234419
Vwp_54_5 wp_54_5 0 0.5276807294387503
Vwn_54_5 wn_54_5 0 0.47231927056124967
Vwp_55_5 wp_55_5 0 0.4920540990135429
Vwn_55_5 wn_55_5 0 0.5079459009864571
Vwp_56_5 wp_56_5 0 0.4688289776850169
Vwn_56_5 wn_56_5 0 0.531171022314983
Vwp_57_5 wp_57_5 0 0.5088119557549005
Vwn_57_5 wn_57_5 0 0.49118804424509954
Vwp_58_5 wp_58_5 0 0.48645105760694696
Vwn_58_5 wn_58_5 0 0.513548942393053
Vwp_59_5 wp_59_5 0 0.5109874724123926
Vwn_59_5 wn_59_5 0 0.4890125275876074
Vwp_60_5 wp_60_5 0 0.4943606408344754
Vwn_60_5 wn_60_5 0 0.5056393591655246
Vwp_61_5 wp_61_5 0 0.533443977197341
Vwn_61_5 wn_61_5 0 0.46655602280265895
Vwp_62_5 wp_62_5 0 0.501683667580112
Vwn_62_5 wn_62_5 0 0.49831633241988804
Vwp_63_5 wp_63_5 0 0.5135427605167039
Vwn_63_5 wn_63_5 0 0.4864572394832961
Vwp_0_6 wp_0_6 0 0.48177419403074123
Vwn_0_6 wn_0_6 0 0.5182258059692588
Vwp_1_6 wp_1_6 0 0.45771062842353843
Vwn_1_6 wn_1_6 0 0.5422893715764616
Vwp_2_6 wp_2_6 0 0.5020299667760363
Vwn_2_6 wn_2_6 0 0.49797003322396377
Vwp_3_6 wp_3_6 0 0.5039294463515277
Vwn_3_6 wn_3_6 0 0.4960705536484723
Vwp_4_6 wp_4_6 0 0.5108044945341335
Vwn_4_6 wn_4_6 0 0.4891955054658666
Vwp_5_6 wp_5_6 0 0.4916928281951768
Vwn_5_6 wn_5_6 0 0.5083071718048232
Vwp_6_6 wp_6_6 0 0.4806224224303431
Vwn_6_6 wn_6_6 0 0.5193775775696569
Vwp_7_6 wp_7_6 0 0.47599256936227397
Vwn_7_6 wn_7_6 0 0.524007430637726
Vwp_8_6 wp_8_6 0 0.50829711372057
Vwn_8_6 wn_8_6 0 0.49170288627943004
Vwp_9_6 wp_9_6 0 0.5106543638914072
Vwn_9_6 wn_9_6 0 0.48934563610859283
Vwp_10_6 wp_10_6 0 0.486863625074056
Vwn_10_6 wn_10_6 0 0.513136374925944
Vwp_11_6 wp_11_6 0 0.49207948069573765
Vwn_11_6 wn_11_6 0 0.5079205193042623
Vwp_12_6 wp_12_6 0 0.48907721836627616
Vwn_12_6 wn_12_6 0 0.5109227816337238
Vwp_13_6 wp_13_6 0 0.47157188775678843
Vwn_13_6 wn_13_6 0 0.5284281122432115
Vwp_14_6 wp_14_6 0 0.5029867341307477
Vwn_14_6 wn_14_6 0 0.49701326586925226
Vwp_15_6 wp_15_6 0 0.512690241749213
Vwn_15_6 wn_15_6 0 0.48730975825078704
Vwp_16_6 wp_16_6 0 0.49664975433902686
Vwn_16_6 wn_16_6 0 0.5033502456609732
Vwp_17_6 wp_17_6 0 0.4786629154302408
Vwn_17_6 wn_17_6 0 0.5213370845697591
Vwp_18_6 wp_18_6 0 0.4970251717482465
Vwn_18_6 wn_18_6 0 0.5029748282517535
Vwp_19_6 wp_19_6 0 0.5204663403593515
Vwn_19_6 wn_19_6 0 0.47953365964064854
Vwp_20_6 wp_20_6 0 0.531948590925993
Vwn_20_6 wn_20_6 0 0.468051409074007
Vwp_21_6 wp_21_6 0 0.504036457088919
Vwn_21_6 wn_21_6 0 0.495963542911081
Vwp_22_6 wp_22_6 0 0.4881658845695625
Vwn_22_6 wn_22_6 0 0.5118341154304376
Vwp_23_6 wp_23_6 0 0.4702163680934403
Vwn_23_6 wn_23_6 0 0.5297836319065596
Vwp_24_6 wp_24_6 0 0.476810958586472
Vwn_24_6 wn_24_6 0 0.5231890414135281
Vwp_25_6 wp_25_6 0 0.4986666867471991
Vwn_25_6 wn_25_6 0 0.5013333132528008
Vwp_26_6 wp_26_6 0 0.5033864814530362
Vwn_26_6 wn_26_6 0 0.4966135185469638
Vwp_27_6 wp_27_6 0 0.5038495988661976
Vwn_27_6 wn_27_6 0 0.4961504011338024
Vwp_28_6 wp_28_6 0 0.4960553380182989
Vwn_28_6 wn_28_6 0 0.5039446619817011
Vwp_29_6 wp_29_6 0 0.47685166842858606
Vwn_29_6 wn_29_6 0 0.5231483315714139
Vwp_30_6 wp_30_6 0 0.47635316105405795
Vwn_30_6 wn_30_6 0 0.523646838945942
Vwp_31_6 wp_31_6 0 0.5022098654648628
Vwn_31_6 wn_31_6 0 0.4977901345351372
Vwp_32_6 wp_32_6 0 0.4876314817702934
Vwn_32_6 wn_32_6 0 0.5123685182297066
Vwp_33_6 wp_33_6 0 0.5195725331231591
Vwn_33_6 wn_33_6 0 0.48042746687684096
Vwp_34_6 wp_34_6 0 0.4781163086974143
Vwn_34_6 wn_34_6 0 0.5218836913025857
Vwp_35_6 wp_35_6 0 0.5253064688550582
Vwn_35_6 wn_35_6 0 0.47469353114494184
Vwp_36_6 wp_36_6 0 0.49000255726661596
Vwn_36_6 wn_36_6 0 0.509997442733384
Vwp_37_6 wp_37_6 0 0.5033478350204706
Vwn_37_6 wn_37_6 0 0.4966521649795294
Vwp_38_6 wp_38_6 0 0.5033474289395601
Vwn_38_6 wn_38_6 0 0.4966525710604399
Vwp_39_6 wp_39_6 0 0.4948398867521175
Vwn_39_6 wn_39_6 0 0.5051601132478825
Vwp_40_6 wp_40_6 0 0.4697977573305828
Vwn_40_6 wn_40_6 0 0.5302022426694172
Vwp_41_6 wp_41_6 0 0.4927640692037323
Vwn_41_6 wn_41_6 0 0.5072359307962677
Vwp_42_6 wp_42_6 0 0.5228369029405098
Vwn_42_6 wn_42_6 0 0.4771630970594902
Vwp_43_6 wp_43_6 0 0.48078810087407975
Vwn_43_6 wn_43_6 0 0.5192118991259203
Vwp_44_6 wp_44_6 0 0.472368362790441
Vwn_44_6 wn_44_6 0 0.5276316372095591
Vwp_45_6 wp_45_6 0 0.49671689754555615
Vwn_45_6 wn_45_6 0 0.5032831024544439
Vwp_46_6 wp_46_6 0 0.49381419401885623
Vwn_46_6 wn_46_6 0 0.5061858059811437
Vwp_47_6 wp_47_6 0 0.48060737362900036
Vwn_47_6 wn_47_6 0 0.5193926263709996
Vwp_48_6 wp_48_6 0 0.4887114092784985
Vwn_48_6 wn_48_6 0 0.5112885907215015
Vwp_49_6 wp_49_6 0 0.49278381375594205
Vwn_49_6 wn_49_6 0 0.507216186244058
Vwp_50_6 wp_50_6 0 0.49380688304802145
Vwn_50_6 wn_50_6 0 0.5061931169519786
Vwp_51_6 wp_51_6 0 0.5024416073354193
Vwn_51_6 wn_51_6 0 0.4975583926645807
Vwp_52_6 wp_52_6 0 0.5105999487848399
Vwn_52_6 wn_52_6 0 0.48940005121516006
Vwp_53_6 wp_53_6 0 0.5058061235775881
Vwn_53_6 wn_53_6 0 0.4941938764224118
Vwp_54_6 wp_54_6 0 0.505126231028477
Vwn_54_6 wn_54_6 0 0.49487376897152296
Vwp_55_6 wp_55_6 0 0.5252021443329484
Vwn_55_6 wn_55_6 0 0.4747978556670515
Vwp_56_6 wp_56_6 0 0.5164295483750794
Vwn_56_6 wn_56_6 0 0.4835704516249206
Vwp_57_6 wp_57_6 0 0.4563073976976132
Vwn_57_6 wn_57_6 0 0.5436926023023868
Vwp_58_6 wp_58_6 0 0.49455257234558514
Vwn_58_6 wn_58_6 0 0.5054474276544149
Vwp_59_6 wp_59_6 0 0.4763517471422457
Vwn_59_6 wn_59_6 0 0.5236482528577543
Vwp_60_6 wp_60_6 0 0.48966295303794244
Vwn_60_6 wn_60_6 0 0.5103370469620576
Vwp_61_6 wp_61_6 0 0.5115661079726462
Vwn_61_6 wn_61_6 0 0.48843389202735377
Vwp_62_6 wp_62_6 0 0.49698220813886373
Vwn_62_6 wn_62_6 0 0.5030177918611363
Vwp_63_6 wp_63_6 0 0.49357416105047597
Vwn_63_6 wn_63_6 0 0.506425838949524
Vwp_0_7 wp_0_7 0 0.5197545729431228
Vwn_0_7 wn_0_7 0 0.4802454270568773
Vwp_1_7 wp_1_7 0 0.4774433308758083
Vwn_1_7 wn_1_7 0 0.5225566691241917
Vwp_2_7 wp_2_7 0 0.49859278474820473
Vwn_2_7 wn_2_7 0 0.5014072152517953
Vwp_3_7 wp_3_7 0 0.5082313828826479
Vwn_3_7 wn_3_7 0 0.49176861711735204
Vwp_4_7 wp_4_7 0 0.5003620205686804
Vwn_4_7 wn_4_7 0 0.4996379794313196
Vwp_5_7 wp_5_7 0 0.48255087183270434
Vwn_5_7 wn_5_7 0 0.5174491281672957
Vwp_6_7 wp_6_7 0 0.4996614865503094
Vwn_6_7 wn_6_7 0 0.5003385134496906
Vwp_7_7 wp_7_7 0 0.5121126826305443
Vwn_7_7 wn_7_7 0 0.4878873173694557
Vwp_8_7 wp_8_7 0 0.5053587495984916
Vwn_8_7 wn_8_7 0 0.49464125040150847
Vwp_9_7 wp_9_7 0 0.504765371386173
Vwn_9_7 wn_9_7 0 0.4952346286138271
Vwp_10_7 wp_10_7 0 0.5046117204430268
Vwn_10_7 wn_10_7 0 0.4953882795569732
Vwp_11_7 wp_11_7 0 0.5020278753771656
Vwn_11_7 wn_11_7 0 0.4979721246228344
Vwp_12_7 wp_12_7 0 0.4813810879642453
Vwn_12_7 wn_12_7 0 0.5186189120357547
Vwp_13_7 wp_13_7 0 0.49536346720397356
Vwn_13_7 wn_13_7 0 0.5046365327960265
Vwp_14_7 wp_14_7 0 0.5064625653951348
Vwn_14_7 wn_14_7 0 0.49353743460486516
Vwp_15_7 wp_15_7 0 0.45328236196173854
Vwn_15_7 wn_15_7 0 0.5467176380382615
Vwp_16_7 wp_16_7 0 0.5113576694877174
Vwn_16_7 wn_16_7 0 0.4886423305122826
Vwp_17_7 wp_17_7 0 0.5050613669318809
Vwn_17_7 wn_17_7 0 0.4949386330681191
Vwp_18_7 wp_18_7 0 0.48373730433628775
Vwn_18_7 wn_18_7 0 0.5162626956637122
Vwp_19_7 wp_19_7 0 0.48880474850083605
Vwn_19_7 wn_19_7 0 0.5111952514991639
Vwp_20_7 wp_20_7 0 0.4969423805551449
Vwn_20_7 wn_20_7 0 0.503057619444855
Vwp_21_7 wp_21_7 0 0.5062015243876045
Vwn_21_7 wn_21_7 0 0.4937984756123955
Vwp_22_7 wp_22_7 0 0.4943896002968439
Vwn_22_7 wn_22_7 0 0.5056103997031561
Vwp_23_7 wp_23_7 0 0.5175050466194526
Vwn_23_7 wn_23_7 0 0.4824949533805474
Vwp_24_7 wp_24_7 0 0.5061968841870079
Vwn_24_7 wn_24_7 0 0.4938031158129921
Vwp_25_7 wp_25_7 0 0.4882014289117892
Vwn_25_7 wn_25_7 0 0.5117985710882108
Vwp_26_7 wp_26_7 0 0.492932271214939
Vwn_26_7 wn_26_7 0 0.507067728785061
Vwp_27_7 wp_27_7 0 0.5034136943524347
Vwn_27_7 wn_27_7 0 0.4965863056475653
Vwp_28_7 wp_28_7 0 0.510925610474035
Vwn_28_7 wn_28_7 0 0.4890743895259651
Vwp_29_7 wp_29_7 0 0.5102002321326519
Vwn_29_7 wn_29_7 0 0.4897997678673482
Vwp_30_7 wp_30_7 0 0.4985360937249339
Vwn_30_7 wn_30_7 0 0.5014639062750661
Vwp_31_7 wp_31_7 0 0.502242425713133
Vwn_31_7 wn_31_7 0 0.49775757428686696
Vwp_32_7 wp_32_7 0 0.4996234843791708
Vwn_32_7 wn_32_7 0 0.5003765156208292
Vwp_33_7 wp_33_7 0 0.5123298488789697
Vwn_33_7 wn_33_7 0 0.4876701511210303
Vwp_34_7 wp_34_7 0 0.4852063322554067
Vwn_34_7 wn_34_7 0 0.5147936677445933
Vwp_35_7 wp_35_7 0 0.5090426403918226
Vwn_35_7 wn_35_7 0 0.4909573596081774
Vwp_36_7 wp_36_7 0 0.4722139540539913
Vwn_36_7 wn_36_7 0 0.5277860459460086
Vwp_37_7 wp_37_7 0 0.5067654943875374
Vwn_37_7 wn_37_7 0 0.4932345056124626
Vwp_38_7 wp_38_7 0 0.5038431922349114
Vwn_38_7 wn_38_7 0 0.49615680776508864
Vwp_39_7 wp_39_7 0 0.4999943877213372
Vwn_39_7 wn_39_7 0 0.5000056122786628
Vwp_40_7 wp_40_7 0 0.46801086004503417
Vwn_40_7 wn_40_7 0 0.5319891399549658
Vwp_41_7 wp_41_7 0 0.5235008610514692
Vwn_41_7 wn_41_7 0 0.47649913894853085
Vwp_42_7 wp_42_7 0 0.5134761671758851
Vwn_42_7 wn_42_7 0 0.48652383282411493
Vwp_43_7 wp_43_7 0 0.5003817249962815
Vwn_43_7 wn_43_7 0 0.4996182750037185
Vwp_44_7 wp_44_7 0 0.5068806099609732
Vwn_44_7 wn_44_7 0 0.4931193900390268
Vwp_45_7 wp_45_7 0 0.4859092677323181
Vwn_45_7 wn_45_7 0 0.5140907322676819
Vwp_46_7 wp_46_7 0 0.5076840973017307
Vwn_46_7 wn_46_7 0 0.49231590269826925
Vwp_47_7 wp_47_7 0 0.5234013072068167
Vwn_47_7 wn_47_7 0 0.4765986927931833
Vwp_48_7 wp_48_7 0 0.4823287161543272
Vwn_48_7 wn_48_7 0 0.5176712838456727
Vwp_49_7 wp_49_7 0 0.5403913622459718
Vwn_49_7 wn_49_7 0 0.45960863775402816
Vwp_50_7 wp_50_7 0 0.49344606559706405
Vwn_50_7 wn_50_7 0 0.506553934402936
Vwp_51_7 wp_51_7 0 0.5124111180941298
Vwn_51_7 wn_51_7 0 0.4875888819058702
Vwp_52_7 wp_52_7 0 0.4876083382726719
Vwn_52_7 wn_52_7 0 0.5123916617273281
Vwp_53_7 wp_53_7 0 0.5058560844920512
Vwn_53_7 wn_53_7 0 0.4941439155079488
Vwp_54_7 wp_54_7 0 0.4808909091651488
Vwn_54_7 wn_54_7 0 0.5191090908348511
Vwp_55_7 wp_55_7 0 0.49011508979601137
Vwn_55_7 wn_55_7 0 0.5098849102039886
Vwp_56_7 wp_56_7 0 0.49657134080043047
Vwn_56_7 wn_56_7 0 0.5034286591995696
Vwp_57_7 wp_57_7 0 0.49016267584380324
Vwn_57_7 wn_57_7 0 0.5098373241561968
Vwp_58_7 wp_58_7 0 0.4963785504951093
Vwn_58_7 wn_58_7 0 0.5036214495048907
Vwp_59_7 wp_59_7 0 0.5146392929561866
Vwn_59_7 wn_59_7 0 0.48536070704381334
Vwp_60_7 wp_60_7 0 0.48084372169099976
Vwn_60_7 wn_60_7 0 0.5191562783090002
Vwp_61_7 wp_61_7 0 0.48206370239768626
Vwn_61_7 wn_61_7 0 0.5179362976023137
Vwp_62_7 wp_62_7 0 0.5007058888235304
Vwn_62_7 wn_62_7 0 0.49929411117646966
Vwp_63_7 wp_63_7 0 0.49153715493241723
Vwn_63_7 wn_63_7 0 0.5084628450675828
Vwp_0_8 wp_0_8 0 0.48494376415871004
Vwn_0_8 wn_0_8 0 0.51505623584129
Vwp_1_8 wp_1_8 0 0.5019804918490715
Vwn_1_8 wn_1_8 0 0.4980195081509286
Vwp_2_8 wp_2_8 0 0.4915344971651779
Vwn_2_8 wn_2_8 0 0.5084655028348222
Vwp_3_8 wp_3_8 0 0.5050421029444627
Vwn_3_8 wn_3_8 0 0.49495789705553733
Vwp_4_8 wp_4_8 0 0.49940359892758013
Vwn_4_8 wn_4_8 0 0.5005964010724199
Vwp_5_8 wp_5_8 0 0.49698177646328595
Vwn_5_8 wn_5_8 0 0.5030182235367141
Vwp_6_8 wp_6_8 0 0.4989764006329103
Vwn_6_8 wn_6_8 0 0.5010235993670897
Vwp_7_8 wp_7_8 0 0.5153486062212259
Vwn_7_8 wn_7_8 0 0.4846513937787741
Vwp_8_8 wp_8_8 0 0.5197115674566564
Vwn_8_8 wn_8_8 0 0.48028843254334364
Vwp_9_8 wp_9_8 0 0.4976059356606358
Vwn_9_8 wn_9_8 0 0.5023940643393642
Vwp_10_8 wp_10_8 0 0.484550486455475
Vwn_10_8 wn_10_8 0 0.515449513544525
Vwp_11_8 wp_11_8 0 0.47733062596785486
Vwn_11_8 wn_11_8 0 0.5226693740321451
Vwp_12_8 wp_12_8 0 0.4664963276992826
Vwn_12_8 wn_12_8 0 0.5335036723007174
Vwp_13_8 wp_13_8 0 0.48236066073349465
Vwn_13_8 wn_13_8 0 0.5176393392665054
Vwp_14_8 wp_14_8 0 0.48721520447372957
Vwn_14_8 wn_14_8 0 0.5127847955262704
Vwp_15_8 wp_15_8 0 0.49921196676685786
Vwn_15_8 wn_15_8 0 0.5007880332331421
Vwp_16_8 wp_16_8 0 0.4717919175894803
Vwn_16_8 wn_16_8 0 0.5282080824105196
Vwp_17_8 wp_17_8 0 0.5214453680199576
Vwn_17_8 wn_17_8 0 0.4785546319800425
Vwp_18_8 wp_18_8 0 0.5159533361866102
Vwn_18_8 wn_18_8 0 0.48404666381338973
Vwp_19_8 wp_19_8 0 0.5186775553767736
Vwn_19_8 wn_19_8 0 0.4813224446232263
Vwp_20_8 wp_20_8 0 0.4923066467787163
Vwn_20_8 wn_20_8 0 0.5076933532212837
Vwp_21_8 wp_21_8 0 0.503660018916196
Vwn_21_8 wn_21_8 0 0.49633998108380395
Vwp_22_8 wp_22_8 0 0.48578953522087015
Vwn_22_8 wn_22_8 0 0.5142104647791299
Vwp_23_8 wp_23_8 0 0.5232471434840217
Vwn_23_8 wn_23_8 0 0.47675285651597826
Vwp_24_8 wp_24_8 0 0.48180462406189634
Vwn_24_8 wn_24_8 0 0.5181953759381036
Vwp_25_8 wp_25_8 0 0.4922956201618879
Vwn_25_8 wn_25_8 0 0.5077043798381121
Vwp_26_8 wp_26_8 0 0.5213512381264395
Vwn_26_8 wn_26_8 0 0.47864876187356054
Vwp_27_8 wp_27_8 0 0.537347181691222
Vwn_27_8 wn_27_8 0 0.4626528183087781
Vwp_28_8 wp_28_8 0 0.4986241028161791
Vwn_28_8 wn_28_8 0 0.5013758971838209
Vwp_29_8 wp_29_8 0 0.49378648661485464
Vwn_29_8 wn_29_8 0 0.5062135133851453
Vwp_30_8 wp_30_8 0 0.46239302094528695
Vwn_30_8 wn_30_8 0 0.5376069790547131
Vwp_31_8 wp_31_8 0 0.5256567802478689
Vwn_31_8 wn_31_8 0 0.4743432197521312
Vwp_32_8 wp_32_8 0 0.504622732669889
Vwn_32_8 wn_32_8 0 0.495377267330111
Vwp_33_8 wp_33_8 0 0.47174088769246575
Vwn_33_8 wn_33_8 0 0.5282591123075342
Vwp_34_8 wp_34_8 0 0.5130703534021533
Vwn_34_8 wn_34_8 0 0.48692964659784665
Vwp_35_8 wp_35_8 0 0.5092082192305898
Vwn_35_8 wn_35_8 0 0.4907917807694102
Vwp_36_8 wp_36_8 0 0.4946840056526695
Vwn_36_8 wn_36_8 0 0.5053159943473305
Vwp_37_8 wp_37_8 0 0.491632454466314
Vwn_37_8 wn_37_8 0 0.508367545533686
Vwp_38_8 wp_38_8 0 0.5109518798725465
Vwn_38_8 wn_38_8 0 0.48904812012745347
Vwp_39_8 wp_39_8 0 0.5035091800072172
Vwn_39_8 wn_39_8 0 0.49649081999278283
Vwp_40_8 wp_40_8 0 0.5073025046305644
Vwn_40_8 wn_40_8 0 0.49269749536943563
Vwp_41_8 wp_41_8 0 0.5183974209891479
Vwn_41_8 wn_41_8 0 0.4816025790108522
Vwp_42_8 wp_42_8 0 0.5178978493011887
Vwn_42_8 wn_42_8 0 0.4821021506988114
Vwp_43_8 wp_43_8 0 0.5114076965820875
Vwn_43_8 wn_43_8 0 0.48859230341791243
Vwp_44_8 wp_44_8 0 0.5087792705612965
Vwn_44_8 wn_44_8 0 0.49122072943870354
Vwp_45_8 wp_45_8 0 0.4808272291433098
Vwn_45_8 wn_45_8 0 0.5191727708566902
Vwp_46_8 wp_46_8 0 0.4832681124947059
Vwn_46_8 wn_46_8 0 0.5167318875052941
Vwp_47_8 wp_47_8 0 0.512277840770061
Vwn_47_8 wn_47_8 0 0.487722159229939
Vwp_48_8 wp_48_8 0 0.5097080416767071
Vwn_48_8 wn_48_8 0 0.4902919583232928
Vwp_49_8 wp_49_8 0 0.5077727261140285
Vwn_49_8 wn_49_8 0 0.4922272738859715
Vwp_50_8 wp_50_8 0 0.5126052078473183
Vwn_50_8 wn_50_8 0 0.48739479215268167
Vwp_51_8 wp_51_8 0 0.4916899497993507
Vwn_51_8 wn_51_8 0 0.5083100502006493
Vwp_52_8 wp_52_8 0 0.5084738514833556
Vwn_52_8 wn_52_8 0 0.49152614851664445
Vwp_53_8 wp_53_8 0 0.48516678481755393
Vwn_53_8 wn_53_8 0 0.5148332151824461
Vwp_54_8 wp_54_8 0 0.5009357021024364
Vwn_54_8 wn_54_8 0 0.49906429789756357
Vwp_55_8 wp_55_8 0 0.5139398892489146
Vwn_55_8 wn_55_8 0 0.4860601107510854
Vwp_56_8 wp_56_8 0 0.48984703298178367
Vwn_56_8 wn_56_8 0 0.5101529670182163
Vwp_57_8 wp_57_8 0 0.5292936190024486
Vwn_57_8 wn_57_8 0 0.47070638099755135
Vwp_58_8 wp_58_8 0 0.5170111924083496
Vwn_58_8 wn_58_8 0 0.4829888075916504
Vwp_59_8 wp_59_8 0 0.5205816073162994
Vwn_59_8 wn_59_8 0 0.47941839268370057
Vwp_60_8 wp_60_8 0 0.4968326539813836
Vwn_60_8 wn_60_8 0 0.5031673460186163
Vwp_61_8 wp_61_8 0 0.4791657584376387
Vwn_61_8 wn_61_8 0 0.5208342415623614
Vwp_62_8 wp_62_8 0 0.4895211525391242
Vwn_62_8 wn_62_8 0 0.5104788474608758
Vwp_63_8 wp_63_8 0 0.5082750045746749
Vwn_63_8 wn_63_8 0 0.49172499542532516
Vwp_0_9 wp_0_9 0 0.49581495449930263
Vwn_0_9 wn_0_9 0 0.5041850455006973
Vwp_1_9 wp_1_9 0 0.5108204775253805
Vwn_1_9 wn_1_9 0 0.4891795224746195
Vwp_2_9 wp_2_9 0 0.5022568237606759
Vwn_2_9 wn_2_9 0 0.497743176239324
Vwp_3_9 wp_3_9 0 0.49115369370198037
Vwn_3_9 wn_3_9 0 0.5088463062980196
Vwp_4_9 wp_4_9 0 0.5140132293358924
Vwn_4_9 wn_4_9 0 0.48598677066410756
Vwp_5_9 wp_5_9 0 0.520276170499067
Vwn_5_9 wn_5_9 0 0.47972382950093295
Vwp_6_9 wp_6_9 0 0.48901776181494194
Vwn_6_9 wn_6_9 0 0.5109822381850581
Vwp_7_9 wp_7_9 0 0.5076786143303127
Vwn_7_9 wn_7_9 0 0.49232138566968725
Vwp_8_9 wp_8_9 0 0.5023489126873089
Vwn_8_9 wn_8_9 0 0.4976510873126912
Vwp_9_9 wp_9_9 0 0.50421319489417
Vwn_9_9 wn_9_9 0 0.49578680510582995
Vwp_10_9 wp_10_9 0 0.49843838801656754
Vwn_10_9 wn_10_9 0 0.5015616119834324
Vwp_11_9 wp_11_9 0 0.4812097785370501
Vwn_11_9 wn_11_9 0 0.51879022146295
Vwp_12_9 wp_12_9 0 0.5211428563632923
Vwn_12_9 wn_12_9 0 0.47885714363670767
Vwp_13_9 wp_13_9 0 0.48434612199379995
Vwn_13_9 wn_13_9 0 0.5156538780062001
Vwp_14_9 wp_14_9 0 0.48694060492772817
Vwn_14_9 wn_14_9 0 0.5130593950722718
Vwp_15_9 wp_15_9 0 0.5098440588863536
Vwn_15_9 wn_15_9 0 0.4901559411136463
Vwp_16_9 wp_16_9 0 0.5026981219976284
Vwn_16_9 wn_16_9 0 0.4973018780023716
Vwp_17_9 wp_17_9 0 0.48805944437083837
Vwn_17_9 wn_17_9 0 0.5119405556291616
Vwp_18_9 wp_18_9 0 0.4901367893527894
Vwn_18_9 wn_18_9 0 0.5098632106472106
Vwp_19_9 wp_19_9 0 0.4976195376374438
Vwn_19_9 wn_19_9 0 0.5023804623625562
Vwp_20_9 wp_20_9 0 0.4934587673004652
Vwn_20_9 wn_20_9 0 0.5065412326995348
Vwp_21_9 wp_21_9 0 0.5096978948607492
Vwn_21_9 wn_21_9 0 0.4903021051392508
Vwp_22_9 wp_22_9 0 0.4825367132261497
Vwn_22_9 wn_22_9 0 0.5174632867738502
Vwp_23_9 wp_23_9 0 0.5054498101872563
Vwn_23_9 wn_23_9 0 0.4945501898127436
Vwp_24_9 wp_24_9 0 0.5229580222682196
Vwn_24_9 wn_24_9 0 0.47704197773178036
Vwp_25_9 wp_25_9 0 0.5030204328884592
Vwn_25_9 wn_25_9 0 0.4969795671115408
Vwp_26_9 wp_26_9 0 0.48667559887775763
Vwn_26_9 wn_26_9 0 0.5133244011222423
Vwp_27_9 wp_27_9 0 0.4891544227733738
Vwn_27_9 wn_27_9 0 0.5108455772266262
Vwp_28_9 wp_28_9 0 0.5006549671410794
Vwn_28_9 wn_28_9 0 0.49934503285892057
Vwp_29_9 wp_29_9 0 0.4906367886917555
Vwn_29_9 wn_29_9 0 0.5093632113082446
Vwp_30_9 wp_30_9 0 0.5185190340800478
Vwn_30_9 wn_30_9 0 0.48148096591995215
Vwp_31_9 wp_31_9 0 0.4723942445380567
Vwn_31_9 wn_31_9 0 0.5276057554619433
Vwp_32_9 wp_32_9 0 0.524584442270356
Vwn_32_9 wn_32_9 0 0.4754155577296439
Vwp_33_9 wp_33_9 0 0.4696251527971824
Vwn_33_9 wn_33_9 0 0.5303748472028176
Vwp_34_9 wp_34_9 0 0.4993848669007509
Vwn_34_9 wn_34_9 0 0.5006151330992491
Vwp_35_9 wp_35_9 0 0.4837554169320369
Vwn_35_9 wn_35_9 0 0.5162445830679632
Vwp_36_9 wp_36_9 0 0.5123027485816214
Vwn_36_9 wn_36_9 0 0.48769725141837855
Vwp_37_9 wp_37_9 0 0.48838949485134286
Vwn_37_9 wn_37_9 0 0.5116105051486571
Vwp_38_9 wp_38_9 0 0.48300398228288266
Vwn_38_9 wn_38_9 0 0.5169960177171173
Vwp_39_9 wp_39_9 0 0.4948996252677646
Vwn_39_9 wn_39_9 0 0.5051003747322353
Vwp_40_9 wp_40_9 0 0.49383486944354316
Vwn_40_9 wn_40_9 0 0.5061651305564568
Vwp_41_9 wp_41_9 0 0.4709745480157188
Vwn_41_9 wn_41_9 0 0.5290254519842812
Vwp_42_9 wp_42_9 0 0.5068177421566257
Vwn_42_9 wn_42_9 0 0.49318225784337427
Vwp_43_9 wp_43_9 0 0.46411061762983113
Vwn_43_9 wn_43_9 0 0.5358893823701688
Vwp_44_9 wp_44_9 0 0.5176450596835549
Vwn_44_9 wn_44_9 0 0.4823549403164451
Vwp_45_9 wp_45_9 0 0.4950490268764497
Vwn_45_9 wn_45_9 0 0.5049509731235503
Vwp_46_9 wp_46_9 0 0.5142951016897145
Vwn_46_9 wn_46_9 0 0.4857048983102855
Vwp_47_9 wp_47_9 0 0.4909916272231799
Vwn_47_9 wn_47_9 0 0.5090083727768201
Vwp_48_9 wp_48_9 0 0.4881033939978519
Vwn_48_9 wn_48_9 0 0.5118966060021481
Vwp_49_9 wp_49_9 0 0.5097762221215865
Vwn_49_9 wn_49_9 0 0.4902237778784135
Vwp_50_9 wp_50_9 0 0.49123790363640624
Vwn_50_9 wn_50_9 0 0.5087620963635938
Vwp_51_9 wp_51_9 0 0.4767859087849934
Vwn_51_9 wn_51_9 0 0.5232140912150066
Vwp_52_9 wp_52_9 0 0.4986938468649122
Vwn_52_9 wn_52_9 0 0.5013061531350879
Vwp_53_9 wp_53_9 0 0.47934395591422113
Vwn_53_9 wn_53_9 0 0.5206560440857789
Vwp_54_9 wp_54_9 0 0.4998063916675081
Vwn_54_9 wn_54_9 0 0.5001936083324919
Vwp_55_9 wp_55_9 0 0.5206840925192148
Vwn_55_9 wn_55_9 0 0.47931590748078523
Vwp_56_9 wp_56_9 0 0.5144400256315372
Vwn_56_9 wn_56_9 0 0.4855599743684627
Vwp_57_9 wp_57_9 0 0.5000277759671414
Vwn_57_9 wn_57_9 0 0.49997222403285857
Vwp_58_9 wp_58_9 0 0.4975142190814699
Vwn_58_9 wn_58_9 0 0.5024857809185301
Vwp_59_9 wp_59_9 0 0.4952482190550932
Vwn_59_9 wn_59_9 0 0.5047517809449068
Vwp_60_9 wp_60_9 0 0.4904368190634225
Vwn_60_9 wn_60_9 0 0.5095631809365775
Vwp_61_9 wp_61_9 0 0.5053261082423391
Vwn_61_9 wn_61_9 0 0.49467389175766086
Vwp_62_9 wp_62_9 0 0.4976317235589198
Vwn_62_9 wn_62_9 0 0.5023682764410802
Vwp_63_9 wp_63_9 0 0.49427451272058864
Vwn_63_9 wn_63_9 0 0.5057254872794114
Xcm_mo0 mop0 mon0 vdd cmld
Rnd_mo0 mop0 mon0 20k
X_0_0 a_xp0 a_xn0 wp_0_0 wn_0_0 mop0 mon0 vdd vbsyn gsyn
X_1_0 a_xp1 a_xn1 wp_1_0 wn_1_0 mop0 mon0 vdd vbsyn gsyn
X_2_0 a_xp2 a_xn2 wp_2_0 wn_2_0 mop0 mon0 vdd vbsyn gsyn
X_3_0 a_xp3 a_xn3 wp_3_0 wn_3_0 mop0 mon0 vdd vbsyn gsyn
X_4_0 a_xp4 a_xn4 wp_4_0 wn_4_0 mop0 mon0 vdd vbsyn gsyn
X_5_0 a_xp5 a_xn5 wp_5_0 wn_5_0 mop0 mon0 vdd vbsyn gsyn
X_6_0 a_xp6 a_xn6 wp_6_0 wn_6_0 mop0 mon0 vdd vbsyn gsyn
X_7_0 a_xp7 a_xn7 wp_7_0 wn_7_0 mop0 mon0 vdd vbsyn gsyn
X_8_0 a_xp8 a_xn8 wp_8_0 wn_8_0 mop0 mon0 vdd vbsyn gsyn
X_9_0 a_xp9 a_xn9 wp_9_0 wn_9_0 mop0 mon0 vdd vbsyn gsyn
X_10_0 a_xp10 a_xn10 wp_10_0 wn_10_0 mop0 mon0 vdd vbsyn gsyn
X_11_0 a_xp11 a_xn11 wp_11_0 wn_11_0 mop0 mon0 vdd vbsyn gsyn
X_12_0 a_xp12 a_xn12 wp_12_0 wn_12_0 mop0 mon0 vdd vbsyn gsyn
X_13_0 a_xp13 a_xn13 wp_13_0 wn_13_0 mop0 mon0 vdd vbsyn gsyn
X_14_0 a_xp14 a_xn14 wp_14_0 wn_14_0 mop0 mon0 vdd vbsyn gsyn
X_15_0 a_xp15 a_xn15 wp_15_0 wn_15_0 mop0 mon0 vdd vbsyn gsyn
X_16_0 a_xp16 a_xn16 wp_16_0 wn_16_0 mop0 mon0 vdd vbsyn gsyn
X_17_0 a_xp17 a_xn17 wp_17_0 wn_17_0 mop0 mon0 vdd vbsyn gsyn
X_18_0 a_xp18 a_xn18 wp_18_0 wn_18_0 mop0 mon0 vdd vbsyn gsyn
X_19_0 a_xp19 a_xn19 wp_19_0 wn_19_0 mop0 mon0 vdd vbsyn gsyn
X_20_0 a_xp20 a_xn20 wp_20_0 wn_20_0 mop0 mon0 vdd vbsyn gsyn
X_21_0 a_xp21 a_xn21 wp_21_0 wn_21_0 mop0 mon0 vdd vbsyn gsyn
X_22_0 a_xp22 a_xn22 wp_22_0 wn_22_0 mop0 mon0 vdd vbsyn gsyn
X_23_0 a_xp23 a_xn23 wp_23_0 wn_23_0 mop0 mon0 vdd vbsyn gsyn
X_24_0 a_xp24 a_xn24 wp_24_0 wn_24_0 mop0 mon0 vdd vbsyn gsyn
X_25_0 a_xp25 a_xn25 wp_25_0 wn_25_0 mop0 mon0 vdd vbsyn gsyn
X_26_0 a_xp26 a_xn26 wp_26_0 wn_26_0 mop0 mon0 vdd vbsyn gsyn
X_27_0 a_xp27 a_xn27 wp_27_0 wn_27_0 mop0 mon0 vdd vbsyn gsyn
X_28_0 a_xp28 a_xn28 wp_28_0 wn_28_0 mop0 mon0 vdd vbsyn gsyn
X_29_0 a_xp29 a_xn29 wp_29_0 wn_29_0 mop0 mon0 vdd vbsyn gsyn
X_30_0 a_xp30 a_xn30 wp_30_0 wn_30_0 mop0 mon0 vdd vbsyn gsyn
X_31_0 a_xp31 a_xn31 wp_31_0 wn_31_0 mop0 mon0 vdd vbsyn gsyn
X_32_0 a_xp32 a_xn32 wp_32_0 wn_32_0 mop0 mon0 vdd vbsyn gsyn
X_33_0 a_xp33 a_xn33 wp_33_0 wn_33_0 mop0 mon0 vdd vbsyn gsyn
X_34_0 a_xp34 a_xn34 wp_34_0 wn_34_0 mop0 mon0 vdd vbsyn gsyn
X_35_0 a_xp35 a_xn35 wp_35_0 wn_35_0 mop0 mon0 vdd vbsyn gsyn
X_36_0 a_xp36 a_xn36 wp_36_0 wn_36_0 mop0 mon0 vdd vbsyn gsyn
X_37_0 a_xp37 a_xn37 wp_37_0 wn_37_0 mop0 mon0 vdd vbsyn gsyn
X_38_0 a_xp38 a_xn38 wp_38_0 wn_38_0 mop0 mon0 vdd vbsyn gsyn
X_39_0 a_xp39 a_xn39 wp_39_0 wn_39_0 mop0 mon0 vdd vbsyn gsyn
X_40_0 a_xp40 a_xn40 wp_40_0 wn_40_0 mop0 mon0 vdd vbsyn gsyn
X_41_0 a_xp41 a_xn41 wp_41_0 wn_41_0 mop0 mon0 vdd vbsyn gsyn
X_42_0 a_xp42 a_xn42 wp_42_0 wn_42_0 mop0 mon0 vdd vbsyn gsyn
X_43_0 a_xp43 a_xn43 wp_43_0 wn_43_0 mop0 mon0 vdd vbsyn gsyn
X_44_0 a_xp44 a_xn44 wp_44_0 wn_44_0 mop0 mon0 vdd vbsyn gsyn
X_45_0 a_xp45 a_xn45 wp_45_0 wn_45_0 mop0 mon0 vdd vbsyn gsyn
X_46_0 a_xp46 a_xn46 wp_46_0 wn_46_0 mop0 mon0 vdd vbsyn gsyn
X_47_0 a_xp47 a_xn47 wp_47_0 wn_47_0 mop0 mon0 vdd vbsyn gsyn
X_48_0 a_xp48 a_xn48 wp_48_0 wn_48_0 mop0 mon0 vdd vbsyn gsyn
X_49_0 a_xp49 a_xn49 wp_49_0 wn_49_0 mop0 mon0 vdd vbsyn gsyn
X_50_0 a_xp50 a_xn50 wp_50_0 wn_50_0 mop0 mon0 vdd vbsyn gsyn
X_51_0 a_xp51 a_xn51 wp_51_0 wn_51_0 mop0 mon0 vdd vbsyn gsyn
X_52_0 a_xp52 a_xn52 wp_52_0 wn_52_0 mop0 mon0 vdd vbsyn gsyn
X_53_0 a_xp53 a_xn53 wp_53_0 wn_53_0 mop0 mon0 vdd vbsyn gsyn
X_54_0 a_xp54 a_xn54 wp_54_0 wn_54_0 mop0 mon0 vdd vbsyn gsyn
X_55_0 a_xp55 a_xn55 wp_55_0 wn_55_0 mop0 mon0 vdd vbsyn gsyn
X_56_0 a_xp56 a_xn56 wp_56_0 wn_56_0 mop0 mon0 vdd vbsyn gsyn
X_57_0 a_xp57 a_xn57 wp_57_0 wn_57_0 mop0 mon0 vdd vbsyn gsyn
X_58_0 a_xp58 a_xn58 wp_58_0 wn_58_0 mop0 mon0 vdd vbsyn gsyn
X_59_0 a_xp59 a_xn59 wp_59_0 wn_59_0 mop0 mon0 vdd vbsyn gsyn
X_60_0 a_xp60 a_xn60 wp_60_0 wn_60_0 mop0 mon0 vdd vbsyn gsyn
X_61_0 a_xp61 a_xn61 wp_61_0 wn_61_0 mop0 mon0 vdd vbsyn gsyn
X_62_0 a_xp62 a_xn62 wp_62_0 wn_62_0 mop0 mon0 vdd vbsyn gsyn
X_63_0 a_xp63 a_xn63 wp_63_0 wn_63_0 mop0 mon0 vdd vbsyn gsyn
Xcm_mo1 mop1 mon1 vdd cmld
Rnd_mo1 mop1 mon1 20k
X_0_1 a_xp0 a_xn0 wp_0_1 wn_0_1 mop1 mon1 vdd vbsyn gsyn
X_1_1 a_xp1 a_xn1 wp_1_1 wn_1_1 mop1 mon1 vdd vbsyn gsyn
X_2_1 a_xp2 a_xn2 wp_2_1 wn_2_1 mop1 mon1 vdd vbsyn gsyn
X_3_1 a_xp3 a_xn3 wp_3_1 wn_3_1 mop1 mon1 vdd vbsyn gsyn
X_4_1 a_xp4 a_xn4 wp_4_1 wn_4_1 mop1 mon1 vdd vbsyn gsyn
X_5_1 a_xp5 a_xn5 wp_5_1 wn_5_1 mop1 mon1 vdd vbsyn gsyn
X_6_1 a_xp6 a_xn6 wp_6_1 wn_6_1 mop1 mon1 vdd vbsyn gsyn
X_7_1 a_xp7 a_xn7 wp_7_1 wn_7_1 mop1 mon1 vdd vbsyn gsyn
X_8_1 a_xp8 a_xn8 wp_8_1 wn_8_1 mop1 mon1 vdd vbsyn gsyn
X_9_1 a_xp9 a_xn9 wp_9_1 wn_9_1 mop1 mon1 vdd vbsyn gsyn
X_10_1 a_xp10 a_xn10 wp_10_1 wn_10_1 mop1 mon1 vdd vbsyn gsyn
X_11_1 a_xp11 a_xn11 wp_11_1 wn_11_1 mop1 mon1 vdd vbsyn gsyn
X_12_1 a_xp12 a_xn12 wp_12_1 wn_12_1 mop1 mon1 vdd vbsyn gsyn
X_13_1 a_xp13 a_xn13 wp_13_1 wn_13_1 mop1 mon1 vdd vbsyn gsyn
X_14_1 a_xp14 a_xn14 wp_14_1 wn_14_1 mop1 mon1 vdd vbsyn gsyn
X_15_1 a_xp15 a_xn15 wp_15_1 wn_15_1 mop1 mon1 vdd vbsyn gsyn
X_16_1 a_xp16 a_xn16 wp_16_1 wn_16_1 mop1 mon1 vdd vbsyn gsyn
X_17_1 a_xp17 a_xn17 wp_17_1 wn_17_1 mop1 mon1 vdd vbsyn gsyn
X_18_1 a_xp18 a_xn18 wp_18_1 wn_18_1 mop1 mon1 vdd vbsyn gsyn
X_19_1 a_xp19 a_xn19 wp_19_1 wn_19_1 mop1 mon1 vdd vbsyn gsyn
X_20_1 a_xp20 a_xn20 wp_20_1 wn_20_1 mop1 mon1 vdd vbsyn gsyn
X_21_1 a_xp21 a_xn21 wp_21_1 wn_21_1 mop1 mon1 vdd vbsyn gsyn
X_22_1 a_xp22 a_xn22 wp_22_1 wn_22_1 mop1 mon1 vdd vbsyn gsyn
X_23_1 a_xp23 a_xn23 wp_23_1 wn_23_1 mop1 mon1 vdd vbsyn gsyn
X_24_1 a_xp24 a_xn24 wp_24_1 wn_24_1 mop1 mon1 vdd vbsyn gsyn
X_25_1 a_xp25 a_xn25 wp_25_1 wn_25_1 mop1 mon1 vdd vbsyn gsyn
X_26_1 a_xp26 a_xn26 wp_26_1 wn_26_1 mop1 mon1 vdd vbsyn gsyn
X_27_1 a_xp27 a_xn27 wp_27_1 wn_27_1 mop1 mon1 vdd vbsyn gsyn
X_28_1 a_xp28 a_xn28 wp_28_1 wn_28_1 mop1 mon1 vdd vbsyn gsyn
X_29_1 a_xp29 a_xn29 wp_29_1 wn_29_1 mop1 mon1 vdd vbsyn gsyn
X_30_1 a_xp30 a_xn30 wp_30_1 wn_30_1 mop1 mon1 vdd vbsyn gsyn
X_31_1 a_xp31 a_xn31 wp_31_1 wn_31_1 mop1 mon1 vdd vbsyn gsyn
X_32_1 a_xp32 a_xn32 wp_32_1 wn_32_1 mop1 mon1 vdd vbsyn gsyn
X_33_1 a_xp33 a_xn33 wp_33_1 wn_33_1 mop1 mon1 vdd vbsyn gsyn
X_34_1 a_xp34 a_xn34 wp_34_1 wn_34_1 mop1 mon1 vdd vbsyn gsyn
X_35_1 a_xp35 a_xn35 wp_35_1 wn_35_1 mop1 mon1 vdd vbsyn gsyn
X_36_1 a_xp36 a_xn36 wp_36_1 wn_36_1 mop1 mon1 vdd vbsyn gsyn
X_37_1 a_xp37 a_xn37 wp_37_1 wn_37_1 mop1 mon1 vdd vbsyn gsyn
X_38_1 a_xp38 a_xn38 wp_38_1 wn_38_1 mop1 mon1 vdd vbsyn gsyn
X_39_1 a_xp39 a_xn39 wp_39_1 wn_39_1 mop1 mon1 vdd vbsyn gsyn
X_40_1 a_xp40 a_xn40 wp_40_1 wn_40_1 mop1 mon1 vdd vbsyn gsyn
X_41_1 a_xp41 a_xn41 wp_41_1 wn_41_1 mop1 mon1 vdd vbsyn gsyn
X_42_1 a_xp42 a_xn42 wp_42_1 wn_42_1 mop1 mon1 vdd vbsyn gsyn
X_43_1 a_xp43 a_xn43 wp_43_1 wn_43_1 mop1 mon1 vdd vbsyn gsyn
X_44_1 a_xp44 a_xn44 wp_44_1 wn_44_1 mop1 mon1 vdd vbsyn gsyn
X_45_1 a_xp45 a_xn45 wp_45_1 wn_45_1 mop1 mon1 vdd vbsyn gsyn
X_46_1 a_xp46 a_xn46 wp_46_1 wn_46_1 mop1 mon1 vdd vbsyn gsyn
X_47_1 a_xp47 a_xn47 wp_47_1 wn_47_1 mop1 mon1 vdd vbsyn gsyn
X_48_1 a_xp48 a_xn48 wp_48_1 wn_48_1 mop1 mon1 vdd vbsyn gsyn
X_49_1 a_xp49 a_xn49 wp_49_1 wn_49_1 mop1 mon1 vdd vbsyn gsyn
X_50_1 a_xp50 a_xn50 wp_50_1 wn_50_1 mop1 mon1 vdd vbsyn gsyn
X_51_1 a_xp51 a_xn51 wp_51_1 wn_51_1 mop1 mon1 vdd vbsyn gsyn
X_52_1 a_xp52 a_xn52 wp_52_1 wn_52_1 mop1 mon1 vdd vbsyn gsyn
X_53_1 a_xp53 a_xn53 wp_53_1 wn_53_1 mop1 mon1 vdd vbsyn gsyn
X_54_1 a_xp54 a_xn54 wp_54_1 wn_54_1 mop1 mon1 vdd vbsyn gsyn
X_55_1 a_xp55 a_xn55 wp_55_1 wn_55_1 mop1 mon1 vdd vbsyn gsyn
X_56_1 a_xp56 a_xn56 wp_56_1 wn_56_1 mop1 mon1 vdd vbsyn gsyn
X_57_1 a_xp57 a_xn57 wp_57_1 wn_57_1 mop1 mon1 vdd vbsyn gsyn
X_58_1 a_xp58 a_xn58 wp_58_1 wn_58_1 mop1 mon1 vdd vbsyn gsyn
X_59_1 a_xp59 a_xn59 wp_59_1 wn_59_1 mop1 mon1 vdd vbsyn gsyn
X_60_1 a_xp60 a_xn60 wp_60_1 wn_60_1 mop1 mon1 vdd vbsyn gsyn
X_61_1 a_xp61 a_xn61 wp_61_1 wn_61_1 mop1 mon1 vdd vbsyn gsyn
X_62_1 a_xp62 a_xn62 wp_62_1 wn_62_1 mop1 mon1 vdd vbsyn gsyn
X_63_1 a_xp63 a_xn63 wp_63_1 wn_63_1 mop1 mon1 vdd vbsyn gsyn
Xcm_mo2 mop2 mon2 vdd cmld
Rnd_mo2 mop2 mon2 20k
X_0_2 a_xp0 a_xn0 wp_0_2 wn_0_2 mop2 mon2 vdd vbsyn gsyn
X_1_2 a_xp1 a_xn1 wp_1_2 wn_1_2 mop2 mon2 vdd vbsyn gsyn
X_2_2 a_xp2 a_xn2 wp_2_2 wn_2_2 mop2 mon2 vdd vbsyn gsyn
X_3_2 a_xp3 a_xn3 wp_3_2 wn_3_2 mop2 mon2 vdd vbsyn gsyn
X_4_2 a_xp4 a_xn4 wp_4_2 wn_4_2 mop2 mon2 vdd vbsyn gsyn
X_5_2 a_xp5 a_xn5 wp_5_2 wn_5_2 mop2 mon2 vdd vbsyn gsyn
X_6_2 a_xp6 a_xn6 wp_6_2 wn_6_2 mop2 mon2 vdd vbsyn gsyn
X_7_2 a_xp7 a_xn7 wp_7_2 wn_7_2 mop2 mon2 vdd vbsyn gsyn
X_8_2 a_xp8 a_xn8 wp_8_2 wn_8_2 mop2 mon2 vdd vbsyn gsyn
X_9_2 a_xp9 a_xn9 wp_9_2 wn_9_2 mop2 mon2 vdd vbsyn gsyn
X_10_2 a_xp10 a_xn10 wp_10_2 wn_10_2 mop2 mon2 vdd vbsyn gsyn
X_11_2 a_xp11 a_xn11 wp_11_2 wn_11_2 mop2 mon2 vdd vbsyn gsyn
X_12_2 a_xp12 a_xn12 wp_12_2 wn_12_2 mop2 mon2 vdd vbsyn gsyn
X_13_2 a_xp13 a_xn13 wp_13_2 wn_13_2 mop2 mon2 vdd vbsyn gsyn
X_14_2 a_xp14 a_xn14 wp_14_2 wn_14_2 mop2 mon2 vdd vbsyn gsyn
X_15_2 a_xp15 a_xn15 wp_15_2 wn_15_2 mop2 mon2 vdd vbsyn gsyn
X_16_2 a_xp16 a_xn16 wp_16_2 wn_16_2 mop2 mon2 vdd vbsyn gsyn
X_17_2 a_xp17 a_xn17 wp_17_2 wn_17_2 mop2 mon2 vdd vbsyn gsyn
X_18_2 a_xp18 a_xn18 wp_18_2 wn_18_2 mop2 mon2 vdd vbsyn gsyn
X_19_2 a_xp19 a_xn19 wp_19_2 wn_19_2 mop2 mon2 vdd vbsyn gsyn
X_20_2 a_xp20 a_xn20 wp_20_2 wn_20_2 mop2 mon2 vdd vbsyn gsyn
X_21_2 a_xp21 a_xn21 wp_21_2 wn_21_2 mop2 mon2 vdd vbsyn gsyn
X_22_2 a_xp22 a_xn22 wp_22_2 wn_22_2 mop2 mon2 vdd vbsyn gsyn
X_23_2 a_xp23 a_xn23 wp_23_2 wn_23_2 mop2 mon2 vdd vbsyn gsyn
X_24_2 a_xp24 a_xn24 wp_24_2 wn_24_2 mop2 mon2 vdd vbsyn gsyn
X_25_2 a_xp25 a_xn25 wp_25_2 wn_25_2 mop2 mon2 vdd vbsyn gsyn
X_26_2 a_xp26 a_xn26 wp_26_2 wn_26_2 mop2 mon2 vdd vbsyn gsyn
X_27_2 a_xp27 a_xn27 wp_27_2 wn_27_2 mop2 mon2 vdd vbsyn gsyn
X_28_2 a_xp28 a_xn28 wp_28_2 wn_28_2 mop2 mon2 vdd vbsyn gsyn
X_29_2 a_xp29 a_xn29 wp_29_2 wn_29_2 mop2 mon2 vdd vbsyn gsyn
X_30_2 a_xp30 a_xn30 wp_30_2 wn_30_2 mop2 mon2 vdd vbsyn gsyn
X_31_2 a_xp31 a_xn31 wp_31_2 wn_31_2 mop2 mon2 vdd vbsyn gsyn
X_32_2 a_xp32 a_xn32 wp_32_2 wn_32_2 mop2 mon2 vdd vbsyn gsyn
X_33_2 a_xp33 a_xn33 wp_33_2 wn_33_2 mop2 mon2 vdd vbsyn gsyn
X_34_2 a_xp34 a_xn34 wp_34_2 wn_34_2 mop2 mon2 vdd vbsyn gsyn
X_35_2 a_xp35 a_xn35 wp_35_2 wn_35_2 mop2 mon2 vdd vbsyn gsyn
X_36_2 a_xp36 a_xn36 wp_36_2 wn_36_2 mop2 mon2 vdd vbsyn gsyn
X_37_2 a_xp37 a_xn37 wp_37_2 wn_37_2 mop2 mon2 vdd vbsyn gsyn
X_38_2 a_xp38 a_xn38 wp_38_2 wn_38_2 mop2 mon2 vdd vbsyn gsyn
X_39_2 a_xp39 a_xn39 wp_39_2 wn_39_2 mop2 mon2 vdd vbsyn gsyn
X_40_2 a_xp40 a_xn40 wp_40_2 wn_40_2 mop2 mon2 vdd vbsyn gsyn
X_41_2 a_xp41 a_xn41 wp_41_2 wn_41_2 mop2 mon2 vdd vbsyn gsyn
X_42_2 a_xp42 a_xn42 wp_42_2 wn_42_2 mop2 mon2 vdd vbsyn gsyn
X_43_2 a_xp43 a_xn43 wp_43_2 wn_43_2 mop2 mon2 vdd vbsyn gsyn
X_44_2 a_xp44 a_xn44 wp_44_2 wn_44_2 mop2 mon2 vdd vbsyn gsyn
X_45_2 a_xp45 a_xn45 wp_45_2 wn_45_2 mop2 mon2 vdd vbsyn gsyn
X_46_2 a_xp46 a_xn46 wp_46_2 wn_46_2 mop2 mon2 vdd vbsyn gsyn
X_47_2 a_xp47 a_xn47 wp_47_2 wn_47_2 mop2 mon2 vdd vbsyn gsyn
X_48_2 a_xp48 a_xn48 wp_48_2 wn_48_2 mop2 mon2 vdd vbsyn gsyn
X_49_2 a_xp49 a_xn49 wp_49_2 wn_49_2 mop2 mon2 vdd vbsyn gsyn
X_50_2 a_xp50 a_xn50 wp_50_2 wn_50_2 mop2 mon2 vdd vbsyn gsyn
X_51_2 a_xp51 a_xn51 wp_51_2 wn_51_2 mop2 mon2 vdd vbsyn gsyn
X_52_2 a_xp52 a_xn52 wp_52_2 wn_52_2 mop2 mon2 vdd vbsyn gsyn
X_53_2 a_xp53 a_xn53 wp_53_2 wn_53_2 mop2 mon2 vdd vbsyn gsyn
X_54_2 a_xp54 a_xn54 wp_54_2 wn_54_2 mop2 mon2 vdd vbsyn gsyn
X_55_2 a_xp55 a_xn55 wp_55_2 wn_55_2 mop2 mon2 vdd vbsyn gsyn
X_56_2 a_xp56 a_xn56 wp_56_2 wn_56_2 mop2 mon2 vdd vbsyn gsyn
X_57_2 a_xp57 a_xn57 wp_57_2 wn_57_2 mop2 mon2 vdd vbsyn gsyn
X_58_2 a_xp58 a_xn58 wp_58_2 wn_58_2 mop2 mon2 vdd vbsyn gsyn
X_59_2 a_xp59 a_xn59 wp_59_2 wn_59_2 mop2 mon2 vdd vbsyn gsyn
X_60_2 a_xp60 a_xn60 wp_60_2 wn_60_2 mop2 mon2 vdd vbsyn gsyn
X_61_2 a_xp61 a_xn61 wp_61_2 wn_61_2 mop2 mon2 vdd vbsyn gsyn
X_62_2 a_xp62 a_xn62 wp_62_2 wn_62_2 mop2 mon2 vdd vbsyn gsyn
X_63_2 a_xp63 a_xn63 wp_63_2 wn_63_2 mop2 mon2 vdd vbsyn gsyn
Xcm_mo3 mop3 mon3 vdd cmld
Rnd_mo3 mop3 mon3 20k
X_0_3 a_xp0 a_xn0 wp_0_3 wn_0_3 mop3 mon3 vdd vbsyn gsyn
X_1_3 a_xp1 a_xn1 wp_1_3 wn_1_3 mop3 mon3 vdd vbsyn gsyn
X_2_3 a_xp2 a_xn2 wp_2_3 wn_2_3 mop3 mon3 vdd vbsyn gsyn
X_3_3 a_xp3 a_xn3 wp_3_3 wn_3_3 mop3 mon3 vdd vbsyn gsyn
X_4_3 a_xp4 a_xn4 wp_4_3 wn_4_3 mop3 mon3 vdd vbsyn gsyn
X_5_3 a_xp5 a_xn5 wp_5_3 wn_5_3 mop3 mon3 vdd vbsyn gsyn
X_6_3 a_xp6 a_xn6 wp_6_3 wn_6_3 mop3 mon3 vdd vbsyn gsyn
X_7_3 a_xp7 a_xn7 wp_7_3 wn_7_3 mop3 mon3 vdd vbsyn gsyn
X_8_3 a_xp8 a_xn8 wp_8_3 wn_8_3 mop3 mon3 vdd vbsyn gsyn
X_9_3 a_xp9 a_xn9 wp_9_3 wn_9_3 mop3 mon3 vdd vbsyn gsyn
X_10_3 a_xp10 a_xn10 wp_10_3 wn_10_3 mop3 mon3 vdd vbsyn gsyn
X_11_3 a_xp11 a_xn11 wp_11_3 wn_11_3 mop3 mon3 vdd vbsyn gsyn
X_12_3 a_xp12 a_xn12 wp_12_3 wn_12_3 mop3 mon3 vdd vbsyn gsyn
X_13_3 a_xp13 a_xn13 wp_13_3 wn_13_3 mop3 mon3 vdd vbsyn gsyn
X_14_3 a_xp14 a_xn14 wp_14_3 wn_14_3 mop3 mon3 vdd vbsyn gsyn
X_15_3 a_xp15 a_xn15 wp_15_3 wn_15_3 mop3 mon3 vdd vbsyn gsyn
X_16_3 a_xp16 a_xn16 wp_16_3 wn_16_3 mop3 mon3 vdd vbsyn gsyn
X_17_3 a_xp17 a_xn17 wp_17_3 wn_17_3 mop3 mon3 vdd vbsyn gsyn
X_18_3 a_xp18 a_xn18 wp_18_3 wn_18_3 mop3 mon3 vdd vbsyn gsyn
X_19_3 a_xp19 a_xn19 wp_19_3 wn_19_3 mop3 mon3 vdd vbsyn gsyn
X_20_3 a_xp20 a_xn20 wp_20_3 wn_20_3 mop3 mon3 vdd vbsyn gsyn
X_21_3 a_xp21 a_xn21 wp_21_3 wn_21_3 mop3 mon3 vdd vbsyn gsyn
X_22_3 a_xp22 a_xn22 wp_22_3 wn_22_3 mop3 mon3 vdd vbsyn gsyn
X_23_3 a_xp23 a_xn23 wp_23_3 wn_23_3 mop3 mon3 vdd vbsyn gsyn
X_24_3 a_xp24 a_xn24 wp_24_3 wn_24_3 mop3 mon3 vdd vbsyn gsyn
X_25_3 a_xp25 a_xn25 wp_25_3 wn_25_3 mop3 mon3 vdd vbsyn gsyn
X_26_3 a_xp26 a_xn26 wp_26_3 wn_26_3 mop3 mon3 vdd vbsyn gsyn
X_27_3 a_xp27 a_xn27 wp_27_3 wn_27_3 mop3 mon3 vdd vbsyn gsyn
X_28_3 a_xp28 a_xn28 wp_28_3 wn_28_3 mop3 mon3 vdd vbsyn gsyn
X_29_3 a_xp29 a_xn29 wp_29_3 wn_29_3 mop3 mon3 vdd vbsyn gsyn
X_30_3 a_xp30 a_xn30 wp_30_3 wn_30_3 mop3 mon3 vdd vbsyn gsyn
X_31_3 a_xp31 a_xn31 wp_31_3 wn_31_3 mop3 mon3 vdd vbsyn gsyn
X_32_3 a_xp32 a_xn32 wp_32_3 wn_32_3 mop3 mon3 vdd vbsyn gsyn
X_33_3 a_xp33 a_xn33 wp_33_3 wn_33_3 mop3 mon3 vdd vbsyn gsyn
X_34_3 a_xp34 a_xn34 wp_34_3 wn_34_3 mop3 mon3 vdd vbsyn gsyn
X_35_3 a_xp35 a_xn35 wp_35_3 wn_35_3 mop3 mon3 vdd vbsyn gsyn
X_36_3 a_xp36 a_xn36 wp_36_3 wn_36_3 mop3 mon3 vdd vbsyn gsyn
X_37_3 a_xp37 a_xn37 wp_37_3 wn_37_3 mop3 mon3 vdd vbsyn gsyn
X_38_3 a_xp38 a_xn38 wp_38_3 wn_38_3 mop3 mon3 vdd vbsyn gsyn
X_39_3 a_xp39 a_xn39 wp_39_3 wn_39_3 mop3 mon3 vdd vbsyn gsyn
X_40_3 a_xp40 a_xn40 wp_40_3 wn_40_3 mop3 mon3 vdd vbsyn gsyn
X_41_3 a_xp41 a_xn41 wp_41_3 wn_41_3 mop3 mon3 vdd vbsyn gsyn
X_42_3 a_xp42 a_xn42 wp_42_3 wn_42_3 mop3 mon3 vdd vbsyn gsyn
X_43_3 a_xp43 a_xn43 wp_43_3 wn_43_3 mop3 mon3 vdd vbsyn gsyn
X_44_3 a_xp44 a_xn44 wp_44_3 wn_44_3 mop3 mon3 vdd vbsyn gsyn
X_45_3 a_xp45 a_xn45 wp_45_3 wn_45_3 mop3 mon3 vdd vbsyn gsyn
X_46_3 a_xp46 a_xn46 wp_46_3 wn_46_3 mop3 mon3 vdd vbsyn gsyn
X_47_3 a_xp47 a_xn47 wp_47_3 wn_47_3 mop3 mon3 vdd vbsyn gsyn
X_48_3 a_xp48 a_xn48 wp_48_3 wn_48_3 mop3 mon3 vdd vbsyn gsyn
X_49_3 a_xp49 a_xn49 wp_49_3 wn_49_3 mop3 mon3 vdd vbsyn gsyn
X_50_3 a_xp50 a_xn50 wp_50_3 wn_50_3 mop3 mon3 vdd vbsyn gsyn
X_51_3 a_xp51 a_xn51 wp_51_3 wn_51_3 mop3 mon3 vdd vbsyn gsyn
X_52_3 a_xp52 a_xn52 wp_52_3 wn_52_3 mop3 mon3 vdd vbsyn gsyn
X_53_3 a_xp53 a_xn53 wp_53_3 wn_53_3 mop3 mon3 vdd vbsyn gsyn
X_54_3 a_xp54 a_xn54 wp_54_3 wn_54_3 mop3 mon3 vdd vbsyn gsyn
X_55_3 a_xp55 a_xn55 wp_55_3 wn_55_3 mop3 mon3 vdd vbsyn gsyn
X_56_3 a_xp56 a_xn56 wp_56_3 wn_56_3 mop3 mon3 vdd vbsyn gsyn
X_57_3 a_xp57 a_xn57 wp_57_3 wn_57_3 mop3 mon3 vdd vbsyn gsyn
X_58_3 a_xp58 a_xn58 wp_58_3 wn_58_3 mop3 mon3 vdd vbsyn gsyn
X_59_3 a_xp59 a_xn59 wp_59_3 wn_59_3 mop3 mon3 vdd vbsyn gsyn
X_60_3 a_xp60 a_xn60 wp_60_3 wn_60_3 mop3 mon3 vdd vbsyn gsyn
X_61_3 a_xp61 a_xn61 wp_61_3 wn_61_3 mop3 mon3 vdd vbsyn gsyn
X_62_3 a_xp62 a_xn62 wp_62_3 wn_62_3 mop3 mon3 vdd vbsyn gsyn
X_63_3 a_xp63 a_xn63 wp_63_3 wn_63_3 mop3 mon3 vdd vbsyn gsyn
Xcm_mo4 mop4 mon4 vdd cmld
Rnd_mo4 mop4 mon4 20k
X_0_4 a_xp0 a_xn0 wp_0_4 wn_0_4 mop4 mon4 vdd vbsyn gsyn
X_1_4 a_xp1 a_xn1 wp_1_4 wn_1_4 mop4 mon4 vdd vbsyn gsyn
X_2_4 a_xp2 a_xn2 wp_2_4 wn_2_4 mop4 mon4 vdd vbsyn gsyn
X_3_4 a_xp3 a_xn3 wp_3_4 wn_3_4 mop4 mon4 vdd vbsyn gsyn
X_4_4 a_xp4 a_xn4 wp_4_4 wn_4_4 mop4 mon4 vdd vbsyn gsyn
X_5_4 a_xp5 a_xn5 wp_5_4 wn_5_4 mop4 mon4 vdd vbsyn gsyn
X_6_4 a_xp6 a_xn6 wp_6_4 wn_6_4 mop4 mon4 vdd vbsyn gsyn
X_7_4 a_xp7 a_xn7 wp_7_4 wn_7_4 mop4 mon4 vdd vbsyn gsyn
X_8_4 a_xp8 a_xn8 wp_8_4 wn_8_4 mop4 mon4 vdd vbsyn gsyn
X_9_4 a_xp9 a_xn9 wp_9_4 wn_9_4 mop4 mon4 vdd vbsyn gsyn
X_10_4 a_xp10 a_xn10 wp_10_4 wn_10_4 mop4 mon4 vdd vbsyn gsyn
X_11_4 a_xp11 a_xn11 wp_11_4 wn_11_4 mop4 mon4 vdd vbsyn gsyn
X_12_4 a_xp12 a_xn12 wp_12_4 wn_12_4 mop4 mon4 vdd vbsyn gsyn
X_13_4 a_xp13 a_xn13 wp_13_4 wn_13_4 mop4 mon4 vdd vbsyn gsyn
X_14_4 a_xp14 a_xn14 wp_14_4 wn_14_4 mop4 mon4 vdd vbsyn gsyn
X_15_4 a_xp15 a_xn15 wp_15_4 wn_15_4 mop4 mon4 vdd vbsyn gsyn
X_16_4 a_xp16 a_xn16 wp_16_4 wn_16_4 mop4 mon4 vdd vbsyn gsyn
X_17_4 a_xp17 a_xn17 wp_17_4 wn_17_4 mop4 mon4 vdd vbsyn gsyn
X_18_4 a_xp18 a_xn18 wp_18_4 wn_18_4 mop4 mon4 vdd vbsyn gsyn
X_19_4 a_xp19 a_xn19 wp_19_4 wn_19_4 mop4 mon4 vdd vbsyn gsyn
X_20_4 a_xp20 a_xn20 wp_20_4 wn_20_4 mop4 mon4 vdd vbsyn gsyn
X_21_4 a_xp21 a_xn21 wp_21_4 wn_21_4 mop4 mon4 vdd vbsyn gsyn
X_22_4 a_xp22 a_xn22 wp_22_4 wn_22_4 mop4 mon4 vdd vbsyn gsyn
X_23_4 a_xp23 a_xn23 wp_23_4 wn_23_4 mop4 mon4 vdd vbsyn gsyn
X_24_4 a_xp24 a_xn24 wp_24_4 wn_24_4 mop4 mon4 vdd vbsyn gsyn
X_25_4 a_xp25 a_xn25 wp_25_4 wn_25_4 mop4 mon4 vdd vbsyn gsyn
X_26_4 a_xp26 a_xn26 wp_26_4 wn_26_4 mop4 mon4 vdd vbsyn gsyn
X_27_4 a_xp27 a_xn27 wp_27_4 wn_27_4 mop4 mon4 vdd vbsyn gsyn
X_28_4 a_xp28 a_xn28 wp_28_4 wn_28_4 mop4 mon4 vdd vbsyn gsyn
X_29_4 a_xp29 a_xn29 wp_29_4 wn_29_4 mop4 mon4 vdd vbsyn gsyn
X_30_4 a_xp30 a_xn30 wp_30_4 wn_30_4 mop4 mon4 vdd vbsyn gsyn
X_31_4 a_xp31 a_xn31 wp_31_4 wn_31_4 mop4 mon4 vdd vbsyn gsyn
X_32_4 a_xp32 a_xn32 wp_32_4 wn_32_4 mop4 mon4 vdd vbsyn gsyn
X_33_4 a_xp33 a_xn33 wp_33_4 wn_33_4 mop4 mon4 vdd vbsyn gsyn
X_34_4 a_xp34 a_xn34 wp_34_4 wn_34_4 mop4 mon4 vdd vbsyn gsyn
X_35_4 a_xp35 a_xn35 wp_35_4 wn_35_4 mop4 mon4 vdd vbsyn gsyn
X_36_4 a_xp36 a_xn36 wp_36_4 wn_36_4 mop4 mon4 vdd vbsyn gsyn
X_37_4 a_xp37 a_xn37 wp_37_4 wn_37_4 mop4 mon4 vdd vbsyn gsyn
X_38_4 a_xp38 a_xn38 wp_38_4 wn_38_4 mop4 mon4 vdd vbsyn gsyn
X_39_4 a_xp39 a_xn39 wp_39_4 wn_39_4 mop4 mon4 vdd vbsyn gsyn
X_40_4 a_xp40 a_xn40 wp_40_4 wn_40_4 mop4 mon4 vdd vbsyn gsyn
X_41_4 a_xp41 a_xn41 wp_41_4 wn_41_4 mop4 mon4 vdd vbsyn gsyn
X_42_4 a_xp42 a_xn42 wp_42_4 wn_42_4 mop4 mon4 vdd vbsyn gsyn
X_43_4 a_xp43 a_xn43 wp_43_4 wn_43_4 mop4 mon4 vdd vbsyn gsyn
X_44_4 a_xp44 a_xn44 wp_44_4 wn_44_4 mop4 mon4 vdd vbsyn gsyn
X_45_4 a_xp45 a_xn45 wp_45_4 wn_45_4 mop4 mon4 vdd vbsyn gsyn
X_46_4 a_xp46 a_xn46 wp_46_4 wn_46_4 mop4 mon4 vdd vbsyn gsyn
X_47_4 a_xp47 a_xn47 wp_47_4 wn_47_4 mop4 mon4 vdd vbsyn gsyn
X_48_4 a_xp48 a_xn48 wp_48_4 wn_48_4 mop4 mon4 vdd vbsyn gsyn
X_49_4 a_xp49 a_xn49 wp_49_4 wn_49_4 mop4 mon4 vdd vbsyn gsyn
X_50_4 a_xp50 a_xn50 wp_50_4 wn_50_4 mop4 mon4 vdd vbsyn gsyn
X_51_4 a_xp51 a_xn51 wp_51_4 wn_51_4 mop4 mon4 vdd vbsyn gsyn
X_52_4 a_xp52 a_xn52 wp_52_4 wn_52_4 mop4 mon4 vdd vbsyn gsyn
X_53_4 a_xp53 a_xn53 wp_53_4 wn_53_4 mop4 mon4 vdd vbsyn gsyn
X_54_4 a_xp54 a_xn54 wp_54_4 wn_54_4 mop4 mon4 vdd vbsyn gsyn
X_55_4 a_xp55 a_xn55 wp_55_4 wn_55_4 mop4 mon4 vdd vbsyn gsyn
X_56_4 a_xp56 a_xn56 wp_56_4 wn_56_4 mop4 mon4 vdd vbsyn gsyn
X_57_4 a_xp57 a_xn57 wp_57_4 wn_57_4 mop4 mon4 vdd vbsyn gsyn
X_58_4 a_xp58 a_xn58 wp_58_4 wn_58_4 mop4 mon4 vdd vbsyn gsyn
X_59_4 a_xp59 a_xn59 wp_59_4 wn_59_4 mop4 mon4 vdd vbsyn gsyn
X_60_4 a_xp60 a_xn60 wp_60_4 wn_60_4 mop4 mon4 vdd vbsyn gsyn
X_61_4 a_xp61 a_xn61 wp_61_4 wn_61_4 mop4 mon4 vdd vbsyn gsyn
X_62_4 a_xp62 a_xn62 wp_62_4 wn_62_4 mop4 mon4 vdd vbsyn gsyn
X_63_4 a_xp63 a_xn63 wp_63_4 wn_63_4 mop4 mon4 vdd vbsyn gsyn
Xcm_mo5 mop5 mon5 vdd cmld
Rnd_mo5 mop5 mon5 20k
X_0_5 a_xp0 a_xn0 wp_0_5 wn_0_5 mop5 mon5 vdd vbsyn gsyn
X_1_5 a_xp1 a_xn1 wp_1_5 wn_1_5 mop5 mon5 vdd vbsyn gsyn
X_2_5 a_xp2 a_xn2 wp_2_5 wn_2_5 mop5 mon5 vdd vbsyn gsyn
X_3_5 a_xp3 a_xn3 wp_3_5 wn_3_5 mop5 mon5 vdd vbsyn gsyn
X_4_5 a_xp4 a_xn4 wp_4_5 wn_4_5 mop5 mon5 vdd vbsyn gsyn
X_5_5 a_xp5 a_xn5 wp_5_5 wn_5_5 mop5 mon5 vdd vbsyn gsyn
X_6_5 a_xp6 a_xn6 wp_6_5 wn_6_5 mop5 mon5 vdd vbsyn gsyn
X_7_5 a_xp7 a_xn7 wp_7_5 wn_7_5 mop5 mon5 vdd vbsyn gsyn
X_8_5 a_xp8 a_xn8 wp_8_5 wn_8_5 mop5 mon5 vdd vbsyn gsyn
X_9_5 a_xp9 a_xn9 wp_9_5 wn_9_5 mop5 mon5 vdd vbsyn gsyn
X_10_5 a_xp10 a_xn10 wp_10_5 wn_10_5 mop5 mon5 vdd vbsyn gsyn
X_11_5 a_xp11 a_xn11 wp_11_5 wn_11_5 mop5 mon5 vdd vbsyn gsyn
X_12_5 a_xp12 a_xn12 wp_12_5 wn_12_5 mop5 mon5 vdd vbsyn gsyn
X_13_5 a_xp13 a_xn13 wp_13_5 wn_13_5 mop5 mon5 vdd vbsyn gsyn
X_14_5 a_xp14 a_xn14 wp_14_5 wn_14_5 mop5 mon5 vdd vbsyn gsyn
X_15_5 a_xp15 a_xn15 wp_15_5 wn_15_5 mop5 mon5 vdd vbsyn gsyn
X_16_5 a_xp16 a_xn16 wp_16_5 wn_16_5 mop5 mon5 vdd vbsyn gsyn
X_17_5 a_xp17 a_xn17 wp_17_5 wn_17_5 mop5 mon5 vdd vbsyn gsyn
X_18_5 a_xp18 a_xn18 wp_18_5 wn_18_5 mop5 mon5 vdd vbsyn gsyn
X_19_5 a_xp19 a_xn19 wp_19_5 wn_19_5 mop5 mon5 vdd vbsyn gsyn
X_20_5 a_xp20 a_xn20 wp_20_5 wn_20_5 mop5 mon5 vdd vbsyn gsyn
X_21_5 a_xp21 a_xn21 wp_21_5 wn_21_5 mop5 mon5 vdd vbsyn gsyn
X_22_5 a_xp22 a_xn22 wp_22_5 wn_22_5 mop5 mon5 vdd vbsyn gsyn
X_23_5 a_xp23 a_xn23 wp_23_5 wn_23_5 mop5 mon5 vdd vbsyn gsyn
X_24_5 a_xp24 a_xn24 wp_24_5 wn_24_5 mop5 mon5 vdd vbsyn gsyn
X_25_5 a_xp25 a_xn25 wp_25_5 wn_25_5 mop5 mon5 vdd vbsyn gsyn
X_26_5 a_xp26 a_xn26 wp_26_5 wn_26_5 mop5 mon5 vdd vbsyn gsyn
X_27_5 a_xp27 a_xn27 wp_27_5 wn_27_5 mop5 mon5 vdd vbsyn gsyn
X_28_5 a_xp28 a_xn28 wp_28_5 wn_28_5 mop5 mon5 vdd vbsyn gsyn
X_29_5 a_xp29 a_xn29 wp_29_5 wn_29_5 mop5 mon5 vdd vbsyn gsyn
X_30_5 a_xp30 a_xn30 wp_30_5 wn_30_5 mop5 mon5 vdd vbsyn gsyn
X_31_5 a_xp31 a_xn31 wp_31_5 wn_31_5 mop5 mon5 vdd vbsyn gsyn
X_32_5 a_xp32 a_xn32 wp_32_5 wn_32_5 mop5 mon5 vdd vbsyn gsyn
X_33_5 a_xp33 a_xn33 wp_33_5 wn_33_5 mop5 mon5 vdd vbsyn gsyn
X_34_5 a_xp34 a_xn34 wp_34_5 wn_34_5 mop5 mon5 vdd vbsyn gsyn
X_35_5 a_xp35 a_xn35 wp_35_5 wn_35_5 mop5 mon5 vdd vbsyn gsyn
X_36_5 a_xp36 a_xn36 wp_36_5 wn_36_5 mop5 mon5 vdd vbsyn gsyn
X_37_5 a_xp37 a_xn37 wp_37_5 wn_37_5 mop5 mon5 vdd vbsyn gsyn
X_38_5 a_xp38 a_xn38 wp_38_5 wn_38_5 mop5 mon5 vdd vbsyn gsyn
X_39_5 a_xp39 a_xn39 wp_39_5 wn_39_5 mop5 mon5 vdd vbsyn gsyn
X_40_5 a_xp40 a_xn40 wp_40_5 wn_40_5 mop5 mon5 vdd vbsyn gsyn
X_41_5 a_xp41 a_xn41 wp_41_5 wn_41_5 mop5 mon5 vdd vbsyn gsyn
X_42_5 a_xp42 a_xn42 wp_42_5 wn_42_5 mop5 mon5 vdd vbsyn gsyn
X_43_5 a_xp43 a_xn43 wp_43_5 wn_43_5 mop5 mon5 vdd vbsyn gsyn
X_44_5 a_xp44 a_xn44 wp_44_5 wn_44_5 mop5 mon5 vdd vbsyn gsyn
X_45_5 a_xp45 a_xn45 wp_45_5 wn_45_5 mop5 mon5 vdd vbsyn gsyn
X_46_5 a_xp46 a_xn46 wp_46_5 wn_46_5 mop5 mon5 vdd vbsyn gsyn
X_47_5 a_xp47 a_xn47 wp_47_5 wn_47_5 mop5 mon5 vdd vbsyn gsyn
X_48_5 a_xp48 a_xn48 wp_48_5 wn_48_5 mop5 mon5 vdd vbsyn gsyn
X_49_5 a_xp49 a_xn49 wp_49_5 wn_49_5 mop5 mon5 vdd vbsyn gsyn
X_50_5 a_xp50 a_xn50 wp_50_5 wn_50_5 mop5 mon5 vdd vbsyn gsyn
X_51_5 a_xp51 a_xn51 wp_51_5 wn_51_5 mop5 mon5 vdd vbsyn gsyn
X_52_5 a_xp52 a_xn52 wp_52_5 wn_52_5 mop5 mon5 vdd vbsyn gsyn
X_53_5 a_xp53 a_xn53 wp_53_5 wn_53_5 mop5 mon5 vdd vbsyn gsyn
X_54_5 a_xp54 a_xn54 wp_54_5 wn_54_5 mop5 mon5 vdd vbsyn gsyn
X_55_5 a_xp55 a_xn55 wp_55_5 wn_55_5 mop5 mon5 vdd vbsyn gsyn
X_56_5 a_xp56 a_xn56 wp_56_5 wn_56_5 mop5 mon5 vdd vbsyn gsyn
X_57_5 a_xp57 a_xn57 wp_57_5 wn_57_5 mop5 mon5 vdd vbsyn gsyn
X_58_5 a_xp58 a_xn58 wp_58_5 wn_58_5 mop5 mon5 vdd vbsyn gsyn
X_59_5 a_xp59 a_xn59 wp_59_5 wn_59_5 mop5 mon5 vdd vbsyn gsyn
X_60_5 a_xp60 a_xn60 wp_60_5 wn_60_5 mop5 mon5 vdd vbsyn gsyn
X_61_5 a_xp61 a_xn61 wp_61_5 wn_61_5 mop5 mon5 vdd vbsyn gsyn
X_62_5 a_xp62 a_xn62 wp_62_5 wn_62_5 mop5 mon5 vdd vbsyn gsyn
X_63_5 a_xp63 a_xn63 wp_63_5 wn_63_5 mop5 mon5 vdd vbsyn gsyn
Xcm_mo6 mop6 mon6 vdd cmld
Rnd_mo6 mop6 mon6 20k
X_0_6 a_xp0 a_xn0 wp_0_6 wn_0_6 mop6 mon6 vdd vbsyn gsyn
X_1_6 a_xp1 a_xn1 wp_1_6 wn_1_6 mop6 mon6 vdd vbsyn gsyn
X_2_6 a_xp2 a_xn2 wp_2_6 wn_2_6 mop6 mon6 vdd vbsyn gsyn
X_3_6 a_xp3 a_xn3 wp_3_6 wn_3_6 mop6 mon6 vdd vbsyn gsyn
X_4_6 a_xp4 a_xn4 wp_4_6 wn_4_6 mop6 mon6 vdd vbsyn gsyn
X_5_6 a_xp5 a_xn5 wp_5_6 wn_5_6 mop6 mon6 vdd vbsyn gsyn
X_6_6 a_xp6 a_xn6 wp_6_6 wn_6_6 mop6 mon6 vdd vbsyn gsyn
X_7_6 a_xp7 a_xn7 wp_7_6 wn_7_6 mop6 mon6 vdd vbsyn gsyn
X_8_6 a_xp8 a_xn8 wp_8_6 wn_8_6 mop6 mon6 vdd vbsyn gsyn
X_9_6 a_xp9 a_xn9 wp_9_6 wn_9_6 mop6 mon6 vdd vbsyn gsyn
X_10_6 a_xp10 a_xn10 wp_10_6 wn_10_6 mop6 mon6 vdd vbsyn gsyn
X_11_6 a_xp11 a_xn11 wp_11_6 wn_11_6 mop6 mon6 vdd vbsyn gsyn
X_12_6 a_xp12 a_xn12 wp_12_6 wn_12_6 mop6 mon6 vdd vbsyn gsyn
X_13_6 a_xp13 a_xn13 wp_13_6 wn_13_6 mop6 mon6 vdd vbsyn gsyn
X_14_6 a_xp14 a_xn14 wp_14_6 wn_14_6 mop6 mon6 vdd vbsyn gsyn
X_15_6 a_xp15 a_xn15 wp_15_6 wn_15_6 mop6 mon6 vdd vbsyn gsyn
X_16_6 a_xp16 a_xn16 wp_16_6 wn_16_6 mop6 mon6 vdd vbsyn gsyn
X_17_6 a_xp17 a_xn17 wp_17_6 wn_17_6 mop6 mon6 vdd vbsyn gsyn
X_18_6 a_xp18 a_xn18 wp_18_6 wn_18_6 mop6 mon6 vdd vbsyn gsyn
X_19_6 a_xp19 a_xn19 wp_19_6 wn_19_6 mop6 mon6 vdd vbsyn gsyn
X_20_6 a_xp20 a_xn20 wp_20_6 wn_20_6 mop6 mon6 vdd vbsyn gsyn
X_21_6 a_xp21 a_xn21 wp_21_6 wn_21_6 mop6 mon6 vdd vbsyn gsyn
X_22_6 a_xp22 a_xn22 wp_22_6 wn_22_6 mop6 mon6 vdd vbsyn gsyn
X_23_6 a_xp23 a_xn23 wp_23_6 wn_23_6 mop6 mon6 vdd vbsyn gsyn
X_24_6 a_xp24 a_xn24 wp_24_6 wn_24_6 mop6 mon6 vdd vbsyn gsyn
X_25_6 a_xp25 a_xn25 wp_25_6 wn_25_6 mop6 mon6 vdd vbsyn gsyn
X_26_6 a_xp26 a_xn26 wp_26_6 wn_26_6 mop6 mon6 vdd vbsyn gsyn
X_27_6 a_xp27 a_xn27 wp_27_6 wn_27_6 mop6 mon6 vdd vbsyn gsyn
X_28_6 a_xp28 a_xn28 wp_28_6 wn_28_6 mop6 mon6 vdd vbsyn gsyn
X_29_6 a_xp29 a_xn29 wp_29_6 wn_29_6 mop6 mon6 vdd vbsyn gsyn
X_30_6 a_xp30 a_xn30 wp_30_6 wn_30_6 mop6 mon6 vdd vbsyn gsyn
X_31_6 a_xp31 a_xn31 wp_31_6 wn_31_6 mop6 mon6 vdd vbsyn gsyn
X_32_6 a_xp32 a_xn32 wp_32_6 wn_32_6 mop6 mon6 vdd vbsyn gsyn
X_33_6 a_xp33 a_xn33 wp_33_6 wn_33_6 mop6 mon6 vdd vbsyn gsyn
X_34_6 a_xp34 a_xn34 wp_34_6 wn_34_6 mop6 mon6 vdd vbsyn gsyn
X_35_6 a_xp35 a_xn35 wp_35_6 wn_35_6 mop6 mon6 vdd vbsyn gsyn
X_36_6 a_xp36 a_xn36 wp_36_6 wn_36_6 mop6 mon6 vdd vbsyn gsyn
X_37_6 a_xp37 a_xn37 wp_37_6 wn_37_6 mop6 mon6 vdd vbsyn gsyn
X_38_6 a_xp38 a_xn38 wp_38_6 wn_38_6 mop6 mon6 vdd vbsyn gsyn
X_39_6 a_xp39 a_xn39 wp_39_6 wn_39_6 mop6 mon6 vdd vbsyn gsyn
X_40_6 a_xp40 a_xn40 wp_40_6 wn_40_6 mop6 mon6 vdd vbsyn gsyn
X_41_6 a_xp41 a_xn41 wp_41_6 wn_41_6 mop6 mon6 vdd vbsyn gsyn
X_42_6 a_xp42 a_xn42 wp_42_6 wn_42_6 mop6 mon6 vdd vbsyn gsyn
X_43_6 a_xp43 a_xn43 wp_43_6 wn_43_6 mop6 mon6 vdd vbsyn gsyn
X_44_6 a_xp44 a_xn44 wp_44_6 wn_44_6 mop6 mon6 vdd vbsyn gsyn
X_45_6 a_xp45 a_xn45 wp_45_6 wn_45_6 mop6 mon6 vdd vbsyn gsyn
X_46_6 a_xp46 a_xn46 wp_46_6 wn_46_6 mop6 mon6 vdd vbsyn gsyn
X_47_6 a_xp47 a_xn47 wp_47_6 wn_47_6 mop6 mon6 vdd vbsyn gsyn
X_48_6 a_xp48 a_xn48 wp_48_6 wn_48_6 mop6 mon6 vdd vbsyn gsyn
X_49_6 a_xp49 a_xn49 wp_49_6 wn_49_6 mop6 mon6 vdd vbsyn gsyn
X_50_6 a_xp50 a_xn50 wp_50_6 wn_50_6 mop6 mon6 vdd vbsyn gsyn
X_51_6 a_xp51 a_xn51 wp_51_6 wn_51_6 mop6 mon6 vdd vbsyn gsyn
X_52_6 a_xp52 a_xn52 wp_52_6 wn_52_6 mop6 mon6 vdd vbsyn gsyn
X_53_6 a_xp53 a_xn53 wp_53_6 wn_53_6 mop6 mon6 vdd vbsyn gsyn
X_54_6 a_xp54 a_xn54 wp_54_6 wn_54_6 mop6 mon6 vdd vbsyn gsyn
X_55_6 a_xp55 a_xn55 wp_55_6 wn_55_6 mop6 mon6 vdd vbsyn gsyn
X_56_6 a_xp56 a_xn56 wp_56_6 wn_56_6 mop6 mon6 vdd vbsyn gsyn
X_57_6 a_xp57 a_xn57 wp_57_6 wn_57_6 mop6 mon6 vdd vbsyn gsyn
X_58_6 a_xp58 a_xn58 wp_58_6 wn_58_6 mop6 mon6 vdd vbsyn gsyn
X_59_6 a_xp59 a_xn59 wp_59_6 wn_59_6 mop6 mon6 vdd vbsyn gsyn
X_60_6 a_xp60 a_xn60 wp_60_6 wn_60_6 mop6 mon6 vdd vbsyn gsyn
X_61_6 a_xp61 a_xn61 wp_61_6 wn_61_6 mop6 mon6 vdd vbsyn gsyn
X_62_6 a_xp62 a_xn62 wp_62_6 wn_62_6 mop6 mon6 vdd vbsyn gsyn
X_63_6 a_xp63 a_xn63 wp_63_6 wn_63_6 mop6 mon6 vdd vbsyn gsyn
Xcm_mo7 mop7 mon7 vdd cmld
Rnd_mo7 mop7 mon7 20k
X_0_7 a_xp0 a_xn0 wp_0_7 wn_0_7 mop7 mon7 vdd vbsyn gsyn
X_1_7 a_xp1 a_xn1 wp_1_7 wn_1_7 mop7 mon7 vdd vbsyn gsyn
X_2_7 a_xp2 a_xn2 wp_2_7 wn_2_7 mop7 mon7 vdd vbsyn gsyn
X_3_7 a_xp3 a_xn3 wp_3_7 wn_3_7 mop7 mon7 vdd vbsyn gsyn
X_4_7 a_xp4 a_xn4 wp_4_7 wn_4_7 mop7 mon7 vdd vbsyn gsyn
X_5_7 a_xp5 a_xn5 wp_5_7 wn_5_7 mop7 mon7 vdd vbsyn gsyn
X_6_7 a_xp6 a_xn6 wp_6_7 wn_6_7 mop7 mon7 vdd vbsyn gsyn
X_7_7 a_xp7 a_xn7 wp_7_7 wn_7_7 mop7 mon7 vdd vbsyn gsyn
X_8_7 a_xp8 a_xn8 wp_8_7 wn_8_7 mop7 mon7 vdd vbsyn gsyn
X_9_7 a_xp9 a_xn9 wp_9_7 wn_9_7 mop7 mon7 vdd vbsyn gsyn
X_10_7 a_xp10 a_xn10 wp_10_7 wn_10_7 mop7 mon7 vdd vbsyn gsyn
X_11_7 a_xp11 a_xn11 wp_11_7 wn_11_7 mop7 mon7 vdd vbsyn gsyn
X_12_7 a_xp12 a_xn12 wp_12_7 wn_12_7 mop7 mon7 vdd vbsyn gsyn
X_13_7 a_xp13 a_xn13 wp_13_7 wn_13_7 mop7 mon7 vdd vbsyn gsyn
X_14_7 a_xp14 a_xn14 wp_14_7 wn_14_7 mop7 mon7 vdd vbsyn gsyn
X_15_7 a_xp15 a_xn15 wp_15_7 wn_15_7 mop7 mon7 vdd vbsyn gsyn
X_16_7 a_xp16 a_xn16 wp_16_7 wn_16_7 mop7 mon7 vdd vbsyn gsyn
X_17_7 a_xp17 a_xn17 wp_17_7 wn_17_7 mop7 mon7 vdd vbsyn gsyn
X_18_7 a_xp18 a_xn18 wp_18_7 wn_18_7 mop7 mon7 vdd vbsyn gsyn
X_19_7 a_xp19 a_xn19 wp_19_7 wn_19_7 mop7 mon7 vdd vbsyn gsyn
X_20_7 a_xp20 a_xn20 wp_20_7 wn_20_7 mop7 mon7 vdd vbsyn gsyn
X_21_7 a_xp21 a_xn21 wp_21_7 wn_21_7 mop7 mon7 vdd vbsyn gsyn
X_22_7 a_xp22 a_xn22 wp_22_7 wn_22_7 mop7 mon7 vdd vbsyn gsyn
X_23_7 a_xp23 a_xn23 wp_23_7 wn_23_7 mop7 mon7 vdd vbsyn gsyn
X_24_7 a_xp24 a_xn24 wp_24_7 wn_24_7 mop7 mon7 vdd vbsyn gsyn
X_25_7 a_xp25 a_xn25 wp_25_7 wn_25_7 mop7 mon7 vdd vbsyn gsyn
X_26_7 a_xp26 a_xn26 wp_26_7 wn_26_7 mop7 mon7 vdd vbsyn gsyn
X_27_7 a_xp27 a_xn27 wp_27_7 wn_27_7 mop7 mon7 vdd vbsyn gsyn
X_28_7 a_xp28 a_xn28 wp_28_7 wn_28_7 mop7 mon7 vdd vbsyn gsyn
X_29_7 a_xp29 a_xn29 wp_29_7 wn_29_7 mop7 mon7 vdd vbsyn gsyn
X_30_7 a_xp30 a_xn30 wp_30_7 wn_30_7 mop7 mon7 vdd vbsyn gsyn
X_31_7 a_xp31 a_xn31 wp_31_7 wn_31_7 mop7 mon7 vdd vbsyn gsyn
X_32_7 a_xp32 a_xn32 wp_32_7 wn_32_7 mop7 mon7 vdd vbsyn gsyn
X_33_7 a_xp33 a_xn33 wp_33_7 wn_33_7 mop7 mon7 vdd vbsyn gsyn
X_34_7 a_xp34 a_xn34 wp_34_7 wn_34_7 mop7 mon7 vdd vbsyn gsyn
X_35_7 a_xp35 a_xn35 wp_35_7 wn_35_7 mop7 mon7 vdd vbsyn gsyn
X_36_7 a_xp36 a_xn36 wp_36_7 wn_36_7 mop7 mon7 vdd vbsyn gsyn
X_37_7 a_xp37 a_xn37 wp_37_7 wn_37_7 mop7 mon7 vdd vbsyn gsyn
X_38_7 a_xp38 a_xn38 wp_38_7 wn_38_7 mop7 mon7 vdd vbsyn gsyn
X_39_7 a_xp39 a_xn39 wp_39_7 wn_39_7 mop7 mon7 vdd vbsyn gsyn
X_40_7 a_xp40 a_xn40 wp_40_7 wn_40_7 mop7 mon7 vdd vbsyn gsyn
X_41_7 a_xp41 a_xn41 wp_41_7 wn_41_7 mop7 mon7 vdd vbsyn gsyn
X_42_7 a_xp42 a_xn42 wp_42_7 wn_42_7 mop7 mon7 vdd vbsyn gsyn
X_43_7 a_xp43 a_xn43 wp_43_7 wn_43_7 mop7 mon7 vdd vbsyn gsyn
X_44_7 a_xp44 a_xn44 wp_44_7 wn_44_7 mop7 mon7 vdd vbsyn gsyn
X_45_7 a_xp45 a_xn45 wp_45_7 wn_45_7 mop7 mon7 vdd vbsyn gsyn
X_46_7 a_xp46 a_xn46 wp_46_7 wn_46_7 mop7 mon7 vdd vbsyn gsyn
X_47_7 a_xp47 a_xn47 wp_47_7 wn_47_7 mop7 mon7 vdd vbsyn gsyn
X_48_7 a_xp48 a_xn48 wp_48_7 wn_48_7 mop7 mon7 vdd vbsyn gsyn
X_49_7 a_xp49 a_xn49 wp_49_7 wn_49_7 mop7 mon7 vdd vbsyn gsyn
X_50_7 a_xp50 a_xn50 wp_50_7 wn_50_7 mop7 mon7 vdd vbsyn gsyn
X_51_7 a_xp51 a_xn51 wp_51_7 wn_51_7 mop7 mon7 vdd vbsyn gsyn
X_52_7 a_xp52 a_xn52 wp_52_7 wn_52_7 mop7 mon7 vdd vbsyn gsyn
X_53_7 a_xp53 a_xn53 wp_53_7 wn_53_7 mop7 mon7 vdd vbsyn gsyn
X_54_7 a_xp54 a_xn54 wp_54_7 wn_54_7 mop7 mon7 vdd vbsyn gsyn
X_55_7 a_xp55 a_xn55 wp_55_7 wn_55_7 mop7 mon7 vdd vbsyn gsyn
X_56_7 a_xp56 a_xn56 wp_56_7 wn_56_7 mop7 mon7 vdd vbsyn gsyn
X_57_7 a_xp57 a_xn57 wp_57_7 wn_57_7 mop7 mon7 vdd vbsyn gsyn
X_58_7 a_xp58 a_xn58 wp_58_7 wn_58_7 mop7 mon7 vdd vbsyn gsyn
X_59_7 a_xp59 a_xn59 wp_59_7 wn_59_7 mop7 mon7 vdd vbsyn gsyn
X_60_7 a_xp60 a_xn60 wp_60_7 wn_60_7 mop7 mon7 vdd vbsyn gsyn
X_61_7 a_xp61 a_xn61 wp_61_7 wn_61_7 mop7 mon7 vdd vbsyn gsyn
X_62_7 a_xp62 a_xn62 wp_62_7 wn_62_7 mop7 mon7 vdd vbsyn gsyn
X_63_7 a_xp63 a_xn63 wp_63_7 wn_63_7 mop7 mon7 vdd vbsyn gsyn
Xcm_mo8 mop8 mon8 vdd cmld
Rnd_mo8 mop8 mon8 20k
X_0_8 a_xp0 a_xn0 wp_0_8 wn_0_8 mop8 mon8 vdd vbsyn gsyn
X_1_8 a_xp1 a_xn1 wp_1_8 wn_1_8 mop8 mon8 vdd vbsyn gsyn
X_2_8 a_xp2 a_xn2 wp_2_8 wn_2_8 mop8 mon8 vdd vbsyn gsyn
X_3_8 a_xp3 a_xn3 wp_3_8 wn_3_8 mop8 mon8 vdd vbsyn gsyn
X_4_8 a_xp4 a_xn4 wp_4_8 wn_4_8 mop8 mon8 vdd vbsyn gsyn
X_5_8 a_xp5 a_xn5 wp_5_8 wn_5_8 mop8 mon8 vdd vbsyn gsyn
X_6_8 a_xp6 a_xn6 wp_6_8 wn_6_8 mop8 mon8 vdd vbsyn gsyn
X_7_8 a_xp7 a_xn7 wp_7_8 wn_7_8 mop8 mon8 vdd vbsyn gsyn
X_8_8 a_xp8 a_xn8 wp_8_8 wn_8_8 mop8 mon8 vdd vbsyn gsyn
X_9_8 a_xp9 a_xn9 wp_9_8 wn_9_8 mop8 mon8 vdd vbsyn gsyn
X_10_8 a_xp10 a_xn10 wp_10_8 wn_10_8 mop8 mon8 vdd vbsyn gsyn
X_11_8 a_xp11 a_xn11 wp_11_8 wn_11_8 mop8 mon8 vdd vbsyn gsyn
X_12_8 a_xp12 a_xn12 wp_12_8 wn_12_8 mop8 mon8 vdd vbsyn gsyn
X_13_8 a_xp13 a_xn13 wp_13_8 wn_13_8 mop8 mon8 vdd vbsyn gsyn
X_14_8 a_xp14 a_xn14 wp_14_8 wn_14_8 mop8 mon8 vdd vbsyn gsyn
X_15_8 a_xp15 a_xn15 wp_15_8 wn_15_8 mop8 mon8 vdd vbsyn gsyn
X_16_8 a_xp16 a_xn16 wp_16_8 wn_16_8 mop8 mon8 vdd vbsyn gsyn
X_17_8 a_xp17 a_xn17 wp_17_8 wn_17_8 mop8 mon8 vdd vbsyn gsyn
X_18_8 a_xp18 a_xn18 wp_18_8 wn_18_8 mop8 mon8 vdd vbsyn gsyn
X_19_8 a_xp19 a_xn19 wp_19_8 wn_19_8 mop8 mon8 vdd vbsyn gsyn
X_20_8 a_xp20 a_xn20 wp_20_8 wn_20_8 mop8 mon8 vdd vbsyn gsyn
X_21_8 a_xp21 a_xn21 wp_21_8 wn_21_8 mop8 mon8 vdd vbsyn gsyn
X_22_8 a_xp22 a_xn22 wp_22_8 wn_22_8 mop8 mon8 vdd vbsyn gsyn
X_23_8 a_xp23 a_xn23 wp_23_8 wn_23_8 mop8 mon8 vdd vbsyn gsyn
X_24_8 a_xp24 a_xn24 wp_24_8 wn_24_8 mop8 mon8 vdd vbsyn gsyn
X_25_8 a_xp25 a_xn25 wp_25_8 wn_25_8 mop8 mon8 vdd vbsyn gsyn
X_26_8 a_xp26 a_xn26 wp_26_8 wn_26_8 mop8 mon8 vdd vbsyn gsyn
X_27_8 a_xp27 a_xn27 wp_27_8 wn_27_8 mop8 mon8 vdd vbsyn gsyn
X_28_8 a_xp28 a_xn28 wp_28_8 wn_28_8 mop8 mon8 vdd vbsyn gsyn
X_29_8 a_xp29 a_xn29 wp_29_8 wn_29_8 mop8 mon8 vdd vbsyn gsyn
X_30_8 a_xp30 a_xn30 wp_30_8 wn_30_8 mop8 mon8 vdd vbsyn gsyn
X_31_8 a_xp31 a_xn31 wp_31_8 wn_31_8 mop8 mon8 vdd vbsyn gsyn
X_32_8 a_xp32 a_xn32 wp_32_8 wn_32_8 mop8 mon8 vdd vbsyn gsyn
X_33_8 a_xp33 a_xn33 wp_33_8 wn_33_8 mop8 mon8 vdd vbsyn gsyn
X_34_8 a_xp34 a_xn34 wp_34_8 wn_34_8 mop8 mon8 vdd vbsyn gsyn
X_35_8 a_xp35 a_xn35 wp_35_8 wn_35_8 mop8 mon8 vdd vbsyn gsyn
X_36_8 a_xp36 a_xn36 wp_36_8 wn_36_8 mop8 mon8 vdd vbsyn gsyn
X_37_8 a_xp37 a_xn37 wp_37_8 wn_37_8 mop8 mon8 vdd vbsyn gsyn
X_38_8 a_xp38 a_xn38 wp_38_8 wn_38_8 mop8 mon8 vdd vbsyn gsyn
X_39_8 a_xp39 a_xn39 wp_39_8 wn_39_8 mop8 mon8 vdd vbsyn gsyn
X_40_8 a_xp40 a_xn40 wp_40_8 wn_40_8 mop8 mon8 vdd vbsyn gsyn
X_41_8 a_xp41 a_xn41 wp_41_8 wn_41_8 mop8 mon8 vdd vbsyn gsyn
X_42_8 a_xp42 a_xn42 wp_42_8 wn_42_8 mop8 mon8 vdd vbsyn gsyn
X_43_8 a_xp43 a_xn43 wp_43_8 wn_43_8 mop8 mon8 vdd vbsyn gsyn
X_44_8 a_xp44 a_xn44 wp_44_8 wn_44_8 mop8 mon8 vdd vbsyn gsyn
X_45_8 a_xp45 a_xn45 wp_45_8 wn_45_8 mop8 mon8 vdd vbsyn gsyn
X_46_8 a_xp46 a_xn46 wp_46_8 wn_46_8 mop8 mon8 vdd vbsyn gsyn
X_47_8 a_xp47 a_xn47 wp_47_8 wn_47_8 mop8 mon8 vdd vbsyn gsyn
X_48_8 a_xp48 a_xn48 wp_48_8 wn_48_8 mop8 mon8 vdd vbsyn gsyn
X_49_8 a_xp49 a_xn49 wp_49_8 wn_49_8 mop8 mon8 vdd vbsyn gsyn
X_50_8 a_xp50 a_xn50 wp_50_8 wn_50_8 mop8 mon8 vdd vbsyn gsyn
X_51_8 a_xp51 a_xn51 wp_51_8 wn_51_8 mop8 mon8 vdd vbsyn gsyn
X_52_8 a_xp52 a_xn52 wp_52_8 wn_52_8 mop8 mon8 vdd vbsyn gsyn
X_53_8 a_xp53 a_xn53 wp_53_8 wn_53_8 mop8 mon8 vdd vbsyn gsyn
X_54_8 a_xp54 a_xn54 wp_54_8 wn_54_8 mop8 mon8 vdd vbsyn gsyn
X_55_8 a_xp55 a_xn55 wp_55_8 wn_55_8 mop8 mon8 vdd vbsyn gsyn
X_56_8 a_xp56 a_xn56 wp_56_8 wn_56_8 mop8 mon8 vdd vbsyn gsyn
X_57_8 a_xp57 a_xn57 wp_57_8 wn_57_8 mop8 mon8 vdd vbsyn gsyn
X_58_8 a_xp58 a_xn58 wp_58_8 wn_58_8 mop8 mon8 vdd vbsyn gsyn
X_59_8 a_xp59 a_xn59 wp_59_8 wn_59_8 mop8 mon8 vdd vbsyn gsyn
X_60_8 a_xp60 a_xn60 wp_60_8 wn_60_8 mop8 mon8 vdd vbsyn gsyn
X_61_8 a_xp61 a_xn61 wp_61_8 wn_61_8 mop8 mon8 vdd vbsyn gsyn
X_62_8 a_xp62 a_xn62 wp_62_8 wn_62_8 mop8 mon8 vdd vbsyn gsyn
X_63_8 a_xp63 a_xn63 wp_63_8 wn_63_8 mop8 mon8 vdd vbsyn gsyn
Xcm_mo9 mop9 mon9 vdd cmld
Rnd_mo9 mop9 mon9 20k
X_0_9 a_xp0 a_xn0 wp_0_9 wn_0_9 mop9 mon9 vdd vbsyn gsyn
X_1_9 a_xp1 a_xn1 wp_1_9 wn_1_9 mop9 mon9 vdd vbsyn gsyn
X_2_9 a_xp2 a_xn2 wp_2_9 wn_2_9 mop9 mon9 vdd vbsyn gsyn
X_3_9 a_xp3 a_xn3 wp_3_9 wn_3_9 mop9 mon9 vdd vbsyn gsyn
X_4_9 a_xp4 a_xn4 wp_4_9 wn_4_9 mop9 mon9 vdd vbsyn gsyn
X_5_9 a_xp5 a_xn5 wp_5_9 wn_5_9 mop9 mon9 vdd vbsyn gsyn
X_6_9 a_xp6 a_xn6 wp_6_9 wn_6_9 mop9 mon9 vdd vbsyn gsyn
X_7_9 a_xp7 a_xn7 wp_7_9 wn_7_9 mop9 mon9 vdd vbsyn gsyn
X_8_9 a_xp8 a_xn8 wp_8_9 wn_8_9 mop9 mon9 vdd vbsyn gsyn
X_9_9 a_xp9 a_xn9 wp_9_9 wn_9_9 mop9 mon9 vdd vbsyn gsyn
X_10_9 a_xp10 a_xn10 wp_10_9 wn_10_9 mop9 mon9 vdd vbsyn gsyn
X_11_9 a_xp11 a_xn11 wp_11_9 wn_11_9 mop9 mon9 vdd vbsyn gsyn
X_12_9 a_xp12 a_xn12 wp_12_9 wn_12_9 mop9 mon9 vdd vbsyn gsyn
X_13_9 a_xp13 a_xn13 wp_13_9 wn_13_9 mop9 mon9 vdd vbsyn gsyn
X_14_9 a_xp14 a_xn14 wp_14_9 wn_14_9 mop9 mon9 vdd vbsyn gsyn
X_15_9 a_xp15 a_xn15 wp_15_9 wn_15_9 mop9 mon9 vdd vbsyn gsyn
X_16_9 a_xp16 a_xn16 wp_16_9 wn_16_9 mop9 mon9 vdd vbsyn gsyn
X_17_9 a_xp17 a_xn17 wp_17_9 wn_17_9 mop9 mon9 vdd vbsyn gsyn
X_18_9 a_xp18 a_xn18 wp_18_9 wn_18_9 mop9 mon9 vdd vbsyn gsyn
X_19_9 a_xp19 a_xn19 wp_19_9 wn_19_9 mop9 mon9 vdd vbsyn gsyn
X_20_9 a_xp20 a_xn20 wp_20_9 wn_20_9 mop9 mon9 vdd vbsyn gsyn
X_21_9 a_xp21 a_xn21 wp_21_9 wn_21_9 mop9 mon9 vdd vbsyn gsyn
X_22_9 a_xp22 a_xn22 wp_22_9 wn_22_9 mop9 mon9 vdd vbsyn gsyn
X_23_9 a_xp23 a_xn23 wp_23_9 wn_23_9 mop9 mon9 vdd vbsyn gsyn
X_24_9 a_xp24 a_xn24 wp_24_9 wn_24_9 mop9 mon9 vdd vbsyn gsyn
X_25_9 a_xp25 a_xn25 wp_25_9 wn_25_9 mop9 mon9 vdd vbsyn gsyn
X_26_9 a_xp26 a_xn26 wp_26_9 wn_26_9 mop9 mon9 vdd vbsyn gsyn
X_27_9 a_xp27 a_xn27 wp_27_9 wn_27_9 mop9 mon9 vdd vbsyn gsyn
X_28_9 a_xp28 a_xn28 wp_28_9 wn_28_9 mop9 mon9 vdd vbsyn gsyn
X_29_9 a_xp29 a_xn29 wp_29_9 wn_29_9 mop9 mon9 vdd vbsyn gsyn
X_30_9 a_xp30 a_xn30 wp_30_9 wn_30_9 mop9 mon9 vdd vbsyn gsyn
X_31_9 a_xp31 a_xn31 wp_31_9 wn_31_9 mop9 mon9 vdd vbsyn gsyn
X_32_9 a_xp32 a_xn32 wp_32_9 wn_32_9 mop9 mon9 vdd vbsyn gsyn
X_33_9 a_xp33 a_xn33 wp_33_9 wn_33_9 mop9 mon9 vdd vbsyn gsyn
X_34_9 a_xp34 a_xn34 wp_34_9 wn_34_9 mop9 mon9 vdd vbsyn gsyn
X_35_9 a_xp35 a_xn35 wp_35_9 wn_35_9 mop9 mon9 vdd vbsyn gsyn
X_36_9 a_xp36 a_xn36 wp_36_9 wn_36_9 mop9 mon9 vdd vbsyn gsyn
X_37_9 a_xp37 a_xn37 wp_37_9 wn_37_9 mop9 mon9 vdd vbsyn gsyn
X_38_9 a_xp38 a_xn38 wp_38_9 wn_38_9 mop9 mon9 vdd vbsyn gsyn
X_39_9 a_xp39 a_xn39 wp_39_9 wn_39_9 mop9 mon9 vdd vbsyn gsyn
X_40_9 a_xp40 a_xn40 wp_40_9 wn_40_9 mop9 mon9 vdd vbsyn gsyn
X_41_9 a_xp41 a_xn41 wp_41_9 wn_41_9 mop9 mon9 vdd vbsyn gsyn
X_42_9 a_xp42 a_xn42 wp_42_9 wn_42_9 mop9 mon9 vdd vbsyn gsyn
X_43_9 a_xp43 a_xn43 wp_43_9 wn_43_9 mop9 mon9 vdd vbsyn gsyn
X_44_9 a_xp44 a_xn44 wp_44_9 wn_44_9 mop9 mon9 vdd vbsyn gsyn
X_45_9 a_xp45 a_xn45 wp_45_9 wn_45_9 mop9 mon9 vdd vbsyn gsyn
X_46_9 a_xp46 a_xn46 wp_46_9 wn_46_9 mop9 mon9 vdd vbsyn gsyn
X_47_9 a_xp47 a_xn47 wp_47_9 wn_47_9 mop9 mon9 vdd vbsyn gsyn
X_48_9 a_xp48 a_xn48 wp_48_9 wn_48_9 mop9 mon9 vdd vbsyn gsyn
X_49_9 a_xp49 a_xn49 wp_49_9 wn_49_9 mop9 mon9 vdd vbsyn gsyn
X_50_9 a_xp50 a_xn50 wp_50_9 wn_50_9 mop9 mon9 vdd vbsyn gsyn
X_51_9 a_xp51 a_xn51 wp_51_9 wn_51_9 mop9 mon9 vdd vbsyn gsyn
X_52_9 a_xp52 a_xn52 wp_52_9 wn_52_9 mop9 mon9 vdd vbsyn gsyn
X_53_9 a_xp53 a_xn53 wp_53_9 wn_53_9 mop9 mon9 vdd vbsyn gsyn
X_54_9 a_xp54 a_xn54 wp_54_9 wn_54_9 mop9 mon9 vdd vbsyn gsyn
X_55_9 a_xp55 a_xn55 wp_55_9 wn_55_9 mop9 mon9 vdd vbsyn gsyn
X_56_9 a_xp56 a_xn56 wp_56_9 wn_56_9 mop9 mon9 vdd vbsyn gsyn
X_57_9 a_xp57 a_xn57 wp_57_9 wn_57_9 mop9 mon9 vdd vbsyn gsyn
X_58_9 a_xp58 a_xn58 wp_58_9 wn_58_9 mop9 mon9 vdd vbsyn gsyn
X_59_9 a_xp59 a_xn59 wp_59_9 wn_59_9 mop9 mon9 vdd vbsyn gsyn
X_60_9 a_xp60 a_xn60 wp_60_9 wn_60_9 mop9 mon9 vdd vbsyn gsyn
X_61_9 a_xp61 a_xn61 wp_61_9 wn_61_9 mop9 mon9 vdd vbsyn gsyn
X_62_9 a_xp62 a_xn62 wp_62_9 wn_62_9 mop9 mon9 vdd vbsyn gsyn
X_63_9 a_xp63 a_xn63 wp_63_9 wn_63_9 mop9 mon9 vdd vbsyn gsyn
.options gmin=1e-10
.end
