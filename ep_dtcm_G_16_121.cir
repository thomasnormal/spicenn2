fully-differential transistor current-mode EP
.model NNR NMOS (LEVEL=1 VTO=0.2  KP=120u LAMBDA=0.02 GAMMA=0 PHI=0.7)
.model PNR PMOS (LEVEL=1 VTO=-0.2 KP=40u  LAMBDA=0.02 GAMMA=0 PHI=0.7)
.subckt dsyn inp inn outp outn wp wn vdd
M1 outp inp tp 0 NNR W=200u L=100u
M2 outn inn tp 0 NNR W=200u L=100u
Mtp tp wp 0 0 NNR W=200u L=100u
M3 outn inp tn 0 NNR W=200u L=100u
M4 outp inn tn 0 NNR W=200u L=100u
Mtn tn wn 0 0 NNR W=200u L=100u
.ends
.subckt dneuron up un ap an vdd vbn
M1 an up tn 0 NNR W=200u L=100u
M2 ap un tn 0 NNR W=200u L=100u
Mt tn vbn 0 0 NNR W=200u L=100u
RLa vdd ap 800k
RLb vdd an 800k
.ends
.subckt dneuron2 up un ap an vdd vbn
M1 m2 up t1 0 NNR W=200u L=100u
M2 m1 un t1 0 NNR W=200u L=100u
Mt1 t1 vbn 0 0 NNR W=200u L=100u
RL1 vdd m1 800k
RL2 vdd m2 800k
M3 an m1 t2 0 NNR W=200u L=100u
M4 ap m2 t2 0 NNR W=200u L=100u
Mt2 t2 vbn 0 0 NNR W=200u L=100u
RL3 vdd ap 800k
RL4 vdd an 800k
.ends

Vdd vdd 0 1.0
Vbn vbn 0 0.30
Vbp_hi bp_hi 0 0.8
Vbp_lo bp_lo 0 0.2
Vtp vtp 0 0.5
Vtn vtn 0 0.5
Vaxp1 a_xp1 0 0.5
Vaxn1 a_xn1 0 0.5
Vaxp2 a_xp2 0 0.5
Vaxn2 a_xn2 0 0.5
Mlp_h1 up_h1 up_h1 vdd vdd PNR W=3000u L=100u
Mln_h1 un_h1 un_h1 vdd vdd PNR W=3000u L=100u
Vbnh1 bnh1 0 0.3000
Xn_h1 up_h1 un_h1 ap_h1 an_h1 vdd bnh1 dneuron
Vwp_i11 wp_i11 0 0.4739
Vwn_i11 wn_i11 0 0.3261
X_i11 a_xp1 a_xn1 up_h1 un_h1 wp_i11 wn_i11 vdd dsyn
Vwp_i21 wp_i21 0 0.3489
Vwn_i21 wn_i21 0 0.4511
X_i21 a_xp2 a_xn2 up_h1 un_h1 wp_i21 wn_i21 vdd dsyn
Vwp_bk1 wp_bk1 0 0.5710
Vwn_bk1 wn_bk1 0 0.3000
X_bk1 up_o un_o up_h1 un_h1 wp_bk1 wn_bk1 vdd dsyn
Vwp_bh1 wp_bh1 0 0.3523
Vwn_bh1 wn_bh1 0 0.4477
X_bh1 bp_hi bp_lo up_h1 un_h1 wp_bh1 wn_bh1 vdd dsyn
Mlp_h2 up_h2 up_h2 vdd vdd PNR W=3000u L=100u
Mln_h2 un_h2 un_h2 vdd vdd PNR W=3000u L=100u
Vbnh2 bnh2 0 0.3000
Xn_h2 up_h2 un_h2 ap_h2 an_h2 vdd bnh2 dneuron
Vwp_i12 wp_i12 0 0.4841
Vwn_i12 wn_i12 0 0.3159
X_i12 a_xp1 a_xn1 up_h2 un_h2 wp_i12 wn_i12 vdd dsyn
Vwp_i22 wp_i22 0 0.5004
Vwn_i22 wn_i22 0 0.3000
X_i22 a_xp2 a_xn2 up_h2 un_h2 wp_i22 wn_i22 vdd dsyn
Vwp_bk2 wp_bk2 0 0.5652
Vwn_bk2 wn_bk2 0 0.3000
X_bk2 up_o un_o up_h2 un_h2 wp_bk2 wn_bk2 vdd dsyn
Vwp_bh2 wp_bh2 0 0.5043
Vwn_bh2 wn_bh2 0 0.3000
X_bh2 bp_hi bp_lo up_h2 un_h2 wp_bh2 wn_bh2 vdd dsyn
Mlp_h3 up_h3 up_h3 vdd vdd PNR W=3000u L=100u
Mln_h3 un_h3 un_h3 vdd vdd PNR W=3000u L=100u
Vbnh3 bnh3 0 0.3000
Xn_h3 up_h3 un_h3 ap_h3 an_h3 vdd bnh3 dneuron
Vwp_i13 wp_i13 0 0.5724
Vwn_i13 wn_i13 0 0.3000
X_i13 a_xp1 a_xn1 up_h3 un_h3 wp_i13 wn_i13 vdd dsyn
Vwp_i23 wp_i23 0 0.4060
Vwn_i23 wn_i23 0 0.3940
X_i23 a_xp2 a_xn2 up_h3 un_h3 wp_i23 wn_i23 vdd dsyn
Vwp_bk3 wp_bk3 0 0.4503
Vwn_bk3 wn_bk3 0 0.3497
X_bk3 up_o un_o up_h3 un_h3 wp_bk3 wn_bk3 vdd dsyn
Vwp_bh3 wp_bh3 0 0.4666
Vwn_bh3 wn_bh3 0 0.3334
X_bh3 bp_hi bp_lo up_h3 un_h3 wp_bh3 wn_bh3 vdd dsyn
Mlp_h4 up_h4 up_h4 vdd vdd PNR W=3000u L=100u
Mln_h4 un_h4 un_h4 vdd vdd PNR W=3000u L=100u
Vbnh4 bnh4 0 0.3000
Xn_h4 up_h4 un_h4 ap_h4 an_h4 vdd bnh4 dneuron
Vwp_i14 wp_i14 0 0.3000
Vwn_i14 wn_i14 0 0.5087
X_i14 a_xp1 a_xn1 up_h4 un_h4 wp_i14 wn_i14 vdd dsyn
Vwp_i24 wp_i24 0 0.3992
Vwn_i24 wn_i24 0 0.4008
X_i24 a_xp2 a_xn2 up_h4 un_h4 wp_i24 wn_i24 vdd dsyn
Vwp_bk4 wp_bk4 0 0.4889
Vwn_bk4 wn_bk4 0 0.3111
X_bk4 up_o un_o up_h4 un_h4 wp_bk4 wn_bk4 vdd dsyn
Vwp_bh4 wp_bh4 0 0.3930
Vwn_bh4 wn_bh4 0 0.4070
X_bh4 bp_hi bp_lo up_h4 un_h4 wp_bh4 wn_bh4 vdd dsyn
Mlp_h5 up_h5 up_h5 vdd vdd PNR W=3000u L=100u
Mln_h5 un_h5 un_h5 vdd vdd PNR W=3000u L=100u
Vbnh5 bnh5 0 0.3000
Xn_h5 up_h5 un_h5 ap_h5 an_h5 vdd bnh5 dneuron
Vwp_i15 wp_i15 0 0.3000
Vwn_i15 wn_i15 0 0.5134
X_i15 a_xp1 a_xn1 up_h5 un_h5 wp_i15 wn_i15 vdd dsyn
Vwp_i25 wp_i25 0 0.4088
Vwn_i25 wn_i25 0 0.3912
X_i25 a_xp2 a_xn2 up_h5 un_h5 wp_i25 wn_i25 vdd dsyn
Vwp_bk5 wp_bk5 0 0.5478
Vwn_bk5 wn_bk5 0 0.3000
X_bk5 up_o un_o up_h5 un_h5 wp_bk5 wn_bk5 vdd dsyn
Vwp_bh5 wp_bh5 0 0.4080
Vwn_bh5 wn_bh5 0 0.3920
X_bh5 bp_hi bp_lo up_h5 un_h5 wp_bh5 wn_bh5 vdd dsyn
Mlp_h6 up_h6 up_h6 vdd vdd PNR W=3000u L=100u
Mln_h6 un_h6 un_h6 vdd vdd PNR W=3000u L=100u
Vbnh6 bnh6 0 0.3000
Xn_h6 up_h6 un_h6 ap_h6 an_h6 vdd bnh6 dneuron
Vwp_i16 wp_i16 0 0.5251
Vwn_i16 wn_i16 0 0.3000
X_i16 a_xp1 a_xn1 up_h6 un_h6 wp_i16 wn_i16 vdd dsyn
Vwp_i26 wp_i26 0 0.4362
Vwn_i26 wn_i26 0 0.3638
X_i26 a_xp2 a_xn2 up_h6 un_h6 wp_i26 wn_i26 vdd dsyn
Vwp_bk6 wp_bk6 0 0.4152
Vwn_bk6 wn_bk6 0 0.3848
X_bk6 up_o un_o up_h6 un_h6 wp_bk6 wn_bk6 vdd dsyn
Vwp_bh6 wp_bh6 0 0.4120
Vwn_bh6 wn_bh6 0 0.3880
X_bh6 bp_hi bp_lo up_h6 un_h6 wp_bh6 wn_bh6 vdd dsyn
Mlp_h7 up_h7 up_h7 vdd vdd PNR W=3000u L=100u
Mln_h7 un_h7 un_h7 vdd vdd PNR W=3000u L=100u
Vbnh7 bnh7 0 0.3000
Xn_h7 up_h7 un_h7 ap_h7 an_h7 vdd bnh7 dneuron
Vwp_i17 wp_i17 0 0.4011
Vwn_i17 wn_i17 0 0.3989
X_i17 a_xp1 a_xn1 up_h7 un_h7 wp_i17 wn_i17 vdd dsyn
Vwp_i27 wp_i27 0 0.3939
Vwn_i27 wn_i27 0 0.4061
X_i27 a_xp2 a_xn2 up_h7 un_h7 wp_i27 wn_i27 vdd dsyn
Vwp_bk7 wp_bk7 0 0.4583
Vwn_bk7 wn_bk7 0 0.3417
X_bk7 up_o un_o up_h7 un_h7 wp_bk7 wn_bk7 vdd dsyn
Vwp_bh7 wp_bh7 0 0.3983
Vwn_bh7 wn_bh7 0 0.4017
X_bh7 bp_hi bp_lo up_h7 un_h7 wp_bh7 wn_bh7 vdd dsyn
Mlp_h8 up_h8 up_h8 vdd vdd PNR W=3000u L=100u
Mln_h8 un_h8 un_h8 vdd vdd PNR W=3000u L=100u
Vbnh8 bnh8 0 0.3000
Xn_h8 up_h8 un_h8 ap_h8 an_h8 vdd bnh8 dneuron
Vwp_i18 wp_i18 0 0.4985
Vwn_i18 wn_i18 0 0.3015
X_i18 a_xp1 a_xn1 up_h8 un_h8 wp_i18 wn_i18 vdd dsyn
Vwp_i28 wp_i28 0 0.3312
Vwn_i28 wn_i28 0 0.4688
X_i28 a_xp2 a_xn2 up_h8 un_h8 wp_i28 wn_i28 vdd dsyn
Vwp_bk8 wp_bk8 0 0.7000
Vwn_bk8 wn_bk8 0 0.3000
X_bk8 up_o un_o up_h8 un_h8 wp_bk8 wn_bk8 vdd dsyn
Vwp_bh8 wp_bh8 0 0.3315
Vwn_bh8 wn_bh8 0 0.4685
X_bh8 bp_hi bp_lo up_h8 un_h8 wp_bh8 wn_bh8 vdd dsyn
Mlp_h9 up_h9 up_h9 vdd vdd PNR W=3000u L=100u
Mln_h9 un_h9 un_h9 vdd vdd PNR W=3000u L=100u
Vbnh9 bnh9 0 0.3000
Xn_h9 up_h9 un_h9 ap_h9 an_h9 vdd bnh9 dneuron
Vwp_i19 wp_i19 0 0.3282
Vwn_i19 wn_i19 0 0.4718
X_i19 a_xp1 a_xn1 up_h9 un_h9 wp_i19 wn_i19 vdd dsyn
Vwp_i29 wp_i29 0 0.4848
Vwn_i29 wn_i29 0 0.3152
X_i29 a_xp2 a_xn2 up_h9 un_h9 wp_i29 wn_i29 vdd dsyn
Vwp_bk9 wp_bk9 0 0.7000
Vwn_bk9 wn_bk9 0 0.3000
X_bk9 up_o un_o up_h9 un_h9 wp_bk9 wn_bk9 vdd dsyn
Vwp_bh9 wp_bh9 0 0.3245
Vwn_bh9 wn_bh9 0 0.4755
X_bh9 bp_hi bp_lo up_h9 un_h9 wp_bh9 wn_bh9 vdd dsyn
Mlp_h10 up_h10 up_h10 vdd vdd PNR W=3000u L=100u
Mln_h10 un_h10 un_h10 vdd vdd PNR W=3000u L=100u
Vbnh10 bnh10 0 0.3000
Xn_h10 up_h10 un_h10 ap_h10 an_h10 vdd bnh10 dneuron
Vwp_i110 wp_i110 0 0.3652
Vwn_i110 wn_i110 0 0.4348
X_i110 a_xp1 a_xn1 up_h10 un_h10 wp_i110 wn_i110 vdd dsyn
Vwp_i210 wp_i210 0 0.3638
Vwn_i210 wn_i210 0 0.4362
X_i210 a_xp2 a_xn2 up_h10 un_h10 wp_i210 wn_i210 vdd dsyn
Vwp_bk10 wp_bk10 0 0.3725
Vwn_bk10 wn_bk10 0 0.4275
X_bk10 up_o un_o up_h10 un_h10 wp_bk10 wn_bk10 vdd dsyn
Vwp_bh10 wp_bh10 0 0.3634
Vwn_bh10 wn_bh10 0 0.4366
X_bh10 bp_hi bp_lo up_h10 un_h10 wp_bh10 wn_bh10 vdd dsyn
Mlp_h11 up_h11 up_h11 vdd vdd PNR W=3000u L=100u
Mln_h11 un_h11 un_h11 vdd vdd PNR W=3000u L=100u
Vbnh11 bnh11 0 0.3000
Xn_h11 up_h11 un_h11 ap_h11 an_h11 vdd bnh11 dneuron
Vwp_i111 wp_i111 0 0.3337
Vwn_i111 wn_i111 0 0.4663
X_i111 a_xp1 a_xn1 up_h11 un_h11 wp_i111 wn_i111 vdd dsyn
Vwp_i211 wp_i211 0 0.5867
Vwn_i211 wn_i211 0 0.3000
X_i211 a_xp2 a_xn2 up_h11 un_h11 wp_i211 wn_i211 vdd dsyn
Vwp_bk11 wp_bk11 0 0.3000
Vwn_bk11 wn_bk11 0 0.5248
X_bk11 up_o un_o up_h11 un_h11 wp_bk11 wn_bk11 vdd dsyn
Vwp_bh11 wp_bh11 0 0.5844
Vwn_bh11 wn_bh11 0 0.3000
X_bh11 bp_hi bp_lo up_h11 un_h11 wp_bh11 wn_bh11 vdd dsyn
Mlp_h12 up_h12 up_h12 vdd vdd PNR W=3000u L=100u
Mln_h12 un_h12 un_h12 vdd vdd PNR W=3000u L=100u
Vbnh12 bnh12 0 0.3000
Xn_h12 up_h12 un_h12 ap_h12 an_h12 vdd bnh12 dneuron
Vwp_i112 wp_i112 0 0.4287
Vwn_i112 wn_i112 0 0.3713
X_i112 a_xp1 a_xn1 up_h12 un_h12 wp_i112 wn_i112 vdd dsyn
Vwp_i212 wp_i212 0 0.4144
Vwn_i212 wn_i212 0 0.3856
X_i212 a_xp2 a_xn2 up_h12 un_h12 wp_i212 wn_i212 vdd dsyn
Vwp_bk12 wp_bk12 0 0.5028
Vwn_bk12 wn_bk12 0 0.3000
X_bk12 up_o un_o up_h12 un_h12 wp_bk12 wn_bk12 vdd dsyn
Vwp_bh12 wp_bh12 0 0.5646
Vwn_bh12 wn_bh12 0 0.3000
X_bh12 bp_hi bp_lo up_h12 un_h12 wp_bh12 wn_bh12 vdd dsyn
Mlp_h13 up_h13 up_h13 vdd vdd PNR W=3000u L=100u
Mln_h13 un_h13 un_h13 vdd vdd PNR W=3000u L=100u
Vbnh13 bnh13 0 0.3000
Xn_h13 up_h13 un_h13 ap_h13 an_h13 vdd bnh13 dneuron
Vwp_i113 wp_i113 0 0.3137
Vwn_i113 wn_i113 0 0.4863
X_i113 a_xp1 a_xn1 up_h13 un_h13 wp_i113 wn_i113 vdd dsyn
Vwp_i213 wp_i213 0 0.3978
Vwn_i213 wn_i213 0 0.4022
X_i213 a_xp2 a_xn2 up_h13 un_h13 wp_i213 wn_i213 vdd dsyn
Vwp_bk13 wp_bk13 0 0.4891
Vwn_bk13 wn_bk13 0 0.3109
X_bk13 up_o un_o up_h13 un_h13 wp_bk13 wn_bk13 vdd dsyn
Vwp_bh13 wp_bh13 0 0.4336
Vwn_bh13 wn_bh13 0 0.3664
X_bh13 bp_hi bp_lo up_h13 un_h13 wp_bh13 wn_bh13 vdd dsyn
Mlp_h14 up_h14 up_h14 vdd vdd PNR W=3000u L=100u
Mln_h14 un_h14 un_h14 vdd vdd PNR W=3000u L=100u
Vbnh14 bnh14 0 0.3000
Xn_h14 up_h14 un_h14 ap_h14 an_h14 vdd bnh14 dneuron
Vwp_i114 wp_i114 0 0.3303
Vwn_i114 wn_i114 0 0.4697
X_i114 a_xp1 a_xn1 up_h14 un_h14 wp_i114 wn_i114 vdd dsyn
Vwp_i214 wp_i214 0 0.6011
Vwn_i214 wn_i214 0 0.3000
X_i214 a_xp2 a_xn2 up_h14 un_h14 wp_i214 wn_i214 vdd dsyn
Vwp_bk14 wp_bk14 0 0.3000
Vwn_bk14 wn_bk14 0 0.5389
X_bk14 up_o un_o up_h14 un_h14 wp_bk14 wn_bk14 vdd dsyn
Vwp_bh14 wp_bh14 0 0.6014
Vwn_bh14 wn_bh14 0 0.3000
X_bh14 bp_hi bp_lo up_h14 un_h14 wp_bh14 wn_bh14 vdd dsyn
Mlp_h15 up_h15 up_h15 vdd vdd PNR W=3000u L=100u
Mln_h15 un_h15 un_h15 vdd vdd PNR W=3000u L=100u
Vbnh15 bnh15 0 0.3000
Xn_h15 up_h15 un_h15 ap_h15 an_h15 vdd bnh15 dneuron
Vwp_i115 wp_i115 0 0.3672
Vwn_i115 wn_i115 0 0.4328
X_i115 a_xp1 a_xn1 up_h15 un_h15 wp_i115 wn_i115 vdd dsyn
Vwp_i215 wp_i215 0 0.3691
Vwn_i215 wn_i215 0 0.4309
X_i215 a_xp2 a_xn2 up_h15 un_h15 wp_i215 wn_i215 vdd dsyn
Vwp_bk15 wp_bk15 0 0.3489
Vwn_bk15 wn_bk15 0 0.4511
X_bk15 up_o un_o up_h15 un_h15 wp_bk15 wn_bk15 vdd dsyn
Vwp_bh15 wp_bh15 0 0.3696
Vwn_bh15 wn_bh15 0 0.4304
X_bh15 bp_hi bp_lo up_h15 un_h15 wp_bh15 wn_bh15 vdd dsyn
Mlp_h16 up_h16 up_h16 vdd vdd PNR W=3000u L=100u
Mln_h16 un_h16 un_h16 vdd vdd PNR W=3000u L=100u
Vbnh16 bnh16 0 0.3000
Xn_h16 up_h16 un_h16 ap_h16 an_h16 vdd bnh16 dneuron
Vwp_i116 wp_i116 0 0.5138
Vwn_i116 wn_i116 0 0.3000
X_i116 a_xp1 a_xn1 up_h16 un_h16 wp_i116 wn_i116 vdd dsyn
Vwp_i216 wp_i216 0 0.5197
Vwn_i216 wn_i216 0 0.3000
X_i216 a_xp2 a_xn2 up_h16 un_h16 wp_i216 wn_i216 vdd dsyn
Vwp_bk16 wp_bk16 0 0.3221
Vwn_bk16 wn_bk16 0 0.4779
X_bk16 up_o un_o up_h16 un_h16 wp_bk16 wn_bk16 vdd dsyn
Vwp_bh16 wp_bh16 0 0.3445
Vwn_bh16 wn_bh16 0 0.4555
X_bh16 bp_hi bp_lo up_h16 un_h16 wp_bh16 wn_bh16 vdd dsyn
Mlp_o up_o up_o vdd vdd PNR W=3000u L=100u
Mln_o un_o un_o vdd vdd PNR W=3000u L=100u
Vwp_fo1 wp_fo1 0 0.5710
Vwn_fo1 wn_fo1 0 0.3000
X_fo1 ap_h1 an_h1 up_o un_o wp_fo1 wn_fo1 vdd dsyn
Vwp_fo2 wp_fo2 0 0.5652
Vwn_fo2 wn_fo2 0 0.3000
X_fo2 ap_h2 an_h2 up_o un_o wp_fo2 wn_fo2 vdd dsyn
Vwp_fo3 wp_fo3 0 0.4503
Vwn_fo3 wn_fo3 0 0.3497
X_fo3 ap_h3 an_h3 up_o un_o wp_fo3 wn_fo3 vdd dsyn
Vwp_fo4 wp_fo4 0 0.4889
Vwn_fo4 wn_fo4 0 0.3111
X_fo4 ap_h4 an_h4 up_o un_o wp_fo4 wn_fo4 vdd dsyn
Vwp_fo5 wp_fo5 0 0.5478
Vwn_fo5 wn_fo5 0 0.3000
X_fo5 ap_h5 an_h5 up_o un_o wp_fo5 wn_fo5 vdd dsyn
Vwp_fo6 wp_fo6 0 0.4152
Vwn_fo6 wn_fo6 0 0.3848
X_fo6 ap_h6 an_h6 up_o un_o wp_fo6 wn_fo6 vdd dsyn
Vwp_fo7 wp_fo7 0 0.4583
Vwn_fo7 wn_fo7 0 0.3417
X_fo7 ap_h7 an_h7 up_o un_o wp_fo7 wn_fo7 vdd dsyn
Vwp_fo8 wp_fo8 0 0.7000
Vwn_fo8 wn_fo8 0 0.3000
X_fo8 ap_h8 an_h8 up_o un_o wp_fo8 wn_fo8 vdd dsyn
Vwp_fo9 wp_fo9 0 0.7000
Vwn_fo9 wn_fo9 0 0.3000
X_fo9 ap_h9 an_h9 up_o un_o wp_fo9 wn_fo9 vdd dsyn
Vwp_fo10 wp_fo10 0 0.3725
Vwn_fo10 wn_fo10 0 0.4275
X_fo10 ap_h10 an_h10 up_o un_o wp_fo10 wn_fo10 vdd dsyn
Vwp_fo11 wp_fo11 0 0.3000
Vwn_fo11 wn_fo11 0 0.5248
X_fo11 ap_h11 an_h11 up_o un_o wp_fo11 wn_fo11 vdd dsyn
Vwp_fo12 wp_fo12 0 0.5028
Vwn_fo12 wn_fo12 0 0.3000
X_fo12 ap_h12 an_h12 up_o un_o wp_fo12 wn_fo12 vdd dsyn
Vwp_fo13 wp_fo13 0 0.4891
Vwn_fo13 wn_fo13 0 0.3109
X_fo13 ap_h13 an_h13 up_o un_o wp_fo13 wn_fo13 vdd dsyn
Vwp_fo14 wp_fo14 0 0.3000
Vwn_fo14 wn_fo14 0 0.5389
X_fo14 ap_h14 an_h14 up_o un_o wp_fo14 wn_fo14 vdd dsyn
Vwp_fo15 wp_fo15 0 0.3489
Vwn_fo15 wn_fo15 0 0.4511
X_fo15 ap_h15 an_h15 up_o un_o wp_fo15 wn_fo15 vdd dsyn
Vwp_fo16 wp_fo16 0 0.3221
Vwn_fo16 wn_fo16 0 0.4779
X_fo16 ap_h16 an_h16 up_o un_o wp_fo16 wn_fo16 vdd dsyn
Vwp_bo_ wp_bo_ 0 0.3854
Vwn_bo_ wn_bo_ 0 0.4146
X_bo_ bp_hi bp_lo up_o un_o wp_bo_ wn_bo_ vdd dsyn
Rbp up_o vtp 1e10
Rbn un_o vtn 1e10
.control
alter Vaxp1 0.2
alter Vaxn1 0.8
alter Vaxp2 0.2
alter Vaxn2 0.8
alter Rbp 1e10
alter Rbn 1e10
op
wrdata gfG_16_121_0.dat v(ap_h1) v(an_h1) v(ap_h2) v(an_h2) v(ap_h3) v(an_h3) v(ap_h4) v(an_h4) v(ap_h5) v(an_h5) v(ap_h6) v(an_h6) v(ap_h7) v(an_h7) v(ap_h8) v(an_h8) v(ap_h9) v(an_h9) v(ap_h10) v(an_h10) v(ap_h11) v(an_h11) v(ap_h12) v(an_h12) v(ap_h13) v(an_h13) v(ap_h14) v(an_h14) v(ap_h15) v(an_h15) v(ap_h16) v(an_h16) v(up_o) v(un_o)
alter Vtp 0.4
alter Vtn 0.6
alter Rbp 200000.0
alter Rbn 200000.0
op
wrdata gnG_16_121_0.dat v(ap_h1) v(an_h1) v(ap_h2) v(an_h2) v(ap_h3) v(an_h3) v(ap_h4) v(an_h4) v(ap_h5) v(an_h5) v(ap_h6) v(an_h6) v(ap_h7) v(an_h7) v(ap_h8) v(an_h8) v(ap_h9) v(an_h9) v(ap_h10) v(an_h10) v(ap_h11) v(an_h11) v(ap_h12) v(an_h12) v(ap_h13) v(an_h13) v(ap_h14) v(an_h14) v(ap_h15) v(an_h15) v(ap_h16) v(an_h16) v(up_o) v(un_o)
alter Vaxp1 0.2
alter Vaxn1 0.8
alter Vaxp2 0.8
alter Vaxn2 0.2
alter Rbp 1e10
alter Rbn 1e10
op
wrdata gfG_16_121_1.dat v(ap_h1) v(an_h1) v(ap_h2) v(an_h2) v(ap_h3) v(an_h3) v(ap_h4) v(an_h4) v(ap_h5) v(an_h5) v(ap_h6) v(an_h6) v(ap_h7) v(an_h7) v(ap_h8) v(an_h8) v(ap_h9) v(an_h9) v(ap_h10) v(an_h10) v(ap_h11) v(an_h11) v(ap_h12) v(an_h12) v(ap_h13) v(an_h13) v(ap_h14) v(an_h14) v(ap_h15) v(an_h15) v(ap_h16) v(an_h16) v(up_o) v(un_o)
alter Vtp 0.6
alter Vtn 0.4
alter Rbp 200000.0
alter Rbn 200000.0
op
wrdata gnG_16_121_1.dat v(ap_h1) v(an_h1) v(ap_h2) v(an_h2) v(ap_h3) v(an_h3) v(ap_h4) v(an_h4) v(ap_h5) v(an_h5) v(ap_h6) v(an_h6) v(ap_h7) v(an_h7) v(ap_h8) v(an_h8) v(ap_h9) v(an_h9) v(ap_h10) v(an_h10) v(ap_h11) v(an_h11) v(ap_h12) v(an_h12) v(ap_h13) v(an_h13) v(ap_h14) v(an_h14) v(ap_h15) v(an_h15) v(ap_h16) v(an_h16) v(up_o) v(un_o)
alter Vaxp1 0.8
alter Vaxn1 0.2
alter Vaxp2 0.2
alter Vaxn2 0.8
alter Rbp 1e10
alter Rbn 1e10
op
wrdata gfG_16_121_2.dat v(ap_h1) v(an_h1) v(ap_h2) v(an_h2) v(ap_h3) v(an_h3) v(ap_h4) v(an_h4) v(ap_h5) v(an_h5) v(ap_h6) v(an_h6) v(ap_h7) v(an_h7) v(ap_h8) v(an_h8) v(ap_h9) v(an_h9) v(ap_h10) v(an_h10) v(ap_h11) v(an_h11) v(ap_h12) v(an_h12) v(ap_h13) v(an_h13) v(ap_h14) v(an_h14) v(ap_h15) v(an_h15) v(ap_h16) v(an_h16) v(up_o) v(un_o)
alter Vtp 0.6
alter Vtn 0.4
alter Rbp 200000.0
alter Rbn 200000.0
op
wrdata gnG_16_121_2.dat v(ap_h1) v(an_h1) v(ap_h2) v(an_h2) v(ap_h3) v(an_h3) v(ap_h4) v(an_h4) v(ap_h5) v(an_h5) v(ap_h6) v(an_h6) v(ap_h7) v(an_h7) v(ap_h8) v(an_h8) v(ap_h9) v(an_h9) v(ap_h10) v(an_h10) v(ap_h11) v(an_h11) v(ap_h12) v(an_h12) v(ap_h13) v(an_h13) v(ap_h14) v(an_h14) v(ap_h15) v(an_h15) v(ap_h16) v(an_h16) v(up_o) v(un_o)
alter Vaxp1 0.8
alter Vaxn1 0.2
alter Vaxp2 0.8
alter Vaxn2 0.2
alter Rbp 1e10
alter Rbn 1e10
op
wrdata gfG_16_121_3.dat v(ap_h1) v(an_h1) v(ap_h2) v(an_h2) v(ap_h3) v(an_h3) v(ap_h4) v(an_h4) v(ap_h5) v(an_h5) v(ap_h6) v(an_h6) v(ap_h7) v(an_h7) v(ap_h8) v(an_h8) v(ap_h9) v(an_h9) v(ap_h10) v(an_h10) v(ap_h11) v(an_h11) v(ap_h12) v(an_h12) v(ap_h13) v(an_h13) v(ap_h14) v(an_h14) v(ap_h15) v(an_h15) v(ap_h16) v(an_h16) v(up_o) v(un_o)
alter Vtp 0.4
alter Vtn 0.6
alter Rbp 200000.0
alter Rbn 200000.0
op
wrdata gnG_16_121_3.dat v(ap_h1) v(an_h1) v(ap_h2) v(an_h2) v(ap_h3) v(an_h3) v(ap_h4) v(an_h4) v(ap_h5) v(an_h5) v(ap_h6) v(an_h6) v(ap_h7) v(an_h7) v(ap_h8) v(an_h8) v(ap_h9) v(an_h9) v(ap_h10) v(an_h10) v(ap_h11) v(an_h11) v(ap_h12) v(an_h12) v(ap_h13) v(an_h13) v(ap_h14) v(an_h14) v(ap_h15) v(an_h15) v(ap_h16) v(an_h16) v(up_o) v(un_o)
.endc
.end
