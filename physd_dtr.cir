digits cds product run
.model NNR NMOS (LEVEL=1 VTO=0.2 KP=120u LAMBDA=0.02 GAMMA=0 PHI=0.7)
.model PNR PMOS (LEVEL=1 VTO=-0.2 KP=40u LAMBDA=0.02 GAMMA=0 PHI=0.7)
.subckt gprod xp xn yp yn wp wn vdd vbn
Mtail nt vbn 0 0 NNR W=400u L=100u
M5 na yp nt 0 NNR W=200u L=100u
M6 nb yn nt 0 NNR W=200u L=100u
M1 iop xp na 0 NNR W=200u L=100u
M2 ion xn na 0 NNR W=200u L=100u
M3 ion xp nb 0 NNR W=200u L=100u
M4 iop xn nb 0 NNR W=200u L=100u
Mlp iop iop vdd vdd PNR W=200u L=100u
Mln ion ion vdd vdd PNR W=200u L=100u
Mpu_wp wp iop vdd vdd PNR W=200u L=100u
MpRn nrn ion vdd vdd PNR W=200u L=100u
MnRn nrn nrn 0 0 NNR W=200u L=100u
Mpd_wp wp nrn 0 0 NNR W=200u L=100u
Mpu_wn wn ion vdd vdd PNR W=200u L=100u
MpRp nrp iop vdd vdd PNR W=200u L=100u
MnRp nrp nrp 0 0 NNR W=200u L=100u
Mpd_wn wn nrp 0 0 NNR W=200u L=100u
.ends
Vdd vdd 0 1.0
Vgbn gbn 0 1.1
Vxp_wih_0_0 xp_wih_0_0 0 PWL(0.0n 0.3950 599.5n 0.3950 600.0n 0.3950 1199.5n 0.3950 1200.0n 0.3950 1799.5n 0.3950 1800.0n 0.3950 2399.5n 0.3950 2400.0n 0.4093 2999.5n 0.4093 3000.0n 0.3950 3599.5n 0.3950 3600.0n 0.3996 4199.5n 0.3996 4200.0n 0.3950 4799.5n 0.3950 4800.0n 0.3950 5399.5n 0.3950 5400.0n 0.3950 5999.5n 0.3950 6000.0n 0.3950 6599.5n 0.3950 6600.0n 0.3950 7199.5n 0.3950 7200.0n 0.3950 7799.5n 0.3950 7800.0n 0.3950 8399.5n 0.3950 8400.0n 0.3950 8999.5n 0.3950 9000.0n 0.3950 9599.5n 0.3950 9600.0n 0.3950 10199.5n 0.3950 10200.0n 0.3950 10799.5n 0.3950 10800.0n 0.3950 11399.5n 0.3950 11400.0n 0.3950 11999.5n 0.3950 12000.0n 0.3950 12599.5n 0.3950 12600.0n 0.3950 13199.5n 0.3950 13200.0n 0.3950 13799.5n 0.3950 13800.0n 0.3950 14399.5n 0.3950)
Vxn_wih_0_0 xn_wih_0_0 0 PWL(0.0n 0.6050 599.5n 0.6050 600.0n 0.6050 1199.5n 0.6050 1200.0n 0.6050 1799.5n 0.6050 1800.0n 0.6050 2399.5n 0.6050 2400.0n 0.5907 2999.5n 0.5907 3000.0n 0.6050 3599.5n 0.6050 3600.0n 0.6004 4199.5n 0.6004 4200.0n 0.6050 4799.5n 0.6050 4800.0n 0.6050 5399.5n 0.6050 5400.0n 0.6050 5999.5n 0.6050 6000.0n 0.6050 6599.5n 0.6050 6600.0n 0.6050 7199.5n 0.6050 7200.0n 0.6050 7799.5n 0.6050 7800.0n 0.6050 8399.5n 0.6050 8400.0n 0.6050 8999.5n 0.6050 9000.0n 0.6050 9599.5n 0.6050 9600.0n 0.6050 10199.5n 0.6050 10200.0n 0.6050 10799.5n 0.6050 10800.0n 0.6050 11399.5n 0.6050 11400.0n 0.6050 11999.5n 0.6050 12000.0n 0.6050 12599.5n 0.6050 12600.0n 0.6050 13199.5n 0.6050 13200.0n 0.6050 13799.5n 0.6050 13800.0n 0.6050 14399.5n 0.6050)
Vyp_wih_0_0 yp_wih_0_0 0 PWL(0.0n 0.5895 599.5n 0.5895 600.0n 0.6373 1199.5n 0.6373 1200.0n 0.5342 1799.5n 0.5342 1800.0n 0.5173 2399.5n 0.5173 2400.0n 0.5233 2999.5n 0.5233 3000.0n 0.5378 3599.5n 0.5378 3600.0n 0.5315 4199.5n 0.5315 4200.0n 0.6065 4799.5n 0.6065 4800.0n 0.5561 5399.5n 0.5561 5400.0n 0.6170 5999.5n 0.6170 6000.0n 0.6210 6599.5n 0.6210 6600.0n 0.5575 7199.5n 0.5575 7200.0n 0.6492 7799.5n 0.6492 7800.0n 0.6510 8399.5n 0.6510 8400.0n 0.5741 8999.5n 0.5741 9000.0n 0.6593 9599.5n 0.6593 9600.0n 0.6623 10199.5n 0.6623 10200.0n 0.6460 10799.5n 0.6460 10800.0n 0.6151 11399.5n 0.6151 11400.0n 0.6495 11999.5n 0.6495 12000.0n 0.6499 12599.5n 0.6499 12600.0n 0.6152 13199.5n 0.6152 13200.0n 0.6652 13799.5n 0.6652 13800.0n 0.5950 14399.5n 0.5950)
Vyn_wih_0_0 yn_wih_0_0 0 PWL(0.0n 0.4105 599.5n 0.4105 600.0n 0.3627 1199.5n 0.3627 1200.0n 0.4658 1799.5n 0.4658 1800.0n 0.4827 2399.5n 0.4827 2400.0n 0.4767 2999.5n 0.4767 3000.0n 0.4622 3599.5n 0.4622 3600.0n 0.4685 4199.5n 0.4685 4200.0n 0.3935 4799.5n 0.3935 4800.0n 0.4439 5399.5n 0.4439 5400.0n 0.3830 5999.5n 0.3830 6000.0n 0.3790 6599.5n 0.3790 6600.0n 0.4425 7199.5n 0.4425 7200.0n 0.3508 7799.5n 0.3508 7800.0n 0.3490 8399.5n 0.3490 8400.0n 0.4259 8999.5n 0.4259 9000.0n 0.3407 9599.5n 0.3407 9600.0n 0.3377 10199.5n 0.3377 10200.0n 0.3540 10799.5n 0.3540 10800.0n 0.3849 11399.5n 0.3849 11400.0n 0.3505 11999.5n 0.3505 12000.0n 0.3501 12599.5n 0.3501 12600.0n 0.3848 13199.5n 0.3848 13200.0n 0.3348 13799.5n 0.3348 13800.0n 0.4050 14399.5n 0.4050)
Cwp_wih_0_0 wp_wih_0_0 0 400p
Cwn_wih_0_0 wn_wih_0_0 0 400p
Xu_wih_0_0 xp_wih_0_0 xn_wih_0_0 yp_wih_0_0 yn_wih_0_0 wp_wih_0_0 wn_wih_0_0 vdd gbn gprod
Vxp_wih_1_0 xp_wih_1_0 0 PWL(0.0n 0.5903 599.5n 0.5903 600.0n 0.5456 1199.5n 0.5456 1200.0n 0.5794 1799.5n 0.5794 1800.0n 0.6050 2399.5n 0.6050 2400.0n 0.6002 2999.5n 0.6002 3000.0n 0.5822 3599.5n 0.5822 3600.0n 0.5776 4199.5n 0.5776 4200.0n 0.5867 4799.5n 0.5867 4800.0n 0.5487 5399.5n 0.5487 5400.0n 0.5654 5999.5n 0.5654 6000.0n 0.5656 6599.5n 0.5656 6600.0n 0.5907 7199.5n 0.5907 7200.0n 0.5309 7799.5n 0.5309 7800.0n 0.4409 8399.5n 0.4409 8400.0n 0.3950 8999.5n 0.3950 9000.0n 0.4115 9599.5n 0.4115 9600.0n 0.4048 10199.5n 0.4048 10200.0n 0.4883 10799.5n 0.4883 10800.0n 0.5781 11399.5n 0.5781 11400.0n 0.5169 11999.5n 0.5169 12000.0n 0.4065 12599.5n 0.4065 12600.0n 0.5303 13199.5n 0.5303 13200.0n 0.4017 13799.5n 0.4017 13800.0n 0.5102 14399.5n 0.5102)
Vxn_wih_1_0 xn_wih_1_0 0 PWL(0.0n 0.4097 599.5n 0.4097 600.0n 0.4544 1199.5n 0.4544 1200.0n 0.4206 1799.5n 0.4206 1800.0n 0.3950 2399.5n 0.3950 2400.0n 0.3998 2999.5n 0.3998 3000.0n 0.4178 3599.5n 0.4178 3600.0n 0.4224 4199.5n 0.4224 4200.0n 0.4133 4799.5n 0.4133 4800.0n 0.4513 5399.5n 0.4513 5400.0n 0.4346 5999.5n 0.4346 6000.0n 0.4344 6599.5n 0.4344 6600.0n 0.4093 7199.5n 0.4093 7200.0n 0.4691 7799.5n 0.4691 7800.0n 0.5591 8399.5n 0.5591 8400.0n 0.6050 8999.5n 0.6050 9000.0n 0.5885 9599.5n 0.5885 9600.0n 0.5952 10199.5n 0.5952 10200.0n 0.5117 10799.5n 0.5117 10800.0n 0.4219 11399.5n 0.4219 11400.0n 0.4831 11999.5n 0.4831 12000.0n 0.5935 12599.5n 0.5935 12600.0n 0.4697 13199.5n 0.4697 13200.0n 0.5983 13799.5n 0.5983 13800.0n 0.4898 14399.5n 0.4898)
Vyp_wih_1_0 yp_wih_1_0 0 PWL(0.0n 0.5895 599.5n 0.5895 600.0n 0.6373 1199.5n 0.6373 1200.0n 0.5342 1799.5n 0.5342 1800.0n 0.5173 2399.5n 0.5173 2400.0n 0.5233 2999.5n 0.5233 3000.0n 0.5378 3599.5n 0.5378 3600.0n 0.5315 4199.5n 0.5315 4200.0n 0.6065 4799.5n 0.6065 4800.0n 0.5561 5399.5n 0.5561 5400.0n 0.6170 5999.5n 0.6170 6000.0n 0.6210 6599.5n 0.6210 6600.0n 0.5575 7199.5n 0.5575 7200.0n 0.6492 7799.5n 0.6492 7800.0n 0.6510 8399.5n 0.6510 8400.0n 0.5741 8999.5n 0.5741 9000.0n 0.6593 9599.5n 0.6593 9600.0n 0.6623 10199.5n 0.6623 10200.0n 0.6460 10799.5n 0.6460 10800.0n 0.6151 11399.5n 0.6151 11400.0n 0.6495 11999.5n 0.6495 12000.0n 0.6499 12599.5n 0.6499 12600.0n 0.6152 13199.5n 0.6152 13200.0n 0.6652 13799.5n 0.6652 13800.0n 0.5950 14399.5n 0.5950)
Vyn_wih_1_0 yn_wih_1_0 0 PWL(0.0n 0.4105 599.5n 0.4105 600.0n 0.3627 1199.5n 0.3627 1200.0n 0.4658 1799.5n 0.4658 1800.0n 0.4827 2399.5n 0.4827 2400.0n 0.4767 2999.5n 0.4767 3000.0n 0.4622 3599.5n 0.4622 3600.0n 0.4685 4199.5n 0.4685 4200.0n 0.3935 4799.5n 0.3935 4800.0n 0.4439 5399.5n 0.4439 5400.0n 0.3830 5999.5n 0.3830 6000.0n 0.3790 6599.5n 0.3790 6600.0n 0.4425 7199.5n 0.4425 7200.0n 0.3508 7799.5n 0.3508 7800.0n 0.3490 8399.5n 0.3490 8400.0n 0.4259 8999.5n 0.4259 9000.0n 0.3407 9599.5n 0.3407 9600.0n 0.3377 10199.5n 0.3377 10200.0n 0.3540 10799.5n 0.3540 10800.0n 0.3849 11399.5n 0.3849 11400.0n 0.3505 11999.5n 0.3505 12000.0n 0.3501 12599.5n 0.3501 12600.0n 0.3848 13199.5n 0.3848 13200.0n 0.3348 13799.5n 0.3348 13800.0n 0.4050 14399.5n 0.4050)
Cwp_wih_1_0 wp_wih_1_0 0 400p
Cwn_wih_1_0 wn_wih_1_0 0 400p
Xu_wih_1_0 xp_wih_1_0 xn_wih_1_0 yp_wih_1_0 yn_wih_1_0 wp_wih_1_0 wn_wih_1_0 vdd gbn gprod
Vxp_wih_4_0 xp_wih_4_0 0 PWL(0.0n 0.4097 599.5n 0.4097 600.0n 0.4029 1199.5n 0.4029 1200.0n 0.4104 1799.5n 0.4104 1800.0n 0.4380 2399.5n 0.4380 2400.0n 0.4570 2999.5n 0.4570 3000.0n 0.4087 3599.5n 0.4087 3600.0n 0.4498 4199.5n 0.4498 4200.0n 0.4270 4799.5n 0.4270 4800.0n 0.4175 5399.5n 0.4175 5400.0n 0.4386 5999.5n 0.4386 6000.0n 0.4125 6599.5n 0.4125 6600.0n 0.4332 7199.5n 0.4332 7200.0n 0.3950 7799.5n 0.3950 7800.0n 0.4245 8399.5n 0.4245 8400.0n 0.3950 8999.5n 0.3950 9000.0n 0.4238 9599.5n 0.4238 9600.0n 0.4114 10199.5n 0.4114 10200.0n 0.4806 10799.5n 0.4806 10800.0n 0.3950 11399.5n 0.3950 11400.0n 0.3950 11999.5n 0.3950 12000.0n 0.3950 12599.5n 0.3950 12600.0n 0.3950 13199.5n 0.3950 13200.0n 0.4250 13799.5n 0.4250 13800.0n 0.3950 14399.5n 0.3950)
Vxn_wih_4_0 xn_wih_4_0 0 PWL(0.0n 0.5903 599.5n 0.5903 600.0n 0.5971 1199.5n 0.5971 1200.0n 0.5896 1799.5n 0.5896 1800.0n 0.5620 2399.5n 0.5620 2400.0n 0.5430 2999.5n 0.5430 3000.0n 0.5913 3599.5n 0.5913 3600.0n 0.5502 4199.5n 0.5502 4200.0n 0.5730 4799.5n 0.5730 4800.0n 0.5825 5399.5n 0.5825 5400.0n 0.5614 5999.5n 0.5614 6000.0n 0.5875 6599.5n 0.5875 6600.0n 0.5668 7199.5n 0.5668 7200.0n 0.6050 7799.5n 0.6050 7800.0n 0.5755 8399.5n 0.5755 8400.0n 0.6050 8999.5n 0.6050 9000.0n 0.5762 9599.5n 0.5762 9600.0n 0.5886 10199.5n 0.5886 10200.0n 0.5194 10799.5n 0.5194 10800.0n 0.6050 11399.5n 0.6050 11400.0n 0.6050 11999.5n 0.6050 12000.0n 0.6050 12599.5n 0.6050 12600.0n 0.6050 13199.5n 0.6050 13200.0n 0.5750 13799.5n 0.5750 13800.0n 0.6050 14399.5n 0.6050)
Vyp_wih_4_0 yp_wih_4_0 0 PWL(0.0n 0.5895 599.5n 0.5895 600.0n 0.6373 1199.5n 0.6373 1200.0n 0.5342 1799.5n 0.5342 1800.0n 0.5173 2399.5n 0.5173 2400.0n 0.5233 2999.5n 0.5233 3000.0n 0.5378 3599.5n 0.5378 3600.0n 0.5315 4199.5n 0.5315 4200.0n 0.6065 4799.5n 0.6065 4800.0n 0.5561 5399.5n 0.5561 5400.0n 0.6170 5999.5n 0.6170 6000.0n 0.6210 6599.5n 0.6210 6600.0n 0.5575 7199.5n 0.5575 7200.0n 0.6492 7799.5n 0.6492 7800.0n 0.6510 8399.5n 0.6510 8400.0n 0.5741 8999.5n 0.5741 9000.0n 0.6593 9599.5n 0.6593 9600.0n 0.6623 10199.5n 0.6623 10200.0n 0.6460 10799.5n 0.6460 10800.0n 0.6151 11399.5n 0.6151 11400.0n 0.6495 11999.5n 0.6495 12000.0n 0.6499 12599.5n 0.6499 12600.0n 0.6152 13199.5n 0.6152 13200.0n 0.6652 13799.5n 0.6652 13800.0n 0.5950 14399.5n 0.5950)
Vyn_wih_4_0 yn_wih_4_0 0 PWL(0.0n 0.4105 599.5n 0.4105 600.0n 0.3627 1199.5n 0.3627 1200.0n 0.4658 1799.5n 0.4658 1800.0n 0.4827 2399.5n 0.4827 2400.0n 0.4767 2999.5n 0.4767 3000.0n 0.4622 3599.5n 0.4622 3600.0n 0.4685 4199.5n 0.4685 4200.0n 0.3935 4799.5n 0.3935 4800.0n 0.4439 5399.5n 0.4439 5400.0n 0.3830 5999.5n 0.3830 6000.0n 0.3790 6599.5n 0.3790 6600.0n 0.4425 7199.5n 0.4425 7200.0n 0.3508 7799.5n 0.3508 7800.0n 0.3490 8399.5n 0.3490 8400.0n 0.4259 8999.5n 0.4259 9000.0n 0.3407 9599.5n 0.3407 9600.0n 0.3377 10199.5n 0.3377 10200.0n 0.3540 10799.5n 0.3540 10800.0n 0.3849 11399.5n 0.3849 11400.0n 0.3505 11999.5n 0.3505 12000.0n 0.3501 12599.5n 0.3501 12600.0n 0.3848 13199.5n 0.3848 13200.0n 0.3348 13799.5n 0.3348 13800.0n 0.4050 14399.5n 0.4050)
Cwp_wih_4_0 wp_wih_4_0 0 400p
Cwn_wih_4_0 wn_wih_4_0 0 400p
Xu_wih_4_0 xp_wih_4_0 xn_wih_4_0 yp_wih_4_0 yn_wih_4_0 wp_wih_4_0 wn_wih_4_0 vdd gbn gprod
Vxp_wih_5_0 xp_wih_5_0 0 PWL(0.0n 0.5708 599.5n 0.5708 600.0n 0.5892 1199.5n 0.5892 1200.0n 0.5077 1799.5n 0.5077 1800.0n 0.5095 2399.5n 0.5095 2400.0n 0.5286 2999.5n 0.5286 3000.0n 0.5137 3599.5n 0.5137 3600.0n 0.5228 4199.5n 0.5228 4200.0n 0.6050 4799.5n 0.6050 4800.0n 0.5000 5399.5n 0.5000 5400.0n 0.6050 5999.5n 0.6050 6000.0n 0.5919 6599.5n 0.5919 6600.0n 0.5525 7199.5n 0.5525 7200.0n 0.6050 7799.5n 0.6050 7800.0n 0.5623 8399.5n 0.5623 8400.0n 0.4294 8999.5n 0.4294 9000.0n 0.5638 9599.5n 0.5638 9600.0n 0.5689 10199.5n 0.5689 10200.0n 0.6050 10799.5n 0.6050 10800.0n 0.5996 11399.5n 0.5996 11400.0n 0.5915 11999.5n 0.5915 12000.0n 0.5325 12599.5n 0.5325 12600.0n 0.5552 13199.5n 0.5552 13200.0n 0.5850 13799.5n 0.5850 13800.0n 0.5271 14399.5n 0.5271)
Vxn_wih_5_0 xn_wih_5_0 0 PWL(0.0n 0.4292 599.5n 0.4292 600.0n 0.4108 1199.5n 0.4108 1200.0n 0.4923 1799.5n 0.4923 1800.0n 0.4905 2399.5n 0.4905 2400.0n 0.4714 2999.5n 0.4714 3000.0n 0.4863 3599.5n 0.4863 3600.0n 0.4772 4199.5n 0.4772 4200.0n 0.3950 4799.5n 0.3950 4800.0n 0.5000 5399.5n 0.5000 5400.0n 0.3950 5999.5n 0.3950 6000.0n 0.4081 6599.5n 0.4081 6600.0n 0.4475 7199.5n 0.4475 7200.0n 0.3950 7799.5n 0.3950 7800.0n 0.4377 8399.5n 0.4377 8400.0n 0.5706 8999.5n 0.5706 9000.0n 0.4362 9599.5n 0.4362 9600.0n 0.4311 10199.5n 0.4311 10200.0n 0.3950 10799.5n 0.3950 10800.0n 0.4004 11399.5n 0.4004 11400.0n 0.4085 11999.5n 0.4085 12000.0n 0.4675 12599.5n 0.4675 12600.0n 0.4448 13199.5n 0.4448 13200.0n 0.4150 13799.5n 0.4150 13800.0n 0.4729 14399.5n 0.4729)
Vyp_wih_5_0 yp_wih_5_0 0 PWL(0.0n 0.5895 599.5n 0.5895 600.0n 0.6373 1199.5n 0.6373 1200.0n 0.5342 1799.5n 0.5342 1800.0n 0.5173 2399.5n 0.5173 2400.0n 0.5233 2999.5n 0.5233 3000.0n 0.5378 3599.5n 0.5378 3600.0n 0.5315 4199.5n 0.5315 4200.0n 0.6065 4799.5n 0.6065 4800.0n 0.5561 5399.5n 0.5561 5400.0n 0.6170 5999.5n 0.6170 6000.0n 0.6210 6599.5n 0.6210 6600.0n 0.5575 7199.5n 0.5575 7200.0n 0.6492 7799.5n 0.6492 7800.0n 0.6510 8399.5n 0.6510 8400.0n 0.5741 8999.5n 0.5741 9000.0n 0.6593 9599.5n 0.6593 9600.0n 0.6623 10199.5n 0.6623 10200.0n 0.6460 10799.5n 0.6460 10800.0n 0.6151 11399.5n 0.6151 11400.0n 0.6495 11999.5n 0.6495 12000.0n 0.6499 12599.5n 0.6499 12600.0n 0.6152 13199.5n 0.6152 13200.0n 0.6652 13799.5n 0.6652 13800.0n 0.5950 14399.5n 0.5950)
Vyn_wih_5_0 yn_wih_5_0 0 PWL(0.0n 0.4105 599.5n 0.4105 600.0n 0.3627 1199.5n 0.3627 1200.0n 0.4658 1799.5n 0.4658 1800.0n 0.4827 2399.5n 0.4827 2400.0n 0.4767 2999.5n 0.4767 3000.0n 0.4622 3599.5n 0.4622 3600.0n 0.4685 4199.5n 0.4685 4200.0n 0.3935 4799.5n 0.3935 4800.0n 0.4439 5399.5n 0.4439 5400.0n 0.3830 5999.5n 0.3830 6000.0n 0.3790 6599.5n 0.3790 6600.0n 0.4425 7199.5n 0.4425 7200.0n 0.3508 7799.5n 0.3508 7800.0n 0.3490 8399.5n 0.3490 8400.0n 0.4259 8999.5n 0.4259 9000.0n 0.3407 9599.5n 0.3407 9600.0n 0.3377 10199.5n 0.3377 10200.0n 0.3540 10799.5n 0.3540 10800.0n 0.3849 11399.5n 0.3849 11400.0n 0.3505 11999.5n 0.3505 12000.0n 0.3501 12599.5n 0.3501 12600.0n 0.3848 13199.5n 0.3848 13200.0n 0.3348 13799.5n 0.3348 13800.0n 0.4050 14399.5n 0.4050)
Cwp_wih_5_0 wp_wih_5_0 0 400p
Cwn_wih_5_0 wn_wih_5_0 0 400p
Xu_wih_5_0 xp_wih_5_0 xn_wih_5_0 yp_wih_5_0 yn_wih_5_0 wp_wih_5_0 wn_wih_5_0 vdd gbn gprod
Vxp_who_0_0 xp_who_0_0 0 PWL(0.0n 0.5895 599.5n 0.5895 600.0n 0.6373 1199.5n 0.6373 1200.0n 0.5342 1799.5n 0.5342 1800.0n 0.5173 2399.5n 0.5173 2400.0n 0.5233 2999.5n 0.5233 3000.0n 0.5378 3599.5n 0.5378 3600.0n 0.5315 4199.5n 0.5315 4200.0n 0.6065 4799.5n 0.6065 4800.0n 0.5561 5399.5n 0.5561 5400.0n 0.6170 5999.5n 0.6170 6000.0n 0.6210 6599.5n 0.6210 6600.0n 0.5575 7199.5n 0.5575 7200.0n 0.6492 7799.5n 0.6492 7800.0n 0.6510 8399.5n 0.6510 8400.0n 0.5741 8999.5n 0.5741 9000.0n 0.6593 9599.5n 0.6593 9600.0n 0.6623 10199.5n 0.6623 10200.0n 0.6460 10799.5n 0.6460 10800.0n 0.6151 11399.5n 0.6151 11400.0n 0.6495 11999.5n 0.6495 12000.0n 0.6499 12599.5n 0.6499 12600.0n 0.6152 13199.5n 0.6152 13200.0n 0.6652 13799.5n 0.6652 13800.0n 0.5950 14399.5n 0.5950)
Vxn_who_0_0 xn_who_0_0 0 PWL(0.0n 0.4105 599.5n 0.4105 600.0n 0.3627 1199.5n 0.3627 1200.0n 0.4658 1799.5n 0.4658 1800.0n 0.4827 2399.5n 0.4827 2400.0n 0.4767 2999.5n 0.4767 3000.0n 0.4622 3599.5n 0.4622 3600.0n 0.4685 4199.5n 0.4685 4200.0n 0.3935 4799.5n 0.3935 4800.0n 0.4439 5399.5n 0.4439 5400.0n 0.3830 5999.5n 0.3830 6000.0n 0.3790 6599.5n 0.3790 6600.0n 0.4425 7199.5n 0.4425 7200.0n 0.3508 7799.5n 0.3508 7800.0n 0.3490 8399.5n 0.3490 8400.0n 0.4259 8999.5n 0.4259 9000.0n 0.3407 9599.5n 0.3407 9600.0n 0.3377 10199.5n 0.3377 10200.0n 0.3540 10799.5n 0.3540 10800.0n 0.3849 11399.5n 0.3849 11400.0n 0.3505 11999.5n 0.3505 12000.0n 0.3501 12599.5n 0.3501 12600.0n 0.3848 13199.5n 0.3848 13200.0n 0.3348 13799.5n 0.3348 13800.0n 0.4050 14399.5n 0.4050)
Vyp_who_0_0 yp_who_0_0 0 PWL(0.0n 0.5073 599.5n 0.5073 600.0n 0.5065 1199.5n 0.5065 1200.0n 0.5065 1799.5n 0.5065 1800.0n 0.5052 2399.5n 0.5052 2400.0n 0.5058 2999.5n 0.5058 3000.0n 0.5039 3599.5n 0.5039 3600.0n 0.5059 4199.5n 0.5059 4200.0n 0.5077 4799.5n 0.5077 4800.0n 0.5054 5399.5n 0.5054 5400.0n 0.5066 5999.5n 0.5066 6000.0n 0.5083 6599.5n 0.5083 6600.0n 0.5078 7199.5n 0.5078 7200.0n 0.5043 7799.5n 0.5043 7800.0n 0.5035 8399.5n 0.5035 8400.0n 0.5035 8999.5n 0.5035 9000.0n 0.5038 9599.5n 0.5038 9600.0n 0.5043 10199.5n 0.5043 10200.0n 0.5053 10799.5n 0.5053 10800.0n 0.5050 11399.5n 0.5050 11400.0n 0.5055 11999.5n 0.5055 12000.0n 0.5043 12599.5n 0.5043 12600.0n 0.5028 13199.5n 0.5028 13200.0n 0.5045 13799.5n 0.5045 13800.0n 0.5043 14399.5n 0.5043)
Vyn_who_0_0 yn_who_0_0 0 PWL(0.0n 0.4927 599.5n 0.4927 600.0n 0.4935 1199.5n 0.4935 1200.0n 0.4935 1799.5n 0.4935 1800.0n 0.4948 2399.5n 0.4948 2400.0n 0.4942 2999.5n 0.4942 3000.0n 0.4961 3599.5n 0.4961 3600.0n 0.4941 4199.5n 0.4941 4200.0n 0.4923 4799.5n 0.4923 4800.0n 0.4946 5399.5n 0.4946 5400.0n 0.4934 5999.5n 0.4934 6000.0n 0.4917 6599.5n 0.4917 6600.0n 0.4922 7199.5n 0.4922 7200.0n 0.4957 7799.5n 0.4957 7800.0n 0.4965 8399.5n 0.4965 8400.0n 0.4965 8999.5n 0.4965 9000.0n 0.4962 9599.5n 0.4962 9600.0n 0.4957 10199.5n 0.4957 10200.0n 0.4947 10799.5n 0.4947 10800.0n 0.4950 11399.5n 0.4950 11400.0n 0.4945 11999.5n 0.4945 12000.0n 0.4957 12599.5n 0.4957 12600.0n 0.4972 13199.5n 0.4972 13200.0n 0.4955 13799.5n 0.4955 13800.0n 0.4957 14399.5n 0.4957)
Cwp_who_0_0 wp_who_0_0 0 400p
Cwn_who_0_0 wn_who_0_0 0 400p
Xu_who_0_0 xp_who_0_0 xn_who_0_0 yp_who_0_0 yn_who_0_0 wp_who_0_0 wn_who_0_0 vdd gbn gprod
Vxp_who_0_1 xp_who_0_1 0 PWL(0.0n 0.5895 599.5n 0.5895 600.0n 0.6373 1199.5n 0.6373 1200.0n 0.5342 1799.5n 0.5342 1800.0n 0.5173 2399.5n 0.5173 2400.0n 0.5233 2999.5n 0.5233 3000.0n 0.5378 3599.5n 0.5378 3600.0n 0.5315 4199.5n 0.5315 4200.0n 0.6065 4799.5n 0.6065 4800.0n 0.5561 5399.5n 0.5561 5400.0n 0.6170 5999.5n 0.6170 6000.0n 0.6210 6599.5n 0.6210 6600.0n 0.5575 7199.5n 0.5575 7200.0n 0.6492 7799.5n 0.6492 7800.0n 0.6510 8399.5n 0.6510 8400.0n 0.5741 8999.5n 0.5741 9000.0n 0.6593 9599.5n 0.6593 9600.0n 0.6623 10199.5n 0.6623 10200.0n 0.6460 10799.5n 0.6460 10800.0n 0.6151 11399.5n 0.6151 11400.0n 0.6495 11999.5n 0.6495 12000.0n 0.6499 12599.5n 0.6499 12600.0n 0.6152 13199.5n 0.6152 13200.0n 0.6652 13799.5n 0.6652 13800.0n 0.5950 14399.5n 0.5950)
Vxn_who_0_1 xn_who_0_1 0 PWL(0.0n 0.4105 599.5n 0.4105 600.0n 0.3627 1199.5n 0.3627 1200.0n 0.4658 1799.5n 0.4658 1800.0n 0.4827 2399.5n 0.4827 2400.0n 0.4767 2999.5n 0.4767 3000.0n 0.4622 3599.5n 0.4622 3600.0n 0.4685 4199.5n 0.4685 4200.0n 0.3935 4799.5n 0.3935 4800.0n 0.4439 5399.5n 0.4439 5400.0n 0.3830 5999.5n 0.3830 6000.0n 0.3790 6599.5n 0.3790 6600.0n 0.4425 7199.5n 0.4425 7200.0n 0.3508 7799.5n 0.3508 7800.0n 0.3490 8399.5n 0.3490 8400.0n 0.4259 8999.5n 0.4259 9000.0n 0.3407 9599.5n 0.3407 9600.0n 0.3377 10199.5n 0.3377 10200.0n 0.3540 10799.5n 0.3540 10800.0n 0.3849 11399.5n 0.3849 11400.0n 0.3505 11999.5n 0.3505 12000.0n 0.3501 12599.5n 0.3501 12600.0n 0.3848 13199.5n 0.3848 13200.0n 0.3348 13799.5n 0.3348 13800.0n 0.4050 14399.5n 0.4050)
Vyp_who_0_1 yp_who_0_1 0 PWL(0.0n 0.4909 599.5n 0.4909 600.0n 0.4933 1199.5n 0.4933 1200.0n 0.4930 1799.5n 0.4930 1800.0n 0.4893 2399.5n 0.4893 2400.0n 0.4904 2999.5n 0.4904 3000.0n 0.4923 3599.5n 0.4923 3600.0n 0.4897 4199.5n 0.4897 4200.0n 0.4890 4799.5n 0.4890 4800.0n 0.4921 5399.5n 0.4921 5400.0n 0.4899 5999.5n 0.4899 6000.0n 0.4870 6599.5n 0.4870 6600.0n 0.4903 7199.5n 0.4903 7200.0n 0.4970 7799.5n 0.4970 7800.0n 0.4989 8399.5n 0.4989 8400.0n 0.4994 8999.5n 0.4994 9000.0n 0.4991 9599.5n 0.4991 9600.0n 0.5000 10199.5n 0.5000 10200.0n 0.4948 10799.5n 0.4948 10800.0n 0.4959 11399.5n 0.4959 11400.0n 0.4926 11999.5n 0.4926 12000.0n 0.4993 12599.5n 0.4993 12600.0n 0.4862 13199.5n 0.4862 13200.0n 0.4993 13799.5n 0.4993 13800.0n 0.4961 14399.5n 0.4961)
Vyn_who_0_1 yn_who_0_1 0 PWL(0.0n 0.5091 599.5n 0.5091 600.0n 0.5067 1199.5n 0.5067 1200.0n 0.5070 1799.5n 0.5070 1800.0n 0.5107 2399.5n 0.5107 2400.0n 0.5096 2999.5n 0.5096 3000.0n 0.5077 3599.5n 0.5077 3600.0n 0.5103 4199.5n 0.5103 4200.0n 0.5110 4799.5n 0.5110 4800.0n 0.5079 5399.5n 0.5079 5400.0n 0.5101 5999.5n 0.5101 6000.0n 0.5130 6599.5n 0.5130 6600.0n 0.5097 7199.5n 0.5097 7200.0n 0.5030 7799.5n 0.5030 7800.0n 0.5011 8399.5n 0.5011 8400.0n 0.5006 8999.5n 0.5006 9000.0n 0.5009 9599.5n 0.5009 9600.0n 0.5000 10199.5n 0.5000 10200.0n 0.5052 10799.5n 0.5052 10800.0n 0.5041 11399.5n 0.5041 11400.0n 0.5074 11999.5n 0.5074 12000.0n 0.5007 12599.5n 0.5007 12600.0n 0.5138 13199.5n 0.5138 13200.0n 0.5007 13799.5n 0.5007 13800.0n 0.5039 14399.5n 0.5039)
Cwp_who_0_1 wp_who_0_1 0 400p
Cwn_who_0_1 wn_who_0_1 0 400p
Xu_who_0_1 xp_who_0_1 xn_who_0_1 yp_who_0_1 yn_who_0_1 wp_who_0_1 wn_who_0_1 vdd gbn gprod
Vxp_bh_0 xp_bh_0 0 PWL(0.0n 0.7100 599.5n 0.7100 600.0n 0.7100 1199.5n 0.7100 1200.0n 0.7100 1799.5n 0.7100 1800.0n 0.7100 2399.5n 0.7100 2400.0n 0.7100 2999.5n 0.7100 3000.0n 0.7100 3599.5n 0.7100 3600.0n 0.7100 4199.5n 0.7100 4200.0n 0.7100 4799.5n 0.7100 4800.0n 0.7100 5399.5n 0.7100 5400.0n 0.7100 5999.5n 0.7100 6000.0n 0.7100 6599.5n 0.7100 6600.0n 0.7100 7199.5n 0.7100 7200.0n 0.7100 7799.5n 0.7100 7800.0n 0.7100 8399.5n 0.7100 8400.0n 0.7100 8999.5n 0.7100 9000.0n 0.7100 9599.5n 0.7100 9600.0n 0.7100 10199.5n 0.7100 10200.0n 0.7100 10799.5n 0.7100 10800.0n 0.7100 11399.5n 0.7100 11400.0n 0.7100 11999.5n 0.7100 12000.0n 0.7100 12599.5n 0.7100 12600.0n 0.7100 13199.5n 0.7100 13200.0n 0.7100 13799.5n 0.7100 13800.0n 0.7100 14399.5n 0.7100)
Vxn_bh_0 xn_bh_0 0 PWL(0.0n 0.2900 599.5n 0.2900 600.0n 0.2900 1199.5n 0.2900 1200.0n 0.2900 1799.5n 0.2900 1800.0n 0.2900 2399.5n 0.2900 2400.0n 0.2900 2999.5n 0.2900 3000.0n 0.2900 3599.5n 0.2900 3600.0n 0.2900 4199.5n 0.2900 4200.0n 0.2900 4799.5n 0.2900 4800.0n 0.2900 5399.5n 0.2900 5400.0n 0.2900 5999.5n 0.2900 6000.0n 0.2900 6599.5n 0.2900 6600.0n 0.2900 7199.5n 0.2900 7200.0n 0.2900 7799.5n 0.2900 7800.0n 0.2900 8399.5n 0.2900 8400.0n 0.2900 8999.5n 0.2900 9000.0n 0.2900 9599.5n 0.2900 9600.0n 0.2900 10199.5n 0.2900 10200.0n 0.2900 10799.5n 0.2900 10800.0n 0.2900 11399.5n 0.2900 11400.0n 0.2900 11999.5n 0.2900 12000.0n 0.2900 12599.5n 0.2900 12600.0n 0.2900 13199.5n 0.2900 13200.0n 0.2900 13799.5n 0.2900 13800.0n 0.2900 14399.5n 0.2900)
Vyp_bh_0 yp_bh_0 0 PWL(0.0n 0.5895 599.5n 0.5895 600.0n 0.6373 1199.5n 0.6373 1200.0n 0.5342 1799.5n 0.5342 1800.0n 0.5173 2399.5n 0.5173 2400.0n 0.5233 2999.5n 0.5233 3000.0n 0.5378 3599.5n 0.5378 3600.0n 0.5315 4199.5n 0.5315 4200.0n 0.6065 4799.5n 0.6065 4800.0n 0.5561 5399.5n 0.5561 5400.0n 0.6170 5999.5n 0.6170 6000.0n 0.6210 6599.5n 0.6210 6600.0n 0.5575 7199.5n 0.5575 7200.0n 0.6492 7799.5n 0.6492 7800.0n 0.6510 8399.5n 0.6510 8400.0n 0.5741 8999.5n 0.5741 9000.0n 0.6593 9599.5n 0.6593 9600.0n 0.6623 10199.5n 0.6623 10200.0n 0.6460 10799.5n 0.6460 10800.0n 0.6151 11399.5n 0.6151 11400.0n 0.6495 11999.5n 0.6495 12000.0n 0.6499 12599.5n 0.6499 12600.0n 0.6152 13199.5n 0.6152 13200.0n 0.6652 13799.5n 0.6652 13800.0n 0.5950 14399.5n 0.5950)
Vyn_bh_0 yn_bh_0 0 PWL(0.0n 0.4105 599.5n 0.4105 600.0n 0.3627 1199.5n 0.3627 1200.0n 0.4658 1799.5n 0.4658 1800.0n 0.4827 2399.5n 0.4827 2400.0n 0.4767 2999.5n 0.4767 3000.0n 0.4622 3599.5n 0.4622 3600.0n 0.4685 4199.5n 0.4685 4200.0n 0.3935 4799.5n 0.3935 4800.0n 0.4439 5399.5n 0.4439 5400.0n 0.3830 5999.5n 0.3830 6000.0n 0.3790 6599.5n 0.3790 6600.0n 0.4425 7199.5n 0.4425 7200.0n 0.3508 7799.5n 0.3508 7800.0n 0.3490 8399.5n 0.3490 8400.0n 0.4259 8999.5n 0.4259 9000.0n 0.3407 9599.5n 0.3407 9600.0n 0.3377 10199.5n 0.3377 10200.0n 0.3540 10799.5n 0.3540 10800.0n 0.3849 11399.5n 0.3849 11400.0n 0.3505 11999.5n 0.3505 12000.0n 0.3501 12599.5n 0.3501 12600.0n 0.3848 13199.5n 0.3848 13200.0n 0.3348 13799.5n 0.3348 13800.0n 0.4050 14399.5n 0.4050)
Cwp_bh_0 wp_bh_0 0 400p
Cwn_bh_0 wn_bh_0 0 400p
Xu_bh_0 xp_bh_0 xn_bh_0 yp_bh_0 yn_bh_0 wp_bh_0 wn_bh_0 vdd gbn gprod
Vxp_wih_0_1 xp_wih_0_1 0 PWL(0.0n 0.3950 599.5n 0.3950 600.0n 0.3950 1199.5n 0.3950 1200.0n 0.3950 1799.5n 0.3950 1800.0n 0.3950 2399.5n 0.3950 2400.0n 0.4093 2999.5n 0.4093 3000.0n 0.3950 3599.5n 0.3950 3600.0n 0.3996 4199.5n 0.3996 4200.0n 0.3950 4799.5n 0.3950 4800.0n 0.3950 5399.5n 0.3950 5400.0n 0.3950 5999.5n 0.3950 6000.0n 0.3950 6599.5n 0.3950 6600.0n 0.3950 7199.5n 0.3950 7200.0n 0.3950 7799.5n 0.3950 7800.0n 0.3950 8399.5n 0.3950 8400.0n 0.3950 8999.5n 0.3950 9000.0n 0.3950 9599.5n 0.3950 9600.0n 0.3950 10199.5n 0.3950 10200.0n 0.3950 10799.5n 0.3950 10800.0n 0.3950 11399.5n 0.3950 11400.0n 0.3950 11999.5n 0.3950 12000.0n 0.3950 12599.5n 0.3950 12600.0n 0.3950 13199.5n 0.3950 13200.0n 0.3950 13799.5n 0.3950 13800.0n 0.3950 14399.5n 0.3950)
Vxn_wih_0_1 xn_wih_0_1 0 PWL(0.0n 0.6050 599.5n 0.6050 600.0n 0.6050 1199.5n 0.6050 1200.0n 0.6050 1799.5n 0.6050 1800.0n 0.6050 2399.5n 0.6050 2400.0n 0.5907 2999.5n 0.5907 3000.0n 0.6050 3599.5n 0.6050 3600.0n 0.6004 4199.5n 0.6004 4200.0n 0.6050 4799.5n 0.6050 4800.0n 0.6050 5399.5n 0.6050 5400.0n 0.6050 5999.5n 0.6050 6000.0n 0.6050 6599.5n 0.6050 6600.0n 0.6050 7199.5n 0.6050 7200.0n 0.6050 7799.5n 0.6050 7800.0n 0.6050 8399.5n 0.6050 8400.0n 0.6050 8999.5n 0.6050 9000.0n 0.6050 9599.5n 0.6050 9600.0n 0.6050 10199.5n 0.6050 10200.0n 0.6050 10799.5n 0.6050 10800.0n 0.6050 11399.5n 0.6050 11400.0n 0.6050 11999.5n 0.6050 12000.0n 0.6050 12599.5n 0.6050 12600.0n 0.6050 13199.5n 0.6050 13200.0n 0.6050 13799.5n 0.6050 13800.0n 0.6050 14399.5n 0.6050)
Vyp_wih_0_1 yp_wih_0_1 0 PWL(0.0n 0.5399 599.5n 0.5399 600.0n 0.5580 1199.5n 0.5580 1200.0n 0.5446 1799.5n 0.5446 1800.0n 0.5297 2399.5n 0.5297 2400.0n 0.5221 2999.5n 0.5221 3000.0n 0.5445 3599.5n 0.5445 3600.0n 0.5308 4199.5n 0.5308 4200.0n 0.5346 4799.5n 0.5346 4800.0n 0.5567 5399.5n 0.5567 5400.0n 0.5393 5999.5n 0.5393 6000.0n 0.5470 6599.5n 0.5470 6600.0n 0.5327 7199.5n 0.5327 7200.0n 0.5637 7799.5n 0.5637 7800.0n 0.5781 8399.5n 0.5781 8400.0n 0.5997 8999.5n 0.5997 9000.0n 0.5899 9599.5n 0.5899 9600.0n 0.5938 10199.5n 0.5938 10200.0n 0.5503 10799.5n 0.5503 10800.0n 0.5461 11399.5n 0.5461 11400.0n 0.5647 11999.5n 0.5647 12000.0n 0.5966 12599.5n 0.5966 12600.0n 0.5622 13199.5n 0.5622 13200.0n 0.5901 13799.5n 0.5901 13800.0n 0.5692 14399.5n 0.5692)
Vyn_wih_0_1 yn_wih_0_1 0 PWL(0.0n 0.4601 599.5n 0.4601 600.0n 0.4420 1199.5n 0.4420 1200.0n 0.4554 1799.5n 0.4554 1800.0n 0.4703 2399.5n 0.4703 2400.0n 0.4779 2999.5n 0.4779 3000.0n 0.4555 3599.5n 0.4555 3600.0n 0.4692 4199.5n 0.4692 4200.0n 0.4654 4799.5n 0.4654 4800.0n 0.4433 5399.5n 0.4433 5400.0n 0.4607 5999.5n 0.4607 6000.0n 0.4530 6599.5n 0.4530 6600.0n 0.4673 7199.5n 0.4673 7200.0n 0.4363 7799.5n 0.4363 7800.0n 0.4219 8399.5n 0.4219 8400.0n 0.4003 8999.5n 0.4003 9000.0n 0.4101 9599.5n 0.4101 9600.0n 0.4062 10199.5n 0.4062 10200.0n 0.4497 10799.5n 0.4497 10800.0n 0.4539 11399.5n 0.4539 11400.0n 0.4353 11999.5n 0.4353 12000.0n 0.4034 12599.5n 0.4034 12600.0n 0.4378 13199.5n 0.4378 13200.0n 0.4099 13799.5n 0.4099 13800.0n 0.4308 14399.5n 0.4308)
Cwp_wih_0_1 wp_wih_0_1 0 400p
Cwn_wih_0_1 wn_wih_0_1 0 400p
Xu_wih_0_1 xp_wih_0_1 xn_wih_0_1 yp_wih_0_1 yn_wih_0_1 wp_wih_0_1 wn_wih_0_1 vdd gbn gprod
Vxp_wih_1_1 xp_wih_1_1 0 PWL(0.0n 0.5903 599.5n 0.5903 600.0n 0.5456 1199.5n 0.5456 1200.0n 0.5794 1799.5n 0.5794 1800.0n 0.6050 2399.5n 0.6050 2400.0n 0.6002 2999.5n 0.6002 3000.0n 0.5822 3599.5n 0.5822 3600.0n 0.5776 4199.5n 0.5776 4200.0n 0.5867 4799.5n 0.5867 4800.0n 0.5487 5399.5n 0.5487 5400.0n 0.5654 5999.5n 0.5654 6000.0n 0.5656 6599.5n 0.5656 6600.0n 0.5907 7199.5n 0.5907 7200.0n 0.5309 7799.5n 0.5309 7800.0n 0.4409 8399.5n 0.4409 8400.0n 0.3950 8999.5n 0.3950 9000.0n 0.4115 9599.5n 0.4115 9600.0n 0.4048 10199.5n 0.4048 10200.0n 0.4883 10799.5n 0.4883 10800.0n 0.5781 11399.5n 0.5781 11400.0n 0.5169 11999.5n 0.5169 12000.0n 0.4065 12599.5n 0.4065 12600.0n 0.5303 13199.5n 0.5303 13200.0n 0.4017 13799.5n 0.4017 13800.0n 0.5102 14399.5n 0.5102)
Vxn_wih_1_1 xn_wih_1_1 0 PWL(0.0n 0.4097 599.5n 0.4097 600.0n 0.4544 1199.5n 0.4544 1200.0n 0.4206 1799.5n 0.4206 1800.0n 0.3950 2399.5n 0.3950 2400.0n 0.3998 2999.5n 0.3998 3000.0n 0.4178 3599.5n 0.4178 3600.0n 0.4224 4199.5n 0.4224 4200.0n 0.4133 4799.5n 0.4133 4800.0n 0.4513 5399.5n 0.4513 5400.0n 0.4346 5999.5n 0.4346 6000.0n 0.4344 6599.5n 0.4344 6600.0n 0.4093 7199.5n 0.4093 7200.0n 0.4691 7799.5n 0.4691 7800.0n 0.5591 8399.5n 0.5591 8400.0n 0.6050 8999.5n 0.6050 9000.0n 0.5885 9599.5n 0.5885 9600.0n 0.5952 10199.5n 0.5952 10200.0n 0.5117 10799.5n 0.5117 10800.0n 0.4219 11399.5n 0.4219 11400.0n 0.4831 11999.5n 0.4831 12000.0n 0.5935 12599.5n 0.5935 12600.0n 0.4697 13199.5n 0.4697 13200.0n 0.5983 13799.5n 0.5983 13800.0n 0.4898 14399.5n 0.4898)
Vyp_wih_1_1 yp_wih_1_1 0 PWL(0.0n 0.5399 599.5n 0.5399 600.0n 0.5580 1199.5n 0.5580 1200.0n 0.5446 1799.5n 0.5446 1800.0n 0.5297 2399.5n 0.5297 2400.0n 0.5221 2999.5n 0.5221 3000.0n 0.5445 3599.5n 0.5445 3600.0n 0.5308 4199.5n 0.5308 4200.0n 0.5346 4799.5n 0.5346 4800.0n 0.5567 5399.5n 0.5567 5400.0n 0.5393 5999.5n 0.5393 6000.0n 0.5470 6599.5n 0.5470 6600.0n 0.5327 7199.5n 0.5327 7200.0n 0.5637 7799.5n 0.5637 7800.0n 0.5781 8399.5n 0.5781 8400.0n 0.5997 8999.5n 0.5997 9000.0n 0.5899 9599.5n 0.5899 9600.0n 0.5938 10199.5n 0.5938 10200.0n 0.5503 10799.5n 0.5503 10800.0n 0.5461 11399.5n 0.5461 11400.0n 0.5647 11999.5n 0.5647 12000.0n 0.5966 12599.5n 0.5966 12600.0n 0.5622 13199.5n 0.5622 13200.0n 0.5901 13799.5n 0.5901 13800.0n 0.5692 14399.5n 0.5692)
Vyn_wih_1_1 yn_wih_1_1 0 PWL(0.0n 0.4601 599.5n 0.4601 600.0n 0.4420 1199.5n 0.4420 1200.0n 0.4554 1799.5n 0.4554 1800.0n 0.4703 2399.5n 0.4703 2400.0n 0.4779 2999.5n 0.4779 3000.0n 0.4555 3599.5n 0.4555 3600.0n 0.4692 4199.5n 0.4692 4200.0n 0.4654 4799.5n 0.4654 4800.0n 0.4433 5399.5n 0.4433 5400.0n 0.4607 5999.5n 0.4607 6000.0n 0.4530 6599.5n 0.4530 6600.0n 0.4673 7199.5n 0.4673 7200.0n 0.4363 7799.5n 0.4363 7800.0n 0.4219 8399.5n 0.4219 8400.0n 0.4003 8999.5n 0.4003 9000.0n 0.4101 9599.5n 0.4101 9600.0n 0.4062 10199.5n 0.4062 10200.0n 0.4497 10799.5n 0.4497 10800.0n 0.4539 11399.5n 0.4539 11400.0n 0.4353 11999.5n 0.4353 12000.0n 0.4034 12599.5n 0.4034 12600.0n 0.4378 13199.5n 0.4378 13200.0n 0.4099 13799.5n 0.4099 13800.0n 0.4308 14399.5n 0.4308)
Cwp_wih_1_1 wp_wih_1_1 0 400p
Cwn_wih_1_1 wn_wih_1_1 0 400p
Xu_wih_1_1 xp_wih_1_1 xn_wih_1_1 yp_wih_1_1 yn_wih_1_1 wp_wih_1_1 wn_wih_1_1 vdd gbn gprod
Vxp_wih_4_1 xp_wih_4_1 0 PWL(0.0n 0.4097 599.5n 0.4097 600.0n 0.4029 1199.5n 0.4029 1200.0n 0.4104 1799.5n 0.4104 1800.0n 0.4380 2399.5n 0.4380 2400.0n 0.4570 2999.5n 0.4570 3000.0n 0.4087 3599.5n 0.4087 3600.0n 0.4498 4199.5n 0.4498 4200.0n 0.4270 4799.5n 0.4270 4800.0n 0.4175 5399.5n 0.4175 5400.0n 0.4386 5999.5n 0.4386 6000.0n 0.4125 6599.5n 0.4125 6600.0n 0.4332 7199.5n 0.4332 7200.0n 0.3950 7799.5n 0.3950 7800.0n 0.4245 8399.5n 0.4245 8400.0n 0.3950 8999.5n 0.3950 9000.0n 0.4238 9599.5n 0.4238 9600.0n 0.4114 10199.5n 0.4114 10200.0n 0.4806 10799.5n 0.4806 10800.0n 0.3950 11399.5n 0.3950 11400.0n 0.3950 11999.5n 0.3950 12000.0n 0.3950 12599.5n 0.3950 12600.0n 0.3950 13199.5n 0.3950 13200.0n 0.4250 13799.5n 0.4250 13800.0n 0.3950 14399.5n 0.3950)
Vxn_wih_4_1 xn_wih_4_1 0 PWL(0.0n 0.5903 599.5n 0.5903 600.0n 0.5971 1199.5n 0.5971 1200.0n 0.5896 1799.5n 0.5896 1800.0n 0.5620 2399.5n 0.5620 2400.0n 0.5430 2999.5n 0.5430 3000.0n 0.5913 3599.5n 0.5913 3600.0n 0.5502 4199.5n 0.5502 4200.0n 0.5730 4799.5n 0.5730 4800.0n 0.5825 5399.5n 0.5825 5400.0n 0.5614 5999.5n 0.5614 6000.0n 0.5875 6599.5n 0.5875 6600.0n 0.5668 7199.5n 0.5668 7200.0n 0.6050 7799.5n 0.6050 7800.0n 0.5755 8399.5n 0.5755 8400.0n 0.6050 8999.5n 0.6050 9000.0n 0.5762 9599.5n 0.5762 9600.0n 0.5886 10199.5n 0.5886 10200.0n 0.5194 10799.5n 0.5194 10800.0n 0.6050 11399.5n 0.6050 11400.0n 0.6050 11999.5n 0.6050 12000.0n 0.6050 12599.5n 0.6050 12600.0n 0.6050 13199.5n 0.6050 13200.0n 0.5750 13799.5n 0.5750 13800.0n 0.6050 14399.5n 0.6050)
Vyp_wih_4_1 yp_wih_4_1 0 PWL(0.0n 0.5399 599.5n 0.5399 600.0n 0.5580 1199.5n 0.5580 1200.0n 0.5446 1799.5n 0.5446 1800.0n 0.5297 2399.5n 0.5297 2400.0n 0.5221 2999.5n 0.5221 3000.0n 0.5445 3599.5n 0.5445 3600.0n 0.5308 4199.5n 0.5308 4200.0n 0.5346 4799.5n 0.5346 4800.0n 0.5567 5399.5n 0.5567 5400.0n 0.5393 5999.5n 0.5393 6000.0n 0.5470 6599.5n 0.5470 6600.0n 0.5327 7199.5n 0.5327 7200.0n 0.5637 7799.5n 0.5637 7800.0n 0.5781 8399.5n 0.5781 8400.0n 0.5997 8999.5n 0.5997 9000.0n 0.5899 9599.5n 0.5899 9600.0n 0.5938 10199.5n 0.5938 10200.0n 0.5503 10799.5n 0.5503 10800.0n 0.5461 11399.5n 0.5461 11400.0n 0.5647 11999.5n 0.5647 12000.0n 0.5966 12599.5n 0.5966 12600.0n 0.5622 13199.5n 0.5622 13200.0n 0.5901 13799.5n 0.5901 13800.0n 0.5692 14399.5n 0.5692)
Vyn_wih_4_1 yn_wih_4_1 0 PWL(0.0n 0.4601 599.5n 0.4601 600.0n 0.4420 1199.5n 0.4420 1200.0n 0.4554 1799.5n 0.4554 1800.0n 0.4703 2399.5n 0.4703 2400.0n 0.4779 2999.5n 0.4779 3000.0n 0.4555 3599.5n 0.4555 3600.0n 0.4692 4199.5n 0.4692 4200.0n 0.4654 4799.5n 0.4654 4800.0n 0.4433 5399.5n 0.4433 5400.0n 0.4607 5999.5n 0.4607 6000.0n 0.4530 6599.5n 0.4530 6600.0n 0.4673 7199.5n 0.4673 7200.0n 0.4363 7799.5n 0.4363 7800.0n 0.4219 8399.5n 0.4219 8400.0n 0.4003 8999.5n 0.4003 9000.0n 0.4101 9599.5n 0.4101 9600.0n 0.4062 10199.5n 0.4062 10200.0n 0.4497 10799.5n 0.4497 10800.0n 0.4539 11399.5n 0.4539 11400.0n 0.4353 11999.5n 0.4353 12000.0n 0.4034 12599.5n 0.4034 12600.0n 0.4378 13199.5n 0.4378 13200.0n 0.4099 13799.5n 0.4099 13800.0n 0.4308 14399.5n 0.4308)
Cwp_wih_4_1 wp_wih_4_1 0 400p
Cwn_wih_4_1 wn_wih_4_1 0 400p
Xu_wih_4_1 xp_wih_4_1 xn_wih_4_1 yp_wih_4_1 yn_wih_4_1 wp_wih_4_1 wn_wih_4_1 vdd gbn gprod
Vxp_wih_5_1 xp_wih_5_1 0 PWL(0.0n 0.5708 599.5n 0.5708 600.0n 0.5892 1199.5n 0.5892 1200.0n 0.5077 1799.5n 0.5077 1800.0n 0.5095 2399.5n 0.5095 2400.0n 0.5286 2999.5n 0.5286 3000.0n 0.5137 3599.5n 0.5137 3600.0n 0.5228 4199.5n 0.5228 4200.0n 0.6050 4799.5n 0.6050 4800.0n 0.5000 5399.5n 0.5000 5400.0n 0.6050 5999.5n 0.6050 6000.0n 0.5919 6599.5n 0.5919 6600.0n 0.5525 7199.5n 0.5525 7200.0n 0.6050 7799.5n 0.6050 7800.0n 0.5623 8399.5n 0.5623 8400.0n 0.4294 8999.5n 0.4294 9000.0n 0.5638 9599.5n 0.5638 9600.0n 0.5689 10199.5n 0.5689 10200.0n 0.6050 10799.5n 0.6050 10800.0n 0.5996 11399.5n 0.5996 11400.0n 0.5915 11999.5n 0.5915 12000.0n 0.5325 12599.5n 0.5325 12600.0n 0.5552 13199.5n 0.5552 13200.0n 0.5850 13799.5n 0.5850 13800.0n 0.5271 14399.5n 0.5271)
Vxn_wih_5_1 xn_wih_5_1 0 PWL(0.0n 0.4292 599.5n 0.4292 600.0n 0.4108 1199.5n 0.4108 1200.0n 0.4923 1799.5n 0.4923 1800.0n 0.4905 2399.5n 0.4905 2400.0n 0.4714 2999.5n 0.4714 3000.0n 0.4863 3599.5n 0.4863 3600.0n 0.4772 4199.5n 0.4772 4200.0n 0.3950 4799.5n 0.3950 4800.0n 0.5000 5399.5n 0.5000 5400.0n 0.3950 5999.5n 0.3950 6000.0n 0.4081 6599.5n 0.4081 6600.0n 0.4475 7199.5n 0.4475 7200.0n 0.3950 7799.5n 0.3950 7800.0n 0.4377 8399.5n 0.4377 8400.0n 0.5706 8999.5n 0.5706 9000.0n 0.4362 9599.5n 0.4362 9600.0n 0.4311 10199.5n 0.4311 10200.0n 0.3950 10799.5n 0.3950 10800.0n 0.4004 11399.5n 0.4004 11400.0n 0.4085 11999.5n 0.4085 12000.0n 0.4675 12599.5n 0.4675 12600.0n 0.4448 13199.5n 0.4448 13200.0n 0.4150 13799.5n 0.4150 13800.0n 0.4729 14399.5n 0.4729)
Vyp_wih_5_1 yp_wih_5_1 0 PWL(0.0n 0.5399 599.5n 0.5399 600.0n 0.5580 1199.5n 0.5580 1200.0n 0.5446 1799.5n 0.5446 1800.0n 0.5297 2399.5n 0.5297 2400.0n 0.5221 2999.5n 0.5221 3000.0n 0.5445 3599.5n 0.5445 3600.0n 0.5308 4199.5n 0.5308 4200.0n 0.5346 4799.5n 0.5346 4800.0n 0.5567 5399.5n 0.5567 5400.0n 0.5393 5999.5n 0.5393 6000.0n 0.5470 6599.5n 0.5470 6600.0n 0.5327 7199.5n 0.5327 7200.0n 0.5637 7799.5n 0.5637 7800.0n 0.5781 8399.5n 0.5781 8400.0n 0.5997 8999.5n 0.5997 9000.0n 0.5899 9599.5n 0.5899 9600.0n 0.5938 10199.5n 0.5938 10200.0n 0.5503 10799.5n 0.5503 10800.0n 0.5461 11399.5n 0.5461 11400.0n 0.5647 11999.5n 0.5647 12000.0n 0.5966 12599.5n 0.5966 12600.0n 0.5622 13199.5n 0.5622 13200.0n 0.5901 13799.5n 0.5901 13800.0n 0.5692 14399.5n 0.5692)
Vyn_wih_5_1 yn_wih_5_1 0 PWL(0.0n 0.4601 599.5n 0.4601 600.0n 0.4420 1199.5n 0.4420 1200.0n 0.4554 1799.5n 0.4554 1800.0n 0.4703 2399.5n 0.4703 2400.0n 0.4779 2999.5n 0.4779 3000.0n 0.4555 3599.5n 0.4555 3600.0n 0.4692 4199.5n 0.4692 4200.0n 0.4654 4799.5n 0.4654 4800.0n 0.4433 5399.5n 0.4433 5400.0n 0.4607 5999.5n 0.4607 6000.0n 0.4530 6599.5n 0.4530 6600.0n 0.4673 7199.5n 0.4673 7200.0n 0.4363 7799.5n 0.4363 7800.0n 0.4219 8399.5n 0.4219 8400.0n 0.4003 8999.5n 0.4003 9000.0n 0.4101 9599.5n 0.4101 9600.0n 0.4062 10199.5n 0.4062 10200.0n 0.4497 10799.5n 0.4497 10800.0n 0.4539 11399.5n 0.4539 11400.0n 0.4353 11999.5n 0.4353 12000.0n 0.4034 12599.5n 0.4034 12600.0n 0.4378 13199.5n 0.4378 13200.0n 0.4099 13799.5n 0.4099 13800.0n 0.4308 14399.5n 0.4308)
Cwp_wih_5_1 wp_wih_5_1 0 400p
Cwn_wih_5_1 wn_wih_5_1 0 400p
Xu_wih_5_1 xp_wih_5_1 xn_wih_5_1 yp_wih_5_1 yn_wih_5_1 wp_wih_5_1 wn_wih_5_1 vdd gbn gprod
Vxp_who_1_0 xp_who_1_0 0 PWL(0.0n 0.5399 599.5n 0.5399 600.0n 0.5580 1199.5n 0.5580 1200.0n 0.5446 1799.5n 0.5446 1800.0n 0.5297 2399.5n 0.5297 2400.0n 0.5221 2999.5n 0.5221 3000.0n 0.5445 3599.5n 0.5445 3600.0n 0.5308 4199.5n 0.5308 4200.0n 0.5346 4799.5n 0.5346 4800.0n 0.5567 5399.5n 0.5567 5400.0n 0.5393 5999.5n 0.5393 6000.0n 0.5470 6599.5n 0.5470 6600.0n 0.5327 7199.5n 0.5327 7200.0n 0.5637 7799.5n 0.5637 7800.0n 0.5781 8399.5n 0.5781 8400.0n 0.5997 8999.5n 0.5997 9000.0n 0.5899 9599.5n 0.5899 9600.0n 0.5938 10199.5n 0.5938 10200.0n 0.5503 10799.5n 0.5503 10800.0n 0.5461 11399.5n 0.5461 11400.0n 0.5647 11999.5n 0.5647 12000.0n 0.5966 12599.5n 0.5966 12600.0n 0.5622 13199.5n 0.5622 13200.0n 0.5901 13799.5n 0.5901 13800.0n 0.5692 14399.5n 0.5692)
Vxn_who_1_0 xn_who_1_0 0 PWL(0.0n 0.4601 599.5n 0.4601 600.0n 0.4420 1199.5n 0.4420 1200.0n 0.4554 1799.5n 0.4554 1800.0n 0.4703 2399.5n 0.4703 2400.0n 0.4779 2999.5n 0.4779 3000.0n 0.4555 3599.5n 0.4555 3600.0n 0.4692 4199.5n 0.4692 4200.0n 0.4654 4799.5n 0.4654 4800.0n 0.4433 5399.5n 0.4433 5400.0n 0.4607 5999.5n 0.4607 6000.0n 0.4530 6599.5n 0.4530 6600.0n 0.4673 7199.5n 0.4673 7200.0n 0.4363 7799.5n 0.4363 7800.0n 0.4219 8399.5n 0.4219 8400.0n 0.4003 8999.5n 0.4003 9000.0n 0.4101 9599.5n 0.4101 9600.0n 0.4062 10199.5n 0.4062 10200.0n 0.4497 10799.5n 0.4497 10800.0n 0.4539 11399.5n 0.4539 11400.0n 0.4353 11999.5n 0.4353 12000.0n 0.4034 12599.5n 0.4034 12600.0n 0.4378 13199.5n 0.4378 13200.0n 0.4099 13799.5n 0.4099 13800.0n 0.4308 14399.5n 0.4308)
Vyp_who_1_0 yp_who_1_0 0 PWL(0.0n 0.5073 599.5n 0.5073 600.0n 0.5065 1199.5n 0.5065 1200.0n 0.5065 1799.5n 0.5065 1800.0n 0.5052 2399.5n 0.5052 2400.0n 0.5058 2999.5n 0.5058 3000.0n 0.5039 3599.5n 0.5039 3600.0n 0.5059 4199.5n 0.5059 4200.0n 0.5077 4799.5n 0.5077 4800.0n 0.5054 5399.5n 0.5054 5400.0n 0.5066 5999.5n 0.5066 6000.0n 0.5083 6599.5n 0.5083 6600.0n 0.5078 7199.5n 0.5078 7200.0n 0.5043 7799.5n 0.5043 7800.0n 0.5035 8399.5n 0.5035 8400.0n 0.5035 8999.5n 0.5035 9000.0n 0.5038 9599.5n 0.5038 9600.0n 0.5043 10199.5n 0.5043 10200.0n 0.5053 10799.5n 0.5053 10800.0n 0.5050 11399.5n 0.5050 11400.0n 0.5055 11999.5n 0.5055 12000.0n 0.5043 12599.5n 0.5043 12600.0n 0.5028 13199.5n 0.5028 13200.0n 0.5045 13799.5n 0.5045 13800.0n 0.5043 14399.5n 0.5043)
Vyn_who_1_0 yn_who_1_0 0 PWL(0.0n 0.4927 599.5n 0.4927 600.0n 0.4935 1199.5n 0.4935 1200.0n 0.4935 1799.5n 0.4935 1800.0n 0.4948 2399.5n 0.4948 2400.0n 0.4942 2999.5n 0.4942 3000.0n 0.4961 3599.5n 0.4961 3600.0n 0.4941 4199.5n 0.4941 4200.0n 0.4923 4799.5n 0.4923 4800.0n 0.4946 5399.5n 0.4946 5400.0n 0.4934 5999.5n 0.4934 6000.0n 0.4917 6599.5n 0.4917 6600.0n 0.4922 7199.5n 0.4922 7200.0n 0.4957 7799.5n 0.4957 7800.0n 0.4965 8399.5n 0.4965 8400.0n 0.4965 8999.5n 0.4965 9000.0n 0.4962 9599.5n 0.4962 9600.0n 0.4957 10199.5n 0.4957 10200.0n 0.4947 10799.5n 0.4947 10800.0n 0.4950 11399.5n 0.4950 11400.0n 0.4945 11999.5n 0.4945 12000.0n 0.4957 12599.5n 0.4957 12600.0n 0.4972 13199.5n 0.4972 13200.0n 0.4955 13799.5n 0.4955 13800.0n 0.4957 14399.5n 0.4957)
Cwp_who_1_0 wp_who_1_0 0 400p
Cwn_who_1_0 wn_who_1_0 0 400p
Xu_who_1_0 xp_who_1_0 xn_who_1_0 yp_who_1_0 yn_who_1_0 wp_who_1_0 wn_who_1_0 vdd gbn gprod
Vxp_who_1_1 xp_who_1_1 0 PWL(0.0n 0.5399 599.5n 0.5399 600.0n 0.5580 1199.5n 0.5580 1200.0n 0.5446 1799.5n 0.5446 1800.0n 0.5297 2399.5n 0.5297 2400.0n 0.5221 2999.5n 0.5221 3000.0n 0.5445 3599.5n 0.5445 3600.0n 0.5308 4199.5n 0.5308 4200.0n 0.5346 4799.5n 0.5346 4800.0n 0.5567 5399.5n 0.5567 5400.0n 0.5393 5999.5n 0.5393 6000.0n 0.5470 6599.5n 0.5470 6600.0n 0.5327 7199.5n 0.5327 7200.0n 0.5637 7799.5n 0.5637 7800.0n 0.5781 8399.5n 0.5781 8400.0n 0.5997 8999.5n 0.5997 9000.0n 0.5899 9599.5n 0.5899 9600.0n 0.5938 10199.5n 0.5938 10200.0n 0.5503 10799.5n 0.5503 10800.0n 0.5461 11399.5n 0.5461 11400.0n 0.5647 11999.5n 0.5647 12000.0n 0.5966 12599.5n 0.5966 12600.0n 0.5622 13199.5n 0.5622 13200.0n 0.5901 13799.5n 0.5901 13800.0n 0.5692 14399.5n 0.5692)
Vxn_who_1_1 xn_who_1_1 0 PWL(0.0n 0.4601 599.5n 0.4601 600.0n 0.4420 1199.5n 0.4420 1200.0n 0.4554 1799.5n 0.4554 1800.0n 0.4703 2399.5n 0.4703 2400.0n 0.4779 2999.5n 0.4779 3000.0n 0.4555 3599.5n 0.4555 3600.0n 0.4692 4199.5n 0.4692 4200.0n 0.4654 4799.5n 0.4654 4800.0n 0.4433 5399.5n 0.4433 5400.0n 0.4607 5999.5n 0.4607 6000.0n 0.4530 6599.5n 0.4530 6600.0n 0.4673 7199.5n 0.4673 7200.0n 0.4363 7799.5n 0.4363 7800.0n 0.4219 8399.5n 0.4219 8400.0n 0.4003 8999.5n 0.4003 9000.0n 0.4101 9599.5n 0.4101 9600.0n 0.4062 10199.5n 0.4062 10200.0n 0.4497 10799.5n 0.4497 10800.0n 0.4539 11399.5n 0.4539 11400.0n 0.4353 11999.5n 0.4353 12000.0n 0.4034 12599.5n 0.4034 12600.0n 0.4378 13199.5n 0.4378 13200.0n 0.4099 13799.5n 0.4099 13800.0n 0.4308 14399.5n 0.4308)
Vyp_who_1_1 yp_who_1_1 0 PWL(0.0n 0.4909 599.5n 0.4909 600.0n 0.4933 1199.5n 0.4933 1200.0n 0.4930 1799.5n 0.4930 1800.0n 0.4893 2399.5n 0.4893 2400.0n 0.4904 2999.5n 0.4904 3000.0n 0.4923 3599.5n 0.4923 3600.0n 0.4897 4199.5n 0.4897 4200.0n 0.4890 4799.5n 0.4890 4800.0n 0.4921 5399.5n 0.4921 5400.0n 0.4899 5999.5n 0.4899 6000.0n 0.4870 6599.5n 0.4870 6600.0n 0.4903 7199.5n 0.4903 7200.0n 0.4970 7799.5n 0.4970 7800.0n 0.4989 8399.5n 0.4989 8400.0n 0.4994 8999.5n 0.4994 9000.0n 0.4991 9599.5n 0.4991 9600.0n 0.5000 10199.5n 0.5000 10200.0n 0.4948 10799.5n 0.4948 10800.0n 0.4959 11399.5n 0.4959 11400.0n 0.4926 11999.5n 0.4926 12000.0n 0.4993 12599.5n 0.4993 12600.0n 0.4862 13199.5n 0.4862 13200.0n 0.4993 13799.5n 0.4993 13800.0n 0.4961 14399.5n 0.4961)
Vyn_who_1_1 yn_who_1_1 0 PWL(0.0n 0.5091 599.5n 0.5091 600.0n 0.5067 1199.5n 0.5067 1200.0n 0.5070 1799.5n 0.5070 1800.0n 0.5107 2399.5n 0.5107 2400.0n 0.5096 2999.5n 0.5096 3000.0n 0.5077 3599.5n 0.5077 3600.0n 0.5103 4199.5n 0.5103 4200.0n 0.5110 4799.5n 0.5110 4800.0n 0.5079 5399.5n 0.5079 5400.0n 0.5101 5999.5n 0.5101 6000.0n 0.5130 6599.5n 0.5130 6600.0n 0.5097 7199.5n 0.5097 7200.0n 0.5030 7799.5n 0.5030 7800.0n 0.5011 8399.5n 0.5011 8400.0n 0.5006 8999.5n 0.5006 9000.0n 0.5009 9599.5n 0.5009 9600.0n 0.5000 10199.5n 0.5000 10200.0n 0.5052 10799.5n 0.5052 10800.0n 0.5041 11399.5n 0.5041 11400.0n 0.5074 11999.5n 0.5074 12000.0n 0.5007 12599.5n 0.5007 12600.0n 0.5138 13199.5n 0.5138 13200.0n 0.5007 13799.5n 0.5007 13800.0n 0.5039 14399.5n 0.5039)
Cwp_who_1_1 wp_who_1_1 0 400p
Cwn_who_1_1 wn_who_1_1 0 400p
Xu_who_1_1 xp_who_1_1 xn_who_1_1 yp_who_1_1 yn_who_1_1 wp_who_1_1 wn_who_1_1 vdd gbn gprod
Vxp_bh_1 xp_bh_1 0 PWL(0.0n 0.7100 599.5n 0.7100 600.0n 0.7100 1199.5n 0.7100 1200.0n 0.7100 1799.5n 0.7100 1800.0n 0.7100 2399.5n 0.7100 2400.0n 0.7100 2999.5n 0.7100 3000.0n 0.7100 3599.5n 0.7100 3600.0n 0.7100 4199.5n 0.7100 4200.0n 0.7100 4799.5n 0.7100 4800.0n 0.7100 5399.5n 0.7100 5400.0n 0.7100 5999.5n 0.7100 6000.0n 0.7100 6599.5n 0.7100 6600.0n 0.7100 7199.5n 0.7100 7200.0n 0.7100 7799.5n 0.7100 7800.0n 0.7100 8399.5n 0.7100 8400.0n 0.7100 8999.5n 0.7100 9000.0n 0.7100 9599.5n 0.7100 9600.0n 0.7100 10199.5n 0.7100 10200.0n 0.7100 10799.5n 0.7100 10800.0n 0.7100 11399.5n 0.7100 11400.0n 0.7100 11999.5n 0.7100 12000.0n 0.7100 12599.5n 0.7100 12600.0n 0.7100 13199.5n 0.7100 13200.0n 0.7100 13799.5n 0.7100 13800.0n 0.7100 14399.5n 0.7100)
Vxn_bh_1 xn_bh_1 0 PWL(0.0n 0.2900 599.5n 0.2900 600.0n 0.2900 1199.5n 0.2900 1200.0n 0.2900 1799.5n 0.2900 1800.0n 0.2900 2399.5n 0.2900 2400.0n 0.2900 2999.5n 0.2900 3000.0n 0.2900 3599.5n 0.2900 3600.0n 0.2900 4199.5n 0.2900 4200.0n 0.2900 4799.5n 0.2900 4800.0n 0.2900 5399.5n 0.2900 5400.0n 0.2900 5999.5n 0.2900 6000.0n 0.2900 6599.5n 0.2900 6600.0n 0.2900 7199.5n 0.2900 7200.0n 0.2900 7799.5n 0.2900 7800.0n 0.2900 8399.5n 0.2900 8400.0n 0.2900 8999.5n 0.2900 9000.0n 0.2900 9599.5n 0.2900 9600.0n 0.2900 10199.5n 0.2900 10200.0n 0.2900 10799.5n 0.2900 10800.0n 0.2900 11399.5n 0.2900 11400.0n 0.2900 11999.5n 0.2900 12000.0n 0.2900 12599.5n 0.2900 12600.0n 0.2900 13199.5n 0.2900 13200.0n 0.2900 13799.5n 0.2900 13800.0n 0.2900 14399.5n 0.2900)
Vyp_bh_1 yp_bh_1 0 PWL(0.0n 0.5399 599.5n 0.5399 600.0n 0.5580 1199.5n 0.5580 1200.0n 0.5446 1799.5n 0.5446 1800.0n 0.5297 2399.5n 0.5297 2400.0n 0.5221 2999.5n 0.5221 3000.0n 0.5445 3599.5n 0.5445 3600.0n 0.5308 4199.5n 0.5308 4200.0n 0.5346 4799.5n 0.5346 4800.0n 0.5567 5399.5n 0.5567 5400.0n 0.5393 5999.5n 0.5393 6000.0n 0.5470 6599.5n 0.5470 6600.0n 0.5327 7199.5n 0.5327 7200.0n 0.5637 7799.5n 0.5637 7800.0n 0.5781 8399.5n 0.5781 8400.0n 0.5997 8999.5n 0.5997 9000.0n 0.5899 9599.5n 0.5899 9600.0n 0.5938 10199.5n 0.5938 10200.0n 0.5503 10799.5n 0.5503 10800.0n 0.5461 11399.5n 0.5461 11400.0n 0.5647 11999.5n 0.5647 12000.0n 0.5966 12599.5n 0.5966 12600.0n 0.5622 13199.5n 0.5622 13200.0n 0.5901 13799.5n 0.5901 13800.0n 0.5692 14399.5n 0.5692)
Vyn_bh_1 yn_bh_1 0 PWL(0.0n 0.4601 599.5n 0.4601 600.0n 0.4420 1199.5n 0.4420 1200.0n 0.4554 1799.5n 0.4554 1800.0n 0.4703 2399.5n 0.4703 2400.0n 0.4779 2999.5n 0.4779 3000.0n 0.4555 3599.5n 0.4555 3600.0n 0.4692 4199.5n 0.4692 4200.0n 0.4654 4799.5n 0.4654 4800.0n 0.4433 5399.5n 0.4433 5400.0n 0.4607 5999.5n 0.4607 6000.0n 0.4530 6599.5n 0.4530 6600.0n 0.4673 7199.5n 0.4673 7200.0n 0.4363 7799.5n 0.4363 7800.0n 0.4219 8399.5n 0.4219 8400.0n 0.4003 8999.5n 0.4003 9000.0n 0.4101 9599.5n 0.4101 9600.0n 0.4062 10199.5n 0.4062 10200.0n 0.4497 10799.5n 0.4497 10800.0n 0.4539 11399.5n 0.4539 11400.0n 0.4353 11999.5n 0.4353 12000.0n 0.4034 12599.5n 0.4034 12600.0n 0.4378 13199.5n 0.4378 13200.0n 0.4099 13799.5n 0.4099 13800.0n 0.4308 14399.5n 0.4308)
Cwp_bh_1 wp_bh_1 0 400p
Cwn_bh_1 wn_bh_1 0 400p
Xu_bh_1 xp_bh_1 xn_bh_1 yp_bh_1 yn_bh_1 wp_bh_1 wn_bh_1 vdd gbn gprod
Vxp_wih_0_2 xp_wih_0_2 0 PWL(0.0n 0.3950 599.5n 0.3950 600.0n 0.3950 1199.5n 0.3950 1200.0n 0.3950 1799.5n 0.3950 1800.0n 0.3950 2399.5n 0.3950 2400.0n 0.4093 2999.5n 0.4093 3000.0n 0.3950 3599.5n 0.3950 3600.0n 0.3996 4199.5n 0.3996 4200.0n 0.3950 4799.5n 0.3950 4800.0n 0.3950 5399.5n 0.3950 5400.0n 0.3950 5999.5n 0.3950 6000.0n 0.3950 6599.5n 0.3950 6600.0n 0.3950 7199.5n 0.3950 7200.0n 0.3950 7799.5n 0.3950 7800.0n 0.3950 8399.5n 0.3950 8400.0n 0.3950 8999.5n 0.3950 9000.0n 0.3950 9599.5n 0.3950 9600.0n 0.3950 10199.5n 0.3950 10200.0n 0.3950 10799.5n 0.3950 10800.0n 0.3950 11399.5n 0.3950 11400.0n 0.3950 11999.5n 0.3950 12000.0n 0.3950 12599.5n 0.3950 12600.0n 0.3950 13199.5n 0.3950 13200.0n 0.3950 13799.5n 0.3950 13800.0n 0.3950 14399.5n 0.3950)
Vxn_wih_0_2 xn_wih_0_2 0 PWL(0.0n 0.6050 599.5n 0.6050 600.0n 0.6050 1199.5n 0.6050 1200.0n 0.6050 1799.5n 0.6050 1800.0n 0.6050 2399.5n 0.6050 2400.0n 0.5907 2999.5n 0.5907 3000.0n 0.6050 3599.5n 0.6050 3600.0n 0.6004 4199.5n 0.6004 4200.0n 0.6050 4799.5n 0.6050 4800.0n 0.6050 5399.5n 0.6050 5400.0n 0.6050 5999.5n 0.6050 6000.0n 0.6050 6599.5n 0.6050 6600.0n 0.6050 7199.5n 0.6050 7200.0n 0.6050 7799.5n 0.6050 7800.0n 0.6050 8399.5n 0.6050 8400.0n 0.6050 8999.5n 0.6050 9000.0n 0.6050 9599.5n 0.6050 9600.0n 0.6050 10199.5n 0.6050 10200.0n 0.6050 10799.5n 0.6050 10800.0n 0.6050 11399.5n 0.6050 11400.0n 0.6050 11999.5n 0.6050 12000.0n 0.6050 12599.5n 0.6050 12600.0n 0.6050 13199.5n 0.6050 13200.0n 0.6050 13799.5n 0.6050 13800.0n 0.6050 14399.5n 0.6050)
Vyp_wih_0_2 yp_wih_0_2 0 PWL(0.0n 0.4377 599.5n 0.4377 600.0n 0.4692 1199.5n 0.4692 1200.0n 0.4272 1799.5n 0.4272 1800.0n 0.4185 2399.5n 0.4185 2400.0n 0.4243 2999.5n 0.4243 3000.0n 0.4260 3599.5n 0.4260 3600.0n 0.4283 4199.5n 0.4283 4200.0n 0.4455 4799.5n 0.4455 4800.0n 0.4464 5399.5n 0.4464 5400.0n 0.4574 5999.5n 0.4574 6000.0n 0.4572 6599.5n 0.4572 6600.0n 0.4303 7199.5n 0.4303 7200.0n 0.4766 7799.5n 0.4766 7800.0n 0.4948 8399.5n 0.4948 8400.0n 0.4922 8999.5n 0.4922 9000.0n 0.5139 9599.5n 0.5139 9600.0n 0.5183 10199.5n 0.5183 10200.0n 0.4855 10799.5n 0.4855 10800.0n 0.4489 11399.5n 0.4489 11400.0n 0.4790 11999.5n 0.4790 12000.0n 0.5088 12599.5n 0.5088 12600.0n 0.4618 13199.5n 0.4618 13200.0n 0.5241 13799.5n 0.5241 13800.0n 0.4635 14399.5n 0.4635)
Vyn_wih_0_2 yn_wih_0_2 0 PWL(0.0n 0.5623 599.5n 0.5623 600.0n 0.5308 1199.5n 0.5308 1200.0n 0.5728 1799.5n 0.5728 1800.0n 0.5815 2399.5n 0.5815 2400.0n 0.5757 2999.5n 0.5757 3000.0n 0.5740 3599.5n 0.5740 3600.0n 0.5717 4199.5n 0.5717 4200.0n 0.5545 4799.5n 0.5545 4800.0n 0.5536 5399.5n 0.5536 5400.0n 0.5426 5999.5n 0.5426 6000.0n 0.5428 6599.5n 0.5428 6600.0n 0.5697 7199.5n 0.5697 7200.0n 0.5234 7799.5n 0.5234 7800.0n 0.5052 8399.5n 0.5052 8400.0n 0.5078 8999.5n 0.5078 9000.0n 0.4861 9599.5n 0.4861 9600.0n 0.4817 10199.5n 0.4817 10200.0n 0.5145 10799.5n 0.5145 10800.0n 0.5511 11399.5n 0.5511 11400.0n 0.5210 11999.5n 0.5210 12000.0n 0.4912 12599.5n 0.4912 12600.0n 0.5382 13199.5n 0.5382 13200.0n 0.4759 13799.5n 0.4759 13800.0n 0.5365 14399.5n 0.5365)
Cwp_wih_0_2 wp_wih_0_2 0 400p
Cwn_wih_0_2 wn_wih_0_2 0 400p
Xu_wih_0_2 xp_wih_0_2 xn_wih_0_2 yp_wih_0_2 yn_wih_0_2 wp_wih_0_2 wn_wih_0_2 vdd gbn gprod
Vxp_wih_1_2 xp_wih_1_2 0 PWL(0.0n 0.5903 599.5n 0.5903 600.0n 0.5456 1199.5n 0.5456 1200.0n 0.5794 1799.5n 0.5794 1800.0n 0.6050 2399.5n 0.6050 2400.0n 0.6002 2999.5n 0.6002 3000.0n 0.5822 3599.5n 0.5822 3600.0n 0.5776 4199.5n 0.5776 4200.0n 0.5867 4799.5n 0.5867 4800.0n 0.5487 5399.5n 0.5487 5400.0n 0.5654 5999.5n 0.5654 6000.0n 0.5656 6599.5n 0.5656 6600.0n 0.5907 7199.5n 0.5907 7200.0n 0.5309 7799.5n 0.5309 7800.0n 0.4409 8399.5n 0.4409 8400.0n 0.3950 8999.5n 0.3950 9000.0n 0.4115 9599.5n 0.4115 9600.0n 0.4048 10199.5n 0.4048 10200.0n 0.4883 10799.5n 0.4883 10800.0n 0.5781 11399.5n 0.5781 11400.0n 0.5169 11999.5n 0.5169 12000.0n 0.4065 12599.5n 0.4065 12600.0n 0.5303 13199.5n 0.5303 13200.0n 0.4017 13799.5n 0.4017 13800.0n 0.5102 14399.5n 0.5102)
Vxn_wih_1_2 xn_wih_1_2 0 PWL(0.0n 0.4097 599.5n 0.4097 600.0n 0.4544 1199.5n 0.4544 1200.0n 0.4206 1799.5n 0.4206 1800.0n 0.3950 2399.5n 0.3950 2400.0n 0.3998 2999.5n 0.3998 3000.0n 0.4178 3599.5n 0.4178 3600.0n 0.4224 4199.5n 0.4224 4200.0n 0.4133 4799.5n 0.4133 4800.0n 0.4513 5399.5n 0.4513 5400.0n 0.4346 5999.5n 0.4346 6000.0n 0.4344 6599.5n 0.4344 6600.0n 0.4093 7199.5n 0.4093 7200.0n 0.4691 7799.5n 0.4691 7800.0n 0.5591 8399.5n 0.5591 8400.0n 0.6050 8999.5n 0.6050 9000.0n 0.5885 9599.5n 0.5885 9600.0n 0.5952 10199.5n 0.5952 10200.0n 0.5117 10799.5n 0.5117 10800.0n 0.4219 11399.5n 0.4219 11400.0n 0.4831 11999.5n 0.4831 12000.0n 0.5935 12599.5n 0.5935 12600.0n 0.4697 13199.5n 0.4697 13200.0n 0.5983 13799.5n 0.5983 13800.0n 0.4898 14399.5n 0.4898)
Vyp_wih_1_2 yp_wih_1_2 0 PWL(0.0n 0.4377 599.5n 0.4377 600.0n 0.4692 1199.5n 0.4692 1200.0n 0.4272 1799.5n 0.4272 1800.0n 0.4185 2399.5n 0.4185 2400.0n 0.4243 2999.5n 0.4243 3000.0n 0.4260 3599.5n 0.4260 3600.0n 0.4283 4199.5n 0.4283 4200.0n 0.4455 4799.5n 0.4455 4800.0n 0.4464 5399.5n 0.4464 5400.0n 0.4574 5999.5n 0.4574 6000.0n 0.4572 6599.5n 0.4572 6600.0n 0.4303 7199.5n 0.4303 7200.0n 0.4766 7799.5n 0.4766 7800.0n 0.4948 8399.5n 0.4948 8400.0n 0.4922 8999.5n 0.4922 9000.0n 0.5139 9599.5n 0.5139 9600.0n 0.5183 10199.5n 0.5183 10200.0n 0.4855 10799.5n 0.4855 10800.0n 0.4489 11399.5n 0.4489 11400.0n 0.4790 11999.5n 0.4790 12000.0n 0.5088 12599.5n 0.5088 12600.0n 0.4618 13199.5n 0.4618 13200.0n 0.5241 13799.5n 0.5241 13800.0n 0.4635 14399.5n 0.4635)
Vyn_wih_1_2 yn_wih_1_2 0 PWL(0.0n 0.5623 599.5n 0.5623 600.0n 0.5308 1199.5n 0.5308 1200.0n 0.5728 1799.5n 0.5728 1800.0n 0.5815 2399.5n 0.5815 2400.0n 0.5757 2999.5n 0.5757 3000.0n 0.5740 3599.5n 0.5740 3600.0n 0.5717 4199.5n 0.5717 4200.0n 0.5545 4799.5n 0.5545 4800.0n 0.5536 5399.5n 0.5536 5400.0n 0.5426 5999.5n 0.5426 6000.0n 0.5428 6599.5n 0.5428 6600.0n 0.5697 7199.5n 0.5697 7200.0n 0.5234 7799.5n 0.5234 7800.0n 0.5052 8399.5n 0.5052 8400.0n 0.5078 8999.5n 0.5078 9000.0n 0.4861 9599.5n 0.4861 9600.0n 0.4817 10199.5n 0.4817 10200.0n 0.5145 10799.5n 0.5145 10800.0n 0.5511 11399.5n 0.5511 11400.0n 0.5210 11999.5n 0.5210 12000.0n 0.4912 12599.5n 0.4912 12600.0n 0.5382 13199.5n 0.5382 13200.0n 0.4759 13799.5n 0.4759 13800.0n 0.5365 14399.5n 0.5365)
Cwp_wih_1_2 wp_wih_1_2 0 400p
Cwn_wih_1_2 wn_wih_1_2 0 400p
Xu_wih_1_2 xp_wih_1_2 xn_wih_1_2 yp_wih_1_2 yn_wih_1_2 wp_wih_1_2 wn_wih_1_2 vdd gbn gprod
Vxp_wih_4_2 xp_wih_4_2 0 PWL(0.0n 0.4097 599.5n 0.4097 600.0n 0.4029 1199.5n 0.4029 1200.0n 0.4104 1799.5n 0.4104 1800.0n 0.4380 2399.5n 0.4380 2400.0n 0.4570 2999.5n 0.4570 3000.0n 0.4087 3599.5n 0.4087 3600.0n 0.4498 4199.5n 0.4498 4200.0n 0.4270 4799.5n 0.4270 4800.0n 0.4175 5399.5n 0.4175 5400.0n 0.4386 5999.5n 0.4386 6000.0n 0.4125 6599.5n 0.4125 6600.0n 0.4332 7199.5n 0.4332 7200.0n 0.3950 7799.5n 0.3950 7800.0n 0.4245 8399.5n 0.4245 8400.0n 0.3950 8999.5n 0.3950 9000.0n 0.4238 9599.5n 0.4238 9600.0n 0.4114 10199.5n 0.4114 10200.0n 0.4806 10799.5n 0.4806 10800.0n 0.3950 11399.5n 0.3950 11400.0n 0.3950 11999.5n 0.3950 12000.0n 0.3950 12599.5n 0.3950 12600.0n 0.3950 13199.5n 0.3950 13200.0n 0.4250 13799.5n 0.4250 13800.0n 0.3950 14399.5n 0.3950)
Vxn_wih_4_2 xn_wih_4_2 0 PWL(0.0n 0.5903 599.5n 0.5903 600.0n 0.5971 1199.5n 0.5971 1200.0n 0.5896 1799.5n 0.5896 1800.0n 0.5620 2399.5n 0.5620 2400.0n 0.5430 2999.5n 0.5430 3000.0n 0.5913 3599.5n 0.5913 3600.0n 0.5502 4199.5n 0.5502 4200.0n 0.5730 4799.5n 0.5730 4800.0n 0.5825 5399.5n 0.5825 5400.0n 0.5614 5999.5n 0.5614 6000.0n 0.5875 6599.5n 0.5875 6600.0n 0.5668 7199.5n 0.5668 7200.0n 0.6050 7799.5n 0.6050 7800.0n 0.5755 8399.5n 0.5755 8400.0n 0.6050 8999.5n 0.6050 9000.0n 0.5762 9599.5n 0.5762 9600.0n 0.5886 10199.5n 0.5886 10200.0n 0.5194 10799.5n 0.5194 10800.0n 0.6050 11399.5n 0.6050 11400.0n 0.6050 11999.5n 0.6050 12000.0n 0.6050 12599.5n 0.6050 12600.0n 0.6050 13199.5n 0.6050 13200.0n 0.5750 13799.5n 0.5750 13800.0n 0.6050 14399.5n 0.6050)
Vyp_wih_4_2 yp_wih_4_2 0 PWL(0.0n 0.4377 599.5n 0.4377 600.0n 0.4692 1199.5n 0.4692 1200.0n 0.4272 1799.5n 0.4272 1800.0n 0.4185 2399.5n 0.4185 2400.0n 0.4243 2999.5n 0.4243 3000.0n 0.4260 3599.5n 0.4260 3600.0n 0.4283 4199.5n 0.4283 4200.0n 0.4455 4799.5n 0.4455 4800.0n 0.4464 5399.5n 0.4464 5400.0n 0.4574 5999.5n 0.4574 6000.0n 0.4572 6599.5n 0.4572 6600.0n 0.4303 7199.5n 0.4303 7200.0n 0.4766 7799.5n 0.4766 7800.0n 0.4948 8399.5n 0.4948 8400.0n 0.4922 8999.5n 0.4922 9000.0n 0.5139 9599.5n 0.5139 9600.0n 0.5183 10199.5n 0.5183 10200.0n 0.4855 10799.5n 0.4855 10800.0n 0.4489 11399.5n 0.4489 11400.0n 0.4790 11999.5n 0.4790 12000.0n 0.5088 12599.5n 0.5088 12600.0n 0.4618 13199.5n 0.4618 13200.0n 0.5241 13799.5n 0.5241 13800.0n 0.4635 14399.5n 0.4635)
Vyn_wih_4_2 yn_wih_4_2 0 PWL(0.0n 0.5623 599.5n 0.5623 600.0n 0.5308 1199.5n 0.5308 1200.0n 0.5728 1799.5n 0.5728 1800.0n 0.5815 2399.5n 0.5815 2400.0n 0.5757 2999.5n 0.5757 3000.0n 0.5740 3599.5n 0.5740 3600.0n 0.5717 4199.5n 0.5717 4200.0n 0.5545 4799.5n 0.5545 4800.0n 0.5536 5399.5n 0.5536 5400.0n 0.5426 5999.5n 0.5426 6000.0n 0.5428 6599.5n 0.5428 6600.0n 0.5697 7199.5n 0.5697 7200.0n 0.5234 7799.5n 0.5234 7800.0n 0.5052 8399.5n 0.5052 8400.0n 0.5078 8999.5n 0.5078 9000.0n 0.4861 9599.5n 0.4861 9600.0n 0.4817 10199.5n 0.4817 10200.0n 0.5145 10799.5n 0.5145 10800.0n 0.5511 11399.5n 0.5511 11400.0n 0.5210 11999.5n 0.5210 12000.0n 0.4912 12599.5n 0.4912 12600.0n 0.5382 13199.5n 0.5382 13200.0n 0.4759 13799.5n 0.4759 13800.0n 0.5365 14399.5n 0.5365)
Cwp_wih_4_2 wp_wih_4_2 0 400p
Cwn_wih_4_2 wn_wih_4_2 0 400p
Xu_wih_4_2 xp_wih_4_2 xn_wih_4_2 yp_wih_4_2 yn_wih_4_2 wp_wih_4_2 wn_wih_4_2 vdd gbn gprod
Vxp_wih_5_2 xp_wih_5_2 0 PWL(0.0n 0.5708 599.5n 0.5708 600.0n 0.5892 1199.5n 0.5892 1200.0n 0.5077 1799.5n 0.5077 1800.0n 0.5095 2399.5n 0.5095 2400.0n 0.5286 2999.5n 0.5286 3000.0n 0.5137 3599.5n 0.5137 3600.0n 0.5228 4199.5n 0.5228 4200.0n 0.6050 4799.5n 0.6050 4800.0n 0.5000 5399.5n 0.5000 5400.0n 0.6050 5999.5n 0.6050 6000.0n 0.5919 6599.5n 0.5919 6600.0n 0.5525 7199.5n 0.5525 7200.0n 0.6050 7799.5n 0.6050 7800.0n 0.5623 8399.5n 0.5623 8400.0n 0.4294 8999.5n 0.4294 9000.0n 0.5638 9599.5n 0.5638 9600.0n 0.5689 10199.5n 0.5689 10200.0n 0.6050 10799.5n 0.6050 10800.0n 0.5996 11399.5n 0.5996 11400.0n 0.5915 11999.5n 0.5915 12000.0n 0.5325 12599.5n 0.5325 12600.0n 0.5552 13199.5n 0.5552 13200.0n 0.5850 13799.5n 0.5850 13800.0n 0.5271 14399.5n 0.5271)
Vxn_wih_5_2 xn_wih_5_2 0 PWL(0.0n 0.4292 599.5n 0.4292 600.0n 0.4108 1199.5n 0.4108 1200.0n 0.4923 1799.5n 0.4923 1800.0n 0.4905 2399.5n 0.4905 2400.0n 0.4714 2999.5n 0.4714 3000.0n 0.4863 3599.5n 0.4863 3600.0n 0.4772 4199.5n 0.4772 4200.0n 0.3950 4799.5n 0.3950 4800.0n 0.5000 5399.5n 0.5000 5400.0n 0.3950 5999.5n 0.3950 6000.0n 0.4081 6599.5n 0.4081 6600.0n 0.4475 7199.5n 0.4475 7200.0n 0.3950 7799.5n 0.3950 7800.0n 0.4377 8399.5n 0.4377 8400.0n 0.5706 8999.5n 0.5706 9000.0n 0.4362 9599.5n 0.4362 9600.0n 0.4311 10199.5n 0.4311 10200.0n 0.3950 10799.5n 0.3950 10800.0n 0.4004 11399.5n 0.4004 11400.0n 0.4085 11999.5n 0.4085 12000.0n 0.4675 12599.5n 0.4675 12600.0n 0.4448 13199.5n 0.4448 13200.0n 0.4150 13799.5n 0.4150 13800.0n 0.4729 14399.5n 0.4729)
Vyp_wih_5_2 yp_wih_5_2 0 PWL(0.0n 0.4377 599.5n 0.4377 600.0n 0.4692 1199.5n 0.4692 1200.0n 0.4272 1799.5n 0.4272 1800.0n 0.4185 2399.5n 0.4185 2400.0n 0.4243 2999.5n 0.4243 3000.0n 0.4260 3599.5n 0.4260 3600.0n 0.4283 4199.5n 0.4283 4200.0n 0.4455 4799.5n 0.4455 4800.0n 0.4464 5399.5n 0.4464 5400.0n 0.4574 5999.5n 0.4574 6000.0n 0.4572 6599.5n 0.4572 6600.0n 0.4303 7199.5n 0.4303 7200.0n 0.4766 7799.5n 0.4766 7800.0n 0.4948 8399.5n 0.4948 8400.0n 0.4922 8999.5n 0.4922 9000.0n 0.5139 9599.5n 0.5139 9600.0n 0.5183 10199.5n 0.5183 10200.0n 0.4855 10799.5n 0.4855 10800.0n 0.4489 11399.5n 0.4489 11400.0n 0.4790 11999.5n 0.4790 12000.0n 0.5088 12599.5n 0.5088 12600.0n 0.4618 13199.5n 0.4618 13200.0n 0.5241 13799.5n 0.5241 13800.0n 0.4635 14399.5n 0.4635)
Vyn_wih_5_2 yn_wih_5_2 0 PWL(0.0n 0.5623 599.5n 0.5623 600.0n 0.5308 1199.5n 0.5308 1200.0n 0.5728 1799.5n 0.5728 1800.0n 0.5815 2399.5n 0.5815 2400.0n 0.5757 2999.5n 0.5757 3000.0n 0.5740 3599.5n 0.5740 3600.0n 0.5717 4199.5n 0.5717 4200.0n 0.5545 4799.5n 0.5545 4800.0n 0.5536 5399.5n 0.5536 5400.0n 0.5426 5999.5n 0.5426 6000.0n 0.5428 6599.5n 0.5428 6600.0n 0.5697 7199.5n 0.5697 7200.0n 0.5234 7799.5n 0.5234 7800.0n 0.5052 8399.5n 0.5052 8400.0n 0.5078 8999.5n 0.5078 9000.0n 0.4861 9599.5n 0.4861 9600.0n 0.4817 10199.5n 0.4817 10200.0n 0.5145 10799.5n 0.5145 10800.0n 0.5511 11399.5n 0.5511 11400.0n 0.5210 11999.5n 0.5210 12000.0n 0.4912 12599.5n 0.4912 12600.0n 0.5382 13199.5n 0.5382 13200.0n 0.4759 13799.5n 0.4759 13800.0n 0.5365 14399.5n 0.5365)
Cwp_wih_5_2 wp_wih_5_2 0 400p
Cwn_wih_5_2 wn_wih_5_2 0 400p
Xu_wih_5_2 xp_wih_5_2 xn_wih_5_2 yp_wih_5_2 yn_wih_5_2 wp_wih_5_2 wn_wih_5_2 vdd gbn gprod
Vxp_who_2_0 xp_who_2_0 0 PWL(0.0n 0.4377 599.5n 0.4377 600.0n 0.4692 1199.5n 0.4692 1200.0n 0.4272 1799.5n 0.4272 1800.0n 0.4185 2399.5n 0.4185 2400.0n 0.4243 2999.5n 0.4243 3000.0n 0.4260 3599.5n 0.4260 3600.0n 0.4283 4199.5n 0.4283 4200.0n 0.4455 4799.5n 0.4455 4800.0n 0.4464 5399.5n 0.4464 5400.0n 0.4574 5999.5n 0.4574 6000.0n 0.4572 6599.5n 0.4572 6600.0n 0.4303 7199.5n 0.4303 7200.0n 0.4766 7799.5n 0.4766 7800.0n 0.4948 8399.5n 0.4948 8400.0n 0.4922 8999.5n 0.4922 9000.0n 0.5139 9599.5n 0.5139 9600.0n 0.5183 10199.5n 0.5183 10200.0n 0.4855 10799.5n 0.4855 10800.0n 0.4489 11399.5n 0.4489 11400.0n 0.4790 11999.5n 0.4790 12000.0n 0.5088 12599.5n 0.5088 12600.0n 0.4618 13199.5n 0.4618 13200.0n 0.5241 13799.5n 0.5241 13800.0n 0.4635 14399.5n 0.4635)
Vxn_who_2_0 xn_who_2_0 0 PWL(0.0n 0.5623 599.5n 0.5623 600.0n 0.5308 1199.5n 0.5308 1200.0n 0.5728 1799.5n 0.5728 1800.0n 0.5815 2399.5n 0.5815 2400.0n 0.5757 2999.5n 0.5757 3000.0n 0.5740 3599.5n 0.5740 3600.0n 0.5717 4199.5n 0.5717 4200.0n 0.5545 4799.5n 0.5545 4800.0n 0.5536 5399.5n 0.5536 5400.0n 0.5426 5999.5n 0.5426 6000.0n 0.5428 6599.5n 0.5428 6600.0n 0.5697 7199.5n 0.5697 7200.0n 0.5234 7799.5n 0.5234 7800.0n 0.5052 8399.5n 0.5052 8400.0n 0.5078 8999.5n 0.5078 9000.0n 0.4861 9599.5n 0.4861 9600.0n 0.4817 10199.5n 0.4817 10200.0n 0.5145 10799.5n 0.5145 10800.0n 0.5511 11399.5n 0.5511 11400.0n 0.5210 11999.5n 0.5210 12000.0n 0.4912 12599.5n 0.4912 12600.0n 0.5382 13199.5n 0.5382 13200.0n 0.4759 13799.5n 0.4759 13800.0n 0.5365 14399.5n 0.5365)
Vyp_who_2_0 yp_who_2_0 0 PWL(0.0n 0.5073 599.5n 0.5073 600.0n 0.5065 1199.5n 0.5065 1200.0n 0.5065 1799.5n 0.5065 1800.0n 0.5052 2399.5n 0.5052 2400.0n 0.5058 2999.5n 0.5058 3000.0n 0.5039 3599.5n 0.5039 3600.0n 0.5059 4199.5n 0.5059 4200.0n 0.5077 4799.5n 0.5077 4800.0n 0.5054 5399.5n 0.5054 5400.0n 0.5066 5999.5n 0.5066 6000.0n 0.5083 6599.5n 0.5083 6600.0n 0.5078 7199.5n 0.5078 7200.0n 0.5043 7799.5n 0.5043 7800.0n 0.5035 8399.5n 0.5035 8400.0n 0.5035 8999.5n 0.5035 9000.0n 0.5038 9599.5n 0.5038 9600.0n 0.5043 10199.5n 0.5043 10200.0n 0.5053 10799.5n 0.5053 10800.0n 0.5050 11399.5n 0.5050 11400.0n 0.5055 11999.5n 0.5055 12000.0n 0.5043 12599.5n 0.5043 12600.0n 0.5028 13199.5n 0.5028 13200.0n 0.5045 13799.5n 0.5045 13800.0n 0.5043 14399.5n 0.5043)
Vyn_who_2_0 yn_who_2_0 0 PWL(0.0n 0.4927 599.5n 0.4927 600.0n 0.4935 1199.5n 0.4935 1200.0n 0.4935 1799.5n 0.4935 1800.0n 0.4948 2399.5n 0.4948 2400.0n 0.4942 2999.5n 0.4942 3000.0n 0.4961 3599.5n 0.4961 3600.0n 0.4941 4199.5n 0.4941 4200.0n 0.4923 4799.5n 0.4923 4800.0n 0.4946 5399.5n 0.4946 5400.0n 0.4934 5999.5n 0.4934 6000.0n 0.4917 6599.5n 0.4917 6600.0n 0.4922 7199.5n 0.4922 7200.0n 0.4957 7799.5n 0.4957 7800.0n 0.4965 8399.5n 0.4965 8400.0n 0.4965 8999.5n 0.4965 9000.0n 0.4962 9599.5n 0.4962 9600.0n 0.4957 10199.5n 0.4957 10200.0n 0.4947 10799.5n 0.4947 10800.0n 0.4950 11399.5n 0.4950 11400.0n 0.4945 11999.5n 0.4945 12000.0n 0.4957 12599.5n 0.4957 12600.0n 0.4972 13199.5n 0.4972 13200.0n 0.4955 13799.5n 0.4955 13800.0n 0.4957 14399.5n 0.4957)
Cwp_who_2_0 wp_who_2_0 0 400p
Cwn_who_2_0 wn_who_2_0 0 400p
Xu_who_2_0 xp_who_2_0 xn_who_2_0 yp_who_2_0 yn_who_2_0 wp_who_2_0 wn_who_2_0 vdd gbn gprod
Vxp_who_2_1 xp_who_2_1 0 PWL(0.0n 0.4377 599.5n 0.4377 600.0n 0.4692 1199.5n 0.4692 1200.0n 0.4272 1799.5n 0.4272 1800.0n 0.4185 2399.5n 0.4185 2400.0n 0.4243 2999.5n 0.4243 3000.0n 0.4260 3599.5n 0.4260 3600.0n 0.4283 4199.5n 0.4283 4200.0n 0.4455 4799.5n 0.4455 4800.0n 0.4464 5399.5n 0.4464 5400.0n 0.4574 5999.5n 0.4574 6000.0n 0.4572 6599.5n 0.4572 6600.0n 0.4303 7199.5n 0.4303 7200.0n 0.4766 7799.5n 0.4766 7800.0n 0.4948 8399.5n 0.4948 8400.0n 0.4922 8999.5n 0.4922 9000.0n 0.5139 9599.5n 0.5139 9600.0n 0.5183 10199.5n 0.5183 10200.0n 0.4855 10799.5n 0.4855 10800.0n 0.4489 11399.5n 0.4489 11400.0n 0.4790 11999.5n 0.4790 12000.0n 0.5088 12599.5n 0.5088 12600.0n 0.4618 13199.5n 0.4618 13200.0n 0.5241 13799.5n 0.5241 13800.0n 0.4635 14399.5n 0.4635)
Vxn_who_2_1 xn_who_2_1 0 PWL(0.0n 0.5623 599.5n 0.5623 600.0n 0.5308 1199.5n 0.5308 1200.0n 0.5728 1799.5n 0.5728 1800.0n 0.5815 2399.5n 0.5815 2400.0n 0.5757 2999.5n 0.5757 3000.0n 0.5740 3599.5n 0.5740 3600.0n 0.5717 4199.5n 0.5717 4200.0n 0.5545 4799.5n 0.5545 4800.0n 0.5536 5399.5n 0.5536 5400.0n 0.5426 5999.5n 0.5426 6000.0n 0.5428 6599.5n 0.5428 6600.0n 0.5697 7199.5n 0.5697 7200.0n 0.5234 7799.5n 0.5234 7800.0n 0.5052 8399.5n 0.5052 8400.0n 0.5078 8999.5n 0.5078 9000.0n 0.4861 9599.5n 0.4861 9600.0n 0.4817 10199.5n 0.4817 10200.0n 0.5145 10799.5n 0.5145 10800.0n 0.5511 11399.5n 0.5511 11400.0n 0.5210 11999.5n 0.5210 12000.0n 0.4912 12599.5n 0.4912 12600.0n 0.5382 13199.5n 0.5382 13200.0n 0.4759 13799.5n 0.4759 13800.0n 0.5365 14399.5n 0.5365)
Vyp_who_2_1 yp_who_2_1 0 PWL(0.0n 0.4909 599.5n 0.4909 600.0n 0.4933 1199.5n 0.4933 1200.0n 0.4930 1799.5n 0.4930 1800.0n 0.4893 2399.5n 0.4893 2400.0n 0.4904 2999.5n 0.4904 3000.0n 0.4923 3599.5n 0.4923 3600.0n 0.4897 4199.5n 0.4897 4200.0n 0.4890 4799.5n 0.4890 4800.0n 0.4921 5399.5n 0.4921 5400.0n 0.4899 5999.5n 0.4899 6000.0n 0.4870 6599.5n 0.4870 6600.0n 0.4903 7199.5n 0.4903 7200.0n 0.4970 7799.5n 0.4970 7800.0n 0.4989 8399.5n 0.4989 8400.0n 0.4994 8999.5n 0.4994 9000.0n 0.4991 9599.5n 0.4991 9600.0n 0.5000 10199.5n 0.5000 10200.0n 0.4948 10799.5n 0.4948 10800.0n 0.4959 11399.5n 0.4959 11400.0n 0.4926 11999.5n 0.4926 12000.0n 0.4993 12599.5n 0.4993 12600.0n 0.4862 13199.5n 0.4862 13200.0n 0.4993 13799.5n 0.4993 13800.0n 0.4961 14399.5n 0.4961)
Vyn_who_2_1 yn_who_2_1 0 PWL(0.0n 0.5091 599.5n 0.5091 600.0n 0.5067 1199.5n 0.5067 1200.0n 0.5070 1799.5n 0.5070 1800.0n 0.5107 2399.5n 0.5107 2400.0n 0.5096 2999.5n 0.5096 3000.0n 0.5077 3599.5n 0.5077 3600.0n 0.5103 4199.5n 0.5103 4200.0n 0.5110 4799.5n 0.5110 4800.0n 0.5079 5399.5n 0.5079 5400.0n 0.5101 5999.5n 0.5101 6000.0n 0.5130 6599.5n 0.5130 6600.0n 0.5097 7199.5n 0.5097 7200.0n 0.5030 7799.5n 0.5030 7800.0n 0.5011 8399.5n 0.5011 8400.0n 0.5006 8999.5n 0.5006 9000.0n 0.5009 9599.5n 0.5009 9600.0n 0.5000 10199.5n 0.5000 10200.0n 0.5052 10799.5n 0.5052 10800.0n 0.5041 11399.5n 0.5041 11400.0n 0.5074 11999.5n 0.5074 12000.0n 0.5007 12599.5n 0.5007 12600.0n 0.5138 13199.5n 0.5138 13200.0n 0.5007 13799.5n 0.5007 13800.0n 0.5039 14399.5n 0.5039)
Cwp_who_2_1 wp_who_2_1 0 400p
Cwn_who_2_1 wn_who_2_1 0 400p
Xu_who_2_1 xp_who_2_1 xn_who_2_1 yp_who_2_1 yn_who_2_1 wp_who_2_1 wn_who_2_1 vdd gbn gprod
Vxp_bh_2 xp_bh_2 0 PWL(0.0n 0.7100 599.5n 0.7100 600.0n 0.7100 1199.5n 0.7100 1200.0n 0.7100 1799.5n 0.7100 1800.0n 0.7100 2399.5n 0.7100 2400.0n 0.7100 2999.5n 0.7100 3000.0n 0.7100 3599.5n 0.7100 3600.0n 0.7100 4199.5n 0.7100 4200.0n 0.7100 4799.5n 0.7100 4800.0n 0.7100 5399.5n 0.7100 5400.0n 0.7100 5999.5n 0.7100 6000.0n 0.7100 6599.5n 0.7100 6600.0n 0.7100 7199.5n 0.7100 7200.0n 0.7100 7799.5n 0.7100 7800.0n 0.7100 8399.5n 0.7100 8400.0n 0.7100 8999.5n 0.7100 9000.0n 0.7100 9599.5n 0.7100 9600.0n 0.7100 10199.5n 0.7100 10200.0n 0.7100 10799.5n 0.7100 10800.0n 0.7100 11399.5n 0.7100 11400.0n 0.7100 11999.5n 0.7100 12000.0n 0.7100 12599.5n 0.7100 12600.0n 0.7100 13199.5n 0.7100 13200.0n 0.7100 13799.5n 0.7100 13800.0n 0.7100 14399.5n 0.7100)
Vxn_bh_2 xn_bh_2 0 PWL(0.0n 0.2900 599.5n 0.2900 600.0n 0.2900 1199.5n 0.2900 1200.0n 0.2900 1799.5n 0.2900 1800.0n 0.2900 2399.5n 0.2900 2400.0n 0.2900 2999.5n 0.2900 3000.0n 0.2900 3599.5n 0.2900 3600.0n 0.2900 4199.5n 0.2900 4200.0n 0.2900 4799.5n 0.2900 4800.0n 0.2900 5399.5n 0.2900 5400.0n 0.2900 5999.5n 0.2900 6000.0n 0.2900 6599.5n 0.2900 6600.0n 0.2900 7199.5n 0.2900 7200.0n 0.2900 7799.5n 0.2900 7800.0n 0.2900 8399.5n 0.2900 8400.0n 0.2900 8999.5n 0.2900 9000.0n 0.2900 9599.5n 0.2900 9600.0n 0.2900 10199.5n 0.2900 10200.0n 0.2900 10799.5n 0.2900 10800.0n 0.2900 11399.5n 0.2900 11400.0n 0.2900 11999.5n 0.2900 12000.0n 0.2900 12599.5n 0.2900 12600.0n 0.2900 13199.5n 0.2900 13200.0n 0.2900 13799.5n 0.2900 13800.0n 0.2900 14399.5n 0.2900)
Vyp_bh_2 yp_bh_2 0 PWL(0.0n 0.4377 599.5n 0.4377 600.0n 0.4692 1199.5n 0.4692 1200.0n 0.4272 1799.5n 0.4272 1800.0n 0.4185 2399.5n 0.4185 2400.0n 0.4243 2999.5n 0.4243 3000.0n 0.4260 3599.5n 0.4260 3600.0n 0.4283 4199.5n 0.4283 4200.0n 0.4455 4799.5n 0.4455 4800.0n 0.4464 5399.5n 0.4464 5400.0n 0.4574 5999.5n 0.4574 6000.0n 0.4572 6599.5n 0.4572 6600.0n 0.4303 7199.5n 0.4303 7200.0n 0.4766 7799.5n 0.4766 7800.0n 0.4948 8399.5n 0.4948 8400.0n 0.4922 8999.5n 0.4922 9000.0n 0.5139 9599.5n 0.5139 9600.0n 0.5183 10199.5n 0.5183 10200.0n 0.4855 10799.5n 0.4855 10800.0n 0.4489 11399.5n 0.4489 11400.0n 0.4790 11999.5n 0.4790 12000.0n 0.5088 12599.5n 0.5088 12600.0n 0.4618 13199.5n 0.4618 13200.0n 0.5241 13799.5n 0.5241 13800.0n 0.4635 14399.5n 0.4635)
Vyn_bh_2 yn_bh_2 0 PWL(0.0n 0.5623 599.5n 0.5623 600.0n 0.5308 1199.5n 0.5308 1200.0n 0.5728 1799.5n 0.5728 1800.0n 0.5815 2399.5n 0.5815 2400.0n 0.5757 2999.5n 0.5757 3000.0n 0.5740 3599.5n 0.5740 3600.0n 0.5717 4199.5n 0.5717 4200.0n 0.5545 4799.5n 0.5545 4800.0n 0.5536 5399.5n 0.5536 5400.0n 0.5426 5999.5n 0.5426 6000.0n 0.5428 6599.5n 0.5428 6600.0n 0.5697 7199.5n 0.5697 7200.0n 0.5234 7799.5n 0.5234 7800.0n 0.5052 8399.5n 0.5052 8400.0n 0.5078 8999.5n 0.5078 9000.0n 0.4861 9599.5n 0.4861 9600.0n 0.4817 10199.5n 0.4817 10200.0n 0.5145 10799.5n 0.5145 10800.0n 0.5511 11399.5n 0.5511 11400.0n 0.5210 11999.5n 0.5210 12000.0n 0.4912 12599.5n 0.4912 12600.0n 0.5382 13199.5n 0.5382 13200.0n 0.4759 13799.5n 0.4759 13800.0n 0.5365 14399.5n 0.5365)
Cwp_bh_2 wp_bh_2 0 400p
Cwn_bh_2 wn_bh_2 0 400p
Xu_bh_2 xp_bh_2 xn_bh_2 yp_bh_2 yn_bh_2 wp_bh_2 wn_bh_2 vdd gbn gprod
Vxp_wih_0_3 xp_wih_0_3 0 PWL(0.0n 0.3950 599.5n 0.3950 600.0n 0.3950 1199.5n 0.3950 1200.0n 0.3950 1799.5n 0.3950 1800.0n 0.3950 2399.5n 0.3950 2400.0n 0.4093 2999.5n 0.4093 3000.0n 0.3950 3599.5n 0.3950 3600.0n 0.3996 4199.5n 0.3996 4200.0n 0.3950 4799.5n 0.3950 4800.0n 0.3950 5399.5n 0.3950 5400.0n 0.3950 5999.5n 0.3950 6000.0n 0.3950 6599.5n 0.3950 6600.0n 0.3950 7199.5n 0.3950 7200.0n 0.3950 7799.5n 0.3950 7800.0n 0.3950 8399.5n 0.3950 8400.0n 0.3950 8999.5n 0.3950 9000.0n 0.3950 9599.5n 0.3950 9600.0n 0.3950 10199.5n 0.3950 10200.0n 0.3950 10799.5n 0.3950 10800.0n 0.3950 11399.5n 0.3950 11400.0n 0.3950 11999.5n 0.3950 12000.0n 0.3950 12599.5n 0.3950 12600.0n 0.3950 13199.5n 0.3950 13200.0n 0.3950 13799.5n 0.3950 13800.0n 0.3950 14399.5n 0.3950)
Vxn_wih_0_3 xn_wih_0_3 0 PWL(0.0n 0.6050 599.5n 0.6050 600.0n 0.6050 1199.5n 0.6050 1200.0n 0.6050 1799.5n 0.6050 1800.0n 0.6050 2399.5n 0.6050 2400.0n 0.5907 2999.5n 0.5907 3000.0n 0.6050 3599.5n 0.6050 3600.0n 0.6004 4199.5n 0.6004 4200.0n 0.6050 4799.5n 0.6050 4800.0n 0.6050 5399.5n 0.6050 5400.0n 0.6050 5999.5n 0.6050 6000.0n 0.6050 6599.5n 0.6050 6600.0n 0.6050 7199.5n 0.6050 7200.0n 0.6050 7799.5n 0.6050 7800.0n 0.6050 8399.5n 0.6050 8400.0n 0.6050 8999.5n 0.6050 9000.0n 0.6050 9599.5n 0.6050 9600.0n 0.6050 10199.5n 0.6050 10200.0n 0.6050 10799.5n 0.6050 10800.0n 0.6050 11399.5n 0.6050 11400.0n 0.6050 11999.5n 0.6050 12000.0n 0.6050 12599.5n 0.6050 12600.0n 0.6050 13199.5n 0.6050 13200.0n 0.6050 13799.5n 0.6050 13800.0n 0.6050 14399.5n 0.6050)
Vyp_wih_0_3 yp_wih_0_3 0 PWL(0.0n 0.6512 599.5n 0.6512 600.0n 0.6686 1199.5n 0.6686 1200.0n 0.5608 1799.5n 0.5608 1800.0n 0.5256 2399.5n 0.5256 2400.0n 0.5393 2999.5n 0.5393 3000.0n 0.5649 3599.5n 0.5649 3600.0n 0.5476 4199.5n 0.5476 4200.0n 0.6598 4799.5n 0.6598 4800.0n 0.5843 5399.5n 0.5843 5400.0n 0.6609 5999.5n 0.6609 6000.0n 0.6640 6599.5n 0.6640 6600.0n 0.6123 7199.5n 0.6123 7200.0n 0.6730 7799.5n 0.6730 7800.0n 0.6726 8399.5n 0.6726 8400.0n 0.5965 8999.5n 0.5965 9000.0n 0.6777 9599.5n 0.6777 9600.0n 0.6804 10199.5n 0.6804 10200.0n 0.6666 10799.5n 0.6666 10800.0n 0.6637 11399.5n 0.6637 11400.0n 0.6727 11999.5n 0.6727 12000.0n 0.6717 12599.5n 0.6717 12600.0n 0.6606 13199.5n 0.6606 13200.0n 0.6824 13799.5n 0.6824 13800.0n 0.6496 14399.5n 0.6496)
Vyn_wih_0_3 yn_wih_0_3 0 PWL(0.0n 0.3488 599.5n 0.3488 600.0n 0.3314 1199.5n 0.3314 1200.0n 0.4392 1799.5n 0.4392 1800.0n 0.4744 2399.5n 0.4744 2400.0n 0.4607 2999.5n 0.4607 3000.0n 0.4351 3599.5n 0.4351 3600.0n 0.4524 4199.5n 0.4524 4200.0n 0.3402 4799.5n 0.3402 4800.0n 0.4157 5399.5n 0.4157 5400.0n 0.3391 5999.5n 0.3391 6000.0n 0.3360 6599.5n 0.3360 6600.0n 0.3877 7199.5n 0.3877 7200.0n 0.3270 7799.5n 0.3270 7800.0n 0.3274 8399.5n 0.3274 8400.0n 0.4035 8999.5n 0.4035 9000.0n 0.3223 9599.5n 0.3223 9600.0n 0.3196 10199.5n 0.3196 10200.0n 0.3334 10799.5n 0.3334 10800.0n 0.3363 11399.5n 0.3363 11400.0n 0.3273 11999.5n 0.3273 12000.0n 0.3283 12599.5n 0.3283 12600.0n 0.3394 13199.5n 0.3394 13200.0n 0.3176 13799.5n 0.3176 13800.0n 0.3504 14399.5n 0.3504)
Cwp_wih_0_3 wp_wih_0_3 0 400p
Cwn_wih_0_3 wn_wih_0_3 0 400p
Xu_wih_0_3 xp_wih_0_3 xn_wih_0_3 yp_wih_0_3 yn_wih_0_3 wp_wih_0_3 wn_wih_0_3 vdd gbn gprod
Vxp_wih_1_3 xp_wih_1_3 0 PWL(0.0n 0.5903 599.5n 0.5903 600.0n 0.5456 1199.5n 0.5456 1200.0n 0.5794 1799.5n 0.5794 1800.0n 0.6050 2399.5n 0.6050 2400.0n 0.6002 2999.5n 0.6002 3000.0n 0.5822 3599.5n 0.5822 3600.0n 0.5776 4199.5n 0.5776 4200.0n 0.5867 4799.5n 0.5867 4800.0n 0.5487 5399.5n 0.5487 5400.0n 0.5654 5999.5n 0.5654 6000.0n 0.5656 6599.5n 0.5656 6600.0n 0.5907 7199.5n 0.5907 7200.0n 0.5309 7799.5n 0.5309 7800.0n 0.4409 8399.5n 0.4409 8400.0n 0.3950 8999.5n 0.3950 9000.0n 0.4115 9599.5n 0.4115 9600.0n 0.4048 10199.5n 0.4048 10200.0n 0.4883 10799.5n 0.4883 10800.0n 0.5781 11399.5n 0.5781 11400.0n 0.5169 11999.5n 0.5169 12000.0n 0.4065 12599.5n 0.4065 12600.0n 0.5303 13199.5n 0.5303 13200.0n 0.4017 13799.5n 0.4017 13800.0n 0.5102 14399.5n 0.5102)
Vxn_wih_1_3 xn_wih_1_3 0 PWL(0.0n 0.4097 599.5n 0.4097 600.0n 0.4544 1199.5n 0.4544 1200.0n 0.4206 1799.5n 0.4206 1800.0n 0.3950 2399.5n 0.3950 2400.0n 0.3998 2999.5n 0.3998 3000.0n 0.4178 3599.5n 0.4178 3600.0n 0.4224 4199.5n 0.4224 4200.0n 0.4133 4799.5n 0.4133 4800.0n 0.4513 5399.5n 0.4513 5400.0n 0.4346 5999.5n 0.4346 6000.0n 0.4344 6599.5n 0.4344 6600.0n 0.4093 7199.5n 0.4093 7200.0n 0.4691 7799.5n 0.4691 7800.0n 0.5591 8399.5n 0.5591 8400.0n 0.6050 8999.5n 0.6050 9000.0n 0.5885 9599.5n 0.5885 9600.0n 0.5952 10199.5n 0.5952 10200.0n 0.5117 10799.5n 0.5117 10800.0n 0.4219 11399.5n 0.4219 11400.0n 0.4831 11999.5n 0.4831 12000.0n 0.5935 12599.5n 0.5935 12600.0n 0.4697 13199.5n 0.4697 13200.0n 0.5983 13799.5n 0.5983 13800.0n 0.4898 14399.5n 0.4898)
Vyp_wih_1_3 yp_wih_1_3 0 PWL(0.0n 0.6512 599.5n 0.6512 600.0n 0.6686 1199.5n 0.6686 1200.0n 0.5608 1799.5n 0.5608 1800.0n 0.5256 2399.5n 0.5256 2400.0n 0.5393 2999.5n 0.5393 3000.0n 0.5649 3599.5n 0.5649 3600.0n 0.5476 4199.5n 0.5476 4200.0n 0.6598 4799.5n 0.6598 4800.0n 0.5843 5399.5n 0.5843 5400.0n 0.6609 5999.5n 0.6609 6000.0n 0.6640 6599.5n 0.6640 6600.0n 0.6123 7199.5n 0.6123 7200.0n 0.6730 7799.5n 0.6730 7800.0n 0.6726 8399.5n 0.6726 8400.0n 0.5965 8999.5n 0.5965 9000.0n 0.6777 9599.5n 0.6777 9600.0n 0.6804 10199.5n 0.6804 10200.0n 0.6666 10799.5n 0.6666 10800.0n 0.6637 11399.5n 0.6637 11400.0n 0.6727 11999.5n 0.6727 12000.0n 0.6717 12599.5n 0.6717 12600.0n 0.6606 13199.5n 0.6606 13200.0n 0.6824 13799.5n 0.6824 13800.0n 0.6496 14399.5n 0.6496)
Vyn_wih_1_3 yn_wih_1_3 0 PWL(0.0n 0.3488 599.5n 0.3488 600.0n 0.3314 1199.5n 0.3314 1200.0n 0.4392 1799.5n 0.4392 1800.0n 0.4744 2399.5n 0.4744 2400.0n 0.4607 2999.5n 0.4607 3000.0n 0.4351 3599.5n 0.4351 3600.0n 0.4524 4199.5n 0.4524 4200.0n 0.3402 4799.5n 0.3402 4800.0n 0.4157 5399.5n 0.4157 5400.0n 0.3391 5999.5n 0.3391 6000.0n 0.3360 6599.5n 0.3360 6600.0n 0.3877 7199.5n 0.3877 7200.0n 0.3270 7799.5n 0.3270 7800.0n 0.3274 8399.5n 0.3274 8400.0n 0.4035 8999.5n 0.4035 9000.0n 0.3223 9599.5n 0.3223 9600.0n 0.3196 10199.5n 0.3196 10200.0n 0.3334 10799.5n 0.3334 10800.0n 0.3363 11399.5n 0.3363 11400.0n 0.3273 11999.5n 0.3273 12000.0n 0.3283 12599.5n 0.3283 12600.0n 0.3394 13199.5n 0.3394 13200.0n 0.3176 13799.5n 0.3176 13800.0n 0.3504 14399.5n 0.3504)
Cwp_wih_1_3 wp_wih_1_3 0 400p
Cwn_wih_1_3 wn_wih_1_3 0 400p
Xu_wih_1_3 xp_wih_1_3 xn_wih_1_3 yp_wih_1_3 yn_wih_1_3 wp_wih_1_3 wn_wih_1_3 vdd gbn gprod
Vxp_wih_4_3 xp_wih_4_3 0 PWL(0.0n 0.4097 599.5n 0.4097 600.0n 0.4029 1199.5n 0.4029 1200.0n 0.4104 1799.5n 0.4104 1800.0n 0.4380 2399.5n 0.4380 2400.0n 0.4570 2999.5n 0.4570 3000.0n 0.4087 3599.5n 0.4087 3600.0n 0.4498 4199.5n 0.4498 4200.0n 0.4270 4799.5n 0.4270 4800.0n 0.4175 5399.5n 0.4175 5400.0n 0.4386 5999.5n 0.4386 6000.0n 0.4125 6599.5n 0.4125 6600.0n 0.4332 7199.5n 0.4332 7200.0n 0.3950 7799.5n 0.3950 7800.0n 0.4245 8399.5n 0.4245 8400.0n 0.3950 8999.5n 0.3950 9000.0n 0.4238 9599.5n 0.4238 9600.0n 0.4114 10199.5n 0.4114 10200.0n 0.4806 10799.5n 0.4806 10800.0n 0.3950 11399.5n 0.3950 11400.0n 0.3950 11999.5n 0.3950 12000.0n 0.3950 12599.5n 0.3950 12600.0n 0.3950 13199.5n 0.3950 13200.0n 0.4250 13799.5n 0.4250 13800.0n 0.3950 14399.5n 0.3950)
Vxn_wih_4_3 xn_wih_4_3 0 PWL(0.0n 0.5903 599.5n 0.5903 600.0n 0.5971 1199.5n 0.5971 1200.0n 0.5896 1799.5n 0.5896 1800.0n 0.5620 2399.5n 0.5620 2400.0n 0.5430 2999.5n 0.5430 3000.0n 0.5913 3599.5n 0.5913 3600.0n 0.5502 4199.5n 0.5502 4200.0n 0.5730 4799.5n 0.5730 4800.0n 0.5825 5399.5n 0.5825 5400.0n 0.5614 5999.5n 0.5614 6000.0n 0.5875 6599.5n 0.5875 6600.0n 0.5668 7199.5n 0.5668 7200.0n 0.6050 7799.5n 0.6050 7800.0n 0.5755 8399.5n 0.5755 8400.0n 0.6050 8999.5n 0.6050 9000.0n 0.5762 9599.5n 0.5762 9600.0n 0.5886 10199.5n 0.5886 10200.0n 0.5194 10799.5n 0.5194 10800.0n 0.6050 11399.5n 0.6050 11400.0n 0.6050 11999.5n 0.6050 12000.0n 0.6050 12599.5n 0.6050 12600.0n 0.6050 13199.5n 0.6050 13200.0n 0.5750 13799.5n 0.5750 13800.0n 0.6050 14399.5n 0.6050)
Vyp_wih_4_3 yp_wih_4_3 0 PWL(0.0n 0.6512 599.5n 0.6512 600.0n 0.6686 1199.5n 0.6686 1200.0n 0.5608 1799.5n 0.5608 1800.0n 0.5256 2399.5n 0.5256 2400.0n 0.5393 2999.5n 0.5393 3000.0n 0.5649 3599.5n 0.5649 3600.0n 0.5476 4199.5n 0.5476 4200.0n 0.6598 4799.5n 0.6598 4800.0n 0.5843 5399.5n 0.5843 5400.0n 0.6609 5999.5n 0.6609 6000.0n 0.6640 6599.5n 0.6640 6600.0n 0.6123 7199.5n 0.6123 7200.0n 0.6730 7799.5n 0.6730 7800.0n 0.6726 8399.5n 0.6726 8400.0n 0.5965 8999.5n 0.5965 9000.0n 0.6777 9599.5n 0.6777 9600.0n 0.6804 10199.5n 0.6804 10200.0n 0.6666 10799.5n 0.6666 10800.0n 0.6637 11399.5n 0.6637 11400.0n 0.6727 11999.5n 0.6727 12000.0n 0.6717 12599.5n 0.6717 12600.0n 0.6606 13199.5n 0.6606 13200.0n 0.6824 13799.5n 0.6824 13800.0n 0.6496 14399.5n 0.6496)
Vyn_wih_4_3 yn_wih_4_3 0 PWL(0.0n 0.3488 599.5n 0.3488 600.0n 0.3314 1199.5n 0.3314 1200.0n 0.4392 1799.5n 0.4392 1800.0n 0.4744 2399.5n 0.4744 2400.0n 0.4607 2999.5n 0.4607 3000.0n 0.4351 3599.5n 0.4351 3600.0n 0.4524 4199.5n 0.4524 4200.0n 0.3402 4799.5n 0.3402 4800.0n 0.4157 5399.5n 0.4157 5400.0n 0.3391 5999.5n 0.3391 6000.0n 0.3360 6599.5n 0.3360 6600.0n 0.3877 7199.5n 0.3877 7200.0n 0.3270 7799.5n 0.3270 7800.0n 0.3274 8399.5n 0.3274 8400.0n 0.4035 8999.5n 0.4035 9000.0n 0.3223 9599.5n 0.3223 9600.0n 0.3196 10199.5n 0.3196 10200.0n 0.3334 10799.5n 0.3334 10800.0n 0.3363 11399.5n 0.3363 11400.0n 0.3273 11999.5n 0.3273 12000.0n 0.3283 12599.5n 0.3283 12600.0n 0.3394 13199.5n 0.3394 13200.0n 0.3176 13799.5n 0.3176 13800.0n 0.3504 14399.5n 0.3504)
Cwp_wih_4_3 wp_wih_4_3 0 400p
Cwn_wih_4_3 wn_wih_4_3 0 400p
Xu_wih_4_3 xp_wih_4_3 xn_wih_4_3 yp_wih_4_3 yn_wih_4_3 wp_wih_4_3 wn_wih_4_3 vdd gbn gprod
Vxp_wih_5_3 xp_wih_5_3 0 PWL(0.0n 0.5708 599.5n 0.5708 600.0n 0.5892 1199.5n 0.5892 1200.0n 0.5077 1799.5n 0.5077 1800.0n 0.5095 2399.5n 0.5095 2400.0n 0.5286 2999.5n 0.5286 3000.0n 0.5137 3599.5n 0.5137 3600.0n 0.5228 4199.5n 0.5228 4200.0n 0.6050 4799.5n 0.6050 4800.0n 0.5000 5399.5n 0.5000 5400.0n 0.6050 5999.5n 0.6050 6000.0n 0.5919 6599.5n 0.5919 6600.0n 0.5525 7199.5n 0.5525 7200.0n 0.6050 7799.5n 0.6050 7800.0n 0.5623 8399.5n 0.5623 8400.0n 0.4294 8999.5n 0.4294 9000.0n 0.5638 9599.5n 0.5638 9600.0n 0.5689 10199.5n 0.5689 10200.0n 0.6050 10799.5n 0.6050 10800.0n 0.5996 11399.5n 0.5996 11400.0n 0.5915 11999.5n 0.5915 12000.0n 0.5325 12599.5n 0.5325 12600.0n 0.5552 13199.5n 0.5552 13200.0n 0.5850 13799.5n 0.5850 13800.0n 0.5271 14399.5n 0.5271)
Vxn_wih_5_3 xn_wih_5_3 0 PWL(0.0n 0.4292 599.5n 0.4292 600.0n 0.4108 1199.5n 0.4108 1200.0n 0.4923 1799.5n 0.4923 1800.0n 0.4905 2399.5n 0.4905 2400.0n 0.4714 2999.5n 0.4714 3000.0n 0.4863 3599.5n 0.4863 3600.0n 0.4772 4199.5n 0.4772 4200.0n 0.3950 4799.5n 0.3950 4800.0n 0.5000 5399.5n 0.5000 5400.0n 0.3950 5999.5n 0.3950 6000.0n 0.4081 6599.5n 0.4081 6600.0n 0.4475 7199.5n 0.4475 7200.0n 0.3950 7799.5n 0.3950 7800.0n 0.4377 8399.5n 0.4377 8400.0n 0.5706 8999.5n 0.5706 9000.0n 0.4362 9599.5n 0.4362 9600.0n 0.4311 10199.5n 0.4311 10200.0n 0.3950 10799.5n 0.3950 10800.0n 0.4004 11399.5n 0.4004 11400.0n 0.4085 11999.5n 0.4085 12000.0n 0.4675 12599.5n 0.4675 12600.0n 0.4448 13199.5n 0.4448 13200.0n 0.4150 13799.5n 0.4150 13800.0n 0.4729 14399.5n 0.4729)
Vyp_wih_5_3 yp_wih_5_3 0 PWL(0.0n 0.6512 599.5n 0.6512 600.0n 0.6686 1199.5n 0.6686 1200.0n 0.5608 1799.5n 0.5608 1800.0n 0.5256 2399.5n 0.5256 2400.0n 0.5393 2999.5n 0.5393 3000.0n 0.5649 3599.5n 0.5649 3600.0n 0.5476 4199.5n 0.5476 4200.0n 0.6598 4799.5n 0.6598 4800.0n 0.5843 5399.5n 0.5843 5400.0n 0.6609 5999.5n 0.6609 6000.0n 0.6640 6599.5n 0.6640 6600.0n 0.6123 7199.5n 0.6123 7200.0n 0.6730 7799.5n 0.6730 7800.0n 0.6726 8399.5n 0.6726 8400.0n 0.5965 8999.5n 0.5965 9000.0n 0.6777 9599.5n 0.6777 9600.0n 0.6804 10199.5n 0.6804 10200.0n 0.6666 10799.5n 0.6666 10800.0n 0.6637 11399.5n 0.6637 11400.0n 0.6727 11999.5n 0.6727 12000.0n 0.6717 12599.5n 0.6717 12600.0n 0.6606 13199.5n 0.6606 13200.0n 0.6824 13799.5n 0.6824 13800.0n 0.6496 14399.5n 0.6496)
Vyn_wih_5_3 yn_wih_5_3 0 PWL(0.0n 0.3488 599.5n 0.3488 600.0n 0.3314 1199.5n 0.3314 1200.0n 0.4392 1799.5n 0.4392 1800.0n 0.4744 2399.5n 0.4744 2400.0n 0.4607 2999.5n 0.4607 3000.0n 0.4351 3599.5n 0.4351 3600.0n 0.4524 4199.5n 0.4524 4200.0n 0.3402 4799.5n 0.3402 4800.0n 0.4157 5399.5n 0.4157 5400.0n 0.3391 5999.5n 0.3391 6000.0n 0.3360 6599.5n 0.3360 6600.0n 0.3877 7199.5n 0.3877 7200.0n 0.3270 7799.5n 0.3270 7800.0n 0.3274 8399.5n 0.3274 8400.0n 0.4035 8999.5n 0.4035 9000.0n 0.3223 9599.5n 0.3223 9600.0n 0.3196 10199.5n 0.3196 10200.0n 0.3334 10799.5n 0.3334 10800.0n 0.3363 11399.5n 0.3363 11400.0n 0.3273 11999.5n 0.3273 12000.0n 0.3283 12599.5n 0.3283 12600.0n 0.3394 13199.5n 0.3394 13200.0n 0.3176 13799.5n 0.3176 13800.0n 0.3504 14399.5n 0.3504)
Cwp_wih_5_3 wp_wih_5_3 0 400p
Cwn_wih_5_3 wn_wih_5_3 0 400p
Xu_wih_5_3 xp_wih_5_3 xn_wih_5_3 yp_wih_5_3 yn_wih_5_3 wp_wih_5_3 wn_wih_5_3 vdd gbn gprod
Vxp_who_3_0 xp_who_3_0 0 PWL(0.0n 0.6512 599.5n 0.6512 600.0n 0.6686 1199.5n 0.6686 1200.0n 0.5608 1799.5n 0.5608 1800.0n 0.5256 2399.5n 0.5256 2400.0n 0.5393 2999.5n 0.5393 3000.0n 0.5649 3599.5n 0.5649 3600.0n 0.5476 4199.5n 0.5476 4200.0n 0.6598 4799.5n 0.6598 4800.0n 0.5843 5399.5n 0.5843 5400.0n 0.6609 5999.5n 0.6609 6000.0n 0.6640 6599.5n 0.6640 6600.0n 0.6123 7199.5n 0.6123 7200.0n 0.6730 7799.5n 0.6730 7800.0n 0.6726 8399.5n 0.6726 8400.0n 0.5965 8999.5n 0.5965 9000.0n 0.6777 9599.5n 0.6777 9600.0n 0.6804 10199.5n 0.6804 10200.0n 0.6666 10799.5n 0.6666 10800.0n 0.6637 11399.5n 0.6637 11400.0n 0.6727 11999.5n 0.6727 12000.0n 0.6717 12599.5n 0.6717 12600.0n 0.6606 13199.5n 0.6606 13200.0n 0.6824 13799.5n 0.6824 13800.0n 0.6496 14399.5n 0.6496)
Vxn_who_3_0 xn_who_3_0 0 PWL(0.0n 0.3488 599.5n 0.3488 600.0n 0.3314 1199.5n 0.3314 1200.0n 0.4392 1799.5n 0.4392 1800.0n 0.4744 2399.5n 0.4744 2400.0n 0.4607 2999.5n 0.4607 3000.0n 0.4351 3599.5n 0.4351 3600.0n 0.4524 4199.5n 0.4524 4200.0n 0.3402 4799.5n 0.3402 4800.0n 0.4157 5399.5n 0.4157 5400.0n 0.3391 5999.5n 0.3391 6000.0n 0.3360 6599.5n 0.3360 6600.0n 0.3877 7199.5n 0.3877 7200.0n 0.3270 7799.5n 0.3270 7800.0n 0.3274 8399.5n 0.3274 8400.0n 0.4035 8999.5n 0.4035 9000.0n 0.3223 9599.5n 0.3223 9600.0n 0.3196 10199.5n 0.3196 10200.0n 0.3334 10799.5n 0.3334 10800.0n 0.3363 11399.5n 0.3363 11400.0n 0.3273 11999.5n 0.3273 12000.0n 0.3283 12599.5n 0.3283 12600.0n 0.3394 13199.5n 0.3394 13200.0n 0.3176 13799.5n 0.3176 13800.0n 0.3504 14399.5n 0.3504)
Vyp_who_3_0 yp_who_3_0 0 PWL(0.0n 0.5073 599.5n 0.5073 600.0n 0.5065 1199.5n 0.5065 1200.0n 0.5065 1799.5n 0.5065 1800.0n 0.5052 2399.5n 0.5052 2400.0n 0.5058 2999.5n 0.5058 3000.0n 0.5039 3599.5n 0.5039 3600.0n 0.5059 4199.5n 0.5059 4200.0n 0.5077 4799.5n 0.5077 4800.0n 0.5054 5399.5n 0.5054 5400.0n 0.5066 5999.5n 0.5066 6000.0n 0.5083 6599.5n 0.5083 6600.0n 0.5078 7199.5n 0.5078 7200.0n 0.5043 7799.5n 0.5043 7800.0n 0.5035 8399.5n 0.5035 8400.0n 0.5035 8999.5n 0.5035 9000.0n 0.5038 9599.5n 0.5038 9600.0n 0.5043 10199.5n 0.5043 10200.0n 0.5053 10799.5n 0.5053 10800.0n 0.5050 11399.5n 0.5050 11400.0n 0.5055 11999.5n 0.5055 12000.0n 0.5043 12599.5n 0.5043 12600.0n 0.5028 13199.5n 0.5028 13200.0n 0.5045 13799.5n 0.5045 13800.0n 0.5043 14399.5n 0.5043)
Vyn_who_3_0 yn_who_3_0 0 PWL(0.0n 0.4927 599.5n 0.4927 600.0n 0.4935 1199.5n 0.4935 1200.0n 0.4935 1799.5n 0.4935 1800.0n 0.4948 2399.5n 0.4948 2400.0n 0.4942 2999.5n 0.4942 3000.0n 0.4961 3599.5n 0.4961 3600.0n 0.4941 4199.5n 0.4941 4200.0n 0.4923 4799.5n 0.4923 4800.0n 0.4946 5399.5n 0.4946 5400.0n 0.4934 5999.5n 0.4934 6000.0n 0.4917 6599.5n 0.4917 6600.0n 0.4922 7199.5n 0.4922 7200.0n 0.4957 7799.5n 0.4957 7800.0n 0.4965 8399.5n 0.4965 8400.0n 0.4965 8999.5n 0.4965 9000.0n 0.4962 9599.5n 0.4962 9600.0n 0.4957 10199.5n 0.4957 10200.0n 0.4947 10799.5n 0.4947 10800.0n 0.4950 11399.5n 0.4950 11400.0n 0.4945 11999.5n 0.4945 12000.0n 0.4957 12599.5n 0.4957 12600.0n 0.4972 13199.5n 0.4972 13200.0n 0.4955 13799.5n 0.4955 13800.0n 0.4957 14399.5n 0.4957)
Cwp_who_3_0 wp_who_3_0 0 400p
Cwn_who_3_0 wn_who_3_0 0 400p
Xu_who_3_0 xp_who_3_0 xn_who_3_0 yp_who_3_0 yn_who_3_0 wp_who_3_0 wn_who_3_0 vdd gbn gprod
Vxp_who_3_1 xp_who_3_1 0 PWL(0.0n 0.6512 599.5n 0.6512 600.0n 0.6686 1199.5n 0.6686 1200.0n 0.5608 1799.5n 0.5608 1800.0n 0.5256 2399.5n 0.5256 2400.0n 0.5393 2999.5n 0.5393 3000.0n 0.5649 3599.5n 0.5649 3600.0n 0.5476 4199.5n 0.5476 4200.0n 0.6598 4799.5n 0.6598 4800.0n 0.5843 5399.5n 0.5843 5400.0n 0.6609 5999.5n 0.6609 6000.0n 0.6640 6599.5n 0.6640 6600.0n 0.6123 7199.5n 0.6123 7200.0n 0.6730 7799.5n 0.6730 7800.0n 0.6726 8399.5n 0.6726 8400.0n 0.5965 8999.5n 0.5965 9000.0n 0.6777 9599.5n 0.6777 9600.0n 0.6804 10199.5n 0.6804 10200.0n 0.6666 10799.5n 0.6666 10800.0n 0.6637 11399.5n 0.6637 11400.0n 0.6727 11999.5n 0.6727 12000.0n 0.6717 12599.5n 0.6717 12600.0n 0.6606 13199.5n 0.6606 13200.0n 0.6824 13799.5n 0.6824 13800.0n 0.6496 14399.5n 0.6496)
Vxn_who_3_1 xn_who_3_1 0 PWL(0.0n 0.3488 599.5n 0.3488 600.0n 0.3314 1199.5n 0.3314 1200.0n 0.4392 1799.5n 0.4392 1800.0n 0.4744 2399.5n 0.4744 2400.0n 0.4607 2999.5n 0.4607 3000.0n 0.4351 3599.5n 0.4351 3600.0n 0.4524 4199.5n 0.4524 4200.0n 0.3402 4799.5n 0.3402 4800.0n 0.4157 5399.5n 0.4157 5400.0n 0.3391 5999.5n 0.3391 6000.0n 0.3360 6599.5n 0.3360 6600.0n 0.3877 7199.5n 0.3877 7200.0n 0.3270 7799.5n 0.3270 7800.0n 0.3274 8399.5n 0.3274 8400.0n 0.4035 8999.5n 0.4035 9000.0n 0.3223 9599.5n 0.3223 9600.0n 0.3196 10199.5n 0.3196 10200.0n 0.3334 10799.5n 0.3334 10800.0n 0.3363 11399.5n 0.3363 11400.0n 0.3273 11999.5n 0.3273 12000.0n 0.3283 12599.5n 0.3283 12600.0n 0.3394 13199.5n 0.3394 13200.0n 0.3176 13799.5n 0.3176 13800.0n 0.3504 14399.5n 0.3504)
Vyp_who_3_1 yp_who_3_1 0 PWL(0.0n 0.4909 599.5n 0.4909 600.0n 0.4933 1199.5n 0.4933 1200.0n 0.4930 1799.5n 0.4930 1800.0n 0.4893 2399.5n 0.4893 2400.0n 0.4904 2999.5n 0.4904 3000.0n 0.4923 3599.5n 0.4923 3600.0n 0.4897 4199.5n 0.4897 4200.0n 0.4890 4799.5n 0.4890 4800.0n 0.4921 5399.5n 0.4921 5400.0n 0.4899 5999.5n 0.4899 6000.0n 0.4870 6599.5n 0.4870 6600.0n 0.4903 7199.5n 0.4903 7200.0n 0.4970 7799.5n 0.4970 7800.0n 0.4989 8399.5n 0.4989 8400.0n 0.4994 8999.5n 0.4994 9000.0n 0.4991 9599.5n 0.4991 9600.0n 0.5000 10199.5n 0.5000 10200.0n 0.4948 10799.5n 0.4948 10800.0n 0.4959 11399.5n 0.4959 11400.0n 0.4926 11999.5n 0.4926 12000.0n 0.4993 12599.5n 0.4993 12600.0n 0.4862 13199.5n 0.4862 13200.0n 0.4993 13799.5n 0.4993 13800.0n 0.4961 14399.5n 0.4961)
Vyn_who_3_1 yn_who_3_1 0 PWL(0.0n 0.5091 599.5n 0.5091 600.0n 0.5067 1199.5n 0.5067 1200.0n 0.5070 1799.5n 0.5070 1800.0n 0.5107 2399.5n 0.5107 2400.0n 0.5096 2999.5n 0.5096 3000.0n 0.5077 3599.5n 0.5077 3600.0n 0.5103 4199.5n 0.5103 4200.0n 0.5110 4799.5n 0.5110 4800.0n 0.5079 5399.5n 0.5079 5400.0n 0.5101 5999.5n 0.5101 6000.0n 0.5130 6599.5n 0.5130 6600.0n 0.5097 7199.5n 0.5097 7200.0n 0.5030 7799.5n 0.5030 7800.0n 0.5011 8399.5n 0.5011 8400.0n 0.5006 8999.5n 0.5006 9000.0n 0.5009 9599.5n 0.5009 9600.0n 0.5000 10199.5n 0.5000 10200.0n 0.5052 10799.5n 0.5052 10800.0n 0.5041 11399.5n 0.5041 11400.0n 0.5074 11999.5n 0.5074 12000.0n 0.5007 12599.5n 0.5007 12600.0n 0.5138 13199.5n 0.5138 13200.0n 0.5007 13799.5n 0.5007 13800.0n 0.5039 14399.5n 0.5039)
Cwp_who_3_1 wp_who_3_1 0 400p
Cwn_who_3_1 wn_who_3_1 0 400p
Xu_who_3_1 xp_who_3_1 xn_who_3_1 yp_who_3_1 yn_who_3_1 wp_who_3_1 wn_who_3_1 vdd gbn gprod
Vxp_bh_3 xp_bh_3 0 PWL(0.0n 0.7100 599.5n 0.7100 600.0n 0.7100 1199.5n 0.7100 1200.0n 0.7100 1799.5n 0.7100 1800.0n 0.7100 2399.5n 0.7100 2400.0n 0.7100 2999.5n 0.7100 3000.0n 0.7100 3599.5n 0.7100 3600.0n 0.7100 4199.5n 0.7100 4200.0n 0.7100 4799.5n 0.7100 4800.0n 0.7100 5399.5n 0.7100 5400.0n 0.7100 5999.5n 0.7100 6000.0n 0.7100 6599.5n 0.7100 6600.0n 0.7100 7199.5n 0.7100 7200.0n 0.7100 7799.5n 0.7100 7800.0n 0.7100 8399.5n 0.7100 8400.0n 0.7100 8999.5n 0.7100 9000.0n 0.7100 9599.5n 0.7100 9600.0n 0.7100 10199.5n 0.7100 10200.0n 0.7100 10799.5n 0.7100 10800.0n 0.7100 11399.5n 0.7100 11400.0n 0.7100 11999.5n 0.7100 12000.0n 0.7100 12599.5n 0.7100 12600.0n 0.7100 13199.5n 0.7100 13200.0n 0.7100 13799.5n 0.7100 13800.0n 0.7100 14399.5n 0.7100)
Vxn_bh_3 xn_bh_3 0 PWL(0.0n 0.2900 599.5n 0.2900 600.0n 0.2900 1199.5n 0.2900 1200.0n 0.2900 1799.5n 0.2900 1800.0n 0.2900 2399.5n 0.2900 2400.0n 0.2900 2999.5n 0.2900 3000.0n 0.2900 3599.5n 0.2900 3600.0n 0.2900 4199.5n 0.2900 4200.0n 0.2900 4799.5n 0.2900 4800.0n 0.2900 5399.5n 0.2900 5400.0n 0.2900 5999.5n 0.2900 6000.0n 0.2900 6599.5n 0.2900 6600.0n 0.2900 7199.5n 0.2900 7200.0n 0.2900 7799.5n 0.2900 7800.0n 0.2900 8399.5n 0.2900 8400.0n 0.2900 8999.5n 0.2900 9000.0n 0.2900 9599.5n 0.2900 9600.0n 0.2900 10199.5n 0.2900 10200.0n 0.2900 10799.5n 0.2900 10800.0n 0.2900 11399.5n 0.2900 11400.0n 0.2900 11999.5n 0.2900 12000.0n 0.2900 12599.5n 0.2900 12600.0n 0.2900 13199.5n 0.2900 13200.0n 0.2900 13799.5n 0.2900 13800.0n 0.2900 14399.5n 0.2900)
Vyp_bh_3 yp_bh_3 0 PWL(0.0n 0.6512 599.5n 0.6512 600.0n 0.6686 1199.5n 0.6686 1200.0n 0.5608 1799.5n 0.5608 1800.0n 0.5256 2399.5n 0.5256 2400.0n 0.5393 2999.5n 0.5393 3000.0n 0.5649 3599.5n 0.5649 3600.0n 0.5476 4199.5n 0.5476 4200.0n 0.6598 4799.5n 0.6598 4800.0n 0.5843 5399.5n 0.5843 5400.0n 0.6609 5999.5n 0.6609 6000.0n 0.6640 6599.5n 0.6640 6600.0n 0.6123 7199.5n 0.6123 7200.0n 0.6730 7799.5n 0.6730 7800.0n 0.6726 8399.5n 0.6726 8400.0n 0.5965 8999.5n 0.5965 9000.0n 0.6777 9599.5n 0.6777 9600.0n 0.6804 10199.5n 0.6804 10200.0n 0.6666 10799.5n 0.6666 10800.0n 0.6637 11399.5n 0.6637 11400.0n 0.6727 11999.5n 0.6727 12000.0n 0.6717 12599.5n 0.6717 12600.0n 0.6606 13199.5n 0.6606 13200.0n 0.6824 13799.5n 0.6824 13800.0n 0.6496 14399.5n 0.6496)
Vyn_bh_3 yn_bh_3 0 PWL(0.0n 0.3488 599.5n 0.3488 600.0n 0.3314 1199.5n 0.3314 1200.0n 0.4392 1799.5n 0.4392 1800.0n 0.4744 2399.5n 0.4744 2400.0n 0.4607 2999.5n 0.4607 3000.0n 0.4351 3599.5n 0.4351 3600.0n 0.4524 4199.5n 0.4524 4200.0n 0.3402 4799.5n 0.3402 4800.0n 0.4157 5399.5n 0.4157 5400.0n 0.3391 5999.5n 0.3391 6000.0n 0.3360 6599.5n 0.3360 6600.0n 0.3877 7199.5n 0.3877 7200.0n 0.3270 7799.5n 0.3270 7800.0n 0.3274 8399.5n 0.3274 8400.0n 0.4035 8999.5n 0.4035 9000.0n 0.3223 9599.5n 0.3223 9600.0n 0.3196 10199.5n 0.3196 10200.0n 0.3334 10799.5n 0.3334 10800.0n 0.3363 11399.5n 0.3363 11400.0n 0.3273 11999.5n 0.3273 12000.0n 0.3283 12599.5n 0.3283 12600.0n 0.3394 13199.5n 0.3394 13200.0n 0.3176 13799.5n 0.3176 13800.0n 0.3504 14399.5n 0.3504)
Cwp_bh_3 wp_bh_3 0 400p
Cwn_bh_3 wn_bh_3 0 400p
Xu_bh_3 xp_bh_3 xn_bh_3 yp_bh_3 yn_bh_3 wp_bh_3 wn_bh_3 vdd gbn gprod
Vxp_wih_2_4 xp_wih_2_4 0 PWL(0.0n 0.5073 599.5n 0.5073 600.0n 0.6050 1199.5n 0.6050 1200.0n 0.5896 1799.5n 0.5896 1800.0n 0.5668 2399.5n 0.5668 2400.0n 0.5620 2999.5n 0.5620 3000.0n 0.5000 3599.5n 0.5000 3600.0n 0.5274 4199.5n 0.5274 4200.0n 0.5867 4799.5n 0.5867 4800.0n 0.5675 5399.5n 0.5675 5400.0n 0.5971 5999.5n 0.5971 6000.0n 0.5525 6599.5n 0.5525 6600.0n 0.6050 7199.5n 0.6050 7200.0n 0.5144 7799.5n 0.5144 7800.0n 0.5952 8399.5n 0.5952 8400.0n 0.5637 8999.5n 0.5637 9000.0n 0.6050 9599.5n 0.6050 9600.0n 0.5689 10199.5n 0.5689 10200.0n 0.6050 10799.5n 0.6050 10800.0n 0.5512 11399.5n 0.5512 11400.0n 0.5169 11999.5n 0.5169 12000.0n 0.5935 12599.5n 0.5935 12600.0n 0.4484 13199.5n 0.4484 13200.0n 0.5917 13799.5n 0.5917 13800.0n 0.5508 14399.5n 0.5508)
Vxn_wih_2_4 xn_wih_2_4 0 PWL(0.0n 0.4927 599.5n 0.4927 600.0n 0.3950 1199.5n 0.3950 1200.0n 0.4104 1799.5n 0.4104 1800.0n 0.4332 2399.5n 0.4332 2400.0n 0.4380 2999.5n 0.4380 3000.0n 0.5000 3599.5n 0.5000 3600.0n 0.4726 4199.5n 0.4726 4200.0n 0.4133 4799.5n 0.4133 4800.0n 0.4325 5399.5n 0.4325 5400.0n 0.4029 5999.5n 0.4029 6000.0n 0.4475 6599.5n 0.4475 6600.0n 0.3950 7199.5n 0.3950 7200.0n 0.4856 7799.5n 0.4856 7800.0n 0.4048 8399.5n 0.4048 8400.0n 0.4363 8999.5n 0.4363 9000.0n 0.3950 9599.5n 0.3950 9600.0n 0.4311 10199.5n 0.4311 10200.0n 0.3950 10799.5n 0.3950 10800.0n 0.4488 11399.5n 0.4488 11400.0n 0.4831 11999.5n 0.4831 12000.0n 0.4065 12599.5n 0.4065 12600.0n 0.5516 13199.5n 0.5516 13200.0n 0.4083 13799.5n 0.4083 13800.0n 0.4492 14399.5n 0.4492)
Vyp_wih_2_4 yp_wih_2_4 0 PWL(0.0n 0.5160 599.5n 0.5160 600.0n 0.5086 1199.5n 0.5086 1200.0n 0.5001 1799.5n 0.5001 1800.0n 0.5217 2399.5n 0.5217 2400.0n 0.5463 2999.5n 0.5463 3000.0n 0.5015 3599.5n 0.5015 3600.0n 0.5109 4199.5n 0.5109 4200.0n 0.5504 4799.5n 0.5504 4800.0n 0.5503 5399.5n 0.5503 5400.0n 0.4766 5999.5n 0.4766 6000.0n 0.5582 6599.5n 0.5582 6600.0n 0.5345 7199.5n 0.5345 7200.0n 0.3736 7799.5n 0.3736 7800.0n 0.3485 8399.5n 0.3485 8400.0n 0.3489 8999.5n 0.3489 9000.0n 0.3772 9599.5n 0.3772 9600.0n 0.3490 10199.5n 0.3490 10200.0n 0.4136 10799.5n 0.4136 10800.0n 0.3518 11399.5n 0.3518 11400.0n 0.4597 11999.5n 0.4597 12000.0n 0.3479 12599.5n 0.3479 12600.0n 0.5550 13199.5n 0.5550 13200.0n 0.3458 13799.5n 0.3458 13800.0n 0.3913 14399.5n 0.3913)
Vyn_wih_2_4 yn_wih_2_4 0 PWL(0.0n 0.4840 599.5n 0.4840 600.0n 0.4914 1199.5n 0.4914 1200.0n 0.4999 1799.5n 0.4999 1800.0n 0.4783 2399.5n 0.4783 2400.0n 0.4537 2999.5n 0.4537 3000.0n 0.4985 3599.5n 0.4985 3600.0n 0.4891 4199.5n 0.4891 4200.0n 0.4496 4799.5n 0.4496 4800.0n 0.4497 5399.5n 0.4497 5400.0n 0.5234 5999.5n 0.5234 6000.0n 0.4418 6599.5n 0.4418 6600.0n 0.4655 7199.5n 0.4655 7200.0n 0.6264 7799.5n 0.6264 7800.0n 0.6515 8399.5n 0.6515 8400.0n 0.6511 8999.5n 0.6511 9000.0n 0.6228 9599.5n 0.6228 9600.0n 0.6510 10199.5n 0.6510 10200.0n 0.5864 10799.5n 0.5864 10800.0n 0.6482 11399.5n 0.6482 11400.0n 0.5403 11999.5n 0.5403 12000.0n 0.6521 12599.5n 0.6521 12600.0n 0.4450 13199.5n 0.4450 13200.0n 0.6542 13799.5n 0.6542 13800.0n 0.6087 14399.5n 0.6087)
Cwp_wih_2_4 wp_wih_2_4 0 400p
Cwn_wih_2_4 wn_wih_2_4 0 400p
Xu_wih_2_4 xp_wih_2_4 xn_wih_2_4 yp_wih_2_4 yn_wih_2_4 wp_wih_2_4 wn_wih_2_4 vdd gbn gprod
Vxp_wih_3_4 xp_wih_3_4 0 PWL(0.0n 0.4048 599.5n 0.4048 600.0n 0.4386 1199.5n 0.4386 1200.0n 0.3950 1799.5n 0.3950 1800.0n 0.3950 2399.5n 0.3950 2400.0n 0.3950 2999.5n 0.3950 3000.0n 0.3950 3599.5n 0.3950 3600.0n 0.3950 4199.5n 0.3950 4200.0n 0.3950 4799.5n 0.3950 4800.0n 0.4025 5399.5n 0.4025 5400.0n 0.4069 5999.5n 0.4069 6000.0n 0.3950 6599.5n 0.3950 6600.0n 0.4045 7199.5n 0.4045 7200.0n 0.3950 7799.5n 0.3950 7800.0n 0.4311 8399.5n 0.4311 8400.0n 0.3984 8999.5n 0.3984 9000.0n 0.4362 9599.5n 0.4362 9600.0n 0.4475 10199.5n 0.4475 10200.0n 0.3950 10799.5n 0.3950 10800.0n 0.3950 11399.5n 0.3950 11400.0n 0.3950 11999.5n 0.3950 12000.0n 0.3950 12599.5n 0.3950 12600.0n 0.3950 13199.5n 0.3950 13200.0n 0.4083 13799.5n 0.4083 13800.0n 0.3950 14399.5n 0.3950)
Vxn_wih_3_4 xn_wih_3_4 0 PWL(0.0n 0.5952 599.5n 0.5952 600.0n 0.5614 1199.5n 0.5614 1200.0n 0.6050 1799.5n 0.6050 1800.0n 0.6050 2399.5n 0.6050 2400.0n 0.6050 2999.5n 0.6050 3000.0n 0.6050 3599.5n 0.6050 3600.0n 0.6050 4199.5n 0.6050 4200.0n 0.6050 4799.5n 0.6050 4800.0n 0.5975 5399.5n 0.5975 5400.0n 0.5931 5999.5n 0.5931 6000.0n 0.6050 6599.5n 0.6050 6600.0n 0.5955 7199.5n 0.5955 7200.0n 0.6050 7799.5n 0.6050 7800.0n 0.5689 8399.5n 0.5689 8400.0n 0.6016 8999.5n 0.6016 9000.0n 0.5638 9599.5n 0.5638 9600.0n 0.5525 10199.5n 0.5525 10200.0n 0.6050 10799.5n 0.6050 10800.0n 0.6050 11399.5n 0.6050 11400.0n 0.6050 11999.5n 0.6050 12000.0n 0.6050 12599.5n 0.6050 12600.0n 0.6050 13199.5n 0.6050 13200.0n 0.5917 13799.5n 0.5917 13800.0n 0.6050 14399.5n 0.6050)
Vyp_wih_3_4 yp_wih_3_4 0 PWL(0.0n 0.5160 599.5n 0.5160 600.0n 0.5086 1199.5n 0.5086 1200.0n 0.5001 1799.5n 0.5001 1800.0n 0.5217 2399.5n 0.5217 2400.0n 0.5463 2999.5n 0.5463 3000.0n 0.5015 3599.5n 0.5015 3600.0n 0.5109 4199.5n 0.5109 4200.0n 0.5504 4799.5n 0.5504 4800.0n 0.5503 5399.5n 0.5503 5400.0n 0.4766 5999.5n 0.4766 6000.0n 0.5582 6599.5n 0.5582 6600.0n 0.5345 7199.5n 0.5345 7200.0n 0.3736 7799.5n 0.3736 7800.0n 0.3485 8399.5n 0.3485 8400.0n 0.3489 8999.5n 0.3489 9000.0n 0.3772 9599.5n 0.3772 9600.0n 0.3490 10199.5n 0.3490 10200.0n 0.4136 10799.5n 0.4136 10800.0n 0.3518 11399.5n 0.3518 11400.0n 0.4597 11999.5n 0.4597 12000.0n 0.3479 12599.5n 0.3479 12600.0n 0.5550 13199.5n 0.5550 13200.0n 0.3458 13799.5n 0.3458 13800.0n 0.3913 14399.5n 0.3913)
Vyn_wih_3_4 yn_wih_3_4 0 PWL(0.0n 0.4840 599.5n 0.4840 600.0n 0.4914 1199.5n 0.4914 1200.0n 0.4999 1799.5n 0.4999 1800.0n 0.4783 2399.5n 0.4783 2400.0n 0.4537 2999.5n 0.4537 3000.0n 0.4985 3599.5n 0.4985 3600.0n 0.4891 4199.5n 0.4891 4200.0n 0.4496 4799.5n 0.4496 4800.0n 0.4497 5399.5n 0.4497 5400.0n 0.5234 5999.5n 0.5234 6000.0n 0.4418 6599.5n 0.4418 6600.0n 0.4655 7199.5n 0.4655 7200.0n 0.6264 7799.5n 0.6264 7800.0n 0.6515 8399.5n 0.6515 8400.0n 0.6511 8999.5n 0.6511 9000.0n 0.6228 9599.5n 0.6228 9600.0n 0.6510 10199.5n 0.6510 10200.0n 0.5864 10799.5n 0.5864 10800.0n 0.6482 11399.5n 0.6482 11400.0n 0.5403 11999.5n 0.5403 12000.0n 0.6521 12599.5n 0.6521 12600.0n 0.4450 13199.5n 0.4450 13200.0n 0.6542 13799.5n 0.6542 13800.0n 0.6087 14399.5n 0.6087)
Cwp_wih_3_4 wp_wih_3_4 0 400p
Cwn_wih_3_4 wn_wih_3_4 0 400p
Xu_wih_3_4 xp_wih_3_4 xn_wih_3_4 yp_wih_3_4 yn_wih_3_4 wp_wih_3_4 wn_wih_3_4 vdd gbn gprod
Vxp_wih_6_4 xp_wih_6_4 0 PWL(0.0n 0.4927 599.5n 0.4927 600.0n 0.5059 1199.5n 0.5059 1200.0n 0.5128 1799.5n 0.5128 1800.0n 0.4857 2399.5n 0.4857 2400.0n 0.4857 2999.5n 0.4857 3000.0n 0.4909 3599.5n 0.4909 3600.0n 0.5000 4199.5n 0.5000 4200.0n 0.4543 4799.5n 0.4543 4800.0n 0.4737 5399.5n 0.4737 5400.0n 0.5297 5999.5n 0.5297 6000.0n 0.4694 6599.5n 0.4694 6600.0n 0.4809 7199.5n 0.4809 7200.0n 0.5762 7799.5n 0.5762 7800.0n 0.6050 8399.5n 0.6050 8400.0n 0.6050 8999.5n 0.6050 9000.0n 0.5679 9599.5n 0.5679 9600.0n 0.6050 10199.5n 0.6050 10200.0n 0.5428 10799.5n 0.5428 10800.0n 0.6050 11399.5n 0.6050 11400.0n 0.5203 11999.5n 0.5203 12000.0n 0.5974 12599.5n 0.5974 12600.0n 0.4519 13199.5n 0.4519 13200.0n 0.6050 13799.5n 0.6050 13800.0n 0.5610 14399.5n 0.5610)
Vxn_wih_6_4 xn_wih_6_4 0 PWL(0.0n 0.5073 599.5n 0.5073 600.0n 0.4941 1199.5n 0.4941 1200.0n 0.4872 1799.5n 0.4872 1800.0n 0.5143 2399.5n 0.5143 2400.0n 0.5143 2999.5n 0.5143 3000.0n 0.5091 3599.5n 0.5091 3600.0n 0.5000 4199.5n 0.5000 4200.0n 0.5457 4799.5n 0.5457 4800.0n 0.5263 5399.5n 0.5263 5400.0n 0.4703 5999.5n 0.4703 6000.0n 0.5306 6599.5n 0.5306 6600.0n 0.5191 7199.5n 0.5191 7200.0n 0.4238 7799.5n 0.4238 7800.0n 0.3950 8399.5n 0.3950 8400.0n 0.3950 8999.5n 0.3950 9000.0n 0.4321 9599.5n 0.4321 9600.0n 0.3950 10199.5n 0.3950 10200.0n 0.4572 10799.5n 0.4572 10800.0n 0.3950 11399.5n 0.3950 11400.0n 0.4797 11999.5n 0.4797 12000.0n 0.4026 12599.5n 0.4026 12600.0n 0.5481 13199.5n 0.5481 13200.0n 0.3950 13799.5n 0.3950 13800.0n 0.4390 14399.5n 0.4390)
Vyp_wih_6_4 yp_wih_6_4 0 PWL(0.0n 0.5160 599.5n 0.5160 600.0n 0.5086 1199.5n 0.5086 1200.0n 0.5001 1799.5n 0.5001 1800.0n 0.5217 2399.5n 0.5217 2400.0n 0.5463 2999.5n 0.5463 3000.0n 0.5015 3599.5n 0.5015 3600.0n 0.5109 4199.5n 0.5109 4200.0n 0.5504 4799.5n 0.5504 4800.0n 0.5503 5399.5n 0.5503 5400.0n 0.4766 5999.5n 0.4766 6000.0n 0.5582 6599.5n 0.5582 6600.0n 0.5345 7199.5n 0.5345 7200.0n 0.3736 7799.5n 0.3736 7800.0n 0.3485 8399.5n 0.3485 8400.0n 0.3489 8999.5n 0.3489 9000.0n 0.3772 9599.5n 0.3772 9600.0n 0.3490 10199.5n 0.3490 10200.0n 0.4136 10799.5n 0.4136 10800.0n 0.3518 11399.5n 0.3518 11400.0n 0.4597 11999.5n 0.4597 12000.0n 0.3479 12599.5n 0.3479 12600.0n 0.5550 13199.5n 0.5550 13200.0n 0.3458 13799.5n 0.3458 13800.0n 0.3913 14399.5n 0.3913)
Vyn_wih_6_4 yn_wih_6_4 0 PWL(0.0n 0.4840 599.5n 0.4840 600.0n 0.4914 1199.5n 0.4914 1200.0n 0.4999 1799.5n 0.4999 1800.0n 0.4783 2399.5n 0.4783 2400.0n 0.4537 2999.5n 0.4537 3000.0n 0.4985 3599.5n 0.4985 3600.0n 0.4891 4199.5n 0.4891 4200.0n 0.4496 4799.5n 0.4496 4800.0n 0.4497 5399.5n 0.4497 5400.0n 0.5234 5999.5n 0.5234 6000.0n 0.4418 6599.5n 0.4418 6600.0n 0.4655 7199.5n 0.4655 7200.0n 0.6264 7799.5n 0.6264 7800.0n 0.6515 8399.5n 0.6515 8400.0n 0.6511 8999.5n 0.6511 9000.0n 0.6228 9599.5n 0.6228 9600.0n 0.6510 10199.5n 0.6510 10200.0n 0.5864 10799.5n 0.5864 10800.0n 0.6482 11399.5n 0.6482 11400.0n 0.5403 11999.5n 0.5403 12000.0n 0.6521 12599.5n 0.6521 12600.0n 0.4450 13199.5n 0.4450 13200.0n 0.6542 13799.5n 0.6542 13800.0n 0.6087 14399.5n 0.6087)
Cwp_wih_6_4 wp_wih_6_4 0 400p
Cwn_wih_6_4 wn_wih_6_4 0 400p
Xu_wih_6_4 xp_wih_6_4 xn_wih_6_4 yp_wih_6_4 yn_wih_6_4 wp_wih_6_4 wn_wih_6_4 vdd gbn gprod
Vxp_wih_7_4 xp_wih_7_4 0 PWL(0.0n 0.4341 599.5n 0.4341 600.0n 0.4663 1199.5n 0.4663 1200.0n 0.4513 1799.5n 0.4513 1800.0n 0.4380 2399.5n 0.4380 2400.0n 0.4618 2999.5n 0.4618 3000.0n 0.4178 3599.5n 0.4178 3600.0n 0.4361 4199.5n 0.4361 4200.0n 0.4315 4799.5n 0.4315 4800.0n 0.4550 5399.5n 0.4550 5400.0n 0.4465 5999.5n 0.4465 6000.0n 0.4475 6599.5n 0.4475 6600.0n 0.4523 7199.5n 0.4523 7200.0n 0.3950 7799.5n 0.3950 7800.0n 0.4212 8399.5n 0.4212 8400.0n 0.3950 8999.5n 0.3950 9000.0n 0.4279 9599.5n 0.4279 9600.0n 0.4212 10199.5n 0.4212 10200.0n 0.3950 10799.5n 0.3950 10800.0n 0.3950 11399.5n 0.3950 11400.0n 0.3950 11999.5n 0.3950 12000.0n 0.3950 12599.5n 0.3950 12600.0n 0.3950 13199.5n 0.3950 13200.0n 0.3950 13799.5n 0.3950 13800.0n 0.3950 14399.5n 0.3950)
Vxn_wih_7_4 xn_wih_7_4 0 PWL(0.0n 0.5659 599.5n 0.5659 600.0n 0.5337 1199.5n 0.5337 1200.0n 0.5487 1799.5n 0.5487 1800.0n 0.5620 2399.5n 0.5620 2400.0n 0.5382 2999.5n 0.5382 3000.0n 0.5822 3599.5n 0.5822 3600.0n 0.5639 4199.5n 0.5639 4200.0n 0.5685 4799.5n 0.5685 4800.0n 0.5450 5399.5n 0.5450 5400.0n 0.5535 5999.5n 0.5535 6000.0n 0.5525 6599.5n 0.5525 6600.0n 0.5477 7199.5n 0.5477 7200.0n 0.6050 7799.5n 0.6050 7800.0n 0.5788 8399.5n 0.5788 8400.0n 0.6050 8999.5n 0.6050 9000.0n 0.5721 9599.5n 0.5721 9600.0n 0.5788 10199.5n 0.5788 10200.0n 0.6050 10799.5n 0.6050 10800.0n 0.6050 11399.5n 0.6050 11400.0n 0.6050 11999.5n 0.6050 12000.0n 0.6050 12599.5n 0.6050 12600.0n 0.6050 13199.5n 0.6050 13200.0n 0.6050 13799.5n 0.6050 13800.0n 0.6050 14399.5n 0.6050)
Vyp_wih_7_4 yp_wih_7_4 0 PWL(0.0n 0.5160 599.5n 0.5160 600.0n 0.5086 1199.5n 0.5086 1200.0n 0.5001 1799.5n 0.5001 1800.0n 0.5217 2399.5n 0.5217 2400.0n 0.5463 2999.5n 0.5463 3000.0n 0.5015 3599.5n 0.5015 3600.0n 0.5109 4199.5n 0.5109 4200.0n 0.5504 4799.5n 0.5504 4800.0n 0.5503 5399.5n 0.5503 5400.0n 0.4766 5999.5n 0.4766 6000.0n 0.5582 6599.5n 0.5582 6600.0n 0.5345 7199.5n 0.5345 7200.0n 0.3736 7799.5n 0.3736 7800.0n 0.3485 8399.5n 0.3485 8400.0n 0.3489 8999.5n 0.3489 9000.0n 0.3772 9599.5n 0.3772 9600.0n 0.3490 10199.5n 0.3490 10200.0n 0.4136 10799.5n 0.4136 10800.0n 0.3518 11399.5n 0.3518 11400.0n 0.4597 11999.5n 0.4597 12000.0n 0.3479 12599.5n 0.3479 12600.0n 0.5550 13199.5n 0.5550 13200.0n 0.3458 13799.5n 0.3458 13800.0n 0.3913 14399.5n 0.3913)
Vyn_wih_7_4 yn_wih_7_4 0 PWL(0.0n 0.4840 599.5n 0.4840 600.0n 0.4914 1199.5n 0.4914 1200.0n 0.4999 1799.5n 0.4999 1800.0n 0.4783 2399.5n 0.4783 2400.0n 0.4537 2999.5n 0.4537 3000.0n 0.4985 3599.5n 0.4985 3600.0n 0.4891 4199.5n 0.4891 4200.0n 0.4496 4799.5n 0.4496 4800.0n 0.4497 5399.5n 0.4497 5400.0n 0.5234 5999.5n 0.5234 6000.0n 0.4418 6599.5n 0.4418 6600.0n 0.4655 7199.5n 0.4655 7200.0n 0.6264 7799.5n 0.6264 7800.0n 0.6515 8399.5n 0.6515 8400.0n 0.6511 8999.5n 0.6511 9000.0n 0.6228 9599.5n 0.6228 9600.0n 0.6510 10199.5n 0.6510 10200.0n 0.5864 10799.5n 0.5864 10800.0n 0.6482 11399.5n 0.6482 11400.0n 0.5403 11999.5n 0.5403 12000.0n 0.6521 12599.5n 0.6521 12600.0n 0.4450 13199.5n 0.4450 13200.0n 0.6542 13799.5n 0.6542 13800.0n 0.6087 14399.5n 0.6087)
Cwp_wih_7_4 wp_wih_7_4 0 400p
Cwn_wih_7_4 wn_wih_7_4 0 400p
Xu_wih_7_4 xp_wih_7_4 xn_wih_7_4 yp_wih_7_4 yn_wih_7_4 wp_wih_7_4 wn_wih_7_4 vdd gbn gprod
Vxp_who_4_0 xp_who_4_0 0 PWL(0.0n 0.5160 599.5n 0.5160 600.0n 0.5086 1199.5n 0.5086 1200.0n 0.5001 1799.5n 0.5001 1800.0n 0.5217 2399.5n 0.5217 2400.0n 0.5463 2999.5n 0.5463 3000.0n 0.5015 3599.5n 0.5015 3600.0n 0.5109 4199.5n 0.5109 4200.0n 0.5504 4799.5n 0.5504 4800.0n 0.5503 5399.5n 0.5503 5400.0n 0.4766 5999.5n 0.4766 6000.0n 0.5582 6599.5n 0.5582 6600.0n 0.5345 7199.5n 0.5345 7200.0n 0.3736 7799.5n 0.3736 7800.0n 0.3485 8399.5n 0.3485 8400.0n 0.3489 8999.5n 0.3489 9000.0n 0.3772 9599.5n 0.3772 9600.0n 0.3490 10199.5n 0.3490 10200.0n 0.4136 10799.5n 0.4136 10800.0n 0.3518 11399.5n 0.3518 11400.0n 0.4597 11999.5n 0.4597 12000.0n 0.3479 12599.5n 0.3479 12600.0n 0.5550 13199.5n 0.5550 13200.0n 0.3458 13799.5n 0.3458 13800.0n 0.3913 14399.5n 0.3913)
Vxn_who_4_0 xn_who_4_0 0 PWL(0.0n 0.4840 599.5n 0.4840 600.0n 0.4914 1199.5n 0.4914 1200.0n 0.4999 1799.5n 0.4999 1800.0n 0.4783 2399.5n 0.4783 2400.0n 0.4537 2999.5n 0.4537 3000.0n 0.4985 3599.5n 0.4985 3600.0n 0.4891 4199.5n 0.4891 4200.0n 0.4496 4799.5n 0.4496 4800.0n 0.4497 5399.5n 0.4497 5400.0n 0.5234 5999.5n 0.5234 6000.0n 0.4418 6599.5n 0.4418 6600.0n 0.4655 7199.5n 0.4655 7200.0n 0.6264 7799.5n 0.6264 7800.0n 0.6515 8399.5n 0.6515 8400.0n 0.6511 8999.5n 0.6511 9000.0n 0.6228 9599.5n 0.6228 9600.0n 0.6510 10199.5n 0.6510 10200.0n 0.5864 10799.5n 0.5864 10800.0n 0.6482 11399.5n 0.6482 11400.0n 0.5403 11999.5n 0.5403 12000.0n 0.6521 12599.5n 0.6521 12600.0n 0.4450 13199.5n 0.4450 13200.0n 0.6542 13799.5n 0.6542 13800.0n 0.6087 14399.5n 0.6087)
Vyp_who_4_0 yp_who_4_0 0 PWL(0.0n 0.5073 599.5n 0.5073 600.0n 0.5065 1199.5n 0.5065 1200.0n 0.5065 1799.5n 0.5065 1800.0n 0.5052 2399.5n 0.5052 2400.0n 0.5058 2999.5n 0.5058 3000.0n 0.5039 3599.5n 0.5039 3600.0n 0.5059 4199.5n 0.5059 4200.0n 0.5077 4799.5n 0.5077 4800.0n 0.5054 5399.5n 0.5054 5400.0n 0.5066 5999.5n 0.5066 6000.0n 0.5083 6599.5n 0.5083 6600.0n 0.5078 7199.5n 0.5078 7200.0n 0.5043 7799.5n 0.5043 7800.0n 0.5035 8399.5n 0.5035 8400.0n 0.5035 8999.5n 0.5035 9000.0n 0.5038 9599.5n 0.5038 9600.0n 0.5043 10199.5n 0.5043 10200.0n 0.5053 10799.5n 0.5053 10800.0n 0.5050 11399.5n 0.5050 11400.0n 0.5055 11999.5n 0.5055 12000.0n 0.5043 12599.5n 0.5043 12600.0n 0.5028 13199.5n 0.5028 13200.0n 0.5045 13799.5n 0.5045 13800.0n 0.5043 14399.5n 0.5043)
Vyn_who_4_0 yn_who_4_0 0 PWL(0.0n 0.4927 599.5n 0.4927 600.0n 0.4935 1199.5n 0.4935 1200.0n 0.4935 1799.5n 0.4935 1800.0n 0.4948 2399.5n 0.4948 2400.0n 0.4942 2999.5n 0.4942 3000.0n 0.4961 3599.5n 0.4961 3600.0n 0.4941 4199.5n 0.4941 4200.0n 0.4923 4799.5n 0.4923 4800.0n 0.4946 5399.5n 0.4946 5400.0n 0.4934 5999.5n 0.4934 6000.0n 0.4917 6599.5n 0.4917 6600.0n 0.4922 7199.5n 0.4922 7200.0n 0.4957 7799.5n 0.4957 7800.0n 0.4965 8399.5n 0.4965 8400.0n 0.4965 8999.5n 0.4965 9000.0n 0.4962 9599.5n 0.4962 9600.0n 0.4957 10199.5n 0.4957 10200.0n 0.4947 10799.5n 0.4947 10800.0n 0.4950 11399.5n 0.4950 11400.0n 0.4945 11999.5n 0.4945 12000.0n 0.4957 12599.5n 0.4957 12600.0n 0.4972 13199.5n 0.4972 13200.0n 0.4955 13799.5n 0.4955 13800.0n 0.4957 14399.5n 0.4957)
Cwp_who_4_0 wp_who_4_0 0 400p
Cwn_who_4_0 wn_who_4_0 0 400p
Xu_who_4_0 xp_who_4_0 xn_who_4_0 yp_who_4_0 yn_who_4_0 wp_who_4_0 wn_who_4_0 vdd gbn gprod
Vxp_who_4_1 xp_who_4_1 0 PWL(0.0n 0.5160 599.5n 0.5160 600.0n 0.5086 1199.5n 0.5086 1200.0n 0.5001 1799.5n 0.5001 1800.0n 0.5217 2399.5n 0.5217 2400.0n 0.5463 2999.5n 0.5463 3000.0n 0.5015 3599.5n 0.5015 3600.0n 0.5109 4199.5n 0.5109 4200.0n 0.5504 4799.5n 0.5504 4800.0n 0.5503 5399.5n 0.5503 5400.0n 0.4766 5999.5n 0.4766 6000.0n 0.5582 6599.5n 0.5582 6600.0n 0.5345 7199.5n 0.5345 7200.0n 0.3736 7799.5n 0.3736 7800.0n 0.3485 8399.5n 0.3485 8400.0n 0.3489 8999.5n 0.3489 9000.0n 0.3772 9599.5n 0.3772 9600.0n 0.3490 10199.5n 0.3490 10200.0n 0.4136 10799.5n 0.4136 10800.0n 0.3518 11399.5n 0.3518 11400.0n 0.4597 11999.5n 0.4597 12000.0n 0.3479 12599.5n 0.3479 12600.0n 0.5550 13199.5n 0.5550 13200.0n 0.3458 13799.5n 0.3458 13800.0n 0.3913 14399.5n 0.3913)
Vxn_who_4_1 xn_who_4_1 0 PWL(0.0n 0.4840 599.5n 0.4840 600.0n 0.4914 1199.5n 0.4914 1200.0n 0.4999 1799.5n 0.4999 1800.0n 0.4783 2399.5n 0.4783 2400.0n 0.4537 2999.5n 0.4537 3000.0n 0.4985 3599.5n 0.4985 3600.0n 0.4891 4199.5n 0.4891 4200.0n 0.4496 4799.5n 0.4496 4800.0n 0.4497 5399.5n 0.4497 5400.0n 0.5234 5999.5n 0.5234 6000.0n 0.4418 6599.5n 0.4418 6600.0n 0.4655 7199.5n 0.4655 7200.0n 0.6264 7799.5n 0.6264 7800.0n 0.6515 8399.5n 0.6515 8400.0n 0.6511 8999.5n 0.6511 9000.0n 0.6228 9599.5n 0.6228 9600.0n 0.6510 10199.5n 0.6510 10200.0n 0.5864 10799.5n 0.5864 10800.0n 0.6482 11399.5n 0.6482 11400.0n 0.5403 11999.5n 0.5403 12000.0n 0.6521 12599.5n 0.6521 12600.0n 0.4450 13199.5n 0.4450 13200.0n 0.6542 13799.5n 0.6542 13800.0n 0.6087 14399.5n 0.6087)
Vyp_who_4_1 yp_who_4_1 0 PWL(0.0n 0.4909 599.5n 0.4909 600.0n 0.4933 1199.5n 0.4933 1200.0n 0.4930 1799.5n 0.4930 1800.0n 0.4893 2399.5n 0.4893 2400.0n 0.4904 2999.5n 0.4904 3000.0n 0.4923 3599.5n 0.4923 3600.0n 0.4897 4199.5n 0.4897 4200.0n 0.4890 4799.5n 0.4890 4800.0n 0.4921 5399.5n 0.4921 5400.0n 0.4899 5999.5n 0.4899 6000.0n 0.4870 6599.5n 0.4870 6600.0n 0.4903 7199.5n 0.4903 7200.0n 0.4970 7799.5n 0.4970 7800.0n 0.4989 8399.5n 0.4989 8400.0n 0.4994 8999.5n 0.4994 9000.0n 0.4991 9599.5n 0.4991 9600.0n 0.5000 10199.5n 0.5000 10200.0n 0.4948 10799.5n 0.4948 10800.0n 0.4959 11399.5n 0.4959 11400.0n 0.4926 11999.5n 0.4926 12000.0n 0.4993 12599.5n 0.4993 12600.0n 0.4862 13199.5n 0.4862 13200.0n 0.4993 13799.5n 0.4993 13800.0n 0.4961 14399.5n 0.4961)
Vyn_who_4_1 yn_who_4_1 0 PWL(0.0n 0.5091 599.5n 0.5091 600.0n 0.5067 1199.5n 0.5067 1200.0n 0.5070 1799.5n 0.5070 1800.0n 0.5107 2399.5n 0.5107 2400.0n 0.5096 2999.5n 0.5096 3000.0n 0.5077 3599.5n 0.5077 3600.0n 0.5103 4199.5n 0.5103 4200.0n 0.5110 4799.5n 0.5110 4800.0n 0.5079 5399.5n 0.5079 5400.0n 0.5101 5999.5n 0.5101 6000.0n 0.5130 6599.5n 0.5130 6600.0n 0.5097 7199.5n 0.5097 7200.0n 0.5030 7799.5n 0.5030 7800.0n 0.5011 8399.5n 0.5011 8400.0n 0.5006 8999.5n 0.5006 9000.0n 0.5009 9599.5n 0.5009 9600.0n 0.5000 10199.5n 0.5000 10200.0n 0.5052 10799.5n 0.5052 10800.0n 0.5041 11399.5n 0.5041 11400.0n 0.5074 11999.5n 0.5074 12000.0n 0.5007 12599.5n 0.5007 12600.0n 0.5138 13199.5n 0.5138 13200.0n 0.5007 13799.5n 0.5007 13800.0n 0.5039 14399.5n 0.5039)
Cwp_who_4_1 wp_who_4_1 0 400p
Cwn_who_4_1 wn_who_4_1 0 400p
Xu_who_4_1 xp_who_4_1 xn_who_4_1 yp_who_4_1 yn_who_4_1 wp_who_4_1 wn_who_4_1 vdd gbn gprod
Vxp_bh_4 xp_bh_4 0 PWL(0.0n 0.7100 599.5n 0.7100 600.0n 0.7100 1199.5n 0.7100 1200.0n 0.7100 1799.5n 0.7100 1800.0n 0.7100 2399.5n 0.7100 2400.0n 0.7100 2999.5n 0.7100 3000.0n 0.7100 3599.5n 0.7100 3600.0n 0.7100 4199.5n 0.7100 4200.0n 0.7100 4799.5n 0.7100 4800.0n 0.7100 5399.5n 0.7100 5400.0n 0.7100 5999.5n 0.7100 6000.0n 0.7100 6599.5n 0.7100 6600.0n 0.7100 7199.5n 0.7100 7200.0n 0.7100 7799.5n 0.7100 7800.0n 0.7100 8399.5n 0.7100 8400.0n 0.7100 8999.5n 0.7100 9000.0n 0.7100 9599.5n 0.7100 9600.0n 0.7100 10199.5n 0.7100 10200.0n 0.7100 10799.5n 0.7100 10800.0n 0.7100 11399.5n 0.7100 11400.0n 0.7100 11999.5n 0.7100 12000.0n 0.7100 12599.5n 0.7100 12600.0n 0.7100 13199.5n 0.7100 13200.0n 0.7100 13799.5n 0.7100 13800.0n 0.7100 14399.5n 0.7100)
Vxn_bh_4 xn_bh_4 0 PWL(0.0n 0.2900 599.5n 0.2900 600.0n 0.2900 1199.5n 0.2900 1200.0n 0.2900 1799.5n 0.2900 1800.0n 0.2900 2399.5n 0.2900 2400.0n 0.2900 2999.5n 0.2900 3000.0n 0.2900 3599.5n 0.2900 3600.0n 0.2900 4199.5n 0.2900 4200.0n 0.2900 4799.5n 0.2900 4800.0n 0.2900 5399.5n 0.2900 5400.0n 0.2900 5999.5n 0.2900 6000.0n 0.2900 6599.5n 0.2900 6600.0n 0.2900 7199.5n 0.2900 7200.0n 0.2900 7799.5n 0.2900 7800.0n 0.2900 8399.5n 0.2900 8400.0n 0.2900 8999.5n 0.2900 9000.0n 0.2900 9599.5n 0.2900 9600.0n 0.2900 10199.5n 0.2900 10200.0n 0.2900 10799.5n 0.2900 10800.0n 0.2900 11399.5n 0.2900 11400.0n 0.2900 11999.5n 0.2900 12000.0n 0.2900 12599.5n 0.2900 12600.0n 0.2900 13199.5n 0.2900 13200.0n 0.2900 13799.5n 0.2900 13800.0n 0.2900 14399.5n 0.2900)
Vyp_bh_4 yp_bh_4 0 PWL(0.0n 0.5160 599.5n 0.5160 600.0n 0.5086 1199.5n 0.5086 1200.0n 0.5001 1799.5n 0.5001 1800.0n 0.5217 2399.5n 0.5217 2400.0n 0.5463 2999.5n 0.5463 3000.0n 0.5015 3599.5n 0.5015 3600.0n 0.5109 4199.5n 0.5109 4200.0n 0.5504 4799.5n 0.5504 4800.0n 0.5503 5399.5n 0.5503 5400.0n 0.4766 5999.5n 0.4766 6000.0n 0.5582 6599.5n 0.5582 6600.0n 0.5345 7199.5n 0.5345 7200.0n 0.3736 7799.5n 0.3736 7800.0n 0.3485 8399.5n 0.3485 8400.0n 0.3489 8999.5n 0.3489 9000.0n 0.3772 9599.5n 0.3772 9600.0n 0.3490 10199.5n 0.3490 10200.0n 0.4136 10799.5n 0.4136 10800.0n 0.3518 11399.5n 0.3518 11400.0n 0.4597 11999.5n 0.4597 12000.0n 0.3479 12599.5n 0.3479 12600.0n 0.5550 13199.5n 0.5550 13200.0n 0.3458 13799.5n 0.3458 13800.0n 0.3913 14399.5n 0.3913)
Vyn_bh_4 yn_bh_4 0 PWL(0.0n 0.4840 599.5n 0.4840 600.0n 0.4914 1199.5n 0.4914 1200.0n 0.4999 1799.5n 0.4999 1800.0n 0.4783 2399.5n 0.4783 2400.0n 0.4537 2999.5n 0.4537 3000.0n 0.4985 3599.5n 0.4985 3600.0n 0.4891 4199.5n 0.4891 4200.0n 0.4496 4799.5n 0.4496 4800.0n 0.4497 5399.5n 0.4497 5400.0n 0.5234 5999.5n 0.5234 6000.0n 0.4418 6599.5n 0.4418 6600.0n 0.4655 7199.5n 0.4655 7200.0n 0.6264 7799.5n 0.6264 7800.0n 0.6515 8399.5n 0.6515 8400.0n 0.6511 8999.5n 0.6511 9000.0n 0.6228 9599.5n 0.6228 9600.0n 0.6510 10199.5n 0.6510 10200.0n 0.5864 10799.5n 0.5864 10800.0n 0.6482 11399.5n 0.6482 11400.0n 0.5403 11999.5n 0.5403 12000.0n 0.6521 12599.5n 0.6521 12600.0n 0.4450 13199.5n 0.4450 13200.0n 0.6542 13799.5n 0.6542 13800.0n 0.6087 14399.5n 0.6087)
Cwp_bh_4 wp_bh_4 0 400p
Cwn_bh_4 wn_bh_4 0 400p
Xu_bh_4 xp_bh_4 xn_bh_4 yp_bh_4 yn_bh_4 wp_bh_4 wn_bh_4 vdd gbn gprod
Vxp_wih_2_5 xp_wih_2_5 0 PWL(0.0n 0.5073 599.5n 0.5073 600.0n 0.6050 1199.5n 0.6050 1200.0n 0.5896 1799.5n 0.5896 1800.0n 0.5668 2399.5n 0.5668 2400.0n 0.5620 2999.5n 0.5620 3000.0n 0.5000 3599.5n 0.5000 3600.0n 0.5274 4199.5n 0.5274 4200.0n 0.5867 4799.5n 0.5867 4800.0n 0.5675 5399.5n 0.5675 5400.0n 0.5971 5999.5n 0.5971 6000.0n 0.5525 6599.5n 0.5525 6600.0n 0.6050 7199.5n 0.6050 7200.0n 0.5144 7799.5n 0.5144 7800.0n 0.5952 8399.5n 0.5952 8400.0n 0.5637 8999.5n 0.5637 9000.0n 0.6050 9599.5n 0.6050 9600.0n 0.5689 10199.5n 0.5689 10200.0n 0.6050 10799.5n 0.6050 10800.0n 0.5512 11399.5n 0.5512 11400.0n 0.5169 11999.5n 0.5169 12000.0n 0.5935 12599.5n 0.5935 12600.0n 0.4484 13199.5n 0.4484 13200.0n 0.5917 13799.5n 0.5917 13800.0n 0.5508 14399.5n 0.5508)
Vxn_wih_2_5 xn_wih_2_5 0 PWL(0.0n 0.4927 599.5n 0.4927 600.0n 0.3950 1199.5n 0.3950 1200.0n 0.4104 1799.5n 0.4104 1800.0n 0.4332 2399.5n 0.4332 2400.0n 0.4380 2999.5n 0.4380 3000.0n 0.5000 3599.5n 0.5000 3600.0n 0.4726 4199.5n 0.4726 4200.0n 0.4133 4799.5n 0.4133 4800.0n 0.4325 5399.5n 0.4325 5400.0n 0.4029 5999.5n 0.4029 6000.0n 0.4475 6599.5n 0.4475 6600.0n 0.3950 7199.5n 0.3950 7200.0n 0.4856 7799.5n 0.4856 7800.0n 0.4048 8399.5n 0.4048 8400.0n 0.4363 8999.5n 0.4363 9000.0n 0.3950 9599.5n 0.3950 9600.0n 0.4311 10199.5n 0.4311 10200.0n 0.3950 10799.5n 0.3950 10800.0n 0.4488 11399.5n 0.4488 11400.0n 0.4831 11999.5n 0.4831 12000.0n 0.4065 12599.5n 0.4065 12600.0n 0.5516 13199.5n 0.5516 13200.0n 0.4083 13799.5n 0.4083 13800.0n 0.4492 14399.5n 0.4492)
Vyp_wih_2_5 yp_wih_2_5 0 PWL(0.0n 0.5088 599.5n 0.5088 600.0n 0.4862 1199.5n 0.4862 1200.0n 0.4785 1799.5n 0.4785 1800.0n 0.4708 2399.5n 0.4708 2400.0n 0.4723 2999.5n 0.4723 3000.0n 0.5122 3599.5n 0.5122 3600.0n 0.5052 4199.5n 0.5052 4200.0n 0.4283 4799.5n 0.4283 4800.0n 0.4602 5399.5n 0.4602 5400.0n 0.4927 5999.5n 0.4927 6000.0n 0.4643 6599.5n 0.4643 6600.0n 0.4495 7199.5n 0.4495 7200.0n 0.6050 7799.5n 0.6050 7800.0n 0.5938 8399.5n 0.5938 8400.0n 0.6017 8999.5n 0.6017 9000.0n 0.5656 9599.5n 0.5656 9600.0n 0.6169 10199.5n 0.6169 10200.0n 0.5135 10799.5n 0.5135 10800.0n 0.6080 11399.5n 0.6080 11400.0n 0.5330 11999.5n 0.5330 12000.0n 0.5804 12599.5n 0.5804 12600.0n 0.4913 13199.5n 0.4913 13200.0n 0.5870 13799.5n 0.5870 13800.0n 0.5707 14399.5n 0.5707)
Vyn_wih_2_5 yn_wih_2_5 0 PWL(0.0n 0.4912 599.5n 0.4912 600.0n 0.5138 1199.5n 0.5138 1200.0n 0.5215 1799.5n 0.5215 1800.0n 0.5292 2399.5n 0.5292 2400.0n 0.5277 2999.5n 0.5277 3000.0n 0.4878 3599.5n 0.4878 3600.0n 0.4948 4199.5n 0.4948 4200.0n 0.5717 4799.5n 0.5717 4800.0n 0.5398 5399.5n 0.5398 5400.0n 0.5073 5999.5n 0.5073 6000.0n 0.5357 6599.5n 0.5357 6600.0n 0.5505 7199.5n 0.5505 7200.0n 0.3950 7799.5n 0.3950 7800.0n 0.4062 8399.5n 0.4062 8400.0n 0.3983 8999.5n 0.3983 9000.0n 0.4344 9599.5n 0.4344 9600.0n 0.3831 10199.5n 0.3831 10200.0n 0.4865 10799.5n 0.4865 10800.0n 0.3920 11399.5n 0.3920 11400.0n 0.4670 11999.5n 0.4670 12000.0n 0.4196 12599.5n 0.4196 12600.0n 0.5087 13199.5n 0.5087 13200.0n 0.4130 13799.5n 0.4130 13800.0n 0.4293 14399.5n 0.4293)
Cwp_wih_2_5 wp_wih_2_5 0 400p
Cwn_wih_2_5 wn_wih_2_5 0 400p
Xu_wih_2_5 xp_wih_2_5 xn_wih_2_5 yp_wih_2_5 yn_wih_2_5 wp_wih_2_5 wn_wih_2_5 vdd gbn gprod
Vxp_wih_3_5 xp_wih_3_5 0 PWL(0.0n 0.4048 599.5n 0.4048 600.0n 0.4386 1199.5n 0.4386 1200.0n 0.3950 1799.5n 0.3950 1800.0n 0.3950 2399.5n 0.3950 2400.0n 0.3950 2999.5n 0.3950 3000.0n 0.3950 3599.5n 0.3950 3600.0n 0.3950 4199.5n 0.3950 4200.0n 0.3950 4799.5n 0.3950 4800.0n 0.4025 5399.5n 0.4025 5400.0n 0.4069 5999.5n 0.4069 6000.0n 0.3950 6599.5n 0.3950 6600.0n 0.4045 7199.5n 0.4045 7200.0n 0.3950 7799.5n 0.3950 7800.0n 0.4311 8399.5n 0.4311 8400.0n 0.3984 8999.5n 0.3984 9000.0n 0.4362 9599.5n 0.4362 9600.0n 0.4475 10199.5n 0.4475 10200.0n 0.3950 10799.5n 0.3950 10800.0n 0.3950 11399.5n 0.3950 11400.0n 0.3950 11999.5n 0.3950 12000.0n 0.3950 12599.5n 0.3950 12600.0n 0.3950 13199.5n 0.3950 13200.0n 0.4083 13799.5n 0.4083 13800.0n 0.3950 14399.5n 0.3950)
Vxn_wih_3_5 xn_wih_3_5 0 PWL(0.0n 0.5952 599.5n 0.5952 600.0n 0.5614 1199.5n 0.5614 1200.0n 0.6050 1799.5n 0.6050 1800.0n 0.6050 2399.5n 0.6050 2400.0n 0.6050 2999.5n 0.6050 3000.0n 0.6050 3599.5n 0.6050 3600.0n 0.6050 4199.5n 0.6050 4200.0n 0.6050 4799.5n 0.6050 4800.0n 0.5975 5399.5n 0.5975 5400.0n 0.5931 5999.5n 0.5931 6000.0n 0.6050 6599.5n 0.6050 6600.0n 0.5955 7199.5n 0.5955 7200.0n 0.6050 7799.5n 0.6050 7800.0n 0.5689 8399.5n 0.5689 8400.0n 0.6016 8999.5n 0.6016 9000.0n 0.5638 9599.5n 0.5638 9600.0n 0.5525 10199.5n 0.5525 10200.0n 0.6050 10799.5n 0.6050 10800.0n 0.6050 11399.5n 0.6050 11400.0n 0.6050 11999.5n 0.6050 12000.0n 0.6050 12599.5n 0.6050 12600.0n 0.6050 13199.5n 0.6050 13200.0n 0.5917 13799.5n 0.5917 13800.0n 0.6050 14399.5n 0.6050)
Vyp_wih_3_5 yp_wih_3_5 0 PWL(0.0n 0.5088 599.5n 0.5088 600.0n 0.4862 1199.5n 0.4862 1200.0n 0.4785 1799.5n 0.4785 1800.0n 0.4708 2399.5n 0.4708 2400.0n 0.4723 2999.5n 0.4723 3000.0n 0.5122 3599.5n 0.5122 3600.0n 0.5052 4199.5n 0.5052 4200.0n 0.4283 4799.5n 0.4283 4800.0n 0.4602 5399.5n 0.4602 5400.0n 0.4927 5999.5n 0.4927 6000.0n 0.4643 6599.5n 0.4643 6600.0n 0.4495 7199.5n 0.4495 7200.0n 0.6050 7799.5n 0.6050 7800.0n 0.5938 8399.5n 0.5938 8400.0n 0.6017 8999.5n 0.6017 9000.0n 0.5656 9599.5n 0.5656 9600.0n 0.6169 10199.5n 0.6169 10200.0n 0.5135 10799.5n 0.5135 10800.0n 0.6080 11399.5n 0.6080 11400.0n 0.5330 11999.5n 0.5330 12000.0n 0.5804 12599.5n 0.5804 12600.0n 0.4913 13199.5n 0.4913 13200.0n 0.5870 13799.5n 0.5870 13800.0n 0.5707 14399.5n 0.5707)
Vyn_wih_3_5 yn_wih_3_5 0 PWL(0.0n 0.4912 599.5n 0.4912 600.0n 0.5138 1199.5n 0.5138 1200.0n 0.5215 1799.5n 0.5215 1800.0n 0.5292 2399.5n 0.5292 2400.0n 0.5277 2999.5n 0.5277 3000.0n 0.4878 3599.5n 0.4878 3600.0n 0.4948 4199.5n 0.4948 4200.0n 0.5717 4799.5n 0.5717 4800.0n 0.5398 5399.5n 0.5398 5400.0n 0.5073 5999.5n 0.5073 6000.0n 0.5357 6599.5n 0.5357 6600.0n 0.5505 7199.5n 0.5505 7200.0n 0.3950 7799.5n 0.3950 7800.0n 0.4062 8399.5n 0.4062 8400.0n 0.3983 8999.5n 0.3983 9000.0n 0.4344 9599.5n 0.4344 9600.0n 0.3831 10199.5n 0.3831 10200.0n 0.4865 10799.5n 0.4865 10800.0n 0.3920 11399.5n 0.3920 11400.0n 0.4670 11999.5n 0.4670 12000.0n 0.4196 12599.5n 0.4196 12600.0n 0.5087 13199.5n 0.5087 13200.0n 0.4130 13799.5n 0.4130 13800.0n 0.4293 14399.5n 0.4293)
Cwp_wih_3_5 wp_wih_3_5 0 400p
Cwn_wih_3_5 wn_wih_3_5 0 400p
Xu_wih_3_5 xp_wih_3_5 xn_wih_3_5 yp_wih_3_5 yn_wih_3_5 wp_wih_3_5 wn_wih_3_5 vdd gbn gprod
Vxp_wih_6_5 xp_wih_6_5 0 PWL(0.0n 0.4927 599.5n 0.4927 600.0n 0.5059 1199.5n 0.5059 1200.0n 0.5128 1799.5n 0.5128 1800.0n 0.4857 2399.5n 0.4857 2400.0n 0.4857 2999.5n 0.4857 3000.0n 0.4909 3599.5n 0.4909 3600.0n 0.5000 4199.5n 0.5000 4200.0n 0.4543 4799.5n 0.4543 4800.0n 0.4737 5399.5n 0.4737 5400.0n 0.5297 5999.5n 0.5297 6000.0n 0.4694 6599.5n 0.4694 6600.0n 0.4809 7199.5n 0.4809 7200.0n 0.5762 7799.5n 0.5762 7800.0n 0.6050 8399.5n 0.6050 8400.0n 0.6050 8999.5n 0.6050 9000.0n 0.5679 9599.5n 0.5679 9600.0n 0.6050 10199.5n 0.6050 10200.0n 0.5428 10799.5n 0.5428 10800.0n 0.6050 11399.5n 0.6050 11400.0n 0.5203 11999.5n 0.5203 12000.0n 0.5974 12599.5n 0.5974 12600.0n 0.4519 13199.5n 0.4519 13200.0n 0.6050 13799.5n 0.6050 13800.0n 0.5610 14399.5n 0.5610)
Vxn_wih_6_5 xn_wih_6_5 0 PWL(0.0n 0.5073 599.5n 0.5073 600.0n 0.4941 1199.5n 0.4941 1200.0n 0.4872 1799.5n 0.4872 1800.0n 0.5143 2399.5n 0.5143 2400.0n 0.5143 2999.5n 0.5143 3000.0n 0.5091 3599.5n 0.5091 3600.0n 0.5000 4199.5n 0.5000 4200.0n 0.5457 4799.5n 0.5457 4800.0n 0.5263 5399.5n 0.5263 5400.0n 0.4703 5999.5n 0.4703 6000.0n 0.5306 6599.5n 0.5306 6600.0n 0.5191 7199.5n 0.5191 7200.0n 0.4238 7799.5n 0.4238 7800.0n 0.3950 8399.5n 0.3950 8400.0n 0.3950 8999.5n 0.3950 9000.0n 0.4321 9599.5n 0.4321 9600.0n 0.3950 10199.5n 0.3950 10200.0n 0.4572 10799.5n 0.4572 10800.0n 0.3950 11399.5n 0.3950 11400.0n 0.4797 11999.5n 0.4797 12000.0n 0.4026 12599.5n 0.4026 12600.0n 0.5481 13199.5n 0.5481 13200.0n 0.3950 13799.5n 0.3950 13800.0n 0.4390 14399.5n 0.4390)
Vyp_wih_6_5 yp_wih_6_5 0 PWL(0.0n 0.5088 599.5n 0.5088 600.0n 0.4862 1199.5n 0.4862 1200.0n 0.4785 1799.5n 0.4785 1800.0n 0.4708 2399.5n 0.4708 2400.0n 0.4723 2999.5n 0.4723 3000.0n 0.5122 3599.5n 0.5122 3600.0n 0.5052 4199.5n 0.5052 4200.0n 0.4283 4799.5n 0.4283 4800.0n 0.4602 5399.5n 0.4602 5400.0n 0.4927 5999.5n 0.4927 6000.0n 0.4643 6599.5n 0.4643 6600.0n 0.4495 7199.5n 0.4495 7200.0n 0.6050 7799.5n 0.6050 7800.0n 0.5938 8399.5n 0.5938 8400.0n 0.6017 8999.5n 0.6017 9000.0n 0.5656 9599.5n 0.5656 9600.0n 0.6169 10199.5n 0.6169 10200.0n 0.5135 10799.5n 0.5135 10800.0n 0.6080 11399.5n 0.6080 11400.0n 0.5330 11999.5n 0.5330 12000.0n 0.5804 12599.5n 0.5804 12600.0n 0.4913 13199.5n 0.4913 13200.0n 0.5870 13799.5n 0.5870 13800.0n 0.5707 14399.5n 0.5707)
Vyn_wih_6_5 yn_wih_6_5 0 PWL(0.0n 0.4912 599.5n 0.4912 600.0n 0.5138 1199.5n 0.5138 1200.0n 0.5215 1799.5n 0.5215 1800.0n 0.5292 2399.5n 0.5292 2400.0n 0.5277 2999.5n 0.5277 3000.0n 0.4878 3599.5n 0.4878 3600.0n 0.4948 4199.5n 0.4948 4200.0n 0.5717 4799.5n 0.5717 4800.0n 0.5398 5399.5n 0.5398 5400.0n 0.5073 5999.5n 0.5073 6000.0n 0.5357 6599.5n 0.5357 6600.0n 0.5505 7199.5n 0.5505 7200.0n 0.3950 7799.5n 0.3950 7800.0n 0.4062 8399.5n 0.4062 8400.0n 0.3983 8999.5n 0.3983 9000.0n 0.4344 9599.5n 0.4344 9600.0n 0.3831 10199.5n 0.3831 10200.0n 0.4865 10799.5n 0.4865 10800.0n 0.3920 11399.5n 0.3920 11400.0n 0.4670 11999.5n 0.4670 12000.0n 0.4196 12599.5n 0.4196 12600.0n 0.5087 13199.5n 0.5087 13200.0n 0.4130 13799.5n 0.4130 13800.0n 0.4293 14399.5n 0.4293)
Cwp_wih_6_5 wp_wih_6_5 0 400p
Cwn_wih_6_5 wn_wih_6_5 0 400p
Xu_wih_6_5 xp_wih_6_5 xn_wih_6_5 yp_wih_6_5 yn_wih_6_5 wp_wih_6_5 wn_wih_6_5 vdd gbn gprod
Vxp_wih_7_5 xp_wih_7_5 0 PWL(0.0n 0.4341 599.5n 0.4341 600.0n 0.4663 1199.5n 0.4663 1200.0n 0.4513 1799.5n 0.4513 1800.0n 0.4380 2399.5n 0.4380 2400.0n 0.4618 2999.5n 0.4618 3000.0n 0.4178 3599.5n 0.4178 3600.0n 0.4361 4199.5n 0.4361 4200.0n 0.4315 4799.5n 0.4315 4800.0n 0.4550 5399.5n 0.4550 5400.0n 0.4465 5999.5n 0.4465 6000.0n 0.4475 6599.5n 0.4475 6600.0n 0.4523 7199.5n 0.4523 7200.0n 0.3950 7799.5n 0.3950 7800.0n 0.4212 8399.5n 0.4212 8400.0n 0.3950 8999.5n 0.3950 9000.0n 0.4279 9599.5n 0.4279 9600.0n 0.4212 10199.5n 0.4212 10200.0n 0.3950 10799.5n 0.3950 10800.0n 0.3950 11399.5n 0.3950 11400.0n 0.3950 11999.5n 0.3950 12000.0n 0.3950 12599.5n 0.3950 12600.0n 0.3950 13199.5n 0.3950 13200.0n 0.3950 13799.5n 0.3950 13800.0n 0.3950 14399.5n 0.3950)
Vxn_wih_7_5 xn_wih_7_5 0 PWL(0.0n 0.5659 599.5n 0.5659 600.0n 0.5337 1199.5n 0.5337 1200.0n 0.5487 1799.5n 0.5487 1800.0n 0.5620 2399.5n 0.5620 2400.0n 0.5382 2999.5n 0.5382 3000.0n 0.5822 3599.5n 0.5822 3600.0n 0.5639 4199.5n 0.5639 4200.0n 0.5685 4799.5n 0.5685 4800.0n 0.5450 5399.5n 0.5450 5400.0n 0.5535 5999.5n 0.5535 6000.0n 0.5525 6599.5n 0.5525 6600.0n 0.5477 7199.5n 0.5477 7200.0n 0.6050 7799.5n 0.6050 7800.0n 0.5788 8399.5n 0.5788 8400.0n 0.6050 8999.5n 0.6050 9000.0n 0.5721 9599.5n 0.5721 9600.0n 0.5788 10199.5n 0.5788 10200.0n 0.6050 10799.5n 0.6050 10800.0n 0.6050 11399.5n 0.6050 11400.0n 0.6050 11999.5n 0.6050 12000.0n 0.6050 12599.5n 0.6050 12600.0n 0.6050 13199.5n 0.6050 13200.0n 0.6050 13799.5n 0.6050 13800.0n 0.6050 14399.5n 0.6050)
Vyp_wih_7_5 yp_wih_7_5 0 PWL(0.0n 0.5088 599.5n 0.5088 600.0n 0.4862 1199.5n 0.4862 1200.0n 0.4785 1799.5n 0.4785 1800.0n 0.4708 2399.5n 0.4708 2400.0n 0.4723 2999.5n 0.4723 3000.0n 0.5122 3599.5n 0.5122 3600.0n 0.5052 4199.5n 0.5052 4200.0n 0.4283 4799.5n 0.4283 4800.0n 0.4602 5399.5n 0.4602 5400.0n 0.4927 5999.5n 0.4927 6000.0n 0.4643 6599.5n 0.4643 6600.0n 0.4495 7199.5n 0.4495 7200.0n 0.6050 7799.5n 0.6050 7800.0n 0.5938 8399.5n 0.5938 8400.0n 0.6017 8999.5n 0.6017 9000.0n 0.5656 9599.5n 0.5656 9600.0n 0.6169 10199.5n 0.6169 10200.0n 0.5135 10799.5n 0.5135 10800.0n 0.6080 11399.5n 0.6080 11400.0n 0.5330 11999.5n 0.5330 12000.0n 0.5804 12599.5n 0.5804 12600.0n 0.4913 13199.5n 0.4913 13200.0n 0.5870 13799.5n 0.5870 13800.0n 0.5707 14399.5n 0.5707)
Vyn_wih_7_5 yn_wih_7_5 0 PWL(0.0n 0.4912 599.5n 0.4912 600.0n 0.5138 1199.5n 0.5138 1200.0n 0.5215 1799.5n 0.5215 1800.0n 0.5292 2399.5n 0.5292 2400.0n 0.5277 2999.5n 0.5277 3000.0n 0.4878 3599.5n 0.4878 3600.0n 0.4948 4199.5n 0.4948 4200.0n 0.5717 4799.5n 0.5717 4800.0n 0.5398 5399.5n 0.5398 5400.0n 0.5073 5999.5n 0.5073 6000.0n 0.5357 6599.5n 0.5357 6600.0n 0.5505 7199.5n 0.5505 7200.0n 0.3950 7799.5n 0.3950 7800.0n 0.4062 8399.5n 0.4062 8400.0n 0.3983 8999.5n 0.3983 9000.0n 0.4344 9599.5n 0.4344 9600.0n 0.3831 10199.5n 0.3831 10200.0n 0.4865 10799.5n 0.4865 10800.0n 0.3920 11399.5n 0.3920 11400.0n 0.4670 11999.5n 0.4670 12000.0n 0.4196 12599.5n 0.4196 12600.0n 0.5087 13199.5n 0.5087 13200.0n 0.4130 13799.5n 0.4130 13800.0n 0.4293 14399.5n 0.4293)
Cwp_wih_7_5 wp_wih_7_5 0 400p
Cwn_wih_7_5 wn_wih_7_5 0 400p
Xu_wih_7_5 xp_wih_7_5 xn_wih_7_5 yp_wih_7_5 yn_wih_7_5 wp_wih_7_5 wn_wih_7_5 vdd gbn gprod
Vxp_who_5_0 xp_who_5_0 0 PWL(0.0n 0.5088 599.5n 0.5088 600.0n 0.4862 1199.5n 0.4862 1200.0n 0.4785 1799.5n 0.4785 1800.0n 0.4708 2399.5n 0.4708 2400.0n 0.4723 2999.5n 0.4723 3000.0n 0.5122 3599.5n 0.5122 3600.0n 0.5052 4199.5n 0.5052 4200.0n 0.4283 4799.5n 0.4283 4800.0n 0.4602 5399.5n 0.4602 5400.0n 0.4927 5999.5n 0.4927 6000.0n 0.4643 6599.5n 0.4643 6600.0n 0.4495 7199.5n 0.4495 7200.0n 0.6050 7799.5n 0.6050 7800.0n 0.5938 8399.5n 0.5938 8400.0n 0.6017 8999.5n 0.6017 9000.0n 0.5656 9599.5n 0.5656 9600.0n 0.6169 10199.5n 0.6169 10200.0n 0.5135 10799.5n 0.5135 10800.0n 0.6080 11399.5n 0.6080 11400.0n 0.5330 11999.5n 0.5330 12000.0n 0.5804 12599.5n 0.5804 12600.0n 0.4913 13199.5n 0.4913 13200.0n 0.5870 13799.5n 0.5870 13800.0n 0.5707 14399.5n 0.5707)
Vxn_who_5_0 xn_who_5_0 0 PWL(0.0n 0.4912 599.5n 0.4912 600.0n 0.5138 1199.5n 0.5138 1200.0n 0.5215 1799.5n 0.5215 1800.0n 0.5292 2399.5n 0.5292 2400.0n 0.5277 2999.5n 0.5277 3000.0n 0.4878 3599.5n 0.4878 3600.0n 0.4948 4199.5n 0.4948 4200.0n 0.5717 4799.5n 0.5717 4800.0n 0.5398 5399.5n 0.5398 5400.0n 0.5073 5999.5n 0.5073 6000.0n 0.5357 6599.5n 0.5357 6600.0n 0.5505 7199.5n 0.5505 7200.0n 0.3950 7799.5n 0.3950 7800.0n 0.4062 8399.5n 0.4062 8400.0n 0.3983 8999.5n 0.3983 9000.0n 0.4344 9599.5n 0.4344 9600.0n 0.3831 10199.5n 0.3831 10200.0n 0.4865 10799.5n 0.4865 10800.0n 0.3920 11399.5n 0.3920 11400.0n 0.4670 11999.5n 0.4670 12000.0n 0.4196 12599.5n 0.4196 12600.0n 0.5087 13199.5n 0.5087 13200.0n 0.4130 13799.5n 0.4130 13800.0n 0.4293 14399.5n 0.4293)
Vyp_who_5_0 yp_who_5_0 0 PWL(0.0n 0.5073 599.5n 0.5073 600.0n 0.5065 1199.5n 0.5065 1200.0n 0.5065 1799.5n 0.5065 1800.0n 0.5052 2399.5n 0.5052 2400.0n 0.5058 2999.5n 0.5058 3000.0n 0.5039 3599.5n 0.5039 3600.0n 0.5059 4199.5n 0.5059 4200.0n 0.5077 4799.5n 0.5077 4800.0n 0.5054 5399.5n 0.5054 5400.0n 0.5066 5999.5n 0.5066 6000.0n 0.5083 6599.5n 0.5083 6600.0n 0.5078 7199.5n 0.5078 7200.0n 0.5043 7799.5n 0.5043 7800.0n 0.5035 8399.5n 0.5035 8400.0n 0.5035 8999.5n 0.5035 9000.0n 0.5038 9599.5n 0.5038 9600.0n 0.5043 10199.5n 0.5043 10200.0n 0.5053 10799.5n 0.5053 10800.0n 0.5050 11399.5n 0.5050 11400.0n 0.5055 11999.5n 0.5055 12000.0n 0.5043 12599.5n 0.5043 12600.0n 0.5028 13199.5n 0.5028 13200.0n 0.5045 13799.5n 0.5045 13800.0n 0.5043 14399.5n 0.5043)
Vyn_who_5_0 yn_who_5_0 0 PWL(0.0n 0.4927 599.5n 0.4927 600.0n 0.4935 1199.5n 0.4935 1200.0n 0.4935 1799.5n 0.4935 1800.0n 0.4948 2399.5n 0.4948 2400.0n 0.4942 2999.5n 0.4942 3000.0n 0.4961 3599.5n 0.4961 3600.0n 0.4941 4199.5n 0.4941 4200.0n 0.4923 4799.5n 0.4923 4800.0n 0.4946 5399.5n 0.4946 5400.0n 0.4934 5999.5n 0.4934 6000.0n 0.4917 6599.5n 0.4917 6600.0n 0.4922 7199.5n 0.4922 7200.0n 0.4957 7799.5n 0.4957 7800.0n 0.4965 8399.5n 0.4965 8400.0n 0.4965 8999.5n 0.4965 9000.0n 0.4962 9599.5n 0.4962 9600.0n 0.4957 10199.5n 0.4957 10200.0n 0.4947 10799.5n 0.4947 10800.0n 0.4950 11399.5n 0.4950 11400.0n 0.4945 11999.5n 0.4945 12000.0n 0.4957 12599.5n 0.4957 12600.0n 0.4972 13199.5n 0.4972 13200.0n 0.4955 13799.5n 0.4955 13800.0n 0.4957 14399.5n 0.4957)
Cwp_who_5_0 wp_who_5_0 0 400p
Cwn_who_5_0 wn_who_5_0 0 400p
Xu_who_5_0 xp_who_5_0 xn_who_5_0 yp_who_5_0 yn_who_5_0 wp_who_5_0 wn_who_5_0 vdd gbn gprod
Vxp_who_5_1 xp_who_5_1 0 PWL(0.0n 0.5088 599.5n 0.5088 600.0n 0.4862 1199.5n 0.4862 1200.0n 0.4785 1799.5n 0.4785 1800.0n 0.4708 2399.5n 0.4708 2400.0n 0.4723 2999.5n 0.4723 3000.0n 0.5122 3599.5n 0.5122 3600.0n 0.5052 4199.5n 0.5052 4200.0n 0.4283 4799.5n 0.4283 4800.0n 0.4602 5399.5n 0.4602 5400.0n 0.4927 5999.5n 0.4927 6000.0n 0.4643 6599.5n 0.4643 6600.0n 0.4495 7199.5n 0.4495 7200.0n 0.6050 7799.5n 0.6050 7800.0n 0.5938 8399.5n 0.5938 8400.0n 0.6017 8999.5n 0.6017 9000.0n 0.5656 9599.5n 0.5656 9600.0n 0.6169 10199.5n 0.6169 10200.0n 0.5135 10799.5n 0.5135 10800.0n 0.6080 11399.5n 0.6080 11400.0n 0.5330 11999.5n 0.5330 12000.0n 0.5804 12599.5n 0.5804 12600.0n 0.4913 13199.5n 0.4913 13200.0n 0.5870 13799.5n 0.5870 13800.0n 0.5707 14399.5n 0.5707)
Vxn_who_5_1 xn_who_5_1 0 PWL(0.0n 0.4912 599.5n 0.4912 600.0n 0.5138 1199.5n 0.5138 1200.0n 0.5215 1799.5n 0.5215 1800.0n 0.5292 2399.5n 0.5292 2400.0n 0.5277 2999.5n 0.5277 3000.0n 0.4878 3599.5n 0.4878 3600.0n 0.4948 4199.5n 0.4948 4200.0n 0.5717 4799.5n 0.5717 4800.0n 0.5398 5399.5n 0.5398 5400.0n 0.5073 5999.5n 0.5073 6000.0n 0.5357 6599.5n 0.5357 6600.0n 0.5505 7199.5n 0.5505 7200.0n 0.3950 7799.5n 0.3950 7800.0n 0.4062 8399.5n 0.4062 8400.0n 0.3983 8999.5n 0.3983 9000.0n 0.4344 9599.5n 0.4344 9600.0n 0.3831 10199.5n 0.3831 10200.0n 0.4865 10799.5n 0.4865 10800.0n 0.3920 11399.5n 0.3920 11400.0n 0.4670 11999.5n 0.4670 12000.0n 0.4196 12599.5n 0.4196 12600.0n 0.5087 13199.5n 0.5087 13200.0n 0.4130 13799.5n 0.4130 13800.0n 0.4293 14399.5n 0.4293)
Vyp_who_5_1 yp_who_5_1 0 PWL(0.0n 0.4909 599.5n 0.4909 600.0n 0.4933 1199.5n 0.4933 1200.0n 0.4930 1799.5n 0.4930 1800.0n 0.4893 2399.5n 0.4893 2400.0n 0.4904 2999.5n 0.4904 3000.0n 0.4923 3599.5n 0.4923 3600.0n 0.4897 4199.5n 0.4897 4200.0n 0.4890 4799.5n 0.4890 4800.0n 0.4921 5399.5n 0.4921 5400.0n 0.4899 5999.5n 0.4899 6000.0n 0.4870 6599.5n 0.4870 6600.0n 0.4903 7199.5n 0.4903 7200.0n 0.4970 7799.5n 0.4970 7800.0n 0.4989 8399.5n 0.4989 8400.0n 0.4994 8999.5n 0.4994 9000.0n 0.4991 9599.5n 0.4991 9600.0n 0.5000 10199.5n 0.5000 10200.0n 0.4948 10799.5n 0.4948 10800.0n 0.4959 11399.5n 0.4959 11400.0n 0.4926 11999.5n 0.4926 12000.0n 0.4993 12599.5n 0.4993 12600.0n 0.4862 13199.5n 0.4862 13200.0n 0.4993 13799.5n 0.4993 13800.0n 0.4961 14399.5n 0.4961)
Vyn_who_5_1 yn_who_5_1 0 PWL(0.0n 0.5091 599.5n 0.5091 600.0n 0.5067 1199.5n 0.5067 1200.0n 0.5070 1799.5n 0.5070 1800.0n 0.5107 2399.5n 0.5107 2400.0n 0.5096 2999.5n 0.5096 3000.0n 0.5077 3599.5n 0.5077 3600.0n 0.5103 4199.5n 0.5103 4200.0n 0.5110 4799.5n 0.5110 4800.0n 0.5079 5399.5n 0.5079 5400.0n 0.5101 5999.5n 0.5101 6000.0n 0.5130 6599.5n 0.5130 6600.0n 0.5097 7199.5n 0.5097 7200.0n 0.5030 7799.5n 0.5030 7800.0n 0.5011 8399.5n 0.5011 8400.0n 0.5006 8999.5n 0.5006 9000.0n 0.5009 9599.5n 0.5009 9600.0n 0.5000 10199.5n 0.5000 10200.0n 0.5052 10799.5n 0.5052 10800.0n 0.5041 11399.5n 0.5041 11400.0n 0.5074 11999.5n 0.5074 12000.0n 0.5007 12599.5n 0.5007 12600.0n 0.5138 13199.5n 0.5138 13200.0n 0.5007 13799.5n 0.5007 13800.0n 0.5039 14399.5n 0.5039)
Cwp_who_5_1 wp_who_5_1 0 400p
Cwn_who_5_1 wn_who_5_1 0 400p
Xu_who_5_1 xp_who_5_1 xn_who_5_1 yp_who_5_1 yn_who_5_1 wp_who_5_1 wn_who_5_1 vdd gbn gprod
Vxp_bh_5 xp_bh_5 0 PWL(0.0n 0.7100 599.5n 0.7100 600.0n 0.7100 1199.5n 0.7100 1200.0n 0.7100 1799.5n 0.7100 1800.0n 0.7100 2399.5n 0.7100 2400.0n 0.7100 2999.5n 0.7100 3000.0n 0.7100 3599.5n 0.7100 3600.0n 0.7100 4199.5n 0.7100 4200.0n 0.7100 4799.5n 0.7100 4800.0n 0.7100 5399.5n 0.7100 5400.0n 0.7100 5999.5n 0.7100 6000.0n 0.7100 6599.5n 0.7100 6600.0n 0.7100 7199.5n 0.7100 7200.0n 0.7100 7799.5n 0.7100 7800.0n 0.7100 8399.5n 0.7100 8400.0n 0.7100 8999.5n 0.7100 9000.0n 0.7100 9599.5n 0.7100 9600.0n 0.7100 10199.5n 0.7100 10200.0n 0.7100 10799.5n 0.7100 10800.0n 0.7100 11399.5n 0.7100 11400.0n 0.7100 11999.5n 0.7100 12000.0n 0.7100 12599.5n 0.7100 12600.0n 0.7100 13199.5n 0.7100 13200.0n 0.7100 13799.5n 0.7100 13800.0n 0.7100 14399.5n 0.7100)
Vxn_bh_5 xn_bh_5 0 PWL(0.0n 0.2900 599.5n 0.2900 600.0n 0.2900 1199.5n 0.2900 1200.0n 0.2900 1799.5n 0.2900 1800.0n 0.2900 2399.5n 0.2900 2400.0n 0.2900 2999.5n 0.2900 3000.0n 0.2900 3599.5n 0.2900 3600.0n 0.2900 4199.5n 0.2900 4200.0n 0.2900 4799.5n 0.2900 4800.0n 0.2900 5399.5n 0.2900 5400.0n 0.2900 5999.5n 0.2900 6000.0n 0.2900 6599.5n 0.2900 6600.0n 0.2900 7199.5n 0.2900 7200.0n 0.2900 7799.5n 0.2900 7800.0n 0.2900 8399.5n 0.2900 8400.0n 0.2900 8999.5n 0.2900 9000.0n 0.2900 9599.5n 0.2900 9600.0n 0.2900 10199.5n 0.2900 10200.0n 0.2900 10799.5n 0.2900 10800.0n 0.2900 11399.5n 0.2900 11400.0n 0.2900 11999.5n 0.2900 12000.0n 0.2900 12599.5n 0.2900 12600.0n 0.2900 13199.5n 0.2900 13200.0n 0.2900 13799.5n 0.2900 13800.0n 0.2900 14399.5n 0.2900)
Vyp_bh_5 yp_bh_5 0 PWL(0.0n 0.5088 599.5n 0.5088 600.0n 0.4862 1199.5n 0.4862 1200.0n 0.4785 1799.5n 0.4785 1800.0n 0.4708 2399.5n 0.4708 2400.0n 0.4723 2999.5n 0.4723 3000.0n 0.5122 3599.5n 0.5122 3600.0n 0.5052 4199.5n 0.5052 4200.0n 0.4283 4799.5n 0.4283 4800.0n 0.4602 5399.5n 0.4602 5400.0n 0.4927 5999.5n 0.4927 6000.0n 0.4643 6599.5n 0.4643 6600.0n 0.4495 7199.5n 0.4495 7200.0n 0.6050 7799.5n 0.6050 7800.0n 0.5938 8399.5n 0.5938 8400.0n 0.6017 8999.5n 0.6017 9000.0n 0.5656 9599.5n 0.5656 9600.0n 0.6169 10199.5n 0.6169 10200.0n 0.5135 10799.5n 0.5135 10800.0n 0.6080 11399.5n 0.6080 11400.0n 0.5330 11999.5n 0.5330 12000.0n 0.5804 12599.5n 0.5804 12600.0n 0.4913 13199.5n 0.4913 13200.0n 0.5870 13799.5n 0.5870 13800.0n 0.5707 14399.5n 0.5707)
Vyn_bh_5 yn_bh_5 0 PWL(0.0n 0.4912 599.5n 0.4912 600.0n 0.5138 1199.5n 0.5138 1200.0n 0.5215 1799.5n 0.5215 1800.0n 0.5292 2399.5n 0.5292 2400.0n 0.5277 2999.5n 0.5277 3000.0n 0.4878 3599.5n 0.4878 3600.0n 0.4948 4199.5n 0.4948 4200.0n 0.5717 4799.5n 0.5717 4800.0n 0.5398 5399.5n 0.5398 5400.0n 0.5073 5999.5n 0.5073 6000.0n 0.5357 6599.5n 0.5357 6600.0n 0.5505 7199.5n 0.5505 7200.0n 0.3950 7799.5n 0.3950 7800.0n 0.4062 8399.5n 0.4062 8400.0n 0.3983 8999.5n 0.3983 9000.0n 0.4344 9599.5n 0.4344 9600.0n 0.3831 10199.5n 0.3831 10200.0n 0.4865 10799.5n 0.4865 10800.0n 0.3920 11399.5n 0.3920 11400.0n 0.4670 11999.5n 0.4670 12000.0n 0.4196 12599.5n 0.4196 12600.0n 0.5087 13199.5n 0.5087 13200.0n 0.4130 13799.5n 0.4130 13800.0n 0.4293 14399.5n 0.4293)
Cwp_bh_5 wp_bh_5 0 400p
Cwn_bh_5 wn_bh_5 0 400p
Xu_bh_5 xp_bh_5 xn_bh_5 yp_bh_5 yn_bh_5 wp_bh_5 wn_bh_5 vdd gbn gprod
Vxp_wih_2_6 xp_wih_2_6 0 PWL(0.0n 0.5073 599.5n 0.5073 600.0n 0.6050 1199.5n 0.6050 1200.0n 0.5896 1799.5n 0.5896 1800.0n 0.5668 2399.5n 0.5668 2400.0n 0.5620 2999.5n 0.5620 3000.0n 0.5000 3599.5n 0.5000 3600.0n 0.5274 4199.5n 0.5274 4200.0n 0.5867 4799.5n 0.5867 4800.0n 0.5675 5399.5n 0.5675 5400.0n 0.5971 5999.5n 0.5971 6000.0n 0.5525 6599.5n 0.5525 6600.0n 0.6050 7199.5n 0.6050 7200.0n 0.5144 7799.5n 0.5144 7800.0n 0.5952 8399.5n 0.5952 8400.0n 0.5637 8999.5n 0.5637 9000.0n 0.6050 9599.5n 0.6050 9600.0n 0.5689 10199.5n 0.5689 10200.0n 0.6050 10799.5n 0.6050 10800.0n 0.5512 11399.5n 0.5512 11400.0n 0.5169 11999.5n 0.5169 12000.0n 0.5935 12599.5n 0.5935 12600.0n 0.4484 13199.5n 0.4484 13200.0n 0.5917 13799.5n 0.5917 13800.0n 0.5508 14399.5n 0.5508)
Vxn_wih_2_6 xn_wih_2_6 0 PWL(0.0n 0.4927 599.5n 0.4927 600.0n 0.3950 1199.5n 0.3950 1200.0n 0.4104 1799.5n 0.4104 1800.0n 0.4332 2399.5n 0.4332 2400.0n 0.4380 2999.5n 0.4380 3000.0n 0.5000 3599.5n 0.5000 3600.0n 0.4726 4199.5n 0.4726 4200.0n 0.4133 4799.5n 0.4133 4800.0n 0.4325 5399.5n 0.4325 5400.0n 0.4029 5999.5n 0.4029 6000.0n 0.4475 6599.5n 0.4475 6600.0n 0.3950 7199.5n 0.3950 7200.0n 0.4856 7799.5n 0.4856 7800.0n 0.4048 8399.5n 0.4048 8400.0n 0.4363 8999.5n 0.4363 9000.0n 0.3950 9599.5n 0.3950 9600.0n 0.4311 10199.5n 0.4311 10200.0n 0.3950 10799.5n 0.3950 10800.0n 0.4488 11399.5n 0.4488 11400.0n 0.4831 11999.5n 0.4831 12000.0n 0.4065 12599.5n 0.4065 12600.0n 0.5516 13199.5n 0.5516 13200.0n 0.4083 13799.5n 0.4083 13800.0n 0.4492 14399.5n 0.4492)
Vyp_wih_2_6 yp_wih_2_6 0 PWL(0.0n 0.3975 599.5n 0.3975 600.0n 0.4258 1199.5n 0.4258 1200.0n 0.3995 1799.5n 0.3995 1800.0n 0.3968 2399.5n 0.3968 2400.0n 0.3945 2999.5n 0.3945 3000.0n 0.3967 3599.5n 0.3967 3600.0n 0.3951 4199.5n 0.3951 4200.0n 0.3980 4799.5n 0.3980 4800.0n 0.3977 5399.5n 0.3977 5400.0n 0.4041 5999.5n 0.4041 6000.0n 0.3934 6599.5n 0.3934 6600.0n 0.4009 7199.5n 0.4009 7200.0n 0.4059 7799.5n 0.4059 7800.0n 0.4305 8399.5n 0.4305 8400.0n 0.4120 8999.5n 0.4120 9000.0n 0.4322 9599.5n 0.4322 9600.0n 0.4458 10199.5n 0.4458 10200.0n 0.4072 10799.5n 0.4072 10800.0n 0.4093 11399.5n 0.4093 11400.0n 0.3999 11999.5n 0.3999 12000.0n 0.4134 12599.5n 0.4134 12600.0n 0.3934 13199.5n 0.3934 13200.0n 0.4176 13799.5n 0.4176 13800.0n 0.4052 14399.5n 0.4052)
Vyn_wih_2_6 yn_wih_2_6 0 PWL(0.0n 0.6025 599.5n 0.6025 600.0n 0.5742 1199.5n 0.5742 1200.0n 0.6005 1799.5n 0.6005 1800.0n 0.6032 2399.5n 0.6032 2400.0n 0.6055 2999.5n 0.6055 3000.0n 0.6033 3599.5n 0.6033 3600.0n 0.6049 4199.5n 0.6049 4200.0n 0.6020 4799.5n 0.6020 4800.0n 0.6023 5399.5n 0.6023 5400.0n 0.5959 5999.5n 0.5959 6000.0n 0.6066 6599.5n 0.6066 6600.0n 0.5991 7199.5n 0.5991 7200.0n 0.5941 7799.5n 0.5941 7800.0n 0.5695 8399.5n 0.5695 8400.0n 0.5880 8999.5n 0.5880 9000.0n 0.5678 9599.5n 0.5678 9600.0n 0.5542 10199.5n 0.5542 10200.0n 0.5928 10799.5n 0.5928 10800.0n 0.5907 11399.5n 0.5907 11400.0n 0.6001 11999.5n 0.6001 12000.0n 0.5866 12599.5n 0.5866 12600.0n 0.6066 13199.5n 0.6066 13200.0n 0.5824 13799.5n 0.5824 13800.0n 0.5948 14399.5n 0.5948)
Cwp_wih_2_6 wp_wih_2_6 0 400p
Cwn_wih_2_6 wn_wih_2_6 0 400p
Xu_wih_2_6 xp_wih_2_6 xn_wih_2_6 yp_wih_2_6 yn_wih_2_6 wp_wih_2_6 wn_wih_2_6 vdd gbn gprod
Vxp_wih_3_6 xp_wih_3_6 0 PWL(0.0n 0.4048 599.5n 0.4048 600.0n 0.4386 1199.5n 0.4386 1200.0n 0.3950 1799.5n 0.3950 1800.0n 0.3950 2399.5n 0.3950 2400.0n 0.3950 2999.5n 0.3950 3000.0n 0.3950 3599.5n 0.3950 3600.0n 0.3950 4199.5n 0.3950 4200.0n 0.3950 4799.5n 0.3950 4800.0n 0.4025 5399.5n 0.4025 5400.0n 0.4069 5999.5n 0.4069 6000.0n 0.3950 6599.5n 0.3950 6600.0n 0.4045 7199.5n 0.4045 7200.0n 0.3950 7799.5n 0.3950 7800.0n 0.4311 8399.5n 0.4311 8400.0n 0.3984 8999.5n 0.3984 9000.0n 0.4362 9599.5n 0.4362 9600.0n 0.4475 10199.5n 0.4475 10200.0n 0.3950 10799.5n 0.3950 10800.0n 0.3950 11399.5n 0.3950 11400.0n 0.3950 11999.5n 0.3950 12000.0n 0.3950 12599.5n 0.3950 12600.0n 0.3950 13199.5n 0.3950 13200.0n 0.4083 13799.5n 0.4083 13800.0n 0.3950 14399.5n 0.3950)
Vxn_wih_3_6 xn_wih_3_6 0 PWL(0.0n 0.5952 599.5n 0.5952 600.0n 0.5614 1199.5n 0.5614 1200.0n 0.6050 1799.5n 0.6050 1800.0n 0.6050 2399.5n 0.6050 2400.0n 0.6050 2999.5n 0.6050 3000.0n 0.6050 3599.5n 0.6050 3600.0n 0.6050 4199.5n 0.6050 4200.0n 0.6050 4799.5n 0.6050 4800.0n 0.5975 5399.5n 0.5975 5400.0n 0.5931 5999.5n 0.5931 6000.0n 0.6050 6599.5n 0.6050 6600.0n 0.5955 7199.5n 0.5955 7200.0n 0.6050 7799.5n 0.6050 7800.0n 0.5689 8399.5n 0.5689 8400.0n 0.6016 8999.5n 0.6016 9000.0n 0.5638 9599.5n 0.5638 9600.0n 0.5525 10199.5n 0.5525 10200.0n 0.6050 10799.5n 0.6050 10800.0n 0.6050 11399.5n 0.6050 11400.0n 0.6050 11999.5n 0.6050 12000.0n 0.6050 12599.5n 0.6050 12600.0n 0.6050 13199.5n 0.6050 13200.0n 0.5917 13799.5n 0.5917 13800.0n 0.6050 14399.5n 0.6050)
Vyp_wih_3_6 yp_wih_3_6 0 PWL(0.0n 0.3975 599.5n 0.3975 600.0n 0.4258 1199.5n 0.4258 1200.0n 0.3995 1799.5n 0.3995 1800.0n 0.3968 2399.5n 0.3968 2400.0n 0.3945 2999.5n 0.3945 3000.0n 0.3967 3599.5n 0.3967 3600.0n 0.3951 4199.5n 0.3951 4200.0n 0.3980 4799.5n 0.3980 4800.0n 0.3977 5399.5n 0.3977 5400.0n 0.4041 5999.5n 0.4041 6000.0n 0.3934 6599.5n 0.3934 6600.0n 0.4009 7199.5n 0.4009 7200.0n 0.4059 7799.5n 0.4059 7800.0n 0.4305 8399.5n 0.4305 8400.0n 0.4120 8999.5n 0.4120 9000.0n 0.4322 9599.5n 0.4322 9600.0n 0.4458 10199.5n 0.4458 10200.0n 0.4072 10799.5n 0.4072 10800.0n 0.4093 11399.5n 0.4093 11400.0n 0.3999 11999.5n 0.3999 12000.0n 0.4134 12599.5n 0.4134 12600.0n 0.3934 13199.5n 0.3934 13200.0n 0.4176 13799.5n 0.4176 13800.0n 0.4052 14399.5n 0.4052)
Vyn_wih_3_6 yn_wih_3_6 0 PWL(0.0n 0.6025 599.5n 0.6025 600.0n 0.5742 1199.5n 0.5742 1200.0n 0.6005 1799.5n 0.6005 1800.0n 0.6032 2399.5n 0.6032 2400.0n 0.6055 2999.5n 0.6055 3000.0n 0.6033 3599.5n 0.6033 3600.0n 0.6049 4199.5n 0.6049 4200.0n 0.6020 4799.5n 0.6020 4800.0n 0.6023 5399.5n 0.6023 5400.0n 0.5959 5999.5n 0.5959 6000.0n 0.6066 6599.5n 0.6066 6600.0n 0.5991 7199.5n 0.5991 7200.0n 0.5941 7799.5n 0.5941 7800.0n 0.5695 8399.5n 0.5695 8400.0n 0.5880 8999.5n 0.5880 9000.0n 0.5678 9599.5n 0.5678 9600.0n 0.5542 10199.5n 0.5542 10200.0n 0.5928 10799.5n 0.5928 10800.0n 0.5907 11399.5n 0.5907 11400.0n 0.6001 11999.5n 0.6001 12000.0n 0.5866 12599.5n 0.5866 12600.0n 0.6066 13199.5n 0.6066 13200.0n 0.5824 13799.5n 0.5824 13800.0n 0.5948 14399.5n 0.5948)
Cwp_wih_3_6 wp_wih_3_6 0 400p
Cwn_wih_3_6 wn_wih_3_6 0 400p
Xu_wih_3_6 xp_wih_3_6 xn_wih_3_6 yp_wih_3_6 yn_wih_3_6 wp_wih_3_6 wn_wih_3_6 vdd gbn gprod
Vxp_wih_6_6 xp_wih_6_6 0 PWL(0.0n 0.4927 599.5n 0.4927 600.0n 0.5059 1199.5n 0.5059 1200.0n 0.5128 1799.5n 0.5128 1800.0n 0.4857 2399.5n 0.4857 2400.0n 0.4857 2999.5n 0.4857 3000.0n 0.4909 3599.5n 0.4909 3600.0n 0.5000 4199.5n 0.5000 4200.0n 0.4543 4799.5n 0.4543 4800.0n 0.4737 5399.5n 0.4737 5400.0n 0.5297 5999.5n 0.5297 6000.0n 0.4694 6599.5n 0.4694 6600.0n 0.4809 7199.5n 0.4809 7200.0n 0.5762 7799.5n 0.5762 7800.0n 0.6050 8399.5n 0.6050 8400.0n 0.6050 8999.5n 0.6050 9000.0n 0.5679 9599.5n 0.5679 9600.0n 0.6050 10199.5n 0.6050 10200.0n 0.5428 10799.5n 0.5428 10800.0n 0.6050 11399.5n 0.6050 11400.0n 0.5203 11999.5n 0.5203 12000.0n 0.5974 12599.5n 0.5974 12600.0n 0.4519 13199.5n 0.4519 13200.0n 0.6050 13799.5n 0.6050 13800.0n 0.5610 14399.5n 0.5610)
Vxn_wih_6_6 xn_wih_6_6 0 PWL(0.0n 0.5073 599.5n 0.5073 600.0n 0.4941 1199.5n 0.4941 1200.0n 0.4872 1799.5n 0.4872 1800.0n 0.5143 2399.5n 0.5143 2400.0n 0.5143 2999.5n 0.5143 3000.0n 0.5091 3599.5n 0.5091 3600.0n 0.5000 4199.5n 0.5000 4200.0n 0.5457 4799.5n 0.5457 4800.0n 0.5263 5399.5n 0.5263 5400.0n 0.4703 5999.5n 0.4703 6000.0n 0.5306 6599.5n 0.5306 6600.0n 0.5191 7199.5n 0.5191 7200.0n 0.4238 7799.5n 0.4238 7800.0n 0.3950 8399.5n 0.3950 8400.0n 0.3950 8999.5n 0.3950 9000.0n 0.4321 9599.5n 0.4321 9600.0n 0.3950 10199.5n 0.3950 10200.0n 0.4572 10799.5n 0.4572 10800.0n 0.3950 11399.5n 0.3950 11400.0n 0.4797 11999.5n 0.4797 12000.0n 0.4026 12599.5n 0.4026 12600.0n 0.5481 13199.5n 0.5481 13200.0n 0.3950 13799.5n 0.3950 13800.0n 0.4390 14399.5n 0.4390)
Vyp_wih_6_6 yp_wih_6_6 0 PWL(0.0n 0.3975 599.5n 0.3975 600.0n 0.4258 1199.5n 0.4258 1200.0n 0.3995 1799.5n 0.3995 1800.0n 0.3968 2399.5n 0.3968 2400.0n 0.3945 2999.5n 0.3945 3000.0n 0.3967 3599.5n 0.3967 3600.0n 0.3951 4199.5n 0.3951 4200.0n 0.3980 4799.5n 0.3980 4800.0n 0.3977 5399.5n 0.3977 5400.0n 0.4041 5999.5n 0.4041 6000.0n 0.3934 6599.5n 0.3934 6600.0n 0.4009 7199.5n 0.4009 7200.0n 0.4059 7799.5n 0.4059 7800.0n 0.4305 8399.5n 0.4305 8400.0n 0.4120 8999.5n 0.4120 9000.0n 0.4322 9599.5n 0.4322 9600.0n 0.4458 10199.5n 0.4458 10200.0n 0.4072 10799.5n 0.4072 10800.0n 0.4093 11399.5n 0.4093 11400.0n 0.3999 11999.5n 0.3999 12000.0n 0.4134 12599.5n 0.4134 12600.0n 0.3934 13199.5n 0.3934 13200.0n 0.4176 13799.5n 0.4176 13800.0n 0.4052 14399.5n 0.4052)
Vyn_wih_6_6 yn_wih_6_6 0 PWL(0.0n 0.6025 599.5n 0.6025 600.0n 0.5742 1199.5n 0.5742 1200.0n 0.6005 1799.5n 0.6005 1800.0n 0.6032 2399.5n 0.6032 2400.0n 0.6055 2999.5n 0.6055 3000.0n 0.6033 3599.5n 0.6033 3600.0n 0.6049 4199.5n 0.6049 4200.0n 0.6020 4799.5n 0.6020 4800.0n 0.6023 5399.5n 0.6023 5400.0n 0.5959 5999.5n 0.5959 6000.0n 0.6066 6599.5n 0.6066 6600.0n 0.5991 7199.5n 0.5991 7200.0n 0.5941 7799.5n 0.5941 7800.0n 0.5695 8399.5n 0.5695 8400.0n 0.5880 8999.5n 0.5880 9000.0n 0.5678 9599.5n 0.5678 9600.0n 0.5542 10199.5n 0.5542 10200.0n 0.5928 10799.5n 0.5928 10800.0n 0.5907 11399.5n 0.5907 11400.0n 0.6001 11999.5n 0.6001 12000.0n 0.5866 12599.5n 0.5866 12600.0n 0.6066 13199.5n 0.6066 13200.0n 0.5824 13799.5n 0.5824 13800.0n 0.5948 14399.5n 0.5948)
Cwp_wih_6_6 wp_wih_6_6 0 400p
Cwn_wih_6_6 wn_wih_6_6 0 400p
Xu_wih_6_6 xp_wih_6_6 xn_wih_6_6 yp_wih_6_6 yn_wih_6_6 wp_wih_6_6 wn_wih_6_6 vdd gbn gprod
Vxp_wih_7_6 xp_wih_7_6 0 PWL(0.0n 0.4341 599.5n 0.4341 600.0n 0.4663 1199.5n 0.4663 1200.0n 0.4513 1799.5n 0.4513 1800.0n 0.4380 2399.5n 0.4380 2400.0n 0.4618 2999.5n 0.4618 3000.0n 0.4178 3599.5n 0.4178 3600.0n 0.4361 4199.5n 0.4361 4200.0n 0.4315 4799.5n 0.4315 4800.0n 0.4550 5399.5n 0.4550 5400.0n 0.4465 5999.5n 0.4465 6000.0n 0.4475 6599.5n 0.4475 6600.0n 0.4523 7199.5n 0.4523 7200.0n 0.3950 7799.5n 0.3950 7800.0n 0.4212 8399.5n 0.4212 8400.0n 0.3950 8999.5n 0.3950 9000.0n 0.4279 9599.5n 0.4279 9600.0n 0.4212 10199.5n 0.4212 10200.0n 0.3950 10799.5n 0.3950 10800.0n 0.3950 11399.5n 0.3950 11400.0n 0.3950 11999.5n 0.3950 12000.0n 0.3950 12599.5n 0.3950 12600.0n 0.3950 13199.5n 0.3950 13200.0n 0.3950 13799.5n 0.3950 13800.0n 0.3950 14399.5n 0.3950)
Vxn_wih_7_6 xn_wih_7_6 0 PWL(0.0n 0.5659 599.5n 0.5659 600.0n 0.5337 1199.5n 0.5337 1200.0n 0.5487 1799.5n 0.5487 1800.0n 0.5620 2399.5n 0.5620 2400.0n 0.5382 2999.5n 0.5382 3000.0n 0.5822 3599.5n 0.5822 3600.0n 0.5639 4199.5n 0.5639 4200.0n 0.5685 4799.5n 0.5685 4800.0n 0.5450 5399.5n 0.5450 5400.0n 0.5535 5999.5n 0.5535 6000.0n 0.5525 6599.5n 0.5525 6600.0n 0.5477 7199.5n 0.5477 7200.0n 0.6050 7799.5n 0.6050 7800.0n 0.5788 8399.5n 0.5788 8400.0n 0.6050 8999.5n 0.6050 9000.0n 0.5721 9599.5n 0.5721 9600.0n 0.5788 10199.5n 0.5788 10200.0n 0.6050 10799.5n 0.6050 10800.0n 0.6050 11399.5n 0.6050 11400.0n 0.6050 11999.5n 0.6050 12000.0n 0.6050 12599.5n 0.6050 12600.0n 0.6050 13199.5n 0.6050 13200.0n 0.6050 13799.5n 0.6050 13800.0n 0.6050 14399.5n 0.6050)
Vyp_wih_7_6 yp_wih_7_6 0 PWL(0.0n 0.3975 599.5n 0.3975 600.0n 0.4258 1199.5n 0.4258 1200.0n 0.3995 1799.5n 0.3995 1800.0n 0.3968 2399.5n 0.3968 2400.0n 0.3945 2999.5n 0.3945 3000.0n 0.3967 3599.5n 0.3967 3600.0n 0.3951 4199.5n 0.3951 4200.0n 0.3980 4799.5n 0.3980 4800.0n 0.3977 5399.5n 0.3977 5400.0n 0.4041 5999.5n 0.4041 6000.0n 0.3934 6599.5n 0.3934 6600.0n 0.4009 7199.5n 0.4009 7200.0n 0.4059 7799.5n 0.4059 7800.0n 0.4305 8399.5n 0.4305 8400.0n 0.4120 8999.5n 0.4120 9000.0n 0.4322 9599.5n 0.4322 9600.0n 0.4458 10199.5n 0.4458 10200.0n 0.4072 10799.5n 0.4072 10800.0n 0.4093 11399.5n 0.4093 11400.0n 0.3999 11999.5n 0.3999 12000.0n 0.4134 12599.5n 0.4134 12600.0n 0.3934 13199.5n 0.3934 13200.0n 0.4176 13799.5n 0.4176 13800.0n 0.4052 14399.5n 0.4052)
Vyn_wih_7_6 yn_wih_7_6 0 PWL(0.0n 0.6025 599.5n 0.6025 600.0n 0.5742 1199.5n 0.5742 1200.0n 0.6005 1799.5n 0.6005 1800.0n 0.6032 2399.5n 0.6032 2400.0n 0.6055 2999.5n 0.6055 3000.0n 0.6033 3599.5n 0.6033 3600.0n 0.6049 4199.5n 0.6049 4200.0n 0.6020 4799.5n 0.6020 4800.0n 0.6023 5399.5n 0.6023 5400.0n 0.5959 5999.5n 0.5959 6000.0n 0.6066 6599.5n 0.6066 6600.0n 0.5991 7199.5n 0.5991 7200.0n 0.5941 7799.5n 0.5941 7800.0n 0.5695 8399.5n 0.5695 8400.0n 0.5880 8999.5n 0.5880 9000.0n 0.5678 9599.5n 0.5678 9600.0n 0.5542 10199.5n 0.5542 10200.0n 0.5928 10799.5n 0.5928 10800.0n 0.5907 11399.5n 0.5907 11400.0n 0.6001 11999.5n 0.6001 12000.0n 0.5866 12599.5n 0.5866 12600.0n 0.6066 13199.5n 0.6066 13200.0n 0.5824 13799.5n 0.5824 13800.0n 0.5948 14399.5n 0.5948)
Cwp_wih_7_6 wp_wih_7_6 0 400p
Cwn_wih_7_6 wn_wih_7_6 0 400p
Xu_wih_7_6 xp_wih_7_6 xn_wih_7_6 yp_wih_7_6 yn_wih_7_6 wp_wih_7_6 wn_wih_7_6 vdd gbn gprod
Vxp_who_6_0 xp_who_6_0 0 PWL(0.0n 0.3975 599.5n 0.3975 600.0n 0.4258 1199.5n 0.4258 1200.0n 0.3995 1799.5n 0.3995 1800.0n 0.3968 2399.5n 0.3968 2400.0n 0.3945 2999.5n 0.3945 3000.0n 0.3967 3599.5n 0.3967 3600.0n 0.3951 4199.5n 0.3951 4200.0n 0.3980 4799.5n 0.3980 4800.0n 0.3977 5399.5n 0.3977 5400.0n 0.4041 5999.5n 0.4041 6000.0n 0.3934 6599.5n 0.3934 6600.0n 0.4009 7199.5n 0.4009 7200.0n 0.4059 7799.5n 0.4059 7800.0n 0.4305 8399.5n 0.4305 8400.0n 0.4120 8999.5n 0.4120 9000.0n 0.4322 9599.5n 0.4322 9600.0n 0.4458 10199.5n 0.4458 10200.0n 0.4072 10799.5n 0.4072 10800.0n 0.4093 11399.5n 0.4093 11400.0n 0.3999 11999.5n 0.3999 12000.0n 0.4134 12599.5n 0.4134 12600.0n 0.3934 13199.5n 0.3934 13200.0n 0.4176 13799.5n 0.4176 13800.0n 0.4052 14399.5n 0.4052)
Vxn_who_6_0 xn_who_6_0 0 PWL(0.0n 0.6025 599.5n 0.6025 600.0n 0.5742 1199.5n 0.5742 1200.0n 0.6005 1799.5n 0.6005 1800.0n 0.6032 2399.5n 0.6032 2400.0n 0.6055 2999.5n 0.6055 3000.0n 0.6033 3599.5n 0.6033 3600.0n 0.6049 4199.5n 0.6049 4200.0n 0.6020 4799.5n 0.6020 4800.0n 0.6023 5399.5n 0.6023 5400.0n 0.5959 5999.5n 0.5959 6000.0n 0.6066 6599.5n 0.6066 6600.0n 0.5991 7199.5n 0.5991 7200.0n 0.5941 7799.5n 0.5941 7800.0n 0.5695 8399.5n 0.5695 8400.0n 0.5880 8999.5n 0.5880 9000.0n 0.5678 9599.5n 0.5678 9600.0n 0.5542 10199.5n 0.5542 10200.0n 0.5928 10799.5n 0.5928 10800.0n 0.5907 11399.5n 0.5907 11400.0n 0.6001 11999.5n 0.6001 12000.0n 0.5866 12599.5n 0.5866 12600.0n 0.6066 13199.5n 0.6066 13200.0n 0.5824 13799.5n 0.5824 13800.0n 0.5948 14399.5n 0.5948)
Vyp_who_6_0 yp_who_6_0 0 PWL(0.0n 0.5073 599.5n 0.5073 600.0n 0.5065 1199.5n 0.5065 1200.0n 0.5065 1799.5n 0.5065 1800.0n 0.5052 2399.5n 0.5052 2400.0n 0.5058 2999.5n 0.5058 3000.0n 0.5039 3599.5n 0.5039 3600.0n 0.5059 4199.5n 0.5059 4200.0n 0.5077 4799.5n 0.5077 4800.0n 0.5054 5399.5n 0.5054 5400.0n 0.5066 5999.5n 0.5066 6000.0n 0.5083 6599.5n 0.5083 6600.0n 0.5078 7199.5n 0.5078 7200.0n 0.5043 7799.5n 0.5043 7800.0n 0.5035 8399.5n 0.5035 8400.0n 0.5035 8999.5n 0.5035 9000.0n 0.5038 9599.5n 0.5038 9600.0n 0.5043 10199.5n 0.5043 10200.0n 0.5053 10799.5n 0.5053 10800.0n 0.5050 11399.5n 0.5050 11400.0n 0.5055 11999.5n 0.5055 12000.0n 0.5043 12599.5n 0.5043 12600.0n 0.5028 13199.5n 0.5028 13200.0n 0.5045 13799.5n 0.5045 13800.0n 0.5043 14399.5n 0.5043)
Vyn_who_6_0 yn_who_6_0 0 PWL(0.0n 0.4927 599.5n 0.4927 600.0n 0.4935 1199.5n 0.4935 1200.0n 0.4935 1799.5n 0.4935 1800.0n 0.4948 2399.5n 0.4948 2400.0n 0.4942 2999.5n 0.4942 3000.0n 0.4961 3599.5n 0.4961 3600.0n 0.4941 4199.5n 0.4941 4200.0n 0.4923 4799.5n 0.4923 4800.0n 0.4946 5399.5n 0.4946 5400.0n 0.4934 5999.5n 0.4934 6000.0n 0.4917 6599.5n 0.4917 6600.0n 0.4922 7199.5n 0.4922 7200.0n 0.4957 7799.5n 0.4957 7800.0n 0.4965 8399.5n 0.4965 8400.0n 0.4965 8999.5n 0.4965 9000.0n 0.4962 9599.5n 0.4962 9600.0n 0.4957 10199.5n 0.4957 10200.0n 0.4947 10799.5n 0.4947 10800.0n 0.4950 11399.5n 0.4950 11400.0n 0.4945 11999.5n 0.4945 12000.0n 0.4957 12599.5n 0.4957 12600.0n 0.4972 13199.5n 0.4972 13200.0n 0.4955 13799.5n 0.4955 13800.0n 0.4957 14399.5n 0.4957)
Cwp_who_6_0 wp_who_6_0 0 400p
Cwn_who_6_0 wn_who_6_0 0 400p
Xu_who_6_0 xp_who_6_0 xn_who_6_0 yp_who_6_0 yn_who_6_0 wp_who_6_0 wn_who_6_0 vdd gbn gprod
Vxp_who_6_1 xp_who_6_1 0 PWL(0.0n 0.3975 599.5n 0.3975 600.0n 0.4258 1199.5n 0.4258 1200.0n 0.3995 1799.5n 0.3995 1800.0n 0.3968 2399.5n 0.3968 2400.0n 0.3945 2999.5n 0.3945 3000.0n 0.3967 3599.5n 0.3967 3600.0n 0.3951 4199.5n 0.3951 4200.0n 0.3980 4799.5n 0.3980 4800.0n 0.3977 5399.5n 0.3977 5400.0n 0.4041 5999.5n 0.4041 6000.0n 0.3934 6599.5n 0.3934 6600.0n 0.4009 7199.5n 0.4009 7200.0n 0.4059 7799.5n 0.4059 7800.0n 0.4305 8399.5n 0.4305 8400.0n 0.4120 8999.5n 0.4120 9000.0n 0.4322 9599.5n 0.4322 9600.0n 0.4458 10199.5n 0.4458 10200.0n 0.4072 10799.5n 0.4072 10800.0n 0.4093 11399.5n 0.4093 11400.0n 0.3999 11999.5n 0.3999 12000.0n 0.4134 12599.5n 0.4134 12600.0n 0.3934 13199.5n 0.3934 13200.0n 0.4176 13799.5n 0.4176 13800.0n 0.4052 14399.5n 0.4052)
Vxn_who_6_1 xn_who_6_1 0 PWL(0.0n 0.6025 599.5n 0.6025 600.0n 0.5742 1199.5n 0.5742 1200.0n 0.6005 1799.5n 0.6005 1800.0n 0.6032 2399.5n 0.6032 2400.0n 0.6055 2999.5n 0.6055 3000.0n 0.6033 3599.5n 0.6033 3600.0n 0.6049 4199.5n 0.6049 4200.0n 0.6020 4799.5n 0.6020 4800.0n 0.6023 5399.5n 0.6023 5400.0n 0.5959 5999.5n 0.5959 6000.0n 0.6066 6599.5n 0.6066 6600.0n 0.5991 7199.5n 0.5991 7200.0n 0.5941 7799.5n 0.5941 7800.0n 0.5695 8399.5n 0.5695 8400.0n 0.5880 8999.5n 0.5880 9000.0n 0.5678 9599.5n 0.5678 9600.0n 0.5542 10199.5n 0.5542 10200.0n 0.5928 10799.5n 0.5928 10800.0n 0.5907 11399.5n 0.5907 11400.0n 0.6001 11999.5n 0.6001 12000.0n 0.5866 12599.5n 0.5866 12600.0n 0.6066 13199.5n 0.6066 13200.0n 0.5824 13799.5n 0.5824 13800.0n 0.5948 14399.5n 0.5948)
Vyp_who_6_1 yp_who_6_1 0 PWL(0.0n 0.4909 599.5n 0.4909 600.0n 0.4933 1199.5n 0.4933 1200.0n 0.4930 1799.5n 0.4930 1800.0n 0.4893 2399.5n 0.4893 2400.0n 0.4904 2999.5n 0.4904 3000.0n 0.4923 3599.5n 0.4923 3600.0n 0.4897 4199.5n 0.4897 4200.0n 0.4890 4799.5n 0.4890 4800.0n 0.4921 5399.5n 0.4921 5400.0n 0.4899 5999.5n 0.4899 6000.0n 0.4870 6599.5n 0.4870 6600.0n 0.4903 7199.5n 0.4903 7200.0n 0.4970 7799.5n 0.4970 7800.0n 0.4989 8399.5n 0.4989 8400.0n 0.4994 8999.5n 0.4994 9000.0n 0.4991 9599.5n 0.4991 9600.0n 0.5000 10199.5n 0.5000 10200.0n 0.4948 10799.5n 0.4948 10800.0n 0.4959 11399.5n 0.4959 11400.0n 0.4926 11999.5n 0.4926 12000.0n 0.4993 12599.5n 0.4993 12600.0n 0.4862 13199.5n 0.4862 13200.0n 0.4993 13799.5n 0.4993 13800.0n 0.4961 14399.5n 0.4961)
Vyn_who_6_1 yn_who_6_1 0 PWL(0.0n 0.5091 599.5n 0.5091 600.0n 0.5067 1199.5n 0.5067 1200.0n 0.5070 1799.5n 0.5070 1800.0n 0.5107 2399.5n 0.5107 2400.0n 0.5096 2999.5n 0.5096 3000.0n 0.5077 3599.5n 0.5077 3600.0n 0.5103 4199.5n 0.5103 4200.0n 0.5110 4799.5n 0.5110 4800.0n 0.5079 5399.5n 0.5079 5400.0n 0.5101 5999.5n 0.5101 6000.0n 0.5130 6599.5n 0.5130 6600.0n 0.5097 7199.5n 0.5097 7200.0n 0.5030 7799.5n 0.5030 7800.0n 0.5011 8399.5n 0.5011 8400.0n 0.5006 8999.5n 0.5006 9000.0n 0.5009 9599.5n 0.5009 9600.0n 0.5000 10199.5n 0.5000 10200.0n 0.5052 10799.5n 0.5052 10800.0n 0.5041 11399.5n 0.5041 11400.0n 0.5074 11999.5n 0.5074 12000.0n 0.5007 12599.5n 0.5007 12600.0n 0.5138 13199.5n 0.5138 13200.0n 0.5007 13799.5n 0.5007 13800.0n 0.5039 14399.5n 0.5039)
Cwp_who_6_1 wp_who_6_1 0 400p
Cwn_who_6_1 wn_who_6_1 0 400p
Xu_who_6_1 xp_who_6_1 xn_who_6_1 yp_who_6_1 yn_who_6_1 wp_who_6_1 wn_who_6_1 vdd gbn gprod
Vxp_bh_6 xp_bh_6 0 PWL(0.0n 0.7100 599.5n 0.7100 600.0n 0.7100 1199.5n 0.7100 1200.0n 0.7100 1799.5n 0.7100 1800.0n 0.7100 2399.5n 0.7100 2400.0n 0.7100 2999.5n 0.7100 3000.0n 0.7100 3599.5n 0.7100 3600.0n 0.7100 4199.5n 0.7100 4200.0n 0.7100 4799.5n 0.7100 4800.0n 0.7100 5399.5n 0.7100 5400.0n 0.7100 5999.5n 0.7100 6000.0n 0.7100 6599.5n 0.7100 6600.0n 0.7100 7199.5n 0.7100 7200.0n 0.7100 7799.5n 0.7100 7800.0n 0.7100 8399.5n 0.7100 8400.0n 0.7100 8999.5n 0.7100 9000.0n 0.7100 9599.5n 0.7100 9600.0n 0.7100 10199.5n 0.7100 10200.0n 0.7100 10799.5n 0.7100 10800.0n 0.7100 11399.5n 0.7100 11400.0n 0.7100 11999.5n 0.7100 12000.0n 0.7100 12599.5n 0.7100 12600.0n 0.7100 13199.5n 0.7100 13200.0n 0.7100 13799.5n 0.7100 13800.0n 0.7100 14399.5n 0.7100)
Vxn_bh_6 xn_bh_6 0 PWL(0.0n 0.2900 599.5n 0.2900 600.0n 0.2900 1199.5n 0.2900 1200.0n 0.2900 1799.5n 0.2900 1800.0n 0.2900 2399.5n 0.2900 2400.0n 0.2900 2999.5n 0.2900 3000.0n 0.2900 3599.5n 0.2900 3600.0n 0.2900 4199.5n 0.2900 4200.0n 0.2900 4799.5n 0.2900 4800.0n 0.2900 5399.5n 0.2900 5400.0n 0.2900 5999.5n 0.2900 6000.0n 0.2900 6599.5n 0.2900 6600.0n 0.2900 7199.5n 0.2900 7200.0n 0.2900 7799.5n 0.2900 7800.0n 0.2900 8399.5n 0.2900 8400.0n 0.2900 8999.5n 0.2900 9000.0n 0.2900 9599.5n 0.2900 9600.0n 0.2900 10199.5n 0.2900 10200.0n 0.2900 10799.5n 0.2900 10800.0n 0.2900 11399.5n 0.2900 11400.0n 0.2900 11999.5n 0.2900 12000.0n 0.2900 12599.5n 0.2900 12600.0n 0.2900 13199.5n 0.2900 13200.0n 0.2900 13799.5n 0.2900 13800.0n 0.2900 14399.5n 0.2900)
Vyp_bh_6 yp_bh_6 0 PWL(0.0n 0.3975 599.5n 0.3975 600.0n 0.4258 1199.5n 0.4258 1200.0n 0.3995 1799.5n 0.3995 1800.0n 0.3968 2399.5n 0.3968 2400.0n 0.3945 2999.5n 0.3945 3000.0n 0.3967 3599.5n 0.3967 3600.0n 0.3951 4199.5n 0.3951 4200.0n 0.3980 4799.5n 0.3980 4800.0n 0.3977 5399.5n 0.3977 5400.0n 0.4041 5999.5n 0.4041 6000.0n 0.3934 6599.5n 0.3934 6600.0n 0.4009 7199.5n 0.4009 7200.0n 0.4059 7799.5n 0.4059 7800.0n 0.4305 8399.5n 0.4305 8400.0n 0.4120 8999.5n 0.4120 9000.0n 0.4322 9599.5n 0.4322 9600.0n 0.4458 10199.5n 0.4458 10200.0n 0.4072 10799.5n 0.4072 10800.0n 0.4093 11399.5n 0.4093 11400.0n 0.3999 11999.5n 0.3999 12000.0n 0.4134 12599.5n 0.4134 12600.0n 0.3934 13199.5n 0.3934 13200.0n 0.4176 13799.5n 0.4176 13800.0n 0.4052 14399.5n 0.4052)
Vyn_bh_6 yn_bh_6 0 PWL(0.0n 0.6025 599.5n 0.6025 600.0n 0.5742 1199.5n 0.5742 1200.0n 0.6005 1799.5n 0.6005 1800.0n 0.6032 2399.5n 0.6032 2400.0n 0.6055 2999.5n 0.6055 3000.0n 0.6033 3599.5n 0.6033 3600.0n 0.6049 4199.5n 0.6049 4200.0n 0.6020 4799.5n 0.6020 4800.0n 0.6023 5399.5n 0.6023 5400.0n 0.5959 5999.5n 0.5959 6000.0n 0.6066 6599.5n 0.6066 6600.0n 0.5991 7199.5n 0.5991 7200.0n 0.5941 7799.5n 0.5941 7800.0n 0.5695 8399.5n 0.5695 8400.0n 0.5880 8999.5n 0.5880 9000.0n 0.5678 9599.5n 0.5678 9600.0n 0.5542 10199.5n 0.5542 10200.0n 0.5928 10799.5n 0.5928 10800.0n 0.5907 11399.5n 0.5907 11400.0n 0.6001 11999.5n 0.6001 12000.0n 0.5866 12599.5n 0.5866 12600.0n 0.6066 13199.5n 0.6066 13200.0n 0.5824 13799.5n 0.5824 13800.0n 0.5948 14399.5n 0.5948)
Cwp_bh_6 wp_bh_6 0 400p
Cwn_bh_6 wn_bh_6 0 400p
Xu_bh_6 xp_bh_6 xn_bh_6 yp_bh_6 yn_bh_6 wp_bh_6 wn_bh_6 vdd gbn gprod
Vxp_wih_2_7 xp_wih_2_7 0 PWL(0.0n 0.5073 599.5n 0.5073 600.0n 0.6050 1199.5n 0.6050 1200.0n 0.5896 1799.5n 0.5896 1800.0n 0.5668 2399.5n 0.5668 2400.0n 0.5620 2999.5n 0.5620 3000.0n 0.5000 3599.5n 0.5000 3600.0n 0.5274 4199.5n 0.5274 4200.0n 0.5867 4799.5n 0.5867 4800.0n 0.5675 5399.5n 0.5675 5400.0n 0.5971 5999.5n 0.5971 6000.0n 0.5525 6599.5n 0.5525 6600.0n 0.6050 7199.5n 0.6050 7200.0n 0.5144 7799.5n 0.5144 7800.0n 0.5952 8399.5n 0.5952 8400.0n 0.5637 8999.5n 0.5637 9000.0n 0.6050 9599.5n 0.6050 9600.0n 0.5689 10199.5n 0.5689 10200.0n 0.6050 10799.5n 0.6050 10800.0n 0.5512 11399.5n 0.5512 11400.0n 0.5169 11999.5n 0.5169 12000.0n 0.5935 12599.5n 0.5935 12600.0n 0.4484 13199.5n 0.4484 13200.0n 0.5917 13799.5n 0.5917 13800.0n 0.5508 14399.5n 0.5508)
Vxn_wih_2_7 xn_wih_2_7 0 PWL(0.0n 0.4927 599.5n 0.4927 600.0n 0.3950 1199.5n 0.3950 1200.0n 0.4104 1799.5n 0.4104 1800.0n 0.4332 2399.5n 0.4332 2400.0n 0.4380 2999.5n 0.4380 3000.0n 0.5000 3599.5n 0.5000 3600.0n 0.4726 4199.5n 0.4726 4200.0n 0.4133 4799.5n 0.4133 4800.0n 0.4325 5399.5n 0.4325 5400.0n 0.4029 5999.5n 0.4029 6000.0n 0.4475 6599.5n 0.4475 6600.0n 0.3950 7199.5n 0.3950 7200.0n 0.4856 7799.5n 0.4856 7800.0n 0.4048 8399.5n 0.4048 8400.0n 0.4363 8999.5n 0.4363 9000.0n 0.3950 9599.5n 0.3950 9600.0n 0.4311 10199.5n 0.4311 10200.0n 0.3950 10799.5n 0.3950 10800.0n 0.4488 11399.5n 0.4488 11400.0n 0.4831 11999.5n 0.4831 12000.0n 0.4065 12599.5n 0.4065 12600.0n 0.5516 13199.5n 0.5516 13200.0n 0.4083 13799.5n 0.4083 13800.0n 0.4492 14399.5n 0.4492)
Vyp_wih_2_7 yp_wih_2_7 0 PWL(0.0n 0.6537 599.5n 0.6537 600.0n 0.5794 1199.5n 0.5794 1200.0n 0.6059 1799.5n 0.6059 1800.0n 0.6225 2399.5n 0.6225 2400.0n 0.6129 2999.5n 0.6129 3000.0n 0.6584 3599.5n 0.6584 3600.0n 0.6514 4199.5n 0.6514 4200.0n 0.6003 4799.5n 0.6003 4800.0n 0.6039 5399.5n 0.6039 5400.0n 0.6127 5999.5n 0.6127 6000.0n 0.6245 6599.5n 0.6245 6600.0n 0.5892 7199.5n 0.5892 7200.0n 0.6696 7799.5n 0.6696 7800.0n 0.6557 8399.5n 0.6557 8400.0n 0.6660 8999.5n 0.6660 9000.0n 0.6391 9599.5n 0.6391 9600.0n 0.6583 10199.5n 0.6583 10200.0n 0.6436 10799.5n 0.6436 10800.0n 0.6686 11399.5n 0.6686 11400.0n 0.6614 11999.5n 0.6614 12000.0n 0.6610 12599.5n 0.6610 12600.0n 0.6632 13199.5n 0.6632 13200.0n 0.6613 13799.5n 0.6613 13800.0n 0.6628 14399.5n 0.6628)
Vyn_wih_2_7 yn_wih_2_7 0 PWL(0.0n 0.3463 599.5n 0.3463 600.0n 0.4206 1199.5n 0.4206 1200.0n 0.3941 1799.5n 0.3941 1800.0n 0.3775 2399.5n 0.3775 2400.0n 0.3871 2999.5n 0.3871 3000.0n 0.3416 3599.5n 0.3416 3600.0n 0.3486 4199.5n 0.3486 4200.0n 0.3997 4799.5n 0.3997 4800.0n 0.3961 5399.5n 0.3961 5400.0n 0.3873 5999.5n 0.3873 6000.0n 0.3755 6599.5n 0.3755 6600.0n 0.4108 7199.5n 0.4108 7200.0n 0.3304 7799.5n 0.3304 7800.0n 0.3443 8399.5n 0.3443 8400.0n 0.3340 8999.5n 0.3340 9000.0n 0.3609 9599.5n 0.3609 9600.0n 0.3417 10199.5n 0.3417 10200.0n 0.3564 10799.5n 0.3564 10800.0n 0.3314 11399.5n 0.3314 11400.0n 0.3386 11999.5n 0.3386 12000.0n 0.3390 12599.5n 0.3390 12600.0n 0.3368 13199.5n 0.3368 13200.0n 0.3387 13799.5n 0.3387 13800.0n 0.3372 14399.5n 0.3372)
Cwp_wih_2_7 wp_wih_2_7 0 400p
Cwn_wih_2_7 wn_wih_2_7 0 400p
Xu_wih_2_7 xp_wih_2_7 xn_wih_2_7 yp_wih_2_7 yn_wih_2_7 wp_wih_2_7 wn_wih_2_7 vdd gbn gprod
Vxp_wih_3_7 xp_wih_3_7 0 PWL(0.0n 0.4048 599.5n 0.4048 600.0n 0.4386 1199.5n 0.4386 1200.0n 0.3950 1799.5n 0.3950 1800.0n 0.3950 2399.5n 0.3950 2400.0n 0.3950 2999.5n 0.3950 3000.0n 0.3950 3599.5n 0.3950 3600.0n 0.3950 4199.5n 0.3950 4200.0n 0.3950 4799.5n 0.3950 4800.0n 0.4025 5399.5n 0.4025 5400.0n 0.4069 5999.5n 0.4069 6000.0n 0.3950 6599.5n 0.3950 6600.0n 0.4045 7199.5n 0.4045 7200.0n 0.3950 7799.5n 0.3950 7800.0n 0.4311 8399.5n 0.4311 8400.0n 0.3984 8999.5n 0.3984 9000.0n 0.4362 9599.5n 0.4362 9600.0n 0.4475 10199.5n 0.4475 10200.0n 0.3950 10799.5n 0.3950 10800.0n 0.3950 11399.5n 0.3950 11400.0n 0.3950 11999.5n 0.3950 12000.0n 0.3950 12599.5n 0.3950 12600.0n 0.3950 13199.5n 0.3950 13200.0n 0.4083 13799.5n 0.4083 13800.0n 0.3950 14399.5n 0.3950)
Vxn_wih_3_7 xn_wih_3_7 0 PWL(0.0n 0.5952 599.5n 0.5952 600.0n 0.5614 1199.5n 0.5614 1200.0n 0.6050 1799.5n 0.6050 1800.0n 0.6050 2399.5n 0.6050 2400.0n 0.6050 2999.5n 0.6050 3000.0n 0.6050 3599.5n 0.6050 3600.0n 0.6050 4199.5n 0.6050 4200.0n 0.6050 4799.5n 0.6050 4800.0n 0.5975 5399.5n 0.5975 5400.0n 0.5931 5999.5n 0.5931 6000.0n 0.6050 6599.5n 0.6050 6600.0n 0.5955 7199.5n 0.5955 7200.0n 0.6050 7799.5n 0.6050 7800.0n 0.5689 8399.5n 0.5689 8400.0n 0.6016 8999.5n 0.6016 9000.0n 0.5638 9599.5n 0.5638 9600.0n 0.5525 10199.5n 0.5525 10200.0n 0.6050 10799.5n 0.6050 10800.0n 0.6050 11399.5n 0.6050 11400.0n 0.6050 11999.5n 0.6050 12000.0n 0.6050 12599.5n 0.6050 12600.0n 0.6050 13199.5n 0.6050 13200.0n 0.5917 13799.5n 0.5917 13800.0n 0.6050 14399.5n 0.6050)
Vyp_wih_3_7 yp_wih_3_7 0 PWL(0.0n 0.6537 599.5n 0.6537 600.0n 0.5794 1199.5n 0.5794 1200.0n 0.6059 1799.5n 0.6059 1800.0n 0.6225 2399.5n 0.6225 2400.0n 0.6129 2999.5n 0.6129 3000.0n 0.6584 3599.5n 0.6584 3600.0n 0.6514 4199.5n 0.6514 4200.0n 0.6003 4799.5n 0.6003 4800.0n 0.6039 5399.5n 0.6039 5400.0n 0.6127 5999.5n 0.6127 6000.0n 0.6245 6599.5n 0.6245 6600.0n 0.5892 7199.5n 0.5892 7200.0n 0.6696 7799.5n 0.6696 7800.0n 0.6557 8399.5n 0.6557 8400.0n 0.6660 8999.5n 0.6660 9000.0n 0.6391 9599.5n 0.6391 9600.0n 0.6583 10199.5n 0.6583 10200.0n 0.6436 10799.5n 0.6436 10800.0n 0.6686 11399.5n 0.6686 11400.0n 0.6614 11999.5n 0.6614 12000.0n 0.6610 12599.5n 0.6610 12600.0n 0.6632 13199.5n 0.6632 13200.0n 0.6613 13799.5n 0.6613 13800.0n 0.6628 14399.5n 0.6628)
Vyn_wih_3_7 yn_wih_3_7 0 PWL(0.0n 0.3463 599.5n 0.3463 600.0n 0.4206 1199.5n 0.4206 1200.0n 0.3941 1799.5n 0.3941 1800.0n 0.3775 2399.5n 0.3775 2400.0n 0.3871 2999.5n 0.3871 3000.0n 0.3416 3599.5n 0.3416 3600.0n 0.3486 4199.5n 0.3486 4200.0n 0.3997 4799.5n 0.3997 4800.0n 0.3961 5399.5n 0.3961 5400.0n 0.3873 5999.5n 0.3873 6000.0n 0.3755 6599.5n 0.3755 6600.0n 0.4108 7199.5n 0.4108 7200.0n 0.3304 7799.5n 0.3304 7800.0n 0.3443 8399.5n 0.3443 8400.0n 0.3340 8999.5n 0.3340 9000.0n 0.3609 9599.5n 0.3609 9600.0n 0.3417 10199.5n 0.3417 10200.0n 0.3564 10799.5n 0.3564 10800.0n 0.3314 11399.5n 0.3314 11400.0n 0.3386 11999.5n 0.3386 12000.0n 0.3390 12599.5n 0.3390 12600.0n 0.3368 13199.5n 0.3368 13200.0n 0.3387 13799.5n 0.3387 13800.0n 0.3372 14399.5n 0.3372)
Cwp_wih_3_7 wp_wih_3_7 0 400p
Cwn_wih_3_7 wn_wih_3_7 0 400p
Xu_wih_3_7 xp_wih_3_7 xn_wih_3_7 yp_wih_3_7 yn_wih_3_7 wp_wih_3_7 wn_wih_3_7 vdd gbn gprod
Vxp_wih_6_7 xp_wih_6_7 0 PWL(0.0n 0.4927 599.5n 0.4927 600.0n 0.5059 1199.5n 0.5059 1200.0n 0.5128 1799.5n 0.5128 1800.0n 0.4857 2399.5n 0.4857 2400.0n 0.4857 2999.5n 0.4857 3000.0n 0.4909 3599.5n 0.4909 3600.0n 0.5000 4199.5n 0.5000 4200.0n 0.4543 4799.5n 0.4543 4800.0n 0.4737 5399.5n 0.4737 5400.0n 0.5297 5999.5n 0.5297 6000.0n 0.4694 6599.5n 0.4694 6600.0n 0.4809 7199.5n 0.4809 7200.0n 0.5762 7799.5n 0.5762 7800.0n 0.6050 8399.5n 0.6050 8400.0n 0.6050 8999.5n 0.6050 9000.0n 0.5679 9599.5n 0.5679 9600.0n 0.6050 10199.5n 0.6050 10200.0n 0.5428 10799.5n 0.5428 10800.0n 0.6050 11399.5n 0.6050 11400.0n 0.5203 11999.5n 0.5203 12000.0n 0.5974 12599.5n 0.5974 12600.0n 0.4519 13199.5n 0.4519 13200.0n 0.6050 13799.5n 0.6050 13800.0n 0.5610 14399.5n 0.5610)
Vxn_wih_6_7 xn_wih_6_7 0 PWL(0.0n 0.5073 599.5n 0.5073 600.0n 0.4941 1199.5n 0.4941 1200.0n 0.4872 1799.5n 0.4872 1800.0n 0.5143 2399.5n 0.5143 2400.0n 0.5143 2999.5n 0.5143 3000.0n 0.5091 3599.5n 0.5091 3600.0n 0.5000 4199.5n 0.5000 4200.0n 0.5457 4799.5n 0.5457 4800.0n 0.5263 5399.5n 0.5263 5400.0n 0.4703 5999.5n 0.4703 6000.0n 0.5306 6599.5n 0.5306 6600.0n 0.5191 7199.5n 0.5191 7200.0n 0.4238 7799.5n 0.4238 7800.0n 0.3950 8399.5n 0.3950 8400.0n 0.3950 8999.5n 0.3950 9000.0n 0.4321 9599.5n 0.4321 9600.0n 0.3950 10199.5n 0.3950 10200.0n 0.4572 10799.5n 0.4572 10800.0n 0.3950 11399.5n 0.3950 11400.0n 0.4797 11999.5n 0.4797 12000.0n 0.4026 12599.5n 0.4026 12600.0n 0.5481 13199.5n 0.5481 13200.0n 0.3950 13799.5n 0.3950 13800.0n 0.4390 14399.5n 0.4390)
Vyp_wih_6_7 yp_wih_6_7 0 PWL(0.0n 0.6537 599.5n 0.6537 600.0n 0.5794 1199.5n 0.5794 1200.0n 0.6059 1799.5n 0.6059 1800.0n 0.6225 2399.5n 0.6225 2400.0n 0.6129 2999.5n 0.6129 3000.0n 0.6584 3599.5n 0.6584 3600.0n 0.6514 4199.5n 0.6514 4200.0n 0.6003 4799.5n 0.6003 4800.0n 0.6039 5399.5n 0.6039 5400.0n 0.6127 5999.5n 0.6127 6000.0n 0.6245 6599.5n 0.6245 6600.0n 0.5892 7199.5n 0.5892 7200.0n 0.6696 7799.5n 0.6696 7800.0n 0.6557 8399.5n 0.6557 8400.0n 0.6660 8999.5n 0.6660 9000.0n 0.6391 9599.5n 0.6391 9600.0n 0.6583 10199.5n 0.6583 10200.0n 0.6436 10799.5n 0.6436 10800.0n 0.6686 11399.5n 0.6686 11400.0n 0.6614 11999.5n 0.6614 12000.0n 0.6610 12599.5n 0.6610 12600.0n 0.6632 13199.5n 0.6632 13200.0n 0.6613 13799.5n 0.6613 13800.0n 0.6628 14399.5n 0.6628)
Vyn_wih_6_7 yn_wih_6_7 0 PWL(0.0n 0.3463 599.5n 0.3463 600.0n 0.4206 1199.5n 0.4206 1200.0n 0.3941 1799.5n 0.3941 1800.0n 0.3775 2399.5n 0.3775 2400.0n 0.3871 2999.5n 0.3871 3000.0n 0.3416 3599.5n 0.3416 3600.0n 0.3486 4199.5n 0.3486 4200.0n 0.3997 4799.5n 0.3997 4800.0n 0.3961 5399.5n 0.3961 5400.0n 0.3873 5999.5n 0.3873 6000.0n 0.3755 6599.5n 0.3755 6600.0n 0.4108 7199.5n 0.4108 7200.0n 0.3304 7799.5n 0.3304 7800.0n 0.3443 8399.5n 0.3443 8400.0n 0.3340 8999.5n 0.3340 9000.0n 0.3609 9599.5n 0.3609 9600.0n 0.3417 10199.5n 0.3417 10200.0n 0.3564 10799.5n 0.3564 10800.0n 0.3314 11399.5n 0.3314 11400.0n 0.3386 11999.5n 0.3386 12000.0n 0.3390 12599.5n 0.3390 12600.0n 0.3368 13199.5n 0.3368 13200.0n 0.3387 13799.5n 0.3387 13800.0n 0.3372 14399.5n 0.3372)
Cwp_wih_6_7 wp_wih_6_7 0 400p
Cwn_wih_6_7 wn_wih_6_7 0 400p
Xu_wih_6_7 xp_wih_6_7 xn_wih_6_7 yp_wih_6_7 yn_wih_6_7 wp_wih_6_7 wn_wih_6_7 vdd gbn gprod
Vxp_wih_7_7 xp_wih_7_7 0 PWL(0.0n 0.4341 599.5n 0.4341 600.0n 0.4663 1199.5n 0.4663 1200.0n 0.4513 1799.5n 0.4513 1800.0n 0.4380 2399.5n 0.4380 2400.0n 0.4618 2999.5n 0.4618 3000.0n 0.4178 3599.5n 0.4178 3600.0n 0.4361 4199.5n 0.4361 4200.0n 0.4315 4799.5n 0.4315 4800.0n 0.4550 5399.5n 0.4550 5400.0n 0.4465 5999.5n 0.4465 6000.0n 0.4475 6599.5n 0.4475 6600.0n 0.4523 7199.5n 0.4523 7200.0n 0.3950 7799.5n 0.3950 7800.0n 0.4212 8399.5n 0.4212 8400.0n 0.3950 8999.5n 0.3950 9000.0n 0.4279 9599.5n 0.4279 9600.0n 0.4212 10199.5n 0.4212 10200.0n 0.3950 10799.5n 0.3950 10800.0n 0.3950 11399.5n 0.3950 11400.0n 0.3950 11999.5n 0.3950 12000.0n 0.3950 12599.5n 0.3950 12600.0n 0.3950 13199.5n 0.3950 13200.0n 0.3950 13799.5n 0.3950 13800.0n 0.3950 14399.5n 0.3950)
Vxn_wih_7_7 xn_wih_7_7 0 PWL(0.0n 0.5659 599.5n 0.5659 600.0n 0.5337 1199.5n 0.5337 1200.0n 0.5487 1799.5n 0.5487 1800.0n 0.5620 2399.5n 0.5620 2400.0n 0.5382 2999.5n 0.5382 3000.0n 0.5822 3599.5n 0.5822 3600.0n 0.5639 4199.5n 0.5639 4200.0n 0.5685 4799.5n 0.5685 4800.0n 0.5450 5399.5n 0.5450 5400.0n 0.5535 5999.5n 0.5535 6000.0n 0.5525 6599.5n 0.5525 6600.0n 0.5477 7199.5n 0.5477 7200.0n 0.6050 7799.5n 0.6050 7800.0n 0.5788 8399.5n 0.5788 8400.0n 0.6050 8999.5n 0.6050 9000.0n 0.5721 9599.5n 0.5721 9600.0n 0.5788 10199.5n 0.5788 10200.0n 0.6050 10799.5n 0.6050 10800.0n 0.6050 11399.5n 0.6050 11400.0n 0.6050 11999.5n 0.6050 12000.0n 0.6050 12599.5n 0.6050 12600.0n 0.6050 13199.5n 0.6050 13200.0n 0.6050 13799.5n 0.6050 13800.0n 0.6050 14399.5n 0.6050)
Vyp_wih_7_7 yp_wih_7_7 0 PWL(0.0n 0.6537 599.5n 0.6537 600.0n 0.5794 1199.5n 0.5794 1200.0n 0.6059 1799.5n 0.6059 1800.0n 0.6225 2399.5n 0.6225 2400.0n 0.6129 2999.5n 0.6129 3000.0n 0.6584 3599.5n 0.6584 3600.0n 0.6514 4199.5n 0.6514 4200.0n 0.6003 4799.5n 0.6003 4800.0n 0.6039 5399.5n 0.6039 5400.0n 0.6127 5999.5n 0.6127 6000.0n 0.6245 6599.5n 0.6245 6600.0n 0.5892 7199.5n 0.5892 7200.0n 0.6696 7799.5n 0.6696 7800.0n 0.6557 8399.5n 0.6557 8400.0n 0.6660 8999.5n 0.6660 9000.0n 0.6391 9599.5n 0.6391 9600.0n 0.6583 10199.5n 0.6583 10200.0n 0.6436 10799.5n 0.6436 10800.0n 0.6686 11399.5n 0.6686 11400.0n 0.6614 11999.5n 0.6614 12000.0n 0.6610 12599.5n 0.6610 12600.0n 0.6632 13199.5n 0.6632 13200.0n 0.6613 13799.5n 0.6613 13800.0n 0.6628 14399.5n 0.6628)
Vyn_wih_7_7 yn_wih_7_7 0 PWL(0.0n 0.3463 599.5n 0.3463 600.0n 0.4206 1199.5n 0.4206 1200.0n 0.3941 1799.5n 0.3941 1800.0n 0.3775 2399.5n 0.3775 2400.0n 0.3871 2999.5n 0.3871 3000.0n 0.3416 3599.5n 0.3416 3600.0n 0.3486 4199.5n 0.3486 4200.0n 0.3997 4799.5n 0.3997 4800.0n 0.3961 5399.5n 0.3961 5400.0n 0.3873 5999.5n 0.3873 6000.0n 0.3755 6599.5n 0.3755 6600.0n 0.4108 7199.5n 0.4108 7200.0n 0.3304 7799.5n 0.3304 7800.0n 0.3443 8399.5n 0.3443 8400.0n 0.3340 8999.5n 0.3340 9000.0n 0.3609 9599.5n 0.3609 9600.0n 0.3417 10199.5n 0.3417 10200.0n 0.3564 10799.5n 0.3564 10800.0n 0.3314 11399.5n 0.3314 11400.0n 0.3386 11999.5n 0.3386 12000.0n 0.3390 12599.5n 0.3390 12600.0n 0.3368 13199.5n 0.3368 13200.0n 0.3387 13799.5n 0.3387 13800.0n 0.3372 14399.5n 0.3372)
Cwp_wih_7_7 wp_wih_7_7 0 400p
Cwn_wih_7_7 wn_wih_7_7 0 400p
Xu_wih_7_7 xp_wih_7_7 xn_wih_7_7 yp_wih_7_7 yn_wih_7_7 wp_wih_7_7 wn_wih_7_7 vdd gbn gprod
Vxp_who_7_0 xp_who_7_0 0 PWL(0.0n 0.6537 599.5n 0.6537 600.0n 0.5794 1199.5n 0.5794 1200.0n 0.6059 1799.5n 0.6059 1800.0n 0.6225 2399.5n 0.6225 2400.0n 0.6129 2999.5n 0.6129 3000.0n 0.6584 3599.5n 0.6584 3600.0n 0.6514 4199.5n 0.6514 4200.0n 0.6003 4799.5n 0.6003 4800.0n 0.6039 5399.5n 0.6039 5400.0n 0.6127 5999.5n 0.6127 6000.0n 0.6245 6599.5n 0.6245 6600.0n 0.5892 7199.5n 0.5892 7200.0n 0.6696 7799.5n 0.6696 7800.0n 0.6557 8399.5n 0.6557 8400.0n 0.6660 8999.5n 0.6660 9000.0n 0.6391 9599.5n 0.6391 9600.0n 0.6583 10199.5n 0.6583 10200.0n 0.6436 10799.5n 0.6436 10800.0n 0.6686 11399.5n 0.6686 11400.0n 0.6614 11999.5n 0.6614 12000.0n 0.6610 12599.5n 0.6610 12600.0n 0.6632 13199.5n 0.6632 13200.0n 0.6613 13799.5n 0.6613 13800.0n 0.6628 14399.5n 0.6628)
Vxn_who_7_0 xn_who_7_0 0 PWL(0.0n 0.3463 599.5n 0.3463 600.0n 0.4206 1199.5n 0.4206 1200.0n 0.3941 1799.5n 0.3941 1800.0n 0.3775 2399.5n 0.3775 2400.0n 0.3871 2999.5n 0.3871 3000.0n 0.3416 3599.5n 0.3416 3600.0n 0.3486 4199.5n 0.3486 4200.0n 0.3997 4799.5n 0.3997 4800.0n 0.3961 5399.5n 0.3961 5400.0n 0.3873 5999.5n 0.3873 6000.0n 0.3755 6599.5n 0.3755 6600.0n 0.4108 7199.5n 0.4108 7200.0n 0.3304 7799.5n 0.3304 7800.0n 0.3443 8399.5n 0.3443 8400.0n 0.3340 8999.5n 0.3340 9000.0n 0.3609 9599.5n 0.3609 9600.0n 0.3417 10199.5n 0.3417 10200.0n 0.3564 10799.5n 0.3564 10800.0n 0.3314 11399.5n 0.3314 11400.0n 0.3386 11999.5n 0.3386 12000.0n 0.3390 12599.5n 0.3390 12600.0n 0.3368 13199.5n 0.3368 13200.0n 0.3387 13799.5n 0.3387 13800.0n 0.3372 14399.5n 0.3372)
Vyp_who_7_0 yp_who_7_0 0 PWL(0.0n 0.5073 599.5n 0.5073 600.0n 0.5065 1199.5n 0.5065 1200.0n 0.5065 1799.5n 0.5065 1800.0n 0.5052 2399.5n 0.5052 2400.0n 0.5058 2999.5n 0.5058 3000.0n 0.5039 3599.5n 0.5039 3600.0n 0.5059 4199.5n 0.5059 4200.0n 0.5077 4799.5n 0.5077 4800.0n 0.5054 5399.5n 0.5054 5400.0n 0.5066 5999.5n 0.5066 6000.0n 0.5083 6599.5n 0.5083 6600.0n 0.5078 7199.5n 0.5078 7200.0n 0.5043 7799.5n 0.5043 7800.0n 0.5035 8399.5n 0.5035 8400.0n 0.5035 8999.5n 0.5035 9000.0n 0.5038 9599.5n 0.5038 9600.0n 0.5043 10199.5n 0.5043 10200.0n 0.5053 10799.5n 0.5053 10800.0n 0.5050 11399.5n 0.5050 11400.0n 0.5055 11999.5n 0.5055 12000.0n 0.5043 12599.5n 0.5043 12600.0n 0.5028 13199.5n 0.5028 13200.0n 0.5045 13799.5n 0.5045 13800.0n 0.5043 14399.5n 0.5043)
Vyn_who_7_0 yn_who_7_0 0 PWL(0.0n 0.4927 599.5n 0.4927 600.0n 0.4935 1199.5n 0.4935 1200.0n 0.4935 1799.5n 0.4935 1800.0n 0.4948 2399.5n 0.4948 2400.0n 0.4942 2999.5n 0.4942 3000.0n 0.4961 3599.5n 0.4961 3600.0n 0.4941 4199.5n 0.4941 4200.0n 0.4923 4799.5n 0.4923 4800.0n 0.4946 5399.5n 0.4946 5400.0n 0.4934 5999.5n 0.4934 6000.0n 0.4917 6599.5n 0.4917 6600.0n 0.4922 7199.5n 0.4922 7200.0n 0.4957 7799.5n 0.4957 7800.0n 0.4965 8399.5n 0.4965 8400.0n 0.4965 8999.5n 0.4965 9000.0n 0.4962 9599.5n 0.4962 9600.0n 0.4957 10199.5n 0.4957 10200.0n 0.4947 10799.5n 0.4947 10800.0n 0.4950 11399.5n 0.4950 11400.0n 0.4945 11999.5n 0.4945 12000.0n 0.4957 12599.5n 0.4957 12600.0n 0.4972 13199.5n 0.4972 13200.0n 0.4955 13799.5n 0.4955 13800.0n 0.4957 14399.5n 0.4957)
Cwp_who_7_0 wp_who_7_0 0 400p
Cwn_who_7_0 wn_who_7_0 0 400p
Xu_who_7_0 xp_who_7_0 xn_who_7_0 yp_who_7_0 yn_who_7_0 wp_who_7_0 wn_who_7_0 vdd gbn gprod
Vxp_who_7_1 xp_who_7_1 0 PWL(0.0n 0.6537 599.5n 0.6537 600.0n 0.5794 1199.5n 0.5794 1200.0n 0.6059 1799.5n 0.6059 1800.0n 0.6225 2399.5n 0.6225 2400.0n 0.6129 2999.5n 0.6129 3000.0n 0.6584 3599.5n 0.6584 3600.0n 0.6514 4199.5n 0.6514 4200.0n 0.6003 4799.5n 0.6003 4800.0n 0.6039 5399.5n 0.6039 5400.0n 0.6127 5999.5n 0.6127 6000.0n 0.6245 6599.5n 0.6245 6600.0n 0.5892 7199.5n 0.5892 7200.0n 0.6696 7799.5n 0.6696 7800.0n 0.6557 8399.5n 0.6557 8400.0n 0.6660 8999.5n 0.6660 9000.0n 0.6391 9599.5n 0.6391 9600.0n 0.6583 10199.5n 0.6583 10200.0n 0.6436 10799.5n 0.6436 10800.0n 0.6686 11399.5n 0.6686 11400.0n 0.6614 11999.5n 0.6614 12000.0n 0.6610 12599.5n 0.6610 12600.0n 0.6632 13199.5n 0.6632 13200.0n 0.6613 13799.5n 0.6613 13800.0n 0.6628 14399.5n 0.6628)
Vxn_who_7_1 xn_who_7_1 0 PWL(0.0n 0.3463 599.5n 0.3463 600.0n 0.4206 1199.5n 0.4206 1200.0n 0.3941 1799.5n 0.3941 1800.0n 0.3775 2399.5n 0.3775 2400.0n 0.3871 2999.5n 0.3871 3000.0n 0.3416 3599.5n 0.3416 3600.0n 0.3486 4199.5n 0.3486 4200.0n 0.3997 4799.5n 0.3997 4800.0n 0.3961 5399.5n 0.3961 5400.0n 0.3873 5999.5n 0.3873 6000.0n 0.3755 6599.5n 0.3755 6600.0n 0.4108 7199.5n 0.4108 7200.0n 0.3304 7799.5n 0.3304 7800.0n 0.3443 8399.5n 0.3443 8400.0n 0.3340 8999.5n 0.3340 9000.0n 0.3609 9599.5n 0.3609 9600.0n 0.3417 10199.5n 0.3417 10200.0n 0.3564 10799.5n 0.3564 10800.0n 0.3314 11399.5n 0.3314 11400.0n 0.3386 11999.5n 0.3386 12000.0n 0.3390 12599.5n 0.3390 12600.0n 0.3368 13199.5n 0.3368 13200.0n 0.3387 13799.5n 0.3387 13800.0n 0.3372 14399.5n 0.3372)
Vyp_who_7_1 yp_who_7_1 0 PWL(0.0n 0.4909 599.5n 0.4909 600.0n 0.4933 1199.5n 0.4933 1200.0n 0.4930 1799.5n 0.4930 1800.0n 0.4893 2399.5n 0.4893 2400.0n 0.4904 2999.5n 0.4904 3000.0n 0.4923 3599.5n 0.4923 3600.0n 0.4897 4199.5n 0.4897 4200.0n 0.4890 4799.5n 0.4890 4800.0n 0.4921 5399.5n 0.4921 5400.0n 0.4899 5999.5n 0.4899 6000.0n 0.4870 6599.5n 0.4870 6600.0n 0.4903 7199.5n 0.4903 7200.0n 0.4970 7799.5n 0.4970 7800.0n 0.4989 8399.5n 0.4989 8400.0n 0.4994 8999.5n 0.4994 9000.0n 0.4991 9599.5n 0.4991 9600.0n 0.5000 10199.5n 0.5000 10200.0n 0.4948 10799.5n 0.4948 10800.0n 0.4959 11399.5n 0.4959 11400.0n 0.4926 11999.5n 0.4926 12000.0n 0.4993 12599.5n 0.4993 12600.0n 0.4862 13199.5n 0.4862 13200.0n 0.4993 13799.5n 0.4993 13800.0n 0.4961 14399.5n 0.4961)
Vyn_who_7_1 yn_who_7_1 0 PWL(0.0n 0.5091 599.5n 0.5091 600.0n 0.5067 1199.5n 0.5067 1200.0n 0.5070 1799.5n 0.5070 1800.0n 0.5107 2399.5n 0.5107 2400.0n 0.5096 2999.5n 0.5096 3000.0n 0.5077 3599.5n 0.5077 3600.0n 0.5103 4199.5n 0.5103 4200.0n 0.5110 4799.5n 0.5110 4800.0n 0.5079 5399.5n 0.5079 5400.0n 0.5101 5999.5n 0.5101 6000.0n 0.5130 6599.5n 0.5130 6600.0n 0.5097 7199.5n 0.5097 7200.0n 0.5030 7799.5n 0.5030 7800.0n 0.5011 8399.5n 0.5011 8400.0n 0.5006 8999.5n 0.5006 9000.0n 0.5009 9599.5n 0.5009 9600.0n 0.5000 10199.5n 0.5000 10200.0n 0.5052 10799.5n 0.5052 10800.0n 0.5041 11399.5n 0.5041 11400.0n 0.5074 11999.5n 0.5074 12000.0n 0.5007 12599.5n 0.5007 12600.0n 0.5138 13199.5n 0.5138 13200.0n 0.5007 13799.5n 0.5007 13800.0n 0.5039 14399.5n 0.5039)
Cwp_who_7_1 wp_who_7_1 0 400p
Cwn_who_7_1 wn_who_7_1 0 400p
Xu_who_7_1 xp_who_7_1 xn_who_7_1 yp_who_7_1 yn_who_7_1 wp_who_7_1 wn_who_7_1 vdd gbn gprod
Vxp_bh_7 xp_bh_7 0 PWL(0.0n 0.7100 599.5n 0.7100 600.0n 0.7100 1199.5n 0.7100 1200.0n 0.7100 1799.5n 0.7100 1800.0n 0.7100 2399.5n 0.7100 2400.0n 0.7100 2999.5n 0.7100 3000.0n 0.7100 3599.5n 0.7100 3600.0n 0.7100 4199.5n 0.7100 4200.0n 0.7100 4799.5n 0.7100 4800.0n 0.7100 5399.5n 0.7100 5400.0n 0.7100 5999.5n 0.7100 6000.0n 0.7100 6599.5n 0.7100 6600.0n 0.7100 7199.5n 0.7100 7200.0n 0.7100 7799.5n 0.7100 7800.0n 0.7100 8399.5n 0.7100 8400.0n 0.7100 8999.5n 0.7100 9000.0n 0.7100 9599.5n 0.7100 9600.0n 0.7100 10199.5n 0.7100 10200.0n 0.7100 10799.5n 0.7100 10800.0n 0.7100 11399.5n 0.7100 11400.0n 0.7100 11999.5n 0.7100 12000.0n 0.7100 12599.5n 0.7100 12600.0n 0.7100 13199.5n 0.7100 13200.0n 0.7100 13799.5n 0.7100 13800.0n 0.7100 14399.5n 0.7100)
Vxn_bh_7 xn_bh_7 0 PWL(0.0n 0.2900 599.5n 0.2900 600.0n 0.2900 1199.5n 0.2900 1200.0n 0.2900 1799.5n 0.2900 1800.0n 0.2900 2399.5n 0.2900 2400.0n 0.2900 2999.5n 0.2900 3000.0n 0.2900 3599.5n 0.2900 3600.0n 0.2900 4199.5n 0.2900 4200.0n 0.2900 4799.5n 0.2900 4800.0n 0.2900 5399.5n 0.2900 5400.0n 0.2900 5999.5n 0.2900 6000.0n 0.2900 6599.5n 0.2900 6600.0n 0.2900 7199.5n 0.2900 7200.0n 0.2900 7799.5n 0.2900 7800.0n 0.2900 8399.5n 0.2900 8400.0n 0.2900 8999.5n 0.2900 9000.0n 0.2900 9599.5n 0.2900 9600.0n 0.2900 10199.5n 0.2900 10200.0n 0.2900 10799.5n 0.2900 10800.0n 0.2900 11399.5n 0.2900 11400.0n 0.2900 11999.5n 0.2900 12000.0n 0.2900 12599.5n 0.2900 12600.0n 0.2900 13199.5n 0.2900 13200.0n 0.2900 13799.5n 0.2900 13800.0n 0.2900 14399.5n 0.2900)
Vyp_bh_7 yp_bh_7 0 PWL(0.0n 0.6537 599.5n 0.6537 600.0n 0.5794 1199.5n 0.5794 1200.0n 0.6059 1799.5n 0.6059 1800.0n 0.6225 2399.5n 0.6225 2400.0n 0.6129 2999.5n 0.6129 3000.0n 0.6584 3599.5n 0.6584 3600.0n 0.6514 4199.5n 0.6514 4200.0n 0.6003 4799.5n 0.6003 4800.0n 0.6039 5399.5n 0.6039 5400.0n 0.6127 5999.5n 0.6127 6000.0n 0.6245 6599.5n 0.6245 6600.0n 0.5892 7199.5n 0.5892 7200.0n 0.6696 7799.5n 0.6696 7800.0n 0.6557 8399.5n 0.6557 8400.0n 0.6660 8999.5n 0.6660 9000.0n 0.6391 9599.5n 0.6391 9600.0n 0.6583 10199.5n 0.6583 10200.0n 0.6436 10799.5n 0.6436 10800.0n 0.6686 11399.5n 0.6686 11400.0n 0.6614 11999.5n 0.6614 12000.0n 0.6610 12599.5n 0.6610 12600.0n 0.6632 13199.5n 0.6632 13200.0n 0.6613 13799.5n 0.6613 13800.0n 0.6628 14399.5n 0.6628)
Vyn_bh_7 yn_bh_7 0 PWL(0.0n 0.3463 599.5n 0.3463 600.0n 0.4206 1199.5n 0.4206 1200.0n 0.3941 1799.5n 0.3941 1800.0n 0.3775 2399.5n 0.3775 2400.0n 0.3871 2999.5n 0.3871 3000.0n 0.3416 3599.5n 0.3416 3600.0n 0.3486 4199.5n 0.3486 4200.0n 0.3997 4799.5n 0.3997 4800.0n 0.3961 5399.5n 0.3961 5400.0n 0.3873 5999.5n 0.3873 6000.0n 0.3755 6599.5n 0.3755 6600.0n 0.4108 7199.5n 0.4108 7200.0n 0.3304 7799.5n 0.3304 7800.0n 0.3443 8399.5n 0.3443 8400.0n 0.3340 8999.5n 0.3340 9000.0n 0.3609 9599.5n 0.3609 9600.0n 0.3417 10199.5n 0.3417 10200.0n 0.3564 10799.5n 0.3564 10800.0n 0.3314 11399.5n 0.3314 11400.0n 0.3386 11999.5n 0.3386 12000.0n 0.3390 12599.5n 0.3390 12600.0n 0.3368 13199.5n 0.3368 13200.0n 0.3387 13799.5n 0.3387 13800.0n 0.3372 14399.5n 0.3372)
Cwp_bh_7 wp_bh_7 0 400p
Cwn_bh_7 wn_bh_7 0 400p
Xu_bh_7 xp_bh_7 xn_bh_7 yp_bh_7 yn_bh_7 wp_bh_7 wn_bh_7 vdd gbn gprod
Vxp_wih_8_8 xp_wih_8_8 0 PWL(0.0n 0.4390 599.5n 0.4390 600.0n 0.4386 1199.5n 0.4386 1200.0n 0.4513 1799.5n 0.4513 1800.0n 0.4236 2399.5n 0.4236 2400.0n 0.4475 2999.5n 0.4475 3000.0n 0.4041 3599.5n 0.4041 3600.0n 0.4178 4199.5n 0.4178 4200.0n 0.4452 4799.5n 0.4452 4800.0n 0.4587 5399.5n 0.4587 5400.0n 0.4267 5999.5n 0.4267 6000.0n 0.4212 6599.5n 0.4212 6600.0n 0.4475 7199.5n 0.4475 7200.0n 0.3950 7799.5n 0.3950 7800.0n 0.3950 8399.5n 0.3950 8400.0n 0.4122 8999.5n 0.4122 9000.0n 0.3950 9599.5n 0.3950 9600.0n 0.4081 10199.5n 0.4081 10200.0n 0.3950 10799.5n 0.3950 10800.0n 0.3950 11399.5n 0.3950 11400.0n 0.3984 11999.5n 0.3984 12000.0n 0.4217 12599.5n 0.4217 12600.0n 0.3950 13199.5n 0.3950 13200.0n 0.3950 13799.5n 0.3950 13800.0n 0.4085 14399.5n 0.4085)
Vxn_wih_8_8 xn_wih_8_8 0 PWL(0.0n 0.5610 599.5n 0.5610 600.0n 0.5614 1199.5n 0.5614 1200.0n 0.5487 1799.5n 0.5487 1800.0n 0.5764 2399.5n 0.5764 2400.0n 0.5525 2999.5n 0.5525 3000.0n 0.5959 3599.5n 0.5959 3600.0n 0.5822 4199.5n 0.5822 4200.0n 0.5548 4799.5n 0.5548 4800.0n 0.5413 5399.5n 0.5413 5400.0n 0.5733 5999.5n 0.5733 6000.0n 0.5788 6599.5n 0.5788 6600.0n 0.5525 7199.5n 0.5525 7200.0n 0.6050 7799.5n 0.6050 7800.0n 0.6050 8399.5n 0.6050 8400.0n 0.5878 8999.5n 0.5878 9000.0n 0.6050 9599.5n 0.6050 9600.0n 0.5919 10199.5n 0.5919 10200.0n 0.6050 10799.5n 0.6050 10800.0n 0.6050 11399.5n 0.6050 11400.0n 0.6016 11999.5n 0.6016 12000.0n 0.5783 12599.5n 0.5783 12600.0n 0.6050 13199.5n 0.6050 13200.0n 0.6050 13799.5n 0.6050 13800.0n 0.5915 14399.5n 0.5915)
Vyp_wih_8_8 yp_wih_8_8 0 PWL(0.0n 0.5521 599.5n 0.5521 600.0n 0.5397 1199.5n 0.5397 1200.0n 0.5404 1799.5n 0.5404 1800.0n 0.5640 2399.5n 0.5640 2400.0n 0.5498 2999.5n 0.5498 3000.0n 0.5594 3599.5n 0.5594 3600.0n 0.5691 4199.5n 0.5691 4200.0n 0.5427 4799.5n 0.5427 4800.0n 0.5257 5399.5n 0.5257 5400.0n 0.5626 5999.5n 0.5626 6000.0n 0.5663 6599.5n 0.5663 6600.0n 0.5440 7199.5n 0.5440 7200.0n 0.5546 7799.5n 0.5546 7800.0n 0.5303 8399.5n 0.5303 8400.0n 0.5263 8999.5n 0.5263 9000.0n 0.5291 9599.5n 0.5291 9600.0n 0.5264 10199.5n 0.5264 10200.0n 0.5462 10799.5n 0.5462 10800.0n 0.5649 11399.5n 0.5649 11400.0n 0.5576 11999.5n 0.5576 12000.0n 0.5209 12599.5n 0.5209 12600.0n 0.5618 13199.5n 0.5618 13200.0n 0.5379 13799.5n 0.5379 13800.0n 0.5702 14399.5n 0.5702)
Vyn_wih_8_8 yn_wih_8_8 0 PWL(0.0n 0.4479 599.5n 0.4479 600.0n 0.4603 1199.5n 0.4603 1200.0n 0.4596 1799.5n 0.4596 1800.0n 0.4360 2399.5n 0.4360 2400.0n 0.4502 2999.5n 0.4502 3000.0n 0.4406 3599.5n 0.4406 3600.0n 0.4309 4199.5n 0.4309 4200.0n 0.4573 4799.5n 0.4573 4800.0n 0.4743 5399.5n 0.4743 5400.0n 0.4374 5999.5n 0.4374 6000.0n 0.4337 6599.5n 0.4337 6600.0n 0.4560 7199.5n 0.4560 7200.0n 0.4454 7799.5n 0.4454 7800.0n 0.4697 8399.5n 0.4697 8400.0n 0.4737 8999.5n 0.4737 9000.0n 0.4709 9599.5n 0.4709 9600.0n 0.4736 10199.5n 0.4736 10200.0n 0.4538 10799.5n 0.4538 10800.0n 0.4351 11399.5n 0.4351 11400.0n 0.4424 11999.5n 0.4424 12000.0n 0.4791 12599.5n 0.4791 12600.0n 0.4382 13199.5n 0.4382 13200.0n 0.4621 13799.5n 0.4621 13800.0n 0.4298 14399.5n 0.4298)
Cwp_wih_8_8 wp_wih_8_8 0 400p
Cwn_wih_8_8 wn_wih_8_8 0 400p
Xu_wih_8_8 xp_wih_8_8 xn_wih_8_8 yp_wih_8_8 yn_wih_8_8 wp_wih_8_8 wn_wih_8_8 vdd gbn gprod
Vxp_wih_9_8 xp_wih_9_8 0 PWL(0.0n 0.5317 599.5n 0.5317 600.0n 0.4980 1199.5n 0.4980 1200.0n 0.5026 1799.5n 0.5026 1800.0n 0.5048 2399.5n 0.5048 2400.0n 0.5191 2999.5n 0.5191 3000.0n 0.5365 3599.5n 0.5365 3600.0n 0.5457 4199.5n 0.5457 4200.0n 0.5457 4799.5n 0.5457 4800.0n 0.5000 5399.5n 0.5000 5400.0n 0.5575 5999.5n 0.5575 6000.0n 0.5000 6599.5n 0.5000 6600.0n 0.5334 7199.5n 0.5334 7200.0n 0.5268 7799.5n 0.5268 7800.0n 0.3950 8399.5n 0.3950 8400.0n 0.5671 8999.5n 0.5671 9000.0n 0.3950 9599.5n 0.3950 9600.0n 0.4573 10199.5n 0.4573 10200.0n 0.4572 10799.5n 0.4572 10800.0n 0.5996 11399.5n 0.5996 11400.0n 0.6050 11999.5n 0.6050 12000.0n 0.5515 12599.5n 0.5515 12600.0n 0.5587 13199.5n 0.5587 13200.0n 0.4550 13799.5n 0.4550 13800.0n 0.6050 14399.5n 0.6050)
Vxn_wih_9_8 xn_wih_9_8 0 PWL(0.0n 0.4683 599.5n 0.4683 600.0n 0.5020 1199.5n 0.5020 1200.0n 0.4974 1799.5n 0.4974 1800.0n 0.4952 2399.5n 0.4952 2400.0n 0.4809 2999.5n 0.4809 3000.0n 0.4635 3599.5n 0.4635 3600.0n 0.4543 4199.5n 0.4543 4200.0n 0.4543 4799.5n 0.4543 4800.0n 0.5000 5399.5n 0.5000 5400.0n 0.4425 5999.5n 0.4425 6000.0n 0.5000 6599.5n 0.5000 6600.0n 0.4666 7199.5n 0.4666 7200.0n 0.4732 7799.5n 0.4732 7800.0n 0.6050 8399.5n 0.6050 8400.0n 0.4329 8999.5n 0.4329 9000.0n 0.6050 9599.5n 0.6050 9600.0n 0.5427 10199.5n 0.5427 10200.0n 0.5428 10799.5n 0.5428 10800.0n 0.4004 11399.5n 0.4004 11400.0n 0.3950 11999.5n 0.3950 12000.0n 0.4485 12599.5n 0.4485 12600.0n 0.4413 13199.5n 0.4413 13200.0n 0.5450 13799.5n 0.5450 13800.0n 0.3950 14399.5n 0.3950)
Vyp_wih_9_8 yp_wih_9_8 0 PWL(0.0n 0.5521 599.5n 0.5521 600.0n 0.5397 1199.5n 0.5397 1200.0n 0.5404 1799.5n 0.5404 1800.0n 0.5640 2399.5n 0.5640 2400.0n 0.5498 2999.5n 0.5498 3000.0n 0.5594 3599.5n 0.5594 3600.0n 0.5691 4199.5n 0.5691 4200.0n 0.5427 4799.5n 0.5427 4800.0n 0.5257 5399.5n 0.5257 5400.0n 0.5626 5999.5n 0.5626 6000.0n 0.5663 6599.5n 0.5663 6600.0n 0.5440 7199.5n 0.5440 7200.0n 0.5546 7799.5n 0.5546 7800.0n 0.5303 8399.5n 0.5303 8400.0n 0.5263 8999.5n 0.5263 9000.0n 0.5291 9599.5n 0.5291 9600.0n 0.5264 10199.5n 0.5264 10200.0n 0.5462 10799.5n 0.5462 10800.0n 0.5649 11399.5n 0.5649 11400.0n 0.5576 11999.5n 0.5576 12000.0n 0.5209 12599.5n 0.5209 12600.0n 0.5618 13199.5n 0.5618 13200.0n 0.5379 13799.5n 0.5379 13800.0n 0.5702 14399.5n 0.5702)
Vyn_wih_9_8 yn_wih_9_8 0 PWL(0.0n 0.4479 599.5n 0.4479 600.0n 0.4603 1199.5n 0.4603 1200.0n 0.4596 1799.5n 0.4596 1800.0n 0.4360 2399.5n 0.4360 2400.0n 0.4502 2999.5n 0.4502 3000.0n 0.4406 3599.5n 0.4406 3600.0n 0.4309 4199.5n 0.4309 4200.0n 0.4573 4799.5n 0.4573 4800.0n 0.4743 5399.5n 0.4743 5400.0n 0.4374 5999.5n 0.4374 6000.0n 0.4337 6599.5n 0.4337 6600.0n 0.4560 7199.5n 0.4560 7200.0n 0.4454 7799.5n 0.4454 7800.0n 0.4697 8399.5n 0.4697 8400.0n 0.4737 8999.5n 0.4737 9000.0n 0.4709 9599.5n 0.4709 9600.0n 0.4736 10199.5n 0.4736 10200.0n 0.4538 10799.5n 0.4538 10800.0n 0.4351 11399.5n 0.4351 11400.0n 0.4424 11999.5n 0.4424 12000.0n 0.4791 12599.5n 0.4791 12600.0n 0.4382 13199.5n 0.4382 13200.0n 0.4621 13799.5n 0.4621 13800.0n 0.4298 14399.5n 0.4298)
Cwp_wih_9_8 wp_wih_9_8 0 400p
Cwn_wih_9_8 wn_wih_9_8 0 400p
Xu_wih_9_8 xp_wih_9_8 xn_wih_9_8 yp_wih_9_8 yn_wih_9_8 wp_wih_9_8 wn_wih_9_8 vdd gbn gprod
Vxp_wih_12_8 xp_wih_12_8 0 PWL(0.0n 0.3950 599.5n 0.3950 600.0n 0.4029 1199.5n 0.4029 1200.0n 0.3950 1799.5n 0.3950 1800.0n 0.3950 2399.5n 0.3950 2400.0n 0.4093 2999.5n 0.4093 3000.0n 0.3950 3599.5n 0.3950 3600.0n 0.3950 4199.5n 0.3950 4200.0n 0.3950 4799.5n 0.3950 4800.0n 0.3950 5399.5n 0.3950 5400.0n 0.3950 5999.5n 0.3950 6000.0n 0.3950 6599.5n 0.3950 6600.0n 0.3998 7199.5n 0.3998 7200.0n 0.3950 7799.5n 0.3950 7800.0n 0.3950 8399.5n 0.3950 8400.0n 0.3950 8999.5n 0.3950 9000.0n 0.3950 9599.5n 0.3950 9600.0n 0.3950 10199.5n 0.3950 10200.0n 0.3950 10799.5n 0.3950 10800.0n 0.3950 11399.5n 0.3950 11400.0n 0.3950 11999.5n 0.3950 12000.0n 0.3950 12599.5n 0.3950 12600.0n 0.3950 13199.5n 0.3950 13200.0n 0.3950 13799.5n 0.3950 13800.0n 0.4052 14399.5n 0.4052)
Vxn_wih_12_8 xn_wih_12_8 0 PWL(0.0n 0.6050 599.5n 0.6050 600.0n 0.5971 1199.5n 0.5971 1200.0n 0.6050 1799.5n 0.6050 1800.0n 0.6050 2399.5n 0.6050 2400.0n 0.5907 2999.5n 0.5907 3000.0n 0.6050 3599.5n 0.6050 3600.0n 0.6050 4199.5n 0.6050 4200.0n 0.6050 4799.5n 0.6050 4800.0n 0.6050 5399.5n 0.6050 5400.0n 0.6050 5999.5n 0.6050 6000.0n 0.6050 6599.5n 0.6050 6600.0n 0.6002 7199.5n 0.6002 7200.0n 0.6050 7799.5n 0.6050 7800.0n 0.6050 8399.5n 0.6050 8400.0n 0.6050 8999.5n 0.6050 9000.0n 0.6050 9599.5n 0.6050 9600.0n 0.6050 10199.5n 0.6050 10200.0n 0.6050 10799.5n 0.6050 10800.0n 0.6050 11399.5n 0.6050 11400.0n 0.6050 11999.5n 0.6050 12000.0n 0.6050 12599.5n 0.6050 12600.0n 0.6050 13199.5n 0.6050 13200.0n 0.6050 13799.5n 0.6050 13800.0n 0.5948 14399.5n 0.5948)
Vyp_wih_12_8 yp_wih_12_8 0 PWL(0.0n 0.5521 599.5n 0.5521 600.0n 0.5397 1199.5n 0.5397 1200.0n 0.5404 1799.5n 0.5404 1800.0n 0.5640 2399.5n 0.5640 2400.0n 0.5498 2999.5n 0.5498 3000.0n 0.5594 3599.5n 0.5594 3600.0n 0.5691 4199.5n 0.5691 4200.0n 0.5427 4799.5n 0.5427 4800.0n 0.5257 5399.5n 0.5257 5400.0n 0.5626 5999.5n 0.5626 6000.0n 0.5663 6599.5n 0.5663 6600.0n 0.5440 7199.5n 0.5440 7200.0n 0.5546 7799.5n 0.5546 7800.0n 0.5303 8399.5n 0.5303 8400.0n 0.5263 8999.5n 0.5263 9000.0n 0.5291 9599.5n 0.5291 9600.0n 0.5264 10199.5n 0.5264 10200.0n 0.5462 10799.5n 0.5462 10800.0n 0.5649 11399.5n 0.5649 11400.0n 0.5576 11999.5n 0.5576 12000.0n 0.5209 12599.5n 0.5209 12600.0n 0.5618 13199.5n 0.5618 13200.0n 0.5379 13799.5n 0.5379 13800.0n 0.5702 14399.5n 0.5702)
Vyn_wih_12_8 yn_wih_12_8 0 PWL(0.0n 0.4479 599.5n 0.4479 600.0n 0.4603 1199.5n 0.4603 1200.0n 0.4596 1799.5n 0.4596 1800.0n 0.4360 2399.5n 0.4360 2400.0n 0.4502 2999.5n 0.4502 3000.0n 0.4406 3599.5n 0.4406 3600.0n 0.4309 4199.5n 0.4309 4200.0n 0.4573 4799.5n 0.4573 4800.0n 0.4743 5399.5n 0.4743 5400.0n 0.4374 5999.5n 0.4374 6000.0n 0.4337 6599.5n 0.4337 6600.0n 0.4560 7199.5n 0.4560 7200.0n 0.4454 7799.5n 0.4454 7800.0n 0.4697 8399.5n 0.4697 8400.0n 0.4737 8999.5n 0.4737 9000.0n 0.4709 9599.5n 0.4709 9600.0n 0.4736 10199.5n 0.4736 10200.0n 0.4538 10799.5n 0.4538 10800.0n 0.4351 11399.5n 0.4351 11400.0n 0.4424 11999.5n 0.4424 12000.0n 0.4791 12599.5n 0.4791 12600.0n 0.4382 13199.5n 0.4382 13200.0n 0.4621 13799.5n 0.4621 13800.0n 0.4298 14399.5n 0.4298)
Cwp_wih_12_8 wp_wih_12_8 0 400p
Cwn_wih_12_8 wn_wih_12_8 0 400p
Xu_wih_12_8 xp_wih_12_8 xn_wih_12_8 yp_wih_12_8 yn_wih_12_8 wp_wih_12_8 wn_wih_12_8 vdd gbn gprod
Vxp_wih_13_8 xp_wih_13_8 0 PWL(0.0n 0.6050 599.5n 0.6050 600.0n 0.5495 1199.5n 0.5495 1200.0n 0.6050 1799.5n 0.6050 1800.0n 0.5811 2399.5n 0.5811 2400.0n 0.6050 2999.5n 0.6050 3000.0n 0.5411 3599.5n 0.5411 3600.0n 0.5867 4199.5n 0.5867 4200.0n 0.5822 4799.5n 0.5822 4800.0n 0.5675 5399.5n 0.5675 5400.0n 0.5852 5999.5n 0.5852 6000.0n 0.5831 6599.5n 0.5831 6600.0n 0.5907 7199.5n 0.5907 7200.0n 0.4938 7799.5n 0.4938 7800.0n 0.4048 8399.5n 0.4048 8400.0n 0.3984 8999.5n 0.3984 9000.0n 0.3950 9599.5n 0.3950 9600.0n 0.3983 10199.5n 0.3983 10200.0n 0.4494 10799.5n 0.4494 10800.0n 0.5512 11399.5n 0.5512 11400.0n 0.5135 11999.5n 0.5135 12000.0n 0.3950 12599.5n 0.3950 12600.0n 0.5338 13199.5n 0.5338 13200.0n 0.4283 13799.5n 0.4283 13800.0n 0.5677 14399.5n 0.5677)
Vxn_wih_13_8 xn_wih_13_8 0 PWL(0.0n 0.3950 599.5n 0.3950 600.0n 0.4505 1199.5n 0.4505 1200.0n 0.3950 1799.5n 0.3950 1800.0n 0.4189 2399.5n 0.4189 2400.0n 0.3950 2999.5n 0.3950 3000.0n 0.4589 3599.5n 0.4589 3600.0n 0.4133 4199.5n 0.4133 4200.0n 0.4178 4799.5n 0.4178 4800.0n 0.4325 5399.5n 0.4325 5400.0n 0.4148 5999.5n 0.4148 6000.0n 0.4169 6599.5n 0.4169 6600.0n 0.4093 7199.5n 0.4093 7200.0n 0.5062 7799.5n 0.5062 7800.0n 0.5952 8399.5n 0.5952 8400.0n 0.6016 8999.5n 0.6016 9000.0n 0.6050 9599.5n 0.6050 9600.0n 0.6017 10199.5n 0.6017 10200.0n 0.5506 10799.5n 0.5506 10800.0n 0.4488 11399.5n 0.4488 11400.0n 0.4865 11999.5n 0.4865 12000.0n 0.6050 12599.5n 0.6050 12600.0n 0.4662 13199.5n 0.4662 13200.0n 0.5717 13799.5n 0.5717 13800.0n 0.4323 14399.5n 0.4323)
Vyp_wih_13_8 yp_wih_13_8 0 PWL(0.0n 0.5521 599.5n 0.5521 600.0n 0.5397 1199.5n 0.5397 1200.0n 0.5404 1799.5n 0.5404 1800.0n 0.5640 2399.5n 0.5640 2400.0n 0.5498 2999.5n 0.5498 3000.0n 0.5594 3599.5n 0.5594 3600.0n 0.5691 4199.5n 0.5691 4200.0n 0.5427 4799.5n 0.5427 4800.0n 0.5257 5399.5n 0.5257 5400.0n 0.5626 5999.5n 0.5626 6000.0n 0.5663 6599.5n 0.5663 6600.0n 0.5440 7199.5n 0.5440 7200.0n 0.5546 7799.5n 0.5546 7800.0n 0.5303 8399.5n 0.5303 8400.0n 0.5263 8999.5n 0.5263 9000.0n 0.5291 9599.5n 0.5291 9600.0n 0.5264 10199.5n 0.5264 10200.0n 0.5462 10799.5n 0.5462 10800.0n 0.5649 11399.5n 0.5649 11400.0n 0.5576 11999.5n 0.5576 12000.0n 0.5209 12599.5n 0.5209 12600.0n 0.5618 13199.5n 0.5618 13200.0n 0.5379 13799.5n 0.5379 13800.0n 0.5702 14399.5n 0.5702)
Vyn_wih_13_8 yn_wih_13_8 0 PWL(0.0n 0.4479 599.5n 0.4479 600.0n 0.4603 1199.5n 0.4603 1200.0n 0.4596 1799.5n 0.4596 1800.0n 0.4360 2399.5n 0.4360 2400.0n 0.4502 2999.5n 0.4502 3000.0n 0.4406 3599.5n 0.4406 3600.0n 0.4309 4199.5n 0.4309 4200.0n 0.4573 4799.5n 0.4573 4800.0n 0.4743 5399.5n 0.4743 5400.0n 0.4374 5999.5n 0.4374 6000.0n 0.4337 6599.5n 0.4337 6600.0n 0.4560 7199.5n 0.4560 7200.0n 0.4454 7799.5n 0.4454 7800.0n 0.4697 8399.5n 0.4697 8400.0n 0.4737 8999.5n 0.4737 9000.0n 0.4709 9599.5n 0.4709 9600.0n 0.4736 10199.5n 0.4736 10200.0n 0.4538 10799.5n 0.4538 10800.0n 0.4351 11399.5n 0.4351 11400.0n 0.4424 11999.5n 0.4424 12000.0n 0.4791 12599.5n 0.4791 12600.0n 0.4382 13199.5n 0.4382 13200.0n 0.4621 13799.5n 0.4621 13800.0n 0.4298 14399.5n 0.4298)
Cwp_wih_13_8 wp_wih_13_8 0 400p
Cwn_wih_13_8 wn_wih_13_8 0 400p
Xu_wih_13_8 xp_wih_13_8 xn_wih_13_8 yp_wih_13_8 yn_wih_13_8 wp_wih_13_8 wn_wih_13_8 vdd gbn gprod
Vxp_who_8_0 xp_who_8_0 0 PWL(0.0n 0.5521 599.5n 0.5521 600.0n 0.5397 1199.5n 0.5397 1200.0n 0.5404 1799.5n 0.5404 1800.0n 0.5640 2399.5n 0.5640 2400.0n 0.5498 2999.5n 0.5498 3000.0n 0.5594 3599.5n 0.5594 3600.0n 0.5691 4199.5n 0.5691 4200.0n 0.5427 4799.5n 0.5427 4800.0n 0.5257 5399.5n 0.5257 5400.0n 0.5626 5999.5n 0.5626 6000.0n 0.5663 6599.5n 0.5663 6600.0n 0.5440 7199.5n 0.5440 7200.0n 0.5546 7799.5n 0.5546 7800.0n 0.5303 8399.5n 0.5303 8400.0n 0.5263 8999.5n 0.5263 9000.0n 0.5291 9599.5n 0.5291 9600.0n 0.5264 10199.5n 0.5264 10200.0n 0.5462 10799.5n 0.5462 10800.0n 0.5649 11399.5n 0.5649 11400.0n 0.5576 11999.5n 0.5576 12000.0n 0.5209 12599.5n 0.5209 12600.0n 0.5618 13199.5n 0.5618 13200.0n 0.5379 13799.5n 0.5379 13800.0n 0.5702 14399.5n 0.5702)
Vxn_who_8_0 xn_who_8_0 0 PWL(0.0n 0.4479 599.5n 0.4479 600.0n 0.4603 1199.5n 0.4603 1200.0n 0.4596 1799.5n 0.4596 1800.0n 0.4360 2399.5n 0.4360 2400.0n 0.4502 2999.5n 0.4502 3000.0n 0.4406 3599.5n 0.4406 3600.0n 0.4309 4199.5n 0.4309 4200.0n 0.4573 4799.5n 0.4573 4800.0n 0.4743 5399.5n 0.4743 5400.0n 0.4374 5999.5n 0.4374 6000.0n 0.4337 6599.5n 0.4337 6600.0n 0.4560 7199.5n 0.4560 7200.0n 0.4454 7799.5n 0.4454 7800.0n 0.4697 8399.5n 0.4697 8400.0n 0.4737 8999.5n 0.4737 9000.0n 0.4709 9599.5n 0.4709 9600.0n 0.4736 10199.5n 0.4736 10200.0n 0.4538 10799.5n 0.4538 10800.0n 0.4351 11399.5n 0.4351 11400.0n 0.4424 11999.5n 0.4424 12000.0n 0.4791 12599.5n 0.4791 12600.0n 0.4382 13199.5n 0.4382 13200.0n 0.4621 13799.5n 0.4621 13800.0n 0.4298 14399.5n 0.4298)
Vyp_who_8_0 yp_who_8_0 0 PWL(0.0n 0.5073 599.5n 0.5073 600.0n 0.5065 1199.5n 0.5065 1200.0n 0.5065 1799.5n 0.5065 1800.0n 0.5052 2399.5n 0.5052 2400.0n 0.5058 2999.5n 0.5058 3000.0n 0.5039 3599.5n 0.5039 3600.0n 0.5059 4199.5n 0.5059 4200.0n 0.5077 4799.5n 0.5077 4800.0n 0.5054 5399.5n 0.5054 5400.0n 0.5066 5999.5n 0.5066 6000.0n 0.5083 6599.5n 0.5083 6600.0n 0.5078 7199.5n 0.5078 7200.0n 0.5043 7799.5n 0.5043 7800.0n 0.5035 8399.5n 0.5035 8400.0n 0.5035 8999.5n 0.5035 9000.0n 0.5038 9599.5n 0.5038 9600.0n 0.5043 10199.5n 0.5043 10200.0n 0.5053 10799.5n 0.5053 10800.0n 0.5050 11399.5n 0.5050 11400.0n 0.5055 11999.5n 0.5055 12000.0n 0.5043 12599.5n 0.5043 12600.0n 0.5028 13199.5n 0.5028 13200.0n 0.5045 13799.5n 0.5045 13800.0n 0.5043 14399.5n 0.5043)
Vyn_who_8_0 yn_who_8_0 0 PWL(0.0n 0.4927 599.5n 0.4927 600.0n 0.4935 1199.5n 0.4935 1200.0n 0.4935 1799.5n 0.4935 1800.0n 0.4948 2399.5n 0.4948 2400.0n 0.4942 2999.5n 0.4942 3000.0n 0.4961 3599.5n 0.4961 3600.0n 0.4941 4199.5n 0.4941 4200.0n 0.4923 4799.5n 0.4923 4800.0n 0.4946 5399.5n 0.4946 5400.0n 0.4934 5999.5n 0.4934 6000.0n 0.4917 6599.5n 0.4917 6600.0n 0.4922 7199.5n 0.4922 7200.0n 0.4957 7799.5n 0.4957 7800.0n 0.4965 8399.5n 0.4965 8400.0n 0.4965 8999.5n 0.4965 9000.0n 0.4962 9599.5n 0.4962 9600.0n 0.4957 10199.5n 0.4957 10200.0n 0.4947 10799.5n 0.4947 10800.0n 0.4950 11399.5n 0.4950 11400.0n 0.4945 11999.5n 0.4945 12000.0n 0.4957 12599.5n 0.4957 12600.0n 0.4972 13199.5n 0.4972 13200.0n 0.4955 13799.5n 0.4955 13800.0n 0.4957 14399.5n 0.4957)
Cwp_who_8_0 wp_who_8_0 0 400p
Cwn_who_8_0 wn_who_8_0 0 400p
Xu_who_8_0 xp_who_8_0 xn_who_8_0 yp_who_8_0 yn_who_8_0 wp_who_8_0 wn_who_8_0 vdd gbn gprod
Vxp_who_8_1 xp_who_8_1 0 PWL(0.0n 0.5521 599.5n 0.5521 600.0n 0.5397 1199.5n 0.5397 1200.0n 0.5404 1799.5n 0.5404 1800.0n 0.5640 2399.5n 0.5640 2400.0n 0.5498 2999.5n 0.5498 3000.0n 0.5594 3599.5n 0.5594 3600.0n 0.5691 4199.5n 0.5691 4200.0n 0.5427 4799.5n 0.5427 4800.0n 0.5257 5399.5n 0.5257 5400.0n 0.5626 5999.5n 0.5626 6000.0n 0.5663 6599.5n 0.5663 6600.0n 0.5440 7199.5n 0.5440 7200.0n 0.5546 7799.5n 0.5546 7800.0n 0.5303 8399.5n 0.5303 8400.0n 0.5263 8999.5n 0.5263 9000.0n 0.5291 9599.5n 0.5291 9600.0n 0.5264 10199.5n 0.5264 10200.0n 0.5462 10799.5n 0.5462 10800.0n 0.5649 11399.5n 0.5649 11400.0n 0.5576 11999.5n 0.5576 12000.0n 0.5209 12599.5n 0.5209 12600.0n 0.5618 13199.5n 0.5618 13200.0n 0.5379 13799.5n 0.5379 13800.0n 0.5702 14399.5n 0.5702)
Vxn_who_8_1 xn_who_8_1 0 PWL(0.0n 0.4479 599.5n 0.4479 600.0n 0.4603 1199.5n 0.4603 1200.0n 0.4596 1799.5n 0.4596 1800.0n 0.4360 2399.5n 0.4360 2400.0n 0.4502 2999.5n 0.4502 3000.0n 0.4406 3599.5n 0.4406 3600.0n 0.4309 4199.5n 0.4309 4200.0n 0.4573 4799.5n 0.4573 4800.0n 0.4743 5399.5n 0.4743 5400.0n 0.4374 5999.5n 0.4374 6000.0n 0.4337 6599.5n 0.4337 6600.0n 0.4560 7199.5n 0.4560 7200.0n 0.4454 7799.5n 0.4454 7800.0n 0.4697 8399.5n 0.4697 8400.0n 0.4737 8999.5n 0.4737 9000.0n 0.4709 9599.5n 0.4709 9600.0n 0.4736 10199.5n 0.4736 10200.0n 0.4538 10799.5n 0.4538 10800.0n 0.4351 11399.5n 0.4351 11400.0n 0.4424 11999.5n 0.4424 12000.0n 0.4791 12599.5n 0.4791 12600.0n 0.4382 13199.5n 0.4382 13200.0n 0.4621 13799.5n 0.4621 13800.0n 0.4298 14399.5n 0.4298)
Vyp_who_8_1 yp_who_8_1 0 PWL(0.0n 0.4909 599.5n 0.4909 600.0n 0.4933 1199.5n 0.4933 1200.0n 0.4930 1799.5n 0.4930 1800.0n 0.4893 2399.5n 0.4893 2400.0n 0.4904 2999.5n 0.4904 3000.0n 0.4923 3599.5n 0.4923 3600.0n 0.4897 4199.5n 0.4897 4200.0n 0.4890 4799.5n 0.4890 4800.0n 0.4921 5399.5n 0.4921 5400.0n 0.4899 5999.5n 0.4899 6000.0n 0.4870 6599.5n 0.4870 6600.0n 0.4903 7199.5n 0.4903 7200.0n 0.4970 7799.5n 0.4970 7800.0n 0.4989 8399.5n 0.4989 8400.0n 0.4994 8999.5n 0.4994 9000.0n 0.4991 9599.5n 0.4991 9600.0n 0.5000 10199.5n 0.5000 10200.0n 0.4948 10799.5n 0.4948 10800.0n 0.4959 11399.5n 0.4959 11400.0n 0.4926 11999.5n 0.4926 12000.0n 0.4993 12599.5n 0.4993 12600.0n 0.4862 13199.5n 0.4862 13200.0n 0.4993 13799.5n 0.4993 13800.0n 0.4961 14399.5n 0.4961)
Vyn_who_8_1 yn_who_8_1 0 PWL(0.0n 0.5091 599.5n 0.5091 600.0n 0.5067 1199.5n 0.5067 1200.0n 0.5070 1799.5n 0.5070 1800.0n 0.5107 2399.5n 0.5107 2400.0n 0.5096 2999.5n 0.5096 3000.0n 0.5077 3599.5n 0.5077 3600.0n 0.5103 4199.5n 0.5103 4200.0n 0.5110 4799.5n 0.5110 4800.0n 0.5079 5399.5n 0.5079 5400.0n 0.5101 5999.5n 0.5101 6000.0n 0.5130 6599.5n 0.5130 6600.0n 0.5097 7199.5n 0.5097 7200.0n 0.5030 7799.5n 0.5030 7800.0n 0.5011 8399.5n 0.5011 8400.0n 0.5006 8999.5n 0.5006 9000.0n 0.5009 9599.5n 0.5009 9600.0n 0.5000 10199.5n 0.5000 10200.0n 0.5052 10799.5n 0.5052 10800.0n 0.5041 11399.5n 0.5041 11400.0n 0.5074 11999.5n 0.5074 12000.0n 0.5007 12599.5n 0.5007 12600.0n 0.5138 13199.5n 0.5138 13200.0n 0.5007 13799.5n 0.5007 13800.0n 0.5039 14399.5n 0.5039)
Cwp_who_8_1 wp_who_8_1 0 400p
Cwn_who_8_1 wn_who_8_1 0 400p
Xu_who_8_1 xp_who_8_1 xn_who_8_1 yp_who_8_1 yn_who_8_1 wp_who_8_1 wn_who_8_1 vdd gbn gprod
Vxp_bh_8 xp_bh_8 0 PWL(0.0n 0.7100 599.5n 0.7100 600.0n 0.7100 1199.5n 0.7100 1200.0n 0.7100 1799.5n 0.7100 1800.0n 0.7100 2399.5n 0.7100 2400.0n 0.7100 2999.5n 0.7100 3000.0n 0.7100 3599.5n 0.7100 3600.0n 0.7100 4199.5n 0.7100 4200.0n 0.7100 4799.5n 0.7100 4800.0n 0.7100 5399.5n 0.7100 5400.0n 0.7100 5999.5n 0.7100 6000.0n 0.7100 6599.5n 0.7100 6600.0n 0.7100 7199.5n 0.7100 7200.0n 0.7100 7799.5n 0.7100 7800.0n 0.7100 8399.5n 0.7100 8400.0n 0.7100 8999.5n 0.7100 9000.0n 0.7100 9599.5n 0.7100 9600.0n 0.7100 10199.5n 0.7100 10200.0n 0.7100 10799.5n 0.7100 10800.0n 0.7100 11399.5n 0.7100 11400.0n 0.7100 11999.5n 0.7100 12000.0n 0.7100 12599.5n 0.7100 12600.0n 0.7100 13199.5n 0.7100 13200.0n 0.7100 13799.5n 0.7100 13800.0n 0.7100 14399.5n 0.7100)
Vxn_bh_8 xn_bh_8 0 PWL(0.0n 0.2900 599.5n 0.2900 600.0n 0.2900 1199.5n 0.2900 1200.0n 0.2900 1799.5n 0.2900 1800.0n 0.2900 2399.5n 0.2900 2400.0n 0.2900 2999.5n 0.2900 3000.0n 0.2900 3599.5n 0.2900 3600.0n 0.2900 4199.5n 0.2900 4200.0n 0.2900 4799.5n 0.2900 4800.0n 0.2900 5399.5n 0.2900 5400.0n 0.2900 5999.5n 0.2900 6000.0n 0.2900 6599.5n 0.2900 6600.0n 0.2900 7199.5n 0.2900 7200.0n 0.2900 7799.5n 0.2900 7800.0n 0.2900 8399.5n 0.2900 8400.0n 0.2900 8999.5n 0.2900 9000.0n 0.2900 9599.5n 0.2900 9600.0n 0.2900 10199.5n 0.2900 10200.0n 0.2900 10799.5n 0.2900 10800.0n 0.2900 11399.5n 0.2900 11400.0n 0.2900 11999.5n 0.2900 12000.0n 0.2900 12599.5n 0.2900 12600.0n 0.2900 13199.5n 0.2900 13200.0n 0.2900 13799.5n 0.2900 13800.0n 0.2900 14399.5n 0.2900)
Vyp_bh_8 yp_bh_8 0 PWL(0.0n 0.5521 599.5n 0.5521 600.0n 0.5397 1199.5n 0.5397 1200.0n 0.5404 1799.5n 0.5404 1800.0n 0.5640 2399.5n 0.5640 2400.0n 0.5498 2999.5n 0.5498 3000.0n 0.5594 3599.5n 0.5594 3600.0n 0.5691 4199.5n 0.5691 4200.0n 0.5427 4799.5n 0.5427 4800.0n 0.5257 5399.5n 0.5257 5400.0n 0.5626 5999.5n 0.5626 6000.0n 0.5663 6599.5n 0.5663 6600.0n 0.5440 7199.5n 0.5440 7200.0n 0.5546 7799.5n 0.5546 7800.0n 0.5303 8399.5n 0.5303 8400.0n 0.5263 8999.5n 0.5263 9000.0n 0.5291 9599.5n 0.5291 9600.0n 0.5264 10199.5n 0.5264 10200.0n 0.5462 10799.5n 0.5462 10800.0n 0.5649 11399.5n 0.5649 11400.0n 0.5576 11999.5n 0.5576 12000.0n 0.5209 12599.5n 0.5209 12600.0n 0.5618 13199.5n 0.5618 13200.0n 0.5379 13799.5n 0.5379 13800.0n 0.5702 14399.5n 0.5702)
Vyn_bh_8 yn_bh_8 0 PWL(0.0n 0.4479 599.5n 0.4479 600.0n 0.4603 1199.5n 0.4603 1200.0n 0.4596 1799.5n 0.4596 1800.0n 0.4360 2399.5n 0.4360 2400.0n 0.4502 2999.5n 0.4502 3000.0n 0.4406 3599.5n 0.4406 3600.0n 0.4309 4199.5n 0.4309 4200.0n 0.4573 4799.5n 0.4573 4800.0n 0.4743 5399.5n 0.4743 5400.0n 0.4374 5999.5n 0.4374 6000.0n 0.4337 6599.5n 0.4337 6600.0n 0.4560 7199.5n 0.4560 7200.0n 0.4454 7799.5n 0.4454 7800.0n 0.4697 8399.5n 0.4697 8400.0n 0.4737 8999.5n 0.4737 9000.0n 0.4709 9599.5n 0.4709 9600.0n 0.4736 10199.5n 0.4736 10200.0n 0.4538 10799.5n 0.4538 10800.0n 0.4351 11399.5n 0.4351 11400.0n 0.4424 11999.5n 0.4424 12000.0n 0.4791 12599.5n 0.4791 12600.0n 0.4382 13199.5n 0.4382 13200.0n 0.4621 13799.5n 0.4621 13800.0n 0.4298 14399.5n 0.4298)
Cwp_bh_8 wp_bh_8 0 400p
Cwn_bh_8 wn_bh_8 0 400p
Xu_bh_8 xp_bh_8 xn_bh_8 yp_bh_8 yn_bh_8 wp_bh_8 wn_bh_8 vdd gbn gprod
Vxp_wih_8_9 xp_wih_8_9 0 PWL(0.0n 0.4390 599.5n 0.4390 600.0n 0.4386 1199.5n 0.4386 1200.0n 0.4513 1799.5n 0.4513 1800.0n 0.4236 2399.5n 0.4236 2400.0n 0.4475 2999.5n 0.4475 3000.0n 0.4041 3599.5n 0.4041 3600.0n 0.4178 4199.5n 0.4178 4200.0n 0.4452 4799.5n 0.4452 4800.0n 0.4587 5399.5n 0.4587 5400.0n 0.4267 5999.5n 0.4267 6000.0n 0.4212 6599.5n 0.4212 6600.0n 0.4475 7199.5n 0.4475 7200.0n 0.3950 7799.5n 0.3950 7800.0n 0.3950 8399.5n 0.3950 8400.0n 0.4122 8999.5n 0.4122 9000.0n 0.3950 9599.5n 0.3950 9600.0n 0.4081 10199.5n 0.4081 10200.0n 0.3950 10799.5n 0.3950 10800.0n 0.3950 11399.5n 0.3950 11400.0n 0.3984 11999.5n 0.3984 12000.0n 0.4217 12599.5n 0.4217 12600.0n 0.3950 13199.5n 0.3950 13200.0n 0.3950 13799.5n 0.3950 13800.0n 0.4085 14399.5n 0.4085)
Vxn_wih_8_9 xn_wih_8_9 0 PWL(0.0n 0.5610 599.5n 0.5610 600.0n 0.5614 1199.5n 0.5614 1200.0n 0.5487 1799.5n 0.5487 1800.0n 0.5764 2399.5n 0.5764 2400.0n 0.5525 2999.5n 0.5525 3000.0n 0.5959 3599.5n 0.5959 3600.0n 0.5822 4199.5n 0.5822 4200.0n 0.5548 4799.5n 0.5548 4800.0n 0.5413 5399.5n 0.5413 5400.0n 0.5733 5999.5n 0.5733 6000.0n 0.5788 6599.5n 0.5788 6600.0n 0.5525 7199.5n 0.5525 7200.0n 0.6050 7799.5n 0.6050 7800.0n 0.6050 8399.5n 0.6050 8400.0n 0.5878 8999.5n 0.5878 9000.0n 0.6050 9599.5n 0.6050 9600.0n 0.5919 10199.5n 0.5919 10200.0n 0.6050 10799.5n 0.6050 10800.0n 0.6050 11399.5n 0.6050 11400.0n 0.6016 11999.5n 0.6016 12000.0n 0.5783 12599.5n 0.5783 12600.0n 0.6050 13199.5n 0.6050 13200.0n 0.6050 13799.5n 0.6050 13800.0n 0.5915 14399.5n 0.5915)
Vyp_wih_8_9 yp_wih_8_9 0 PWL(0.0n 0.3744 599.5n 0.3744 600.0n 0.3910 1199.5n 0.3910 1200.0n 0.3918 1799.5n 0.3918 1800.0n 0.3626 2399.5n 0.3626 2400.0n 0.3876 2999.5n 0.3876 3000.0n 0.3620 3599.5n 0.3620 3600.0n 0.3547 4199.5n 0.3547 4200.0n 0.3812 4799.5n 0.3812 4800.0n 0.4049 5399.5n 0.4049 5400.0n 0.3592 5999.5n 0.3592 6000.0n 0.3583 6599.5n 0.3583 6600.0n 0.3852 7199.5n 0.3852 7200.0n 0.3680 7799.5n 0.3680 7800.0n 0.4042 8399.5n 0.4042 8400.0n 0.3875 8999.5n 0.3875 9000.0n 0.4052 9599.5n 0.4052 9600.0n 0.3986 10199.5n 0.3986 10200.0n 0.3785 10799.5n 0.3785 10800.0n 0.3517 11399.5n 0.3517 11400.0n 0.3534 11999.5n 0.3534 12000.0n 0.3958 12599.5n 0.3958 12600.0n 0.3540 13199.5n 0.3540 13200.0n 0.3880 13799.5n 0.3880 13800.0n 0.3531 14399.5n 0.3531)
Vyn_wih_8_9 yn_wih_8_9 0 PWL(0.0n 0.6256 599.5n 0.6256 600.0n 0.6090 1199.5n 0.6090 1200.0n 0.6082 1799.5n 0.6082 1800.0n 0.6374 2399.5n 0.6374 2400.0n 0.6124 2999.5n 0.6124 3000.0n 0.6380 3599.5n 0.6380 3600.0n 0.6453 4199.5n 0.6453 4200.0n 0.6188 4799.5n 0.6188 4800.0n 0.5951 5399.5n 0.5951 5400.0n 0.6408 5999.5n 0.6408 6000.0n 0.6417 6599.5n 0.6417 6600.0n 0.6148 7199.5n 0.6148 7200.0n 0.6320 7799.5n 0.6320 7800.0n 0.5958 8399.5n 0.5958 8400.0n 0.6125 8999.5n 0.6125 9000.0n 0.5948 9599.5n 0.5948 9600.0n 0.6014 10199.5n 0.6014 10200.0n 0.6215 10799.5n 0.6215 10800.0n 0.6483 11399.5n 0.6483 11400.0n 0.6466 11999.5n 0.6466 12000.0n 0.6042 12599.5n 0.6042 12600.0n 0.6460 13199.5n 0.6460 13200.0n 0.6120 13799.5n 0.6120 13800.0n 0.6469 14399.5n 0.6469)
Cwp_wih_8_9 wp_wih_8_9 0 400p
Cwn_wih_8_9 wn_wih_8_9 0 400p
Xu_wih_8_9 xp_wih_8_9 xn_wih_8_9 yp_wih_8_9 yn_wih_8_9 wp_wih_8_9 wn_wih_8_9 vdd gbn gprod
Vxp_wih_9_9 xp_wih_9_9 0 PWL(0.0n 0.5317 599.5n 0.5317 600.0n 0.4980 1199.5n 0.4980 1200.0n 0.5026 1799.5n 0.5026 1800.0n 0.5048 2399.5n 0.5048 2400.0n 0.5191 2999.5n 0.5191 3000.0n 0.5365 3599.5n 0.5365 3600.0n 0.5457 4199.5n 0.5457 4200.0n 0.5457 4799.5n 0.5457 4800.0n 0.5000 5399.5n 0.5000 5400.0n 0.5575 5999.5n 0.5575 6000.0n 0.5000 6599.5n 0.5000 6600.0n 0.5334 7199.5n 0.5334 7200.0n 0.5268 7799.5n 0.5268 7800.0n 0.3950 8399.5n 0.3950 8400.0n 0.5671 8999.5n 0.5671 9000.0n 0.3950 9599.5n 0.3950 9600.0n 0.4573 10199.5n 0.4573 10200.0n 0.4572 10799.5n 0.4572 10800.0n 0.5996 11399.5n 0.5996 11400.0n 0.6050 11999.5n 0.6050 12000.0n 0.5515 12599.5n 0.5515 12600.0n 0.5587 13199.5n 0.5587 13200.0n 0.4550 13799.5n 0.4550 13800.0n 0.6050 14399.5n 0.6050)
Vxn_wih_9_9 xn_wih_9_9 0 PWL(0.0n 0.4683 599.5n 0.4683 600.0n 0.5020 1199.5n 0.5020 1200.0n 0.4974 1799.5n 0.4974 1800.0n 0.4952 2399.5n 0.4952 2400.0n 0.4809 2999.5n 0.4809 3000.0n 0.4635 3599.5n 0.4635 3600.0n 0.4543 4199.5n 0.4543 4200.0n 0.4543 4799.5n 0.4543 4800.0n 0.5000 5399.5n 0.5000 5400.0n 0.4425 5999.5n 0.4425 6000.0n 0.5000 6599.5n 0.5000 6600.0n 0.4666 7199.5n 0.4666 7200.0n 0.4732 7799.5n 0.4732 7800.0n 0.6050 8399.5n 0.6050 8400.0n 0.4329 8999.5n 0.4329 9000.0n 0.6050 9599.5n 0.6050 9600.0n 0.5427 10199.5n 0.5427 10200.0n 0.5428 10799.5n 0.5428 10800.0n 0.4004 11399.5n 0.4004 11400.0n 0.3950 11999.5n 0.3950 12000.0n 0.4485 12599.5n 0.4485 12600.0n 0.4413 13199.5n 0.4413 13200.0n 0.5450 13799.5n 0.5450 13800.0n 0.3950 14399.5n 0.3950)
Vyp_wih_9_9 yp_wih_9_9 0 PWL(0.0n 0.3744 599.5n 0.3744 600.0n 0.3910 1199.5n 0.3910 1200.0n 0.3918 1799.5n 0.3918 1800.0n 0.3626 2399.5n 0.3626 2400.0n 0.3876 2999.5n 0.3876 3000.0n 0.3620 3599.5n 0.3620 3600.0n 0.3547 4199.5n 0.3547 4200.0n 0.3812 4799.5n 0.3812 4800.0n 0.4049 5399.5n 0.4049 5400.0n 0.3592 5999.5n 0.3592 6000.0n 0.3583 6599.5n 0.3583 6600.0n 0.3852 7199.5n 0.3852 7200.0n 0.3680 7799.5n 0.3680 7800.0n 0.4042 8399.5n 0.4042 8400.0n 0.3875 8999.5n 0.3875 9000.0n 0.4052 9599.5n 0.4052 9600.0n 0.3986 10199.5n 0.3986 10200.0n 0.3785 10799.5n 0.3785 10800.0n 0.3517 11399.5n 0.3517 11400.0n 0.3534 11999.5n 0.3534 12000.0n 0.3958 12599.5n 0.3958 12600.0n 0.3540 13199.5n 0.3540 13200.0n 0.3880 13799.5n 0.3880 13800.0n 0.3531 14399.5n 0.3531)
Vyn_wih_9_9 yn_wih_9_9 0 PWL(0.0n 0.6256 599.5n 0.6256 600.0n 0.6090 1199.5n 0.6090 1200.0n 0.6082 1799.5n 0.6082 1800.0n 0.6374 2399.5n 0.6374 2400.0n 0.6124 2999.5n 0.6124 3000.0n 0.6380 3599.5n 0.6380 3600.0n 0.6453 4199.5n 0.6453 4200.0n 0.6188 4799.5n 0.6188 4800.0n 0.5951 5399.5n 0.5951 5400.0n 0.6408 5999.5n 0.6408 6000.0n 0.6417 6599.5n 0.6417 6600.0n 0.6148 7199.5n 0.6148 7200.0n 0.6320 7799.5n 0.6320 7800.0n 0.5958 8399.5n 0.5958 8400.0n 0.6125 8999.5n 0.6125 9000.0n 0.5948 9599.5n 0.5948 9600.0n 0.6014 10199.5n 0.6014 10200.0n 0.6215 10799.5n 0.6215 10800.0n 0.6483 11399.5n 0.6483 11400.0n 0.6466 11999.5n 0.6466 12000.0n 0.6042 12599.5n 0.6042 12600.0n 0.6460 13199.5n 0.6460 13200.0n 0.6120 13799.5n 0.6120 13800.0n 0.6469 14399.5n 0.6469)
Cwp_wih_9_9 wp_wih_9_9 0 400p
Cwn_wih_9_9 wn_wih_9_9 0 400p
Xu_wih_9_9 xp_wih_9_9 xn_wih_9_9 yp_wih_9_9 yn_wih_9_9 wp_wih_9_9 wn_wih_9_9 vdd gbn gprod
Vxp_wih_12_9 xp_wih_12_9 0 PWL(0.0n 0.3950 599.5n 0.3950 600.0n 0.4029 1199.5n 0.4029 1200.0n 0.3950 1799.5n 0.3950 1800.0n 0.3950 2399.5n 0.3950 2400.0n 0.4093 2999.5n 0.4093 3000.0n 0.3950 3599.5n 0.3950 3600.0n 0.3950 4199.5n 0.3950 4200.0n 0.3950 4799.5n 0.3950 4800.0n 0.3950 5399.5n 0.3950 5400.0n 0.3950 5999.5n 0.3950 6000.0n 0.3950 6599.5n 0.3950 6600.0n 0.3998 7199.5n 0.3998 7200.0n 0.3950 7799.5n 0.3950 7800.0n 0.3950 8399.5n 0.3950 8400.0n 0.3950 8999.5n 0.3950 9000.0n 0.3950 9599.5n 0.3950 9600.0n 0.3950 10199.5n 0.3950 10200.0n 0.3950 10799.5n 0.3950 10800.0n 0.3950 11399.5n 0.3950 11400.0n 0.3950 11999.5n 0.3950 12000.0n 0.3950 12599.5n 0.3950 12600.0n 0.3950 13199.5n 0.3950 13200.0n 0.3950 13799.5n 0.3950 13800.0n 0.4052 14399.5n 0.4052)
Vxn_wih_12_9 xn_wih_12_9 0 PWL(0.0n 0.6050 599.5n 0.6050 600.0n 0.5971 1199.5n 0.5971 1200.0n 0.6050 1799.5n 0.6050 1800.0n 0.6050 2399.5n 0.6050 2400.0n 0.5907 2999.5n 0.5907 3000.0n 0.6050 3599.5n 0.6050 3600.0n 0.6050 4199.5n 0.6050 4200.0n 0.6050 4799.5n 0.6050 4800.0n 0.6050 5399.5n 0.6050 5400.0n 0.6050 5999.5n 0.6050 6000.0n 0.6050 6599.5n 0.6050 6600.0n 0.6002 7199.5n 0.6002 7200.0n 0.6050 7799.5n 0.6050 7800.0n 0.6050 8399.5n 0.6050 8400.0n 0.6050 8999.5n 0.6050 9000.0n 0.6050 9599.5n 0.6050 9600.0n 0.6050 10199.5n 0.6050 10200.0n 0.6050 10799.5n 0.6050 10800.0n 0.6050 11399.5n 0.6050 11400.0n 0.6050 11999.5n 0.6050 12000.0n 0.6050 12599.5n 0.6050 12600.0n 0.6050 13199.5n 0.6050 13200.0n 0.6050 13799.5n 0.6050 13800.0n 0.5948 14399.5n 0.5948)
Vyp_wih_12_9 yp_wih_12_9 0 PWL(0.0n 0.3744 599.5n 0.3744 600.0n 0.3910 1199.5n 0.3910 1200.0n 0.3918 1799.5n 0.3918 1800.0n 0.3626 2399.5n 0.3626 2400.0n 0.3876 2999.5n 0.3876 3000.0n 0.3620 3599.5n 0.3620 3600.0n 0.3547 4199.5n 0.3547 4200.0n 0.3812 4799.5n 0.3812 4800.0n 0.4049 5399.5n 0.4049 5400.0n 0.3592 5999.5n 0.3592 6000.0n 0.3583 6599.5n 0.3583 6600.0n 0.3852 7199.5n 0.3852 7200.0n 0.3680 7799.5n 0.3680 7800.0n 0.4042 8399.5n 0.4042 8400.0n 0.3875 8999.5n 0.3875 9000.0n 0.4052 9599.5n 0.4052 9600.0n 0.3986 10199.5n 0.3986 10200.0n 0.3785 10799.5n 0.3785 10800.0n 0.3517 11399.5n 0.3517 11400.0n 0.3534 11999.5n 0.3534 12000.0n 0.3958 12599.5n 0.3958 12600.0n 0.3540 13199.5n 0.3540 13200.0n 0.3880 13799.5n 0.3880 13800.0n 0.3531 14399.5n 0.3531)
Vyn_wih_12_9 yn_wih_12_9 0 PWL(0.0n 0.6256 599.5n 0.6256 600.0n 0.6090 1199.5n 0.6090 1200.0n 0.6082 1799.5n 0.6082 1800.0n 0.6374 2399.5n 0.6374 2400.0n 0.6124 2999.5n 0.6124 3000.0n 0.6380 3599.5n 0.6380 3600.0n 0.6453 4199.5n 0.6453 4200.0n 0.6188 4799.5n 0.6188 4800.0n 0.5951 5399.5n 0.5951 5400.0n 0.6408 5999.5n 0.6408 6000.0n 0.6417 6599.5n 0.6417 6600.0n 0.6148 7199.5n 0.6148 7200.0n 0.6320 7799.5n 0.6320 7800.0n 0.5958 8399.5n 0.5958 8400.0n 0.6125 8999.5n 0.6125 9000.0n 0.5948 9599.5n 0.5948 9600.0n 0.6014 10199.5n 0.6014 10200.0n 0.6215 10799.5n 0.6215 10800.0n 0.6483 11399.5n 0.6483 11400.0n 0.6466 11999.5n 0.6466 12000.0n 0.6042 12599.5n 0.6042 12600.0n 0.6460 13199.5n 0.6460 13200.0n 0.6120 13799.5n 0.6120 13800.0n 0.6469 14399.5n 0.6469)
Cwp_wih_12_9 wp_wih_12_9 0 400p
Cwn_wih_12_9 wn_wih_12_9 0 400p
Xu_wih_12_9 xp_wih_12_9 xn_wih_12_9 yp_wih_12_9 yn_wih_12_9 wp_wih_12_9 wn_wih_12_9 vdd gbn gprod
Vxp_wih_13_9 xp_wih_13_9 0 PWL(0.0n 0.6050 599.5n 0.6050 600.0n 0.5495 1199.5n 0.5495 1200.0n 0.6050 1799.5n 0.6050 1800.0n 0.5811 2399.5n 0.5811 2400.0n 0.6050 2999.5n 0.6050 3000.0n 0.5411 3599.5n 0.5411 3600.0n 0.5867 4199.5n 0.5867 4200.0n 0.5822 4799.5n 0.5822 4800.0n 0.5675 5399.5n 0.5675 5400.0n 0.5852 5999.5n 0.5852 6000.0n 0.5831 6599.5n 0.5831 6600.0n 0.5907 7199.5n 0.5907 7200.0n 0.4938 7799.5n 0.4938 7800.0n 0.4048 8399.5n 0.4048 8400.0n 0.3984 8999.5n 0.3984 9000.0n 0.3950 9599.5n 0.3950 9600.0n 0.3983 10199.5n 0.3983 10200.0n 0.4494 10799.5n 0.4494 10800.0n 0.5512 11399.5n 0.5512 11400.0n 0.5135 11999.5n 0.5135 12000.0n 0.3950 12599.5n 0.3950 12600.0n 0.5338 13199.5n 0.5338 13200.0n 0.4283 13799.5n 0.4283 13800.0n 0.5677 14399.5n 0.5677)
Vxn_wih_13_9 xn_wih_13_9 0 PWL(0.0n 0.3950 599.5n 0.3950 600.0n 0.4505 1199.5n 0.4505 1200.0n 0.3950 1799.5n 0.3950 1800.0n 0.4189 2399.5n 0.4189 2400.0n 0.3950 2999.5n 0.3950 3000.0n 0.4589 3599.5n 0.4589 3600.0n 0.4133 4199.5n 0.4133 4200.0n 0.4178 4799.5n 0.4178 4800.0n 0.4325 5399.5n 0.4325 5400.0n 0.4148 5999.5n 0.4148 6000.0n 0.4169 6599.5n 0.4169 6600.0n 0.4093 7199.5n 0.4093 7200.0n 0.5062 7799.5n 0.5062 7800.0n 0.5952 8399.5n 0.5952 8400.0n 0.6016 8999.5n 0.6016 9000.0n 0.6050 9599.5n 0.6050 9600.0n 0.6017 10199.5n 0.6017 10200.0n 0.5506 10799.5n 0.5506 10800.0n 0.4488 11399.5n 0.4488 11400.0n 0.4865 11999.5n 0.4865 12000.0n 0.6050 12599.5n 0.6050 12600.0n 0.4662 13199.5n 0.4662 13200.0n 0.5717 13799.5n 0.5717 13800.0n 0.4323 14399.5n 0.4323)
Vyp_wih_13_9 yp_wih_13_9 0 PWL(0.0n 0.3744 599.5n 0.3744 600.0n 0.3910 1199.5n 0.3910 1200.0n 0.3918 1799.5n 0.3918 1800.0n 0.3626 2399.5n 0.3626 2400.0n 0.3876 2999.5n 0.3876 3000.0n 0.3620 3599.5n 0.3620 3600.0n 0.3547 4199.5n 0.3547 4200.0n 0.3812 4799.5n 0.3812 4800.0n 0.4049 5399.5n 0.4049 5400.0n 0.3592 5999.5n 0.3592 6000.0n 0.3583 6599.5n 0.3583 6600.0n 0.3852 7199.5n 0.3852 7200.0n 0.3680 7799.5n 0.3680 7800.0n 0.4042 8399.5n 0.4042 8400.0n 0.3875 8999.5n 0.3875 9000.0n 0.4052 9599.5n 0.4052 9600.0n 0.3986 10199.5n 0.3986 10200.0n 0.3785 10799.5n 0.3785 10800.0n 0.3517 11399.5n 0.3517 11400.0n 0.3534 11999.5n 0.3534 12000.0n 0.3958 12599.5n 0.3958 12600.0n 0.3540 13199.5n 0.3540 13200.0n 0.3880 13799.5n 0.3880 13800.0n 0.3531 14399.5n 0.3531)
Vyn_wih_13_9 yn_wih_13_9 0 PWL(0.0n 0.6256 599.5n 0.6256 600.0n 0.6090 1199.5n 0.6090 1200.0n 0.6082 1799.5n 0.6082 1800.0n 0.6374 2399.5n 0.6374 2400.0n 0.6124 2999.5n 0.6124 3000.0n 0.6380 3599.5n 0.6380 3600.0n 0.6453 4199.5n 0.6453 4200.0n 0.6188 4799.5n 0.6188 4800.0n 0.5951 5399.5n 0.5951 5400.0n 0.6408 5999.5n 0.6408 6000.0n 0.6417 6599.5n 0.6417 6600.0n 0.6148 7199.5n 0.6148 7200.0n 0.6320 7799.5n 0.6320 7800.0n 0.5958 8399.5n 0.5958 8400.0n 0.6125 8999.5n 0.6125 9000.0n 0.5948 9599.5n 0.5948 9600.0n 0.6014 10199.5n 0.6014 10200.0n 0.6215 10799.5n 0.6215 10800.0n 0.6483 11399.5n 0.6483 11400.0n 0.6466 11999.5n 0.6466 12000.0n 0.6042 12599.5n 0.6042 12600.0n 0.6460 13199.5n 0.6460 13200.0n 0.6120 13799.5n 0.6120 13800.0n 0.6469 14399.5n 0.6469)
Cwp_wih_13_9 wp_wih_13_9 0 400p
Cwn_wih_13_9 wn_wih_13_9 0 400p
Xu_wih_13_9 xp_wih_13_9 xn_wih_13_9 yp_wih_13_9 yn_wih_13_9 wp_wih_13_9 wn_wih_13_9 vdd gbn gprod
Vxp_who_9_0 xp_who_9_0 0 PWL(0.0n 0.3744 599.5n 0.3744 600.0n 0.3910 1199.5n 0.3910 1200.0n 0.3918 1799.5n 0.3918 1800.0n 0.3626 2399.5n 0.3626 2400.0n 0.3876 2999.5n 0.3876 3000.0n 0.3620 3599.5n 0.3620 3600.0n 0.3547 4199.5n 0.3547 4200.0n 0.3812 4799.5n 0.3812 4800.0n 0.4049 5399.5n 0.4049 5400.0n 0.3592 5999.5n 0.3592 6000.0n 0.3583 6599.5n 0.3583 6600.0n 0.3852 7199.5n 0.3852 7200.0n 0.3680 7799.5n 0.3680 7800.0n 0.4042 8399.5n 0.4042 8400.0n 0.3875 8999.5n 0.3875 9000.0n 0.4052 9599.5n 0.4052 9600.0n 0.3986 10199.5n 0.3986 10200.0n 0.3785 10799.5n 0.3785 10800.0n 0.3517 11399.5n 0.3517 11400.0n 0.3534 11999.5n 0.3534 12000.0n 0.3958 12599.5n 0.3958 12600.0n 0.3540 13199.5n 0.3540 13200.0n 0.3880 13799.5n 0.3880 13800.0n 0.3531 14399.5n 0.3531)
Vxn_who_9_0 xn_who_9_0 0 PWL(0.0n 0.6256 599.5n 0.6256 600.0n 0.6090 1199.5n 0.6090 1200.0n 0.6082 1799.5n 0.6082 1800.0n 0.6374 2399.5n 0.6374 2400.0n 0.6124 2999.5n 0.6124 3000.0n 0.6380 3599.5n 0.6380 3600.0n 0.6453 4199.5n 0.6453 4200.0n 0.6188 4799.5n 0.6188 4800.0n 0.5951 5399.5n 0.5951 5400.0n 0.6408 5999.5n 0.6408 6000.0n 0.6417 6599.5n 0.6417 6600.0n 0.6148 7199.5n 0.6148 7200.0n 0.6320 7799.5n 0.6320 7800.0n 0.5958 8399.5n 0.5958 8400.0n 0.6125 8999.5n 0.6125 9000.0n 0.5948 9599.5n 0.5948 9600.0n 0.6014 10199.5n 0.6014 10200.0n 0.6215 10799.5n 0.6215 10800.0n 0.6483 11399.5n 0.6483 11400.0n 0.6466 11999.5n 0.6466 12000.0n 0.6042 12599.5n 0.6042 12600.0n 0.6460 13199.5n 0.6460 13200.0n 0.6120 13799.5n 0.6120 13800.0n 0.6469 14399.5n 0.6469)
Vyp_who_9_0 yp_who_9_0 0 PWL(0.0n 0.5073 599.5n 0.5073 600.0n 0.5065 1199.5n 0.5065 1200.0n 0.5065 1799.5n 0.5065 1800.0n 0.5052 2399.5n 0.5052 2400.0n 0.5058 2999.5n 0.5058 3000.0n 0.5039 3599.5n 0.5039 3600.0n 0.5059 4199.5n 0.5059 4200.0n 0.5077 4799.5n 0.5077 4800.0n 0.5054 5399.5n 0.5054 5400.0n 0.5066 5999.5n 0.5066 6000.0n 0.5083 6599.5n 0.5083 6600.0n 0.5078 7199.5n 0.5078 7200.0n 0.5043 7799.5n 0.5043 7800.0n 0.5035 8399.5n 0.5035 8400.0n 0.5035 8999.5n 0.5035 9000.0n 0.5038 9599.5n 0.5038 9600.0n 0.5043 10199.5n 0.5043 10200.0n 0.5053 10799.5n 0.5053 10800.0n 0.5050 11399.5n 0.5050 11400.0n 0.5055 11999.5n 0.5055 12000.0n 0.5043 12599.5n 0.5043 12600.0n 0.5028 13199.5n 0.5028 13200.0n 0.5045 13799.5n 0.5045 13800.0n 0.5043 14399.5n 0.5043)
Vyn_who_9_0 yn_who_9_0 0 PWL(0.0n 0.4927 599.5n 0.4927 600.0n 0.4935 1199.5n 0.4935 1200.0n 0.4935 1799.5n 0.4935 1800.0n 0.4948 2399.5n 0.4948 2400.0n 0.4942 2999.5n 0.4942 3000.0n 0.4961 3599.5n 0.4961 3600.0n 0.4941 4199.5n 0.4941 4200.0n 0.4923 4799.5n 0.4923 4800.0n 0.4946 5399.5n 0.4946 5400.0n 0.4934 5999.5n 0.4934 6000.0n 0.4917 6599.5n 0.4917 6600.0n 0.4922 7199.5n 0.4922 7200.0n 0.4957 7799.5n 0.4957 7800.0n 0.4965 8399.5n 0.4965 8400.0n 0.4965 8999.5n 0.4965 9000.0n 0.4962 9599.5n 0.4962 9600.0n 0.4957 10199.5n 0.4957 10200.0n 0.4947 10799.5n 0.4947 10800.0n 0.4950 11399.5n 0.4950 11400.0n 0.4945 11999.5n 0.4945 12000.0n 0.4957 12599.5n 0.4957 12600.0n 0.4972 13199.5n 0.4972 13200.0n 0.4955 13799.5n 0.4955 13800.0n 0.4957 14399.5n 0.4957)
Cwp_who_9_0 wp_who_9_0 0 400p
Cwn_who_9_0 wn_who_9_0 0 400p
Xu_who_9_0 xp_who_9_0 xn_who_9_0 yp_who_9_0 yn_who_9_0 wp_who_9_0 wn_who_9_0 vdd gbn gprod
Vxp_who_9_1 xp_who_9_1 0 PWL(0.0n 0.3744 599.5n 0.3744 600.0n 0.3910 1199.5n 0.3910 1200.0n 0.3918 1799.5n 0.3918 1800.0n 0.3626 2399.5n 0.3626 2400.0n 0.3876 2999.5n 0.3876 3000.0n 0.3620 3599.5n 0.3620 3600.0n 0.3547 4199.5n 0.3547 4200.0n 0.3812 4799.5n 0.3812 4800.0n 0.4049 5399.5n 0.4049 5400.0n 0.3592 5999.5n 0.3592 6000.0n 0.3583 6599.5n 0.3583 6600.0n 0.3852 7199.5n 0.3852 7200.0n 0.3680 7799.5n 0.3680 7800.0n 0.4042 8399.5n 0.4042 8400.0n 0.3875 8999.5n 0.3875 9000.0n 0.4052 9599.5n 0.4052 9600.0n 0.3986 10199.5n 0.3986 10200.0n 0.3785 10799.5n 0.3785 10800.0n 0.3517 11399.5n 0.3517 11400.0n 0.3534 11999.5n 0.3534 12000.0n 0.3958 12599.5n 0.3958 12600.0n 0.3540 13199.5n 0.3540 13200.0n 0.3880 13799.5n 0.3880 13800.0n 0.3531 14399.5n 0.3531)
Vxn_who_9_1 xn_who_9_1 0 PWL(0.0n 0.6256 599.5n 0.6256 600.0n 0.6090 1199.5n 0.6090 1200.0n 0.6082 1799.5n 0.6082 1800.0n 0.6374 2399.5n 0.6374 2400.0n 0.6124 2999.5n 0.6124 3000.0n 0.6380 3599.5n 0.6380 3600.0n 0.6453 4199.5n 0.6453 4200.0n 0.6188 4799.5n 0.6188 4800.0n 0.5951 5399.5n 0.5951 5400.0n 0.6408 5999.5n 0.6408 6000.0n 0.6417 6599.5n 0.6417 6600.0n 0.6148 7199.5n 0.6148 7200.0n 0.6320 7799.5n 0.6320 7800.0n 0.5958 8399.5n 0.5958 8400.0n 0.6125 8999.5n 0.6125 9000.0n 0.5948 9599.5n 0.5948 9600.0n 0.6014 10199.5n 0.6014 10200.0n 0.6215 10799.5n 0.6215 10800.0n 0.6483 11399.5n 0.6483 11400.0n 0.6466 11999.5n 0.6466 12000.0n 0.6042 12599.5n 0.6042 12600.0n 0.6460 13199.5n 0.6460 13200.0n 0.6120 13799.5n 0.6120 13800.0n 0.6469 14399.5n 0.6469)
Vyp_who_9_1 yp_who_9_1 0 PWL(0.0n 0.4909 599.5n 0.4909 600.0n 0.4933 1199.5n 0.4933 1200.0n 0.4930 1799.5n 0.4930 1800.0n 0.4893 2399.5n 0.4893 2400.0n 0.4904 2999.5n 0.4904 3000.0n 0.4923 3599.5n 0.4923 3600.0n 0.4897 4199.5n 0.4897 4200.0n 0.4890 4799.5n 0.4890 4800.0n 0.4921 5399.5n 0.4921 5400.0n 0.4899 5999.5n 0.4899 6000.0n 0.4870 6599.5n 0.4870 6600.0n 0.4903 7199.5n 0.4903 7200.0n 0.4970 7799.5n 0.4970 7800.0n 0.4989 8399.5n 0.4989 8400.0n 0.4994 8999.5n 0.4994 9000.0n 0.4991 9599.5n 0.4991 9600.0n 0.5000 10199.5n 0.5000 10200.0n 0.4948 10799.5n 0.4948 10800.0n 0.4959 11399.5n 0.4959 11400.0n 0.4926 11999.5n 0.4926 12000.0n 0.4993 12599.5n 0.4993 12600.0n 0.4862 13199.5n 0.4862 13200.0n 0.4993 13799.5n 0.4993 13800.0n 0.4961 14399.5n 0.4961)
Vyn_who_9_1 yn_who_9_1 0 PWL(0.0n 0.5091 599.5n 0.5091 600.0n 0.5067 1199.5n 0.5067 1200.0n 0.5070 1799.5n 0.5070 1800.0n 0.5107 2399.5n 0.5107 2400.0n 0.5096 2999.5n 0.5096 3000.0n 0.5077 3599.5n 0.5077 3600.0n 0.5103 4199.5n 0.5103 4200.0n 0.5110 4799.5n 0.5110 4800.0n 0.5079 5399.5n 0.5079 5400.0n 0.5101 5999.5n 0.5101 6000.0n 0.5130 6599.5n 0.5130 6600.0n 0.5097 7199.5n 0.5097 7200.0n 0.5030 7799.5n 0.5030 7800.0n 0.5011 8399.5n 0.5011 8400.0n 0.5006 8999.5n 0.5006 9000.0n 0.5009 9599.5n 0.5009 9600.0n 0.5000 10199.5n 0.5000 10200.0n 0.5052 10799.5n 0.5052 10800.0n 0.5041 11399.5n 0.5041 11400.0n 0.5074 11999.5n 0.5074 12000.0n 0.5007 12599.5n 0.5007 12600.0n 0.5138 13199.5n 0.5138 13200.0n 0.5007 13799.5n 0.5007 13800.0n 0.5039 14399.5n 0.5039)
Cwp_who_9_1 wp_who_9_1 0 400p
Cwn_who_9_1 wn_who_9_1 0 400p
Xu_who_9_1 xp_who_9_1 xn_who_9_1 yp_who_9_1 yn_who_9_1 wp_who_9_1 wn_who_9_1 vdd gbn gprod
Vxp_bh_9 xp_bh_9 0 PWL(0.0n 0.7100 599.5n 0.7100 600.0n 0.7100 1199.5n 0.7100 1200.0n 0.7100 1799.5n 0.7100 1800.0n 0.7100 2399.5n 0.7100 2400.0n 0.7100 2999.5n 0.7100 3000.0n 0.7100 3599.5n 0.7100 3600.0n 0.7100 4199.5n 0.7100 4200.0n 0.7100 4799.5n 0.7100 4800.0n 0.7100 5399.5n 0.7100 5400.0n 0.7100 5999.5n 0.7100 6000.0n 0.7100 6599.5n 0.7100 6600.0n 0.7100 7199.5n 0.7100 7200.0n 0.7100 7799.5n 0.7100 7800.0n 0.7100 8399.5n 0.7100 8400.0n 0.7100 8999.5n 0.7100 9000.0n 0.7100 9599.5n 0.7100 9600.0n 0.7100 10199.5n 0.7100 10200.0n 0.7100 10799.5n 0.7100 10800.0n 0.7100 11399.5n 0.7100 11400.0n 0.7100 11999.5n 0.7100 12000.0n 0.7100 12599.5n 0.7100 12600.0n 0.7100 13199.5n 0.7100 13200.0n 0.7100 13799.5n 0.7100 13800.0n 0.7100 14399.5n 0.7100)
Vxn_bh_9 xn_bh_9 0 PWL(0.0n 0.2900 599.5n 0.2900 600.0n 0.2900 1199.5n 0.2900 1200.0n 0.2900 1799.5n 0.2900 1800.0n 0.2900 2399.5n 0.2900 2400.0n 0.2900 2999.5n 0.2900 3000.0n 0.2900 3599.5n 0.2900 3600.0n 0.2900 4199.5n 0.2900 4200.0n 0.2900 4799.5n 0.2900 4800.0n 0.2900 5399.5n 0.2900 5400.0n 0.2900 5999.5n 0.2900 6000.0n 0.2900 6599.5n 0.2900 6600.0n 0.2900 7199.5n 0.2900 7200.0n 0.2900 7799.5n 0.2900 7800.0n 0.2900 8399.5n 0.2900 8400.0n 0.2900 8999.5n 0.2900 9000.0n 0.2900 9599.5n 0.2900 9600.0n 0.2900 10199.5n 0.2900 10200.0n 0.2900 10799.5n 0.2900 10800.0n 0.2900 11399.5n 0.2900 11400.0n 0.2900 11999.5n 0.2900 12000.0n 0.2900 12599.5n 0.2900 12600.0n 0.2900 13199.5n 0.2900 13200.0n 0.2900 13799.5n 0.2900 13800.0n 0.2900 14399.5n 0.2900)
Vyp_bh_9 yp_bh_9 0 PWL(0.0n 0.3744 599.5n 0.3744 600.0n 0.3910 1199.5n 0.3910 1200.0n 0.3918 1799.5n 0.3918 1800.0n 0.3626 2399.5n 0.3626 2400.0n 0.3876 2999.5n 0.3876 3000.0n 0.3620 3599.5n 0.3620 3600.0n 0.3547 4199.5n 0.3547 4200.0n 0.3812 4799.5n 0.3812 4800.0n 0.4049 5399.5n 0.4049 5400.0n 0.3592 5999.5n 0.3592 6000.0n 0.3583 6599.5n 0.3583 6600.0n 0.3852 7199.5n 0.3852 7200.0n 0.3680 7799.5n 0.3680 7800.0n 0.4042 8399.5n 0.4042 8400.0n 0.3875 8999.5n 0.3875 9000.0n 0.4052 9599.5n 0.4052 9600.0n 0.3986 10199.5n 0.3986 10200.0n 0.3785 10799.5n 0.3785 10800.0n 0.3517 11399.5n 0.3517 11400.0n 0.3534 11999.5n 0.3534 12000.0n 0.3958 12599.5n 0.3958 12600.0n 0.3540 13199.5n 0.3540 13200.0n 0.3880 13799.5n 0.3880 13800.0n 0.3531 14399.5n 0.3531)
Vyn_bh_9 yn_bh_9 0 PWL(0.0n 0.6256 599.5n 0.6256 600.0n 0.6090 1199.5n 0.6090 1200.0n 0.6082 1799.5n 0.6082 1800.0n 0.6374 2399.5n 0.6374 2400.0n 0.6124 2999.5n 0.6124 3000.0n 0.6380 3599.5n 0.6380 3600.0n 0.6453 4199.5n 0.6453 4200.0n 0.6188 4799.5n 0.6188 4800.0n 0.5951 5399.5n 0.5951 5400.0n 0.6408 5999.5n 0.6408 6000.0n 0.6417 6599.5n 0.6417 6600.0n 0.6148 7199.5n 0.6148 7200.0n 0.6320 7799.5n 0.6320 7800.0n 0.5958 8399.5n 0.5958 8400.0n 0.6125 8999.5n 0.6125 9000.0n 0.5948 9599.5n 0.5948 9600.0n 0.6014 10199.5n 0.6014 10200.0n 0.6215 10799.5n 0.6215 10800.0n 0.6483 11399.5n 0.6483 11400.0n 0.6466 11999.5n 0.6466 12000.0n 0.6042 12599.5n 0.6042 12600.0n 0.6460 13199.5n 0.6460 13200.0n 0.6120 13799.5n 0.6120 13800.0n 0.6469 14399.5n 0.6469)
Cwp_bh_9 wp_bh_9 0 400p
Cwn_bh_9 wn_bh_9 0 400p
Xu_bh_9 xp_bh_9 xn_bh_9 yp_bh_9 yn_bh_9 wp_bh_9 wn_bh_9 vdd gbn gprod
Vxp_wih_8_10 xp_wih_8_10 0 PWL(0.0n 0.4390 599.5n 0.4390 600.0n 0.4386 1199.5n 0.4386 1200.0n 0.4513 1799.5n 0.4513 1800.0n 0.4236 2399.5n 0.4236 2400.0n 0.4475 2999.5n 0.4475 3000.0n 0.4041 3599.5n 0.4041 3600.0n 0.4178 4199.5n 0.4178 4200.0n 0.4452 4799.5n 0.4452 4800.0n 0.4587 5399.5n 0.4587 5400.0n 0.4267 5999.5n 0.4267 6000.0n 0.4212 6599.5n 0.4212 6600.0n 0.4475 7199.5n 0.4475 7200.0n 0.3950 7799.5n 0.3950 7800.0n 0.3950 8399.5n 0.3950 8400.0n 0.4122 8999.5n 0.4122 9000.0n 0.3950 9599.5n 0.3950 9600.0n 0.4081 10199.5n 0.4081 10200.0n 0.3950 10799.5n 0.3950 10800.0n 0.3950 11399.5n 0.3950 11400.0n 0.3984 11999.5n 0.3984 12000.0n 0.4217 12599.5n 0.4217 12600.0n 0.3950 13199.5n 0.3950 13200.0n 0.3950 13799.5n 0.3950 13800.0n 0.4085 14399.5n 0.4085)
Vxn_wih_8_10 xn_wih_8_10 0 PWL(0.0n 0.5610 599.5n 0.5610 600.0n 0.5614 1199.5n 0.5614 1200.0n 0.5487 1799.5n 0.5487 1800.0n 0.5764 2399.5n 0.5764 2400.0n 0.5525 2999.5n 0.5525 3000.0n 0.5959 3599.5n 0.5959 3600.0n 0.5822 4199.5n 0.5822 4200.0n 0.5548 4799.5n 0.5548 4800.0n 0.5413 5399.5n 0.5413 5400.0n 0.5733 5999.5n 0.5733 6000.0n 0.5788 6599.5n 0.5788 6600.0n 0.5525 7199.5n 0.5525 7200.0n 0.6050 7799.5n 0.6050 7800.0n 0.6050 8399.5n 0.6050 8400.0n 0.5878 8999.5n 0.5878 9000.0n 0.6050 9599.5n 0.6050 9600.0n 0.5919 10199.5n 0.5919 10200.0n 0.6050 10799.5n 0.6050 10800.0n 0.6050 11399.5n 0.6050 11400.0n 0.6016 11999.5n 0.6016 12000.0n 0.5783 12599.5n 0.5783 12600.0n 0.6050 13199.5n 0.6050 13200.0n 0.6050 13799.5n 0.6050 13800.0n 0.5915 14399.5n 0.5915)
Vyp_wih_8_10 yp_wih_8_10 0 PWL(0.0n 0.4745 599.5n 0.4745 600.0n 0.5052 1199.5n 0.5052 1200.0n 0.4544 1799.5n 0.4544 1800.0n 0.4971 2399.5n 0.4971 2400.0n 0.4661 2999.5n 0.4661 3000.0n 0.5429 3599.5n 0.5429 3600.0n 0.5059 4199.5n 0.5059 4200.0n 0.4763 4799.5n 0.4763 4800.0n 0.4655 5399.5n 0.4655 5400.0n 0.5014 5999.5n 0.5014 6000.0n 0.4983 6599.5n 0.4983 6600.0n 0.4692 7199.5n 0.4692 7200.0n 0.5609 7799.5n 0.5609 7800.0n 0.5819 8399.5n 0.5819 8400.0n 0.6120 8999.5n 0.6120 9000.0n 0.5842 9599.5n 0.5842 9600.0n 0.5946 10199.5n 0.5946 10200.0n 0.5706 10799.5n 0.5706 10800.0n 0.5557 11399.5n 0.5557 11400.0n 0.5732 11999.5n 0.5732 12000.0n 0.6022 12599.5n 0.6022 12600.0n 0.5574 13199.5n 0.5574 13200.0n 0.5867 13799.5n 0.5867 13800.0n 0.5395 14399.5n 0.5395)
Vyn_wih_8_10 yn_wih_8_10 0 PWL(0.0n 0.5255 599.5n 0.5255 600.0n 0.4948 1199.5n 0.4948 1200.0n 0.5456 1799.5n 0.5456 1800.0n 0.5029 2399.5n 0.5029 2400.0n 0.5339 2999.5n 0.5339 3000.0n 0.4571 3599.5n 0.4571 3600.0n 0.4941 4199.5n 0.4941 4200.0n 0.5237 4799.5n 0.5237 4800.0n 0.5345 5399.5n 0.5345 5400.0n 0.4986 5999.5n 0.4986 6000.0n 0.5017 6599.5n 0.5017 6600.0n 0.5308 7199.5n 0.5308 7200.0n 0.4391 7799.5n 0.4391 7800.0n 0.4181 8399.5n 0.4181 8400.0n 0.3880 8999.5n 0.3880 9000.0n 0.4158 9599.5n 0.4158 9600.0n 0.4054 10199.5n 0.4054 10200.0n 0.4294 10799.5n 0.4294 10800.0n 0.4443 11399.5n 0.4443 11400.0n 0.4268 11999.5n 0.4268 12000.0n 0.3978 12599.5n 0.3978 12600.0n 0.4426 13199.5n 0.4426 13200.0n 0.4133 13799.5n 0.4133 13800.0n 0.4605 14399.5n 0.4605)
Cwp_wih_8_10 wp_wih_8_10 0 400p
Cwn_wih_8_10 wn_wih_8_10 0 400p
Xu_wih_8_10 xp_wih_8_10 xn_wih_8_10 yp_wih_8_10 yn_wih_8_10 wp_wih_8_10 wn_wih_8_10 vdd gbn gprod
Vxp_wih_9_10 xp_wih_9_10 0 PWL(0.0n 0.5317 599.5n 0.5317 600.0n 0.4980 1199.5n 0.4980 1200.0n 0.5026 1799.5n 0.5026 1800.0n 0.5048 2399.5n 0.5048 2400.0n 0.5191 2999.5n 0.5191 3000.0n 0.5365 3599.5n 0.5365 3600.0n 0.5457 4199.5n 0.5457 4200.0n 0.5457 4799.5n 0.5457 4800.0n 0.5000 5399.5n 0.5000 5400.0n 0.5575 5999.5n 0.5575 6000.0n 0.5000 6599.5n 0.5000 6600.0n 0.5334 7199.5n 0.5334 7200.0n 0.5268 7799.5n 0.5268 7800.0n 0.3950 8399.5n 0.3950 8400.0n 0.5671 8999.5n 0.5671 9000.0n 0.3950 9599.5n 0.3950 9600.0n 0.4573 10199.5n 0.4573 10200.0n 0.4572 10799.5n 0.4572 10800.0n 0.5996 11399.5n 0.5996 11400.0n 0.6050 11999.5n 0.6050 12000.0n 0.5515 12599.5n 0.5515 12600.0n 0.5587 13199.5n 0.5587 13200.0n 0.4550 13799.5n 0.4550 13800.0n 0.6050 14399.5n 0.6050)
Vxn_wih_9_10 xn_wih_9_10 0 PWL(0.0n 0.4683 599.5n 0.4683 600.0n 0.5020 1199.5n 0.5020 1200.0n 0.4974 1799.5n 0.4974 1800.0n 0.4952 2399.5n 0.4952 2400.0n 0.4809 2999.5n 0.4809 3000.0n 0.4635 3599.5n 0.4635 3600.0n 0.4543 4199.5n 0.4543 4200.0n 0.4543 4799.5n 0.4543 4800.0n 0.5000 5399.5n 0.5000 5400.0n 0.4425 5999.5n 0.4425 6000.0n 0.5000 6599.5n 0.5000 6600.0n 0.4666 7199.5n 0.4666 7200.0n 0.4732 7799.5n 0.4732 7800.0n 0.6050 8399.5n 0.6050 8400.0n 0.4329 8999.5n 0.4329 9000.0n 0.6050 9599.5n 0.6050 9600.0n 0.5427 10199.5n 0.5427 10200.0n 0.5428 10799.5n 0.5428 10800.0n 0.4004 11399.5n 0.4004 11400.0n 0.3950 11999.5n 0.3950 12000.0n 0.4485 12599.5n 0.4485 12600.0n 0.4413 13199.5n 0.4413 13200.0n 0.5450 13799.5n 0.5450 13800.0n 0.3950 14399.5n 0.3950)
Vyp_wih_9_10 yp_wih_9_10 0 PWL(0.0n 0.4745 599.5n 0.4745 600.0n 0.5052 1199.5n 0.5052 1200.0n 0.4544 1799.5n 0.4544 1800.0n 0.4971 2399.5n 0.4971 2400.0n 0.4661 2999.5n 0.4661 3000.0n 0.5429 3599.5n 0.5429 3600.0n 0.5059 4199.5n 0.5059 4200.0n 0.4763 4799.5n 0.4763 4800.0n 0.4655 5399.5n 0.4655 5400.0n 0.5014 5999.5n 0.5014 6000.0n 0.4983 6599.5n 0.4983 6600.0n 0.4692 7199.5n 0.4692 7200.0n 0.5609 7799.5n 0.5609 7800.0n 0.5819 8399.5n 0.5819 8400.0n 0.6120 8999.5n 0.6120 9000.0n 0.5842 9599.5n 0.5842 9600.0n 0.5946 10199.5n 0.5946 10200.0n 0.5706 10799.5n 0.5706 10800.0n 0.5557 11399.5n 0.5557 11400.0n 0.5732 11999.5n 0.5732 12000.0n 0.6022 12599.5n 0.6022 12600.0n 0.5574 13199.5n 0.5574 13200.0n 0.5867 13799.5n 0.5867 13800.0n 0.5395 14399.5n 0.5395)
Vyn_wih_9_10 yn_wih_9_10 0 PWL(0.0n 0.5255 599.5n 0.5255 600.0n 0.4948 1199.5n 0.4948 1200.0n 0.5456 1799.5n 0.5456 1800.0n 0.5029 2399.5n 0.5029 2400.0n 0.5339 2999.5n 0.5339 3000.0n 0.4571 3599.5n 0.4571 3600.0n 0.4941 4199.5n 0.4941 4200.0n 0.5237 4799.5n 0.5237 4800.0n 0.5345 5399.5n 0.5345 5400.0n 0.4986 5999.5n 0.4986 6000.0n 0.5017 6599.5n 0.5017 6600.0n 0.5308 7199.5n 0.5308 7200.0n 0.4391 7799.5n 0.4391 7800.0n 0.4181 8399.5n 0.4181 8400.0n 0.3880 8999.5n 0.3880 9000.0n 0.4158 9599.5n 0.4158 9600.0n 0.4054 10199.5n 0.4054 10200.0n 0.4294 10799.5n 0.4294 10800.0n 0.4443 11399.5n 0.4443 11400.0n 0.4268 11999.5n 0.4268 12000.0n 0.3978 12599.5n 0.3978 12600.0n 0.4426 13199.5n 0.4426 13200.0n 0.4133 13799.5n 0.4133 13800.0n 0.4605 14399.5n 0.4605)
Cwp_wih_9_10 wp_wih_9_10 0 400p
Cwn_wih_9_10 wn_wih_9_10 0 400p
Xu_wih_9_10 xp_wih_9_10 xn_wih_9_10 yp_wih_9_10 yn_wih_9_10 wp_wih_9_10 wn_wih_9_10 vdd gbn gprod
Vxp_wih_12_10 xp_wih_12_10 0 PWL(0.0n 0.3950 599.5n 0.3950 600.0n 0.4029 1199.5n 0.4029 1200.0n 0.3950 1799.5n 0.3950 1800.0n 0.3950 2399.5n 0.3950 2400.0n 0.4093 2999.5n 0.4093 3000.0n 0.3950 3599.5n 0.3950 3600.0n 0.3950 4199.5n 0.3950 4200.0n 0.3950 4799.5n 0.3950 4800.0n 0.3950 5399.5n 0.3950 5400.0n 0.3950 5999.5n 0.3950 6000.0n 0.3950 6599.5n 0.3950 6600.0n 0.3998 7199.5n 0.3998 7200.0n 0.3950 7799.5n 0.3950 7800.0n 0.3950 8399.5n 0.3950 8400.0n 0.3950 8999.5n 0.3950 9000.0n 0.3950 9599.5n 0.3950 9600.0n 0.3950 10199.5n 0.3950 10200.0n 0.3950 10799.5n 0.3950 10800.0n 0.3950 11399.5n 0.3950 11400.0n 0.3950 11999.5n 0.3950 12000.0n 0.3950 12599.5n 0.3950 12600.0n 0.3950 13199.5n 0.3950 13200.0n 0.3950 13799.5n 0.3950 13800.0n 0.4052 14399.5n 0.4052)
Vxn_wih_12_10 xn_wih_12_10 0 PWL(0.0n 0.6050 599.5n 0.6050 600.0n 0.5971 1199.5n 0.5971 1200.0n 0.6050 1799.5n 0.6050 1800.0n 0.6050 2399.5n 0.6050 2400.0n 0.5907 2999.5n 0.5907 3000.0n 0.6050 3599.5n 0.6050 3600.0n 0.6050 4199.5n 0.6050 4200.0n 0.6050 4799.5n 0.6050 4800.0n 0.6050 5399.5n 0.6050 5400.0n 0.6050 5999.5n 0.6050 6000.0n 0.6050 6599.5n 0.6050 6600.0n 0.6002 7199.5n 0.6002 7200.0n 0.6050 7799.5n 0.6050 7800.0n 0.6050 8399.5n 0.6050 8400.0n 0.6050 8999.5n 0.6050 9000.0n 0.6050 9599.5n 0.6050 9600.0n 0.6050 10199.5n 0.6050 10200.0n 0.6050 10799.5n 0.6050 10800.0n 0.6050 11399.5n 0.6050 11400.0n 0.6050 11999.5n 0.6050 12000.0n 0.6050 12599.5n 0.6050 12600.0n 0.6050 13199.5n 0.6050 13200.0n 0.6050 13799.5n 0.6050 13800.0n 0.5948 14399.5n 0.5948)
Vyp_wih_12_10 yp_wih_12_10 0 PWL(0.0n 0.4745 599.5n 0.4745 600.0n 0.5052 1199.5n 0.5052 1200.0n 0.4544 1799.5n 0.4544 1800.0n 0.4971 2399.5n 0.4971 2400.0n 0.4661 2999.5n 0.4661 3000.0n 0.5429 3599.5n 0.5429 3600.0n 0.5059 4199.5n 0.5059 4200.0n 0.4763 4799.5n 0.4763 4800.0n 0.4655 5399.5n 0.4655 5400.0n 0.5014 5999.5n 0.5014 6000.0n 0.4983 6599.5n 0.4983 6600.0n 0.4692 7199.5n 0.4692 7200.0n 0.5609 7799.5n 0.5609 7800.0n 0.5819 8399.5n 0.5819 8400.0n 0.6120 8999.5n 0.6120 9000.0n 0.5842 9599.5n 0.5842 9600.0n 0.5946 10199.5n 0.5946 10200.0n 0.5706 10799.5n 0.5706 10800.0n 0.5557 11399.5n 0.5557 11400.0n 0.5732 11999.5n 0.5732 12000.0n 0.6022 12599.5n 0.6022 12600.0n 0.5574 13199.5n 0.5574 13200.0n 0.5867 13799.5n 0.5867 13800.0n 0.5395 14399.5n 0.5395)
Vyn_wih_12_10 yn_wih_12_10 0 PWL(0.0n 0.5255 599.5n 0.5255 600.0n 0.4948 1199.5n 0.4948 1200.0n 0.5456 1799.5n 0.5456 1800.0n 0.5029 2399.5n 0.5029 2400.0n 0.5339 2999.5n 0.5339 3000.0n 0.4571 3599.5n 0.4571 3600.0n 0.4941 4199.5n 0.4941 4200.0n 0.5237 4799.5n 0.5237 4800.0n 0.5345 5399.5n 0.5345 5400.0n 0.4986 5999.5n 0.4986 6000.0n 0.5017 6599.5n 0.5017 6600.0n 0.5308 7199.5n 0.5308 7200.0n 0.4391 7799.5n 0.4391 7800.0n 0.4181 8399.5n 0.4181 8400.0n 0.3880 8999.5n 0.3880 9000.0n 0.4158 9599.5n 0.4158 9600.0n 0.4054 10199.5n 0.4054 10200.0n 0.4294 10799.5n 0.4294 10800.0n 0.4443 11399.5n 0.4443 11400.0n 0.4268 11999.5n 0.4268 12000.0n 0.3978 12599.5n 0.3978 12600.0n 0.4426 13199.5n 0.4426 13200.0n 0.4133 13799.5n 0.4133 13800.0n 0.4605 14399.5n 0.4605)
Cwp_wih_12_10 wp_wih_12_10 0 400p
Cwn_wih_12_10 wn_wih_12_10 0 400p
Xu_wih_12_10 xp_wih_12_10 xn_wih_12_10 yp_wih_12_10 yn_wih_12_10 wp_wih_12_10 wn_wih_12_10 vdd gbn gprod
Vxp_wih_13_10 xp_wih_13_10 0 PWL(0.0n 0.6050 599.5n 0.6050 600.0n 0.5495 1199.5n 0.5495 1200.0n 0.6050 1799.5n 0.6050 1800.0n 0.5811 2399.5n 0.5811 2400.0n 0.6050 2999.5n 0.6050 3000.0n 0.5411 3599.5n 0.5411 3600.0n 0.5867 4199.5n 0.5867 4200.0n 0.5822 4799.5n 0.5822 4800.0n 0.5675 5399.5n 0.5675 5400.0n 0.5852 5999.5n 0.5852 6000.0n 0.5831 6599.5n 0.5831 6600.0n 0.5907 7199.5n 0.5907 7200.0n 0.4938 7799.5n 0.4938 7800.0n 0.4048 8399.5n 0.4048 8400.0n 0.3984 8999.5n 0.3984 9000.0n 0.3950 9599.5n 0.3950 9600.0n 0.3983 10199.5n 0.3983 10200.0n 0.4494 10799.5n 0.4494 10800.0n 0.5512 11399.5n 0.5512 11400.0n 0.5135 11999.5n 0.5135 12000.0n 0.3950 12599.5n 0.3950 12600.0n 0.5338 13199.5n 0.5338 13200.0n 0.4283 13799.5n 0.4283 13800.0n 0.5677 14399.5n 0.5677)
Vxn_wih_13_10 xn_wih_13_10 0 PWL(0.0n 0.3950 599.5n 0.3950 600.0n 0.4505 1199.5n 0.4505 1200.0n 0.3950 1799.5n 0.3950 1800.0n 0.4189 2399.5n 0.4189 2400.0n 0.3950 2999.5n 0.3950 3000.0n 0.4589 3599.5n 0.4589 3600.0n 0.4133 4199.5n 0.4133 4200.0n 0.4178 4799.5n 0.4178 4800.0n 0.4325 5399.5n 0.4325 5400.0n 0.4148 5999.5n 0.4148 6000.0n 0.4169 6599.5n 0.4169 6600.0n 0.4093 7199.5n 0.4093 7200.0n 0.5062 7799.5n 0.5062 7800.0n 0.5952 8399.5n 0.5952 8400.0n 0.6016 8999.5n 0.6016 9000.0n 0.6050 9599.5n 0.6050 9600.0n 0.6017 10199.5n 0.6017 10200.0n 0.5506 10799.5n 0.5506 10800.0n 0.4488 11399.5n 0.4488 11400.0n 0.4865 11999.5n 0.4865 12000.0n 0.6050 12599.5n 0.6050 12600.0n 0.4662 13199.5n 0.4662 13200.0n 0.5717 13799.5n 0.5717 13800.0n 0.4323 14399.5n 0.4323)
Vyp_wih_13_10 yp_wih_13_10 0 PWL(0.0n 0.4745 599.5n 0.4745 600.0n 0.5052 1199.5n 0.5052 1200.0n 0.4544 1799.5n 0.4544 1800.0n 0.4971 2399.5n 0.4971 2400.0n 0.4661 2999.5n 0.4661 3000.0n 0.5429 3599.5n 0.5429 3600.0n 0.5059 4199.5n 0.5059 4200.0n 0.4763 4799.5n 0.4763 4800.0n 0.4655 5399.5n 0.4655 5400.0n 0.5014 5999.5n 0.5014 6000.0n 0.4983 6599.5n 0.4983 6600.0n 0.4692 7199.5n 0.4692 7200.0n 0.5609 7799.5n 0.5609 7800.0n 0.5819 8399.5n 0.5819 8400.0n 0.6120 8999.5n 0.6120 9000.0n 0.5842 9599.5n 0.5842 9600.0n 0.5946 10199.5n 0.5946 10200.0n 0.5706 10799.5n 0.5706 10800.0n 0.5557 11399.5n 0.5557 11400.0n 0.5732 11999.5n 0.5732 12000.0n 0.6022 12599.5n 0.6022 12600.0n 0.5574 13199.5n 0.5574 13200.0n 0.5867 13799.5n 0.5867 13800.0n 0.5395 14399.5n 0.5395)
Vyn_wih_13_10 yn_wih_13_10 0 PWL(0.0n 0.5255 599.5n 0.5255 600.0n 0.4948 1199.5n 0.4948 1200.0n 0.5456 1799.5n 0.5456 1800.0n 0.5029 2399.5n 0.5029 2400.0n 0.5339 2999.5n 0.5339 3000.0n 0.4571 3599.5n 0.4571 3600.0n 0.4941 4199.5n 0.4941 4200.0n 0.5237 4799.5n 0.5237 4800.0n 0.5345 5399.5n 0.5345 5400.0n 0.4986 5999.5n 0.4986 6000.0n 0.5017 6599.5n 0.5017 6600.0n 0.5308 7199.5n 0.5308 7200.0n 0.4391 7799.5n 0.4391 7800.0n 0.4181 8399.5n 0.4181 8400.0n 0.3880 8999.5n 0.3880 9000.0n 0.4158 9599.5n 0.4158 9600.0n 0.4054 10199.5n 0.4054 10200.0n 0.4294 10799.5n 0.4294 10800.0n 0.4443 11399.5n 0.4443 11400.0n 0.4268 11999.5n 0.4268 12000.0n 0.3978 12599.5n 0.3978 12600.0n 0.4426 13199.5n 0.4426 13200.0n 0.4133 13799.5n 0.4133 13800.0n 0.4605 14399.5n 0.4605)
Cwp_wih_13_10 wp_wih_13_10 0 400p
Cwn_wih_13_10 wn_wih_13_10 0 400p
Xu_wih_13_10 xp_wih_13_10 xn_wih_13_10 yp_wih_13_10 yn_wih_13_10 wp_wih_13_10 wn_wih_13_10 vdd gbn gprod
Vxp_who_10_0 xp_who_10_0 0 PWL(0.0n 0.4745 599.5n 0.4745 600.0n 0.5052 1199.5n 0.5052 1200.0n 0.4544 1799.5n 0.4544 1800.0n 0.4971 2399.5n 0.4971 2400.0n 0.4661 2999.5n 0.4661 3000.0n 0.5429 3599.5n 0.5429 3600.0n 0.5059 4199.5n 0.5059 4200.0n 0.4763 4799.5n 0.4763 4800.0n 0.4655 5399.5n 0.4655 5400.0n 0.5014 5999.5n 0.5014 6000.0n 0.4983 6599.5n 0.4983 6600.0n 0.4692 7199.5n 0.4692 7200.0n 0.5609 7799.5n 0.5609 7800.0n 0.5819 8399.5n 0.5819 8400.0n 0.6120 8999.5n 0.6120 9000.0n 0.5842 9599.5n 0.5842 9600.0n 0.5946 10199.5n 0.5946 10200.0n 0.5706 10799.5n 0.5706 10800.0n 0.5557 11399.5n 0.5557 11400.0n 0.5732 11999.5n 0.5732 12000.0n 0.6022 12599.5n 0.6022 12600.0n 0.5574 13199.5n 0.5574 13200.0n 0.5867 13799.5n 0.5867 13800.0n 0.5395 14399.5n 0.5395)
Vxn_who_10_0 xn_who_10_0 0 PWL(0.0n 0.5255 599.5n 0.5255 600.0n 0.4948 1199.5n 0.4948 1200.0n 0.5456 1799.5n 0.5456 1800.0n 0.5029 2399.5n 0.5029 2400.0n 0.5339 2999.5n 0.5339 3000.0n 0.4571 3599.5n 0.4571 3600.0n 0.4941 4199.5n 0.4941 4200.0n 0.5237 4799.5n 0.5237 4800.0n 0.5345 5399.5n 0.5345 5400.0n 0.4986 5999.5n 0.4986 6000.0n 0.5017 6599.5n 0.5017 6600.0n 0.5308 7199.5n 0.5308 7200.0n 0.4391 7799.5n 0.4391 7800.0n 0.4181 8399.5n 0.4181 8400.0n 0.3880 8999.5n 0.3880 9000.0n 0.4158 9599.5n 0.4158 9600.0n 0.4054 10199.5n 0.4054 10200.0n 0.4294 10799.5n 0.4294 10800.0n 0.4443 11399.5n 0.4443 11400.0n 0.4268 11999.5n 0.4268 12000.0n 0.3978 12599.5n 0.3978 12600.0n 0.4426 13199.5n 0.4426 13200.0n 0.4133 13799.5n 0.4133 13800.0n 0.4605 14399.5n 0.4605)
Vyp_who_10_0 yp_who_10_0 0 PWL(0.0n 0.5073 599.5n 0.5073 600.0n 0.5065 1199.5n 0.5065 1200.0n 0.5065 1799.5n 0.5065 1800.0n 0.5052 2399.5n 0.5052 2400.0n 0.5058 2999.5n 0.5058 3000.0n 0.5039 3599.5n 0.5039 3600.0n 0.5059 4199.5n 0.5059 4200.0n 0.5077 4799.5n 0.5077 4800.0n 0.5054 5399.5n 0.5054 5400.0n 0.5066 5999.5n 0.5066 6000.0n 0.5083 6599.5n 0.5083 6600.0n 0.5078 7199.5n 0.5078 7200.0n 0.5043 7799.5n 0.5043 7800.0n 0.5035 8399.5n 0.5035 8400.0n 0.5035 8999.5n 0.5035 9000.0n 0.5038 9599.5n 0.5038 9600.0n 0.5043 10199.5n 0.5043 10200.0n 0.5053 10799.5n 0.5053 10800.0n 0.5050 11399.5n 0.5050 11400.0n 0.5055 11999.5n 0.5055 12000.0n 0.5043 12599.5n 0.5043 12600.0n 0.5028 13199.5n 0.5028 13200.0n 0.5045 13799.5n 0.5045 13800.0n 0.5043 14399.5n 0.5043)
Vyn_who_10_0 yn_who_10_0 0 PWL(0.0n 0.4927 599.5n 0.4927 600.0n 0.4935 1199.5n 0.4935 1200.0n 0.4935 1799.5n 0.4935 1800.0n 0.4948 2399.5n 0.4948 2400.0n 0.4942 2999.5n 0.4942 3000.0n 0.4961 3599.5n 0.4961 3600.0n 0.4941 4199.5n 0.4941 4200.0n 0.4923 4799.5n 0.4923 4800.0n 0.4946 5399.5n 0.4946 5400.0n 0.4934 5999.5n 0.4934 6000.0n 0.4917 6599.5n 0.4917 6600.0n 0.4922 7199.5n 0.4922 7200.0n 0.4957 7799.5n 0.4957 7800.0n 0.4965 8399.5n 0.4965 8400.0n 0.4965 8999.5n 0.4965 9000.0n 0.4962 9599.5n 0.4962 9600.0n 0.4957 10199.5n 0.4957 10200.0n 0.4947 10799.5n 0.4947 10800.0n 0.4950 11399.5n 0.4950 11400.0n 0.4945 11999.5n 0.4945 12000.0n 0.4957 12599.5n 0.4957 12600.0n 0.4972 13199.5n 0.4972 13200.0n 0.4955 13799.5n 0.4955 13800.0n 0.4957 14399.5n 0.4957)
Cwp_who_10_0 wp_who_10_0 0 400p
Cwn_who_10_0 wn_who_10_0 0 400p
Xu_who_10_0 xp_who_10_0 xn_who_10_0 yp_who_10_0 yn_who_10_0 wp_who_10_0 wn_who_10_0 vdd gbn gprod
Vxp_who_10_1 xp_who_10_1 0 PWL(0.0n 0.4745 599.5n 0.4745 600.0n 0.5052 1199.5n 0.5052 1200.0n 0.4544 1799.5n 0.4544 1800.0n 0.4971 2399.5n 0.4971 2400.0n 0.4661 2999.5n 0.4661 3000.0n 0.5429 3599.5n 0.5429 3600.0n 0.5059 4199.5n 0.5059 4200.0n 0.4763 4799.5n 0.4763 4800.0n 0.4655 5399.5n 0.4655 5400.0n 0.5014 5999.5n 0.5014 6000.0n 0.4983 6599.5n 0.4983 6600.0n 0.4692 7199.5n 0.4692 7200.0n 0.5609 7799.5n 0.5609 7800.0n 0.5819 8399.5n 0.5819 8400.0n 0.6120 8999.5n 0.6120 9000.0n 0.5842 9599.5n 0.5842 9600.0n 0.5946 10199.5n 0.5946 10200.0n 0.5706 10799.5n 0.5706 10800.0n 0.5557 11399.5n 0.5557 11400.0n 0.5732 11999.5n 0.5732 12000.0n 0.6022 12599.5n 0.6022 12600.0n 0.5574 13199.5n 0.5574 13200.0n 0.5867 13799.5n 0.5867 13800.0n 0.5395 14399.5n 0.5395)
Vxn_who_10_1 xn_who_10_1 0 PWL(0.0n 0.5255 599.5n 0.5255 600.0n 0.4948 1199.5n 0.4948 1200.0n 0.5456 1799.5n 0.5456 1800.0n 0.5029 2399.5n 0.5029 2400.0n 0.5339 2999.5n 0.5339 3000.0n 0.4571 3599.5n 0.4571 3600.0n 0.4941 4199.5n 0.4941 4200.0n 0.5237 4799.5n 0.5237 4800.0n 0.5345 5399.5n 0.5345 5400.0n 0.4986 5999.5n 0.4986 6000.0n 0.5017 6599.5n 0.5017 6600.0n 0.5308 7199.5n 0.5308 7200.0n 0.4391 7799.5n 0.4391 7800.0n 0.4181 8399.5n 0.4181 8400.0n 0.3880 8999.5n 0.3880 9000.0n 0.4158 9599.5n 0.4158 9600.0n 0.4054 10199.5n 0.4054 10200.0n 0.4294 10799.5n 0.4294 10800.0n 0.4443 11399.5n 0.4443 11400.0n 0.4268 11999.5n 0.4268 12000.0n 0.3978 12599.5n 0.3978 12600.0n 0.4426 13199.5n 0.4426 13200.0n 0.4133 13799.5n 0.4133 13800.0n 0.4605 14399.5n 0.4605)
Vyp_who_10_1 yp_who_10_1 0 PWL(0.0n 0.4909 599.5n 0.4909 600.0n 0.4933 1199.5n 0.4933 1200.0n 0.4930 1799.5n 0.4930 1800.0n 0.4893 2399.5n 0.4893 2400.0n 0.4904 2999.5n 0.4904 3000.0n 0.4923 3599.5n 0.4923 3600.0n 0.4897 4199.5n 0.4897 4200.0n 0.4890 4799.5n 0.4890 4800.0n 0.4921 5399.5n 0.4921 5400.0n 0.4899 5999.5n 0.4899 6000.0n 0.4870 6599.5n 0.4870 6600.0n 0.4903 7199.5n 0.4903 7200.0n 0.4970 7799.5n 0.4970 7800.0n 0.4989 8399.5n 0.4989 8400.0n 0.4994 8999.5n 0.4994 9000.0n 0.4991 9599.5n 0.4991 9600.0n 0.5000 10199.5n 0.5000 10200.0n 0.4948 10799.5n 0.4948 10800.0n 0.4959 11399.5n 0.4959 11400.0n 0.4926 11999.5n 0.4926 12000.0n 0.4993 12599.5n 0.4993 12600.0n 0.4862 13199.5n 0.4862 13200.0n 0.4993 13799.5n 0.4993 13800.0n 0.4961 14399.5n 0.4961)
Vyn_who_10_1 yn_who_10_1 0 PWL(0.0n 0.5091 599.5n 0.5091 600.0n 0.5067 1199.5n 0.5067 1200.0n 0.5070 1799.5n 0.5070 1800.0n 0.5107 2399.5n 0.5107 2400.0n 0.5096 2999.5n 0.5096 3000.0n 0.5077 3599.5n 0.5077 3600.0n 0.5103 4199.5n 0.5103 4200.0n 0.5110 4799.5n 0.5110 4800.0n 0.5079 5399.5n 0.5079 5400.0n 0.5101 5999.5n 0.5101 6000.0n 0.5130 6599.5n 0.5130 6600.0n 0.5097 7199.5n 0.5097 7200.0n 0.5030 7799.5n 0.5030 7800.0n 0.5011 8399.5n 0.5011 8400.0n 0.5006 8999.5n 0.5006 9000.0n 0.5009 9599.5n 0.5009 9600.0n 0.5000 10199.5n 0.5000 10200.0n 0.5052 10799.5n 0.5052 10800.0n 0.5041 11399.5n 0.5041 11400.0n 0.5074 11999.5n 0.5074 12000.0n 0.5007 12599.5n 0.5007 12600.0n 0.5138 13199.5n 0.5138 13200.0n 0.5007 13799.5n 0.5007 13800.0n 0.5039 14399.5n 0.5039)
Cwp_who_10_1 wp_who_10_1 0 400p
Cwn_who_10_1 wn_who_10_1 0 400p
Xu_who_10_1 xp_who_10_1 xn_who_10_1 yp_who_10_1 yn_who_10_1 wp_who_10_1 wn_who_10_1 vdd gbn gprod
Vxp_bh_10 xp_bh_10 0 PWL(0.0n 0.7100 599.5n 0.7100 600.0n 0.7100 1199.5n 0.7100 1200.0n 0.7100 1799.5n 0.7100 1800.0n 0.7100 2399.5n 0.7100 2400.0n 0.7100 2999.5n 0.7100 3000.0n 0.7100 3599.5n 0.7100 3600.0n 0.7100 4199.5n 0.7100 4200.0n 0.7100 4799.5n 0.7100 4800.0n 0.7100 5399.5n 0.7100 5400.0n 0.7100 5999.5n 0.7100 6000.0n 0.7100 6599.5n 0.7100 6600.0n 0.7100 7199.5n 0.7100 7200.0n 0.7100 7799.5n 0.7100 7800.0n 0.7100 8399.5n 0.7100 8400.0n 0.7100 8999.5n 0.7100 9000.0n 0.7100 9599.5n 0.7100 9600.0n 0.7100 10199.5n 0.7100 10200.0n 0.7100 10799.5n 0.7100 10800.0n 0.7100 11399.5n 0.7100 11400.0n 0.7100 11999.5n 0.7100 12000.0n 0.7100 12599.5n 0.7100 12600.0n 0.7100 13199.5n 0.7100 13200.0n 0.7100 13799.5n 0.7100 13800.0n 0.7100 14399.5n 0.7100)
Vxn_bh_10 xn_bh_10 0 PWL(0.0n 0.2900 599.5n 0.2900 600.0n 0.2900 1199.5n 0.2900 1200.0n 0.2900 1799.5n 0.2900 1800.0n 0.2900 2399.5n 0.2900 2400.0n 0.2900 2999.5n 0.2900 3000.0n 0.2900 3599.5n 0.2900 3600.0n 0.2900 4199.5n 0.2900 4200.0n 0.2900 4799.5n 0.2900 4800.0n 0.2900 5399.5n 0.2900 5400.0n 0.2900 5999.5n 0.2900 6000.0n 0.2900 6599.5n 0.2900 6600.0n 0.2900 7199.5n 0.2900 7200.0n 0.2900 7799.5n 0.2900 7800.0n 0.2900 8399.5n 0.2900 8400.0n 0.2900 8999.5n 0.2900 9000.0n 0.2900 9599.5n 0.2900 9600.0n 0.2900 10199.5n 0.2900 10200.0n 0.2900 10799.5n 0.2900 10800.0n 0.2900 11399.5n 0.2900 11400.0n 0.2900 11999.5n 0.2900 12000.0n 0.2900 12599.5n 0.2900 12600.0n 0.2900 13199.5n 0.2900 13200.0n 0.2900 13799.5n 0.2900 13800.0n 0.2900 14399.5n 0.2900)
Vyp_bh_10 yp_bh_10 0 PWL(0.0n 0.4745 599.5n 0.4745 600.0n 0.5052 1199.5n 0.5052 1200.0n 0.4544 1799.5n 0.4544 1800.0n 0.4971 2399.5n 0.4971 2400.0n 0.4661 2999.5n 0.4661 3000.0n 0.5429 3599.5n 0.5429 3600.0n 0.5059 4199.5n 0.5059 4200.0n 0.4763 4799.5n 0.4763 4800.0n 0.4655 5399.5n 0.4655 5400.0n 0.5014 5999.5n 0.5014 6000.0n 0.4983 6599.5n 0.4983 6600.0n 0.4692 7199.5n 0.4692 7200.0n 0.5609 7799.5n 0.5609 7800.0n 0.5819 8399.5n 0.5819 8400.0n 0.6120 8999.5n 0.6120 9000.0n 0.5842 9599.5n 0.5842 9600.0n 0.5946 10199.5n 0.5946 10200.0n 0.5706 10799.5n 0.5706 10800.0n 0.5557 11399.5n 0.5557 11400.0n 0.5732 11999.5n 0.5732 12000.0n 0.6022 12599.5n 0.6022 12600.0n 0.5574 13199.5n 0.5574 13200.0n 0.5867 13799.5n 0.5867 13800.0n 0.5395 14399.5n 0.5395)
Vyn_bh_10 yn_bh_10 0 PWL(0.0n 0.5255 599.5n 0.5255 600.0n 0.4948 1199.5n 0.4948 1200.0n 0.5456 1799.5n 0.5456 1800.0n 0.5029 2399.5n 0.5029 2400.0n 0.5339 2999.5n 0.5339 3000.0n 0.4571 3599.5n 0.4571 3600.0n 0.4941 4199.5n 0.4941 4200.0n 0.5237 4799.5n 0.5237 4800.0n 0.5345 5399.5n 0.5345 5400.0n 0.4986 5999.5n 0.4986 6000.0n 0.5017 6599.5n 0.5017 6600.0n 0.5308 7199.5n 0.5308 7200.0n 0.4391 7799.5n 0.4391 7800.0n 0.4181 8399.5n 0.4181 8400.0n 0.3880 8999.5n 0.3880 9000.0n 0.4158 9599.5n 0.4158 9600.0n 0.4054 10199.5n 0.4054 10200.0n 0.4294 10799.5n 0.4294 10800.0n 0.4443 11399.5n 0.4443 11400.0n 0.4268 11999.5n 0.4268 12000.0n 0.3978 12599.5n 0.3978 12600.0n 0.4426 13199.5n 0.4426 13200.0n 0.4133 13799.5n 0.4133 13800.0n 0.4605 14399.5n 0.4605)
Cwp_bh_10 wp_bh_10 0 400p
Cwn_bh_10 wn_bh_10 0 400p
Xu_bh_10 xp_bh_10 xn_bh_10 yp_bh_10 yn_bh_10 wp_bh_10 wn_bh_10 vdd gbn gprod
Vxp_wih_8_11 xp_wih_8_11 0 PWL(0.0n 0.4390 599.5n 0.4390 600.0n 0.4386 1199.5n 0.4386 1200.0n 0.4513 1799.5n 0.4513 1800.0n 0.4236 2399.5n 0.4236 2400.0n 0.4475 2999.5n 0.4475 3000.0n 0.4041 3599.5n 0.4041 3600.0n 0.4178 4199.5n 0.4178 4200.0n 0.4452 4799.5n 0.4452 4800.0n 0.4587 5399.5n 0.4587 5400.0n 0.4267 5999.5n 0.4267 6000.0n 0.4212 6599.5n 0.4212 6600.0n 0.4475 7199.5n 0.4475 7200.0n 0.3950 7799.5n 0.3950 7800.0n 0.3950 8399.5n 0.3950 8400.0n 0.4122 8999.5n 0.4122 9000.0n 0.3950 9599.5n 0.3950 9600.0n 0.4081 10199.5n 0.4081 10200.0n 0.3950 10799.5n 0.3950 10800.0n 0.3950 11399.5n 0.3950 11400.0n 0.3984 11999.5n 0.3984 12000.0n 0.4217 12599.5n 0.4217 12600.0n 0.3950 13199.5n 0.3950 13200.0n 0.3950 13799.5n 0.3950 13800.0n 0.4085 14399.5n 0.4085)
Vxn_wih_8_11 xn_wih_8_11 0 PWL(0.0n 0.5610 599.5n 0.5610 600.0n 0.5614 1199.5n 0.5614 1200.0n 0.5487 1799.5n 0.5487 1800.0n 0.5764 2399.5n 0.5764 2400.0n 0.5525 2999.5n 0.5525 3000.0n 0.5959 3599.5n 0.5959 3600.0n 0.5822 4199.5n 0.5822 4200.0n 0.5548 4799.5n 0.5548 4800.0n 0.5413 5399.5n 0.5413 5400.0n 0.5733 5999.5n 0.5733 6000.0n 0.5788 6599.5n 0.5788 6600.0n 0.5525 7199.5n 0.5525 7200.0n 0.6050 7799.5n 0.6050 7800.0n 0.6050 8399.5n 0.6050 8400.0n 0.5878 8999.5n 0.5878 9000.0n 0.6050 9599.5n 0.6050 9600.0n 0.5919 10199.5n 0.5919 10200.0n 0.6050 10799.5n 0.6050 10800.0n 0.6050 11399.5n 0.6050 11400.0n 0.6016 11999.5n 0.6016 12000.0n 0.5783 12599.5n 0.5783 12600.0n 0.6050 13199.5n 0.6050 13200.0n 0.6050 13799.5n 0.6050 13800.0n 0.5915 14399.5n 0.5915)
Vyp_wih_8_11 yp_wih_8_11 0 PWL(0.0n 0.4468 599.5n 0.4468 600.0n 0.4816 1199.5n 0.4816 1200.0n 0.4648 1799.5n 0.4648 1800.0n 0.4326 2399.5n 0.4326 2400.0n 0.4612 2999.5n 0.4612 3000.0n 0.4548 3599.5n 0.4548 3600.0n 0.4279 4199.5n 0.4279 4200.0n 0.4627 4799.5n 0.4627 4800.0n 0.4912 5399.5n 0.4912 5400.0n 0.4382 5999.5n 0.4382 6000.0n 0.4272 6599.5n 0.4272 6600.0n 0.4640 7199.5n 0.4640 7200.0n 0.4720 7799.5n 0.4720 7800.0n 0.5142 8399.5n 0.5142 8400.0n 0.5378 8999.5n 0.5378 9000.0n 0.5170 9599.5n 0.5170 9600.0n 0.5290 10199.5n 0.5290 10200.0n 0.4866 10799.5n 0.4866 10800.0n 0.4542 11399.5n 0.4542 11400.0n 0.4707 11999.5n 0.4707 12000.0n 0.5443 12599.5n 0.5443 12600.0n 0.4518 13199.5n 0.4518 13200.0n 0.5089 13799.5n 0.5089 13800.0n 0.4476 14399.5n 0.4476)
Vyn_wih_8_11 yn_wih_8_11 0 PWL(0.0n 0.5532 599.5n 0.5532 600.0n 0.5184 1199.5n 0.5184 1200.0n 0.5352 1799.5n 0.5352 1800.0n 0.5674 2399.5n 0.5674 2400.0n 0.5388 2999.5n 0.5388 3000.0n 0.5452 3599.5n 0.5452 3600.0n 0.5721 4199.5n 0.5721 4200.0n 0.5373 4799.5n 0.5373 4800.0n 0.5088 5399.5n 0.5088 5400.0n 0.5618 5999.5n 0.5618 6000.0n 0.5728 6599.5n 0.5728 6600.0n 0.5360 7199.5n 0.5360 7200.0n 0.5280 7799.5n 0.5280 7800.0n 0.4858 8399.5n 0.4858 8400.0n 0.4622 8999.5n 0.4622 9000.0n 0.4830 9599.5n 0.4830 9600.0n 0.4710 10199.5n 0.4710 10200.0n 0.5134 10799.5n 0.5134 10800.0n 0.5458 11399.5n 0.5458 11400.0n 0.5293 11999.5n 0.5293 12000.0n 0.4557 12599.5n 0.4557 12600.0n 0.5482 13199.5n 0.5482 13200.0n 0.4911 13799.5n 0.4911 13800.0n 0.5524 14399.5n 0.5524)
Cwp_wih_8_11 wp_wih_8_11 0 400p
Cwn_wih_8_11 wn_wih_8_11 0 400p
Xu_wih_8_11 xp_wih_8_11 xn_wih_8_11 yp_wih_8_11 yn_wih_8_11 wp_wih_8_11 wn_wih_8_11 vdd gbn gprod
Vxp_wih_9_11 xp_wih_9_11 0 PWL(0.0n 0.5317 599.5n 0.5317 600.0n 0.4980 1199.5n 0.4980 1200.0n 0.5026 1799.5n 0.5026 1800.0n 0.5048 2399.5n 0.5048 2400.0n 0.5191 2999.5n 0.5191 3000.0n 0.5365 3599.5n 0.5365 3600.0n 0.5457 4199.5n 0.5457 4200.0n 0.5457 4799.5n 0.5457 4800.0n 0.5000 5399.5n 0.5000 5400.0n 0.5575 5999.5n 0.5575 6000.0n 0.5000 6599.5n 0.5000 6600.0n 0.5334 7199.5n 0.5334 7200.0n 0.5268 7799.5n 0.5268 7800.0n 0.3950 8399.5n 0.3950 8400.0n 0.5671 8999.5n 0.5671 9000.0n 0.3950 9599.5n 0.3950 9600.0n 0.4573 10199.5n 0.4573 10200.0n 0.4572 10799.5n 0.4572 10800.0n 0.5996 11399.5n 0.5996 11400.0n 0.6050 11999.5n 0.6050 12000.0n 0.5515 12599.5n 0.5515 12600.0n 0.5587 13199.5n 0.5587 13200.0n 0.4550 13799.5n 0.4550 13800.0n 0.6050 14399.5n 0.6050)
Vxn_wih_9_11 xn_wih_9_11 0 PWL(0.0n 0.4683 599.5n 0.4683 600.0n 0.5020 1199.5n 0.5020 1200.0n 0.4974 1799.5n 0.4974 1800.0n 0.4952 2399.5n 0.4952 2400.0n 0.4809 2999.5n 0.4809 3000.0n 0.4635 3599.5n 0.4635 3600.0n 0.4543 4199.5n 0.4543 4200.0n 0.4543 4799.5n 0.4543 4800.0n 0.5000 5399.5n 0.5000 5400.0n 0.4425 5999.5n 0.4425 6000.0n 0.5000 6599.5n 0.5000 6600.0n 0.4666 7199.5n 0.4666 7200.0n 0.4732 7799.5n 0.4732 7800.0n 0.6050 8399.5n 0.6050 8400.0n 0.4329 8999.5n 0.4329 9000.0n 0.6050 9599.5n 0.6050 9600.0n 0.5427 10199.5n 0.5427 10200.0n 0.5428 10799.5n 0.5428 10800.0n 0.4004 11399.5n 0.4004 11400.0n 0.3950 11999.5n 0.3950 12000.0n 0.4485 12599.5n 0.4485 12600.0n 0.4413 13199.5n 0.4413 13200.0n 0.5450 13799.5n 0.5450 13800.0n 0.3950 14399.5n 0.3950)
Vyp_wih_9_11 yp_wih_9_11 0 PWL(0.0n 0.4468 599.5n 0.4468 600.0n 0.4816 1199.5n 0.4816 1200.0n 0.4648 1799.5n 0.4648 1800.0n 0.4326 2399.5n 0.4326 2400.0n 0.4612 2999.5n 0.4612 3000.0n 0.4548 3599.5n 0.4548 3600.0n 0.4279 4199.5n 0.4279 4200.0n 0.4627 4799.5n 0.4627 4800.0n 0.4912 5399.5n 0.4912 5400.0n 0.4382 5999.5n 0.4382 6000.0n 0.4272 6599.5n 0.4272 6600.0n 0.4640 7199.5n 0.4640 7200.0n 0.4720 7799.5n 0.4720 7800.0n 0.5142 8399.5n 0.5142 8400.0n 0.5378 8999.5n 0.5378 9000.0n 0.5170 9599.5n 0.5170 9600.0n 0.5290 10199.5n 0.5290 10200.0n 0.4866 10799.5n 0.4866 10800.0n 0.4542 11399.5n 0.4542 11400.0n 0.4707 11999.5n 0.4707 12000.0n 0.5443 12599.5n 0.5443 12600.0n 0.4518 13199.5n 0.4518 13200.0n 0.5089 13799.5n 0.5089 13800.0n 0.4476 14399.5n 0.4476)
Vyn_wih_9_11 yn_wih_9_11 0 PWL(0.0n 0.5532 599.5n 0.5532 600.0n 0.5184 1199.5n 0.5184 1200.0n 0.5352 1799.5n 0.5352 1800.0n 0.5674 2399.5n 0.5674 2400.0n 0.5388 2999.5n 0.5388 3000.0n 0.5452 3599.5n 0.5452 3600.0n 0.5721 4199.5n 0.5721 4200.0n 0.5373 4799.5n 0.5373 4800.0n 0.5088 5399.5n 0.5088 5400.0n 0.5618 5999.5n 0.5618 6000.0n 0.5728 6599.5n 0.5728 6600.0n 0.5360 7199.5n 0.5360 7200.0n 0.5280 7799.5n 0.5280 7800.0n 0.4858 8399.5n 0.4858 8400.0n 0.4622 8999.5n 0.4622 9000.0n 0.4830 9599.5n 0.4830 9600.0n 0.4710 10199.5n 0.4710 10200.0n 0.5134 10799.5n 0.5134 10800.0n 0.5458 11399.5n 0.5458 11400.0n 0.5293 11999.5n 0.5293 12000.0n 0.4557 12599.5n 0.4557 12600.0n 0.5482 13199.5n 0.5482 13200.0n 0.4911 13799.5n 0.4911 13800.0n 0.5524 14399.5n 0.5524)
Cwp_wih_9_11 wp_wih_9_11 0 400p
Cwn_wih_9_11 wn_wih_9_11 0 400p
Xu_wih_9_11 xp_wih_9_11 xn_wih_9_11 yp_wih_9_11 yn_wih_9_11 wp_wih_9_11 wn_wih_9_11 vdd gbn gprod
Vxp_wih_12_11 xp_wih_12_11 0 PWL(0.0n 0.3950 599.5n 0.3950 600.0n 0.4029 1199.5n 0.4029 1200.0n 0.3950 1799.5n 0.3950 1800.0n 0.3950 2399.5n 0.3950 2400.0n 0.4093 2999.5n 0.4093 3000.0n 0.3950 3599.5n 0.3950 3600.0n 0.3950 4199.5n 0.3950 4200.0n 0.3950 4799.5n 0.3950 4800.0n 0.3950 5399.5n 0.3950 5400.0n 0.3950 5999.5n 0.3950 6000.0n 0.3950 6599.5n 0.3950 6600.0n 0.3998 7199.5n 0.3998 7200.0n 0.3950 7799.5n 0.3950 7800.0n 0.3950 8399.5n 0.3950 8400.0n 0.3950 8999.5n 0.3950 9000.0n 0.3950 9599.5n 0.3950 9600.0n 0.3950 10199.5n 0.3950 10200.0n 0.3950 10799.5n 0.3950 10800.0n 0.3950 11399.5n 0.3950 11400.0n 0.3950 11999.5n 0.3950 12000.0n 0.3950 12599.5n 0.3950 12600.0n 0.3950 13199.5n 0.3950 13200.0n 0.3950 13799.5n 0.3950 13800.0n 0.4052 14399.5n 0.4052)
Vxn_wih_12_11 xn_wih_12_11 0 PWL(0.0n 0.6050 599.5n 0.6050 600.0n 0.5971 1199.5n 0.5971 1200.0n 0.6050 1799.5n 0.6050 1800.0n 0.6050 2399.5n 0.6050 2400.0n 0.5907 2999.5n 0.5907 3000.0n 0.6050 3599.5n 0.6050 3600.0n 0.6050 4199.5n 0.6050 4200.0n 0.6050 4799.5n 0.6050 4800.0n 0.6050 5399.5n 0.6050 5400.0n 0.6050 5999.5n 0.6050 6000.0n 0.6050 6599.5n 0.6050 6600.0n 0.6002 7199.5n 0.6002 7200.0n 0.6050 7799.5n 0.6050 7800.0n 0.6050 8399.5n 0.6050 8400.0n 0.6050 8999.5n 0.6050 9000.0n 0.6050 9599.5n 0.6050 9600.0n 0.6050 10199.5n 0.6050 10200.0n 0.6050 10799.5n 0.6050 10800.0n 0.6050 11399.5n 0.6050 11400.0n 0.6050 11999.5n 0.6050 12000.0n 0.6050 12599.5n 0.6050 12600.0n 0.6050 13199.5n 0.6050 13200.0n 0.6050 13799.5n 0.6050 13800.0n 0.5948 14399.5n 0.5948)
Vyp_wih_12_11 yp_wih_12_11 0 PWL(0.0n 0.4468 599.5n 0.4468 600.0n 0.4816 1199.5n 0.4816 1200.0n 0.4648 1799.5n 0.4648 1800.0n 0.4326 2399.5n 0.4326 2400.0n 0.4612 2999.5n 0.4612 3000.0n 0.4548 3599.5n 0.4548 3600.0n 0.4279 4199.5n 0.4279 4200.0n 0.4627 4799.5n 0.4627 4800.0n 0.4912 5399.5n 0.4912 5400.0n 0.4382 5999.5n 0.4382 6000.0n 0.4272 6599.5n 0.4272 6600.0n 0.4640 7199.5n 0.4640 7200.0n 0.4720 7799.5n 0.4720 7800.0n 0.5142 8399.5n 0.5142 8400.0n 0.5378 8999.5n 0.5378 9000.0n 0.5170 9599.5n 0.5170 9600.0n 0.5290 10199.5n 0.5290 10200.0n 0.4866 10799.5n 0.4866 10800.0n 0.4542 11399.5n 0.4542 11400.0n 0.4707 11999.5n 0.4707 12000.0n 0.5443 12599.5n 0.5443 12600.0n 0.4518 13199.5n 0.4518 13200.0n 0.5089 13799.5n 0.5089 13800.0n 0.4476 14399.5n 0.4476)
Vyn_wih_12_11 yn_wih_12_11 0 PWL(0.0n 0.5532 599.5n 0.5532 600.0n 0.5184 1199.5n 0.5184 1200.0n 0.5352 1799.5n 0.5352 1800.0n 0.5674 2399.5n 0.5674 2400.0n 0.5388 2999.5n 0.5388 3000.0n 0.5452 3599.5n 0.5452 3600.0n 0.5721 4199.5n 0.5721 4200.0n 0.5373 4799.5n 0.5373 4800.0n 0.5088 5399.5n 0.5088 5400.0n 0.5618 5999.5n 0.5618 6000.0n 0.5728 6599.5n 0.5728 6600.0n 0.5360 7199.5n 0.5360 7200.0n 0.5280 7799.5n 0.5280 7800.0n 0.4858 8399.5n 0.4858 8400.0n 0.4622 8999.5n 0.4622 9000.0n 0.4830 9599.5n 0.4830 9600.0n 0.4710 10199.5n 0.4710 10200.0n 0.5134 10799.5n 0.5134 10800.0n 0.5458 11399.5n 0.5458 11400.0n 0.5293 11999.5n 0.5293 12000.0n 0.4557 12599.5n 0.4557 12600.0n 0.5482 13199.5n 0.5482 13200.0n 0.4911 13799.5n 0.4911 13800.0n 0.5524 14399.5n 0.5524)
Cwp_wih_12_11 wp_wih_12_11 0 400p
Cwn_wih_12_11 wn_wih_12_11 0 400p
Xu_wih_12_11 xp_wih_12_11 xn_wih_12_11 yp_wih_12_11 yn_wih_12_11 wp_wih_12_11 wn_wih_12_11 vdd gbn gprod
Vxp_wih_13_11 xp_wih_13_11 0 PWL(0.0n 0.6050 599.5n 0.6050 600.0n 0.5495 1199.5n 0.5495 1200.0n 0.6050 1799.5n 0.6050 1800.0n 0.5811 2399.5n 0.5811 2400.0n 0.6050 2999.5n 0.6050 3000.0n 0.5411 3599.5n 0.5411 3600.0n 0.5867 4199.5n 0.5867 4200.0n 0.5822 4799.5n 0.5822 4800.0n 0.5675 5399.5n 0.5675 5400.0n 0.5852 5999.5n 0.5852 6000.0n 0.5831 6599.5n 0.5831 6600.0n 0.5907 7199.5n 0.5907 7200.0n 0.4938 7799.5n 0.4938 7800.0n 0.4048 8399.5n 0.4048 8400.0n 0.3984 8999.5n 0.3984 9000.0n 0.3950 9599.5n 0.3950 9600.0n 0.3983 10199.5n 0.3983 10200.0n 0.4494 10799.5n 0.4494 10800.0n 0.5512 11399.5n 0.5512 11400.0n 0.5135 11999.5n 0.5135 12000.0n 0.3950 12599.5n 0.3950 12600.0n 0.5338 13199.5n 0.5338 13200.0n 0.4283 13799.5n 0.4283 13800.0n 0.5677 14399.5n 0.5677)
Vxn_wih_13_11 xn_wih_13_11 0 PWL(0.0n 0.3950 599.5n 0.3950 600.0n 0.4505 1199.5n 0.4505 1200.0n 0.3950 1799.5n 0.3950 1800.0n 0.4189 2399.5n 0.4189 2400.0n 0.3950 2999.5n 0.3950 3000.0n 0.4589 3599.5n 0.4589 3600.0n 0.4133 4199.5n 0.4133 4200.0n 0.4178 4799.5n 0.4178 4800.0n 0.4325 5399.5n 0.4325 5400.0n 0.4148 5999.5n 0.4148 6000.0n 0.4169 6599.5n 0.4169 6600.0n 0.4093 7199.5n 0.4093 7200.0n 0.5062 7799.5n 0.5062 7800.0n 0.5952 8399.5n 0.5952 8400.0n 0.6016 8999.5n 0.6016 9000.0n 0.6050 9599.5n 0.6050 9600.0n 0.6017 10199.5n 0.6017 10200.0n 0.5506 10799.5n 0.5506 10800.0n 0.4488 11399.5n 0.4488 11400.0n 0.4865 11999.5n 0.4865 12000.0n 0.6050 12599.5n 0.6050 12600.0n 0.4662 13199.5n 0.4662 13200.0n 0.5717 13799.5n 0.5717 13800.0n 0.4323 14399.5n 0.4323)
Vyp_wih_13_11 yp_wih_13_11 0 PWL(0.0n 0.4468 599.5n 0.4468 600.0n 0.4816 1199.5n 0.4816 1200.0n 0.4648 1799.5n 0.4648 1800.0n 0.4326 2399.5n 0.4326 2400.0n 0.4612 2999.5n 0.4612 3000.0n 0.4548 3599.5n 0.4548 3600.0n 0.4279 4199.5n 0.4279 4200.0n 0.4627 4799.5n 0.4627 4800.0n 0.4912 5399.5n 0.4912 5400.0n 0.4382 5999.5n 0.4382 6000.0n 0.4272 6599.5n 0.4272 6600.0n 0.4640 7199.5n 0.4640 7200.0n 0.4720 7799.5n 0.4720 7800.0n 0.5142 8399.5n 0.5142 8400.0n 0.5378 8999.5n 0.5378 9000.0n 0.5170 9599.5n 0.5170 9600.0n 0.5290 10199.5n 0.5290 10200.0n 0.4866 10799.5n 0.4866 10800.0n 0.4542 11399.5n 0.4542 11400.0n 0.4707 11999.5n 0.4707 12000.0n 0.5443 12599.5n 0.5443 12600.0n 0.4518 13199.5n 0.4518 13200.0n 0.5089 13799.5n 0.5089 13800.0n 0.4476 14399.5n 0.4476)
Vyn_wih_13_11 yn_wih_13_11 0 PWL(0.0n 0.5532 599.5n 0.5532 600.0n 0.5184 1199.5n 0.5184 1200.0n 0.5352 1799.5n 0.5352 1800.0n 0.5674 2399.5n 0.5674 2400.0n 0.5388 2999.5n 0.5388 3000.0n 0.5452 3599.5n 0.5452 3600.0n 0.5721 4199.5n 0.5721 4200.0n 0.5373 4799.5n 0.5373 4800.0n 0.5088 5399.5n 0.5088 5400.0n 0.5618 5999.5n 0.5618 6000.0n 0.5728 6599.5n 0.5728 6600.0n 0.5360 7199.5n 0.5360 7200.0n 0.5280 7799.5n 0.5280 7800.0n 0.4858 8399.5n 0.4858 8400.0n 0.4622 8999.5n 0.4622 9000.0n 0.4830 9599.5n 0.4830 9600.0n 0.4710 10199.5n 0.4710 10200.0n 0.5134 10799.5n 0.5134 10800.0n 0.5458 11399.5n 0.5458 11400.0n 0.5293 11999.5n 0.5293 12000.0n 0.4557 12599.5n 0.4557 12600.0n 0.5482 13199.5n 0.5482 13200.0n 0.4911 13799.5n 0.4911 13800.0n 0.5524 14399.5n 0.5524)
Cwp_wih_13_11 wp_wih_13_11 0 400p
Cwn_wih_13_11 wn_wih_13_11 0 400p
Xu_wih_13_11 xp_wih_13_11 xn_wih_13_11 yp_wih_13_11 yn_wih_13_11 wp_wih_13_11 wn_wih_13_11 vdd gbn gprod
Vxp_who_11_0 xp_who_11_0 0 PWL(0.0n 0.4468 599.5n 0.4468 600.0n 0.4816 1199.5n 0.4816 1200.0n 0.4648 1799.5n 0.4648 1800.0n 0.4326 2399.5n 0.4326 2400.0n 0.4612 2999.5n 0.4612 3000.0n 0.4548 3599.5n 0.4548 3600.0n 0.4279 4199.5n 0.4279 4200.0n 0.4627 4799.5n 0.4627 4800.0n 0.4912 5399.5n 0.4912 5400.0n 0.4382 5999.5n 0.4382 6000.0n 0.4272 6599.5n 0.4272 6600.0n 0.4640 7199.5n 0.4640 7200.0n 0.4720 7799.5n 0.4720 7800.0n 0.5142 8399.5n 0.5142 8400.0n 0.5378 8999.5n 0.5378 9000.0n 0.5170 9599.5n 0.5170 9600.0n 0.5290 10199.5n 0.5290 10200.0n 0.4866 10799.5n 0.4866 10800.0n 0.4542 11399.5n 0.4542 11400.0n 0.4707 11999.5n 0.4707 12000.0n 0.5443 12599.5n 0.5443 12600.0n 0.4518 13199.5n 0.4518 13200.0n 0.5089 13799.5n 0.5089 13800.0n 0.4476 14399.5n 0.4476)
Vxn_who_11_0 xn_who_11_0 0 PWL(0.0n 0.5532 599.5n 0.5532 600.0n 0.5184 1199.5n 0.5184 1200.0n 0.5352 1799.5n 0.5352 1800.0n 0.5674 2399.5n 0.5674 2400.0n 0.5388 2999.5n 0.5388 3000.0n 0.5452 3599.5n 0.5452 3600.0n 0.5721 4199.5n 0.5721 4200.0n 0.5373 4799.5n 0.5373 4800.0n 0.5088 5399.5n 0.5088 5400.0n 0.5618 5999.5n 0.5618 6000.0n 0.5728 6599.5n 0.5728 6600.0n 0.5360 7199.5n 0.5360 7200.0n 0.5280 7799.5n 0.5280 7800.0n 0.4858 8399.5n 0.4858 8400.0n 0.4622 8999.5n 0.4622 9000.0n 0.4830 9599.5n 0.4830 9600.0n 0.4710 10199.5n 0.4710 10200.0n 0.5134 10799.5n 0.5134 10800.0n 0.5458 11399.5n 0.5458 11400.0n 0.5293 11999.5n 0.5293 12000.0n 0.4557 12599.5n 0.4557 12600.0n 0.5482 13199.5n 0.5482 13200.0n 0.4911 13799.5n 0.4911 13800.0n 0.5524 14399.5n 0.5524)
Vyp_who_11_0 yp_who_11_0 0 PWL(0.0n 0.5073 599.5n 0.5073 600.0n 0.5065 1199.5n 0.5065 1200.0n 0.5065 1799.5n 0.5065 1800.0n 0.5052 2399.5n 0.5052 2400.0n 0.5058 2999.5n 0.5058 3000.0n 0.5039 3599.5n 0.5039 3600.0n 0.5059 4199.5n 0.5059 4200.0n 0.5077 4799.5n 0.5077 4800.0n 0.5054 5399.5n 0.5054 5400.0n 0.5066 5999.5n 0.5066 6000.0n 0.5083 6599.5n 0.5083 6600.0n 0.5078 7199.5n 0.5078 7200.0n 0.5043 7799.5n 0.5043 7800.0n 0.5035 8399.5n 0.5035 8400.0n 0.5035 8999.5n 0.5035 9000.0n 0.5038 9599.5n 0.5038 9600.0n 0.5043 10199.5n 0.5043 10200.0n 0.5053 10799.5n 0.5053 10800.0n 0.5050 11399.5n 0.5050 11400.0n 0.5055 11999.5n 0.5055 12000.0n 0.5043 12599.5n 0.5043 12600.0n 0.5028 13199.5n 0.5028 13200.0n 0.5045 13799.5n 0.5045 13800.0n 0.5043 14399.5n 0.5043)
Vyn_who_11_0 yn_who_11_0 0 PWL(0.0n 0.4927 599.5n 0.4927 600.0n 0.4935 1199.5n 0.4935 1200.0n 0.4935 1799.5n 0.4935 1800.0n 0.4948 2399.5n 0.4948 2400.0n 0.4942 2999.5n 0.4942 3000.0n 0.4961 3599.5n 0.4961 3600.0n 0.4941 4199.5n 0.4941 4200.0n 0.4923 4799.5n 0.4923 4800.0n 0.4946 5399.5n 0.4946 5400.0n 0.4934 5999.5n 0.4934 6000.0n 0.4917 6599.5n 0.4917 6600.0n 0.4922 7199.5n 0.4922 7200.0n 0.4957 7799.5n 0.4957 7800.0n 0.4965 8399.5n 0.4965 8400.0n 0.4965 8999.5n 0.4965 9000.0n 0.4962 9599.5n 0.4962 9600.0n 0.4957 10199.5n 0.4957 10200.0n 0.4947 10799.5n 0.4947 10800.0n 0.4950 11399.5n 0.4950 11400.0n 0.4945 11999.5n 0.4945 12000.0n 0.4957 12599.5n 0.4957 12600.0n 0.4972 13199.5n 0.4972 13200.0n 0.4955 13799.5n 0.4955 13800.0n 0.4957 14399.5n 0.4957)
Cwp_who_11_0 wp_who_11_0 0 400p
Cwn_who_11_0 wn_who_11_0 0 400p
Xu_who_11_0 xp_who_11_0 xn_who_11_0 yp_who_11_0 yn_who_11_0 wp_who_11_0 wn_who_11_0 vdd gbn gprod
Vxp_who_11_1 xp_who_11_1 0 PWL(0.0n 0.4468 599.5n 0.4468 600.0n 0.4816 1199.5n 0.4816 1200.0n 0.4648 1799.5n 0.4648 1800.0n 0.4326 2399.5n 0.4326 2400.0n 0.4612 2999.5n 0.4612 3000.0n 0.4548 3599.5n 0.4548 3600.0n 0.4279 4199.5n 0.4279 4200.0n 0.4627 4799.5n 0.4627 4800.0n 0.4912 5399.5n 0.4912 5400.0n 0.4382 5999.5n 0.4382 6000.0n 0.4272 6599.5n 0.4272 6600.0n 0.4640 7199.5n 0.4640 7200.0n 0.4720 7799.5n 0.4720 7800.0n 0.5142 8399.5n 0.5142 8400.0n 0.5378 8999.5n 0.5378 9000.0n 0.5170 9599.5n 0.5170 9600.0n 0.5290 10199.5n 0.5290 10200.0n 0.4866 10799.5n 0.4866 10800.0n 0.4542 11399.5n 0.4542 11400.0n 0.4707 11999.5n 0.4707 12000.0n 0.5443 12599.5n 0.5443 12600.0n 0.4518 13199.5n 0.4518 13200.0n 0.5089 13799.5n 0.5089 13800.0n 0.4476 14399.5n 0.4476)
Vxn_who_11_1 xn_who_11_1 0 PWL(0.0n 0.5532 599.5n 0.5532 600.0n 0.5184 1199.5n 0.5184 1200.0n 0.5352 1799.5n 0.5352 1800.0n 0.5674 2399.5n 0.5674 2400.0n 0.5388 2999.5n 0.5388 3000.0n 0.5452 3599.5n 0.5452 3600.0n 0.5721 4199.5n 0.5721 4200.0n 0.5373 4799.5n 0.5373 4800.0n 0.5088 5399.5n 0.5088 5400.0n 0.5618 5999.5n 0.5618 6000.0n 0.5728 6599.5n 0.5728 6600.0n 0.5360 7199.5n 0.5360 7200.0n 0.5280 7799.5n 0.5280 7800.0n 0.4858 8399.5n 0.4858 8400.0n 0.4622 8999.5n 0.4622 9000.0n 0.4830 9599.5n 0.4830 9600.0n 0.4710 10199.5n 0.4710 10200.0n 0.5134 10799.5n 0.5134 10800.0n 0.5458 11399.5n 0.5458 11400.0n 0.5293 11999.5n 0.5293 12000.0n 0.4557 12599.5n 0.4557 12600.0n 0.5482 13199.5n 0.5482 13200.0n 0.4911 13799.5n 0.4911 13800.0n 0.5524 14399.5n 0.5524)
Vyp_who_11_1 yp_who_11_1 0 PWL(0.0n 0.4909 599.5n 0.4909 600.0n 0.4933 1199.5n 0.4933 1200.0n 0.4930 1799.5n 0.4930 1800.0n 0.4893 2399.5n 0.4893 2400.0n 0.4904 2999.5n 0.4904 3000.0n 0.4923 3599.5n 0.4923 3600.0n 0.4897 4199.5n 0.4897 4200.0n 0.4890 4799.5n 0.4890 4800.0n 0.4921 5399.5n 0.4921 5400.0n 0.4899 5999.5n 0.4899 6000.0n 0.4870 6599.5n 0.4870 6600.0n 0.4903 7199.5n 0.4903 7200.0n 0.4970 7799.5n 0.4970 7800.0n 0.4989 8399.5n 0.4989 8400.0n 0.4994 8999.5n 0.4994 9000.0n 0.4991 9599.5n 0.4991 9600.0n 0.5000 10199.5n 0.5000 10200.0n 0.4948 10799.5n 0.4948 10800.0n 0.4959 11399.5n 0.4959 11400.0n 0.4926 11999.5n 0.4926 12000.0n 0.4993 12599.5n 0.4993 12600.0n 0.4862 13199.5n 0.4862 13200.0n 0.4993 13799.5n 0.4993 13800.0n 0.4961 14399.5n 0.4961)
Vyn_who_11_1 yn_who_11_1 0 PWL(0.0n 0.5091 599.5n 0.5091 600.0n 0.5067 1199.5n 0.5067 1200.0n 0.5070 1799.5n 0.5070 1800.0n 0.5107 2399.5n 0.5107 2400.0n 0.5096 2999.5n 0.5096 3000.0n 0.5077 3599.5n 0.5077 3600.0n 0.5103 4199.5n 0.5103 4200.0n 0.5110 4799.5n 0.5110 4800.0n 0.5079 5399.5n 0.5079 5400.0n 0.5101 5999.5n 0.5101 6000.0n 0.5130 6599.5n 0.5130 6600.0n 0.5097 7199.5n 0.5097 7200.0n 0.5030 7799.5n 0.5030 7800.0n 0.5011 8399.5n 0.5011 8400.0n 0.5006 8999.5n 0.5006 9000.0n 0.5009 9599.5n 0.5009 9600.0n 0.5000 10199.5n 0.5000 10200.0n 0.5052 10799.5n 0.5052 10800.0n 0.5041 11399.5n 0.5041 11400.0n 0.5074 11999.5n 0.5074 12000.0n 0.5007 12599.5n 0.5007 12600.0n 0.5138 13199.5n 0.5138 13200.0n 0.5007 13799.5n 0.5007 13800.0n 0.5039 14399.5n 0.5039)
Cwp_who_11_1 wp_who_11_1 0 400p
Cwn_who_11_1 wn_who_11_1 0 400p
Xu_who_11_1 xp_who_11_1 xn_who_11_1 yp_who_11_1 yn_who_11_1 wp_who_11_1 wn_who_11_1 vdd gbn gprod
Vxp_bh_11 xp_bh_11 0 PWL(0.0n 0.7100 599.5n 0.7100 600.0n 0.7100 1199.5n 0.7100 1200.0n 0.7100 1799.5n 0.7100 1800.0n 0.7100 2399.5n 0.7100 2400.0n 0.7100 2999.5n 0.7100 3000.0n 0.7100 3599.5n 0.7100 3600.0n 0.7100 4199.5n 0.7100 4200.0n 0.7100 4799.5n 0.7100 4800.0n 0.7100 5399.5n 0.7100 5400.0n 0.7100 5999.5n 0.7100 6000.0n 0.7100 6599.5n 0.7100 6600.0n 0.7100 7199.5n 0.7100 7200.0n 0.7100 7799.5n 0.7100 7800.0n 0.7100 8399.5n 0.7100 8400.0n 0.7100 8999.5n 0.7100 9000.0n 0.7100 9599.5n 0.7100 9600.0n 0.7100 10199.5n 0.7100 10200.0n 0.7100 10799.5n 0.7100 10800.0n 0.7100 11399.5n 0.7100 11400.0n 0.7100 11999.5n 0.7100 12000.0n 0.7100 12599.5n 0.7100 12600.0n 0.7100 13199.5n 0.7100 13200.0n 0.7100 13799.5n 0.7100 13800.0n 0.7100 14399.5n 0.7100)
Vxn_bh_11 xn_bh_11 0 PWL(0.0n 0.2900 599.5n 0.2900 600.0n 0.2900 1199.5n 0.2900 1200.0n 0.2900 1799.5n 0.2900 1800.0n 0.2900 2399.5n 0.2900 2400.0n 0.2900 2999.5n 0.2900 3000.0n 0.2900 3599.5n 0.2900 3600.0n 0.2900 4199.5n 0.2900 4200.0n 0.2900 4799.5n 0.2900 4800.0n 0.2900 5399.5n 0.2900 5400.0n 0.2900 5999.5n 0.2900 6000.0n 0.2900 6599.5n 0.2900 6600.0n 0.2900 7199.5n 0.2900 7200.0n 0.2900 7799.5n 0.2900 7800.0n 0.2900 8399.5n 0.2900 8400.0n 0.2900 8999.5n 0.2900 9000.0n 0.2900 9599.5n 0.2900 9600.0n 0.2900 10199.5n 0.2900 10200.0n 0.2900 10799.5n 0.2900 10800.0n 0.2900 11399.5n 0.2900 11400.0n 0.2900 11999.5n 0.2900 12000.0n 0.2900 12599.5n 0.2900 12600.0n 0.2900 13199.5n 0.2900 13200.0n 0.2900 13799.5n 0.2900 13800.0n 0.2900 14399.5n 0.2900)
Vyp_bh_11 yp_bh_11 0 PWL(0.0n 0.4468 599.5n 0.4468 600.0n 0.4816 1199.5n 0.4816 1200.0n 0.4648 1799.5n 0.4648 1800.0n 0.4326 2399.5n 0.4326 2400.0n 0.4612 2999.5n 0.4612 3000.0n 0.4548 3599.5n 0.4548 3600.0n 0.4279 4199.5n 0.4279 4200.0n 0.4627 4799.5n 0.4627 4800.0n 0.4912 5399.5n 0.4912 5400.0n 0.4382 5999.5n 0.4382 6000.0n 0.4272 6599.5n 0.4272 6600.0n 0.4640 7199.5n 0.4640 7200.0n 0.4720 7799.5n 0.4720 7800.0n 0.5142 8399.5n 0.5142 8400.0n 0.5378 8999.5n 0.5378 9000.0n 0.5170 9599.5n 0.5170 9600.0n 0.5290 10199.5n 0.5290 10200.0n 0.4866 10799.5n 0.4866 10800.0n 0.4542 11399.5n 0.4542 11400.0n 0.4707 11999.5n 0.4707 12000.0n 0.5443 12599.5n 0.5443 12600.0n 0.4518 13199.5n 0.4518 13200.0n 0.5089 13799.5n 0.5089 13800.0n 0.4476 14399.5n 0.4476)
Vyn_bh_11 yn_bh_11 0 PWL(0.0n 0.5532 599.5n 0.5532 600.0n 0.5184 1199.5n 0.5184 1200.0n 0.5352 1799.5n 0.5352 1800.0n 0.5674 2399.5n 0.5674 2400.0n 0.5388 2999.5n 0.5388 3000.0n 0.5452 3599.5n 0.5452 3600.0n 0.5721 4199.5n 0.5721 4200.0n 0.5373 4799.5n 0.5373 4800.0n 0.5088 5399.5n 0.5088 5400.0n 0.5618 5999.5n 0.5618 6000.0n 0.5728 6599.5n 0.5728 6600.0n 0.5360 7199.5n 0.5360 7200.0n 0.5280 7799.5n 0.5280 7800.0n 0.4858 8399.5n 0.4858 8400.0n 0.4622 8999.5n 0.4622 9000.0n 0.4830 9599.5n 0.4830 9600.0n 0.4710 10199.5n 0.4710 10200.0n 0.5134 10799.5n 0.5134 10800.0n 0.5458 11399.5n 0.5458 11400.0n 0.5293 11999.5n 0.5293 12000.0n 0.4557 12599.5n 0.4557 12600.0n 0.5482 13199.5n 0.5482 13200.0n 0.4911 13799.5n 0.4911 13800.0n 0.5524 14399.5n 0.5524)
Cwp_bh_11 wp_bh_11 0 400p
Cwn_bh_11 wn_bh_11 0 400p
Xu_bh_11 xp_bh_11 xn_bh_11 yp_bh_11 yn_bh_11 wp_bh_11 wn_bh_11 vdd gbn gprod
Vxp_wih_10_12 xp_wih_10_12 0 PWL(0.0n 0.4780 599.5n 0.4780 600.0n 0.4782 1199.5n 0.4782 1200.0n 0.4616 1799.5n 0.4616 1800.0n 0.4427 2399.5n 0.4427 2400.0n 0.4570 2999.5n 0.4570 3000.0n 0.4178 3599.5n 0.4178 3600.0n 0.4817 4199.5n 0.4817 4200.0n 0.4270 4799.5n 0.4270 4800.0n 0.4662 5399.5n 0.4662 5400.0n 0.5654 5999.5n 0.5654 6000.0n 0.4694 6599.5n 0.4694 6600.0n 0.4809 7199.5n 0.4809 7200.0n 0.5515 7799.5n 0.5515 7800.0n 0.5820 8399.5n 0.5820 8400.0n 0.5809 8999.5n 0.5809 9000.0n 0.5432 9599.5n 0.5432 9600.0n 0.6050 10199.5n 0.6050 10200.0n 0.5272 10799.5n 0.5272 10800.0n 0.5727 11399.5n 0.5727 11400.0n 0.5237 11999.5n 0.5237 12000.0n 0.6050 12599.5n 0.6050 12600.0n 0.5374 13199.5n 0.5374 13200.0n 0.5350 13799.5n 0.5350 13800.0n 0.4763 14399.5n 0.4763)
Vxn_wih_10_12 xn_wih_10_12 0 PWL(0.0n 0.5220 599.5n 0.5220 600.0n 0.5218 1199.5n 0.5218 1200.0n 0.5384 1799.5n 0.5384 1800.0n 0.5573 2399.5n 0.5573 2400.0n 0.5430 2999.5n 0.5430 3000.0n 0.5822 3599.5n 0.5822 3600.0n 0.5183 4199.5n 0.5183 4200.0n 0.5730 4799.5n 0.5730 4800.0n 0.5338 5399.5n 0.5338 5400.0n 0.4346 5999.5n 0.4346 6000.0n 0.5306 6599.5n 0.5306 6600.0n 0.5191 7199.5n 0.5191 7200.0n 0.4485 7799.5n 0.4485 7800.0n 0.4180 8399.5n 0.4180 8400.0n 0.4191 8999.5n 0.4191 9000.0n 0.4568 9599.5n 0.4568 9600.0n 0.3950 10199.5n 0.3950 10200.0n 0.4728 10799.5n 0.4728 10800.0n 0.4273 11399.5n 0.4273 11400.0n 0.4763 11999.5n 0.4763 12000.0n 0.3950 12599.5n 0.3950 12600.0n 0.4626 13199.5n 0.4626 13200.0n 0.4650 13799.5n 0.4650 13800.0n 0.5237 14399.5n 0.5237)
Vyp_wih_10_12 yp_wih_10_12 0 PWL(0.0n 0.5038 599.5n 0.5038 600.0n 0.4765 1199.5n 0.4765 1200.0n 0.5076 1799.5n 0.5076 1800.0n 0.5204 2399.5n 0.5204 2400.0n 0.4979 2999.5n 0.4979 3000.0n 0.5327 3599.5n 0.5327 3600.0n 0.4940 4199.5n 0.4940 4200.0n 0.5334 4799.5n 0.5334 4800.0n 0.4973 5399.5n 0.4973 5400.0n 0.4631 5999.5n 0.4631 6000.0n 0.5027 6599.5n 0.5027 6600.0n 0.5071 7199.5n 0.5071 7200.0n 0.4509 7799.5n 0.4509 7800.0n 0.4602 8399.5n 0.4602 8400.0n 0.4490 8999.5n 0.4490 9000.0n 0.4816 9599.5n 0.4816 9600.0n 0.4448 10199.5n 0.4448 10200.0n 0.4879 10799.5n 0.4879 10800.0n 0.4724 11399.5n 0.4724 11400.0n 0.4900 11999.5n 0.4900 12000.0n 0.4627 12599.5n 0.4627 12600.0n 0.5135 13199.5n 0.5135 13200.0n 0.4905 13799.5n 0.4905 13800.0n 0.4830 14399.5n 0.4830)
Vyn_wih_10_12 yn_wih_10_12 0 PWL(0.0n 0.4962 599.5n 0.4962 600.0n 0.5235 1199.5n 0.5235 1200.0n 0.4924 1799.5n 0.4924 1800.0n 0.4796 2399.5n 0.4796 2400.0n 0.5021 2999.5n 0.5021 3000.0n 0.4673 3599.5n 0.4673 3600.0n 0.5060 4199.5n 0.5060 4200.0n 0.4666 4799.5n 0.4666 4800.0n 0.5027 5399.5n 0.5027 5400.0n 0.5369 5999.5n 0.5369 6000.0n 0.4973 6599.5n 0.4973 6600.0n 0.4929 7199.5n 0.4929 7200.0n 0.5491 7799.5n 0.5491 7800.0n 0.5398 8399.5n 0.5398 8400.0n 0.5510 8999.5n 0.5510 9000.0n 0.5184 9599.5n 0.5184 9600.0n 0.5552 10199.5n 0.5552 10200.0n 0.5121 10799.5n 0.5121 10800.0n 0.5276 11399.5n 0.5276 11400.0n 0.5100 11999.5n 0.5100 12000.0n 0.5373 12599.5n 0.5373 12600.0n 0.4865 13199.5n 0.4865 13200.0n 0.5095 13799.5n 0.5095 13800.0n 0.5170 14399.5n 0.5170)
Cwp_wih_10_12 wp_wih_10_12 0 400p
Cwn_wih_10_12 wn_wih_10_12 0 400p
Xu_wih_10_12 xp_wih_10_12 xn_wih_10_12 yp_wih_10_12 yn_wih_10_12 wp_wih_10_12 wn_wih_10_12 vdd gbn gprod
Vxp_wih_11_12 xp_wih_11_12 0 PWL(0.0n 0.4536 599.5n 0.4536 600.0n 0.4386 1199.5n 0.4386 1200.0n 0.4565 1799.5n 0.4565 1800.0n 0.4618 2399.5n 0.4618 2400.0n 0.4666 2999.5n 0.4666 3000.0n 0.5046 3599.5n 0.5046 3600.0n 0.4772 4199.5n 0.4772 4200.0n 0.4635 4799.5n 0.4635 4800.0n 0.4887 5399.5n 0.4887 5400.0n 0.4108 5999.5n 0.4108 6000.0n 0.4694 6599.5n 0.4694 6600.0n 0.4475 7199.5n 0.4475 7200.0n 0.3950 7799.5n 0.3950 7800.0n 0.4212 8399.5n 0.4212 8400.0n 0.3950 8999.5n 0.3950 9000.0n 0.4238 9599.5n 0.4238 9600.0n 0.4048 10199.5n 0.4048 10200.0n 0.3950 10799.5n 0.3950 10800.0n 0.3950 11399.5n 0.3950 11400.0n 0.3950 11999.5n 0.3950 12000.0n 0.3950 12599.5n 0.3950 12600.0n 0.3950 13199.5n 0.3950 13200.0n 0.3950 13799.5n 0.3950 13800.0n 0.3950 14399.5n 0.3950)
Vxn_wih_11_12 xn_wih_11_12 0 PWL(0.0n 0.5464 599.5n 0.5464 600.0n 0.5614 1199.5n 0.5614 1200.0n 0.5435 1799.5n 0.5435 1800.0n 0.5382 2399.5n 0.5382 2400.0n 0.5334 2999.5n 0.5334 3000.0n 0.4954 3599.5n 0.4954 3600.0n 0.5228 4199.5n 0.5228 4200.0n 0.5365 4799.5n 0.5365 4800.0n 0.5113 5399.5n 0.5113 5400.0n 0.5892 5999.5n 0.5892 6000.0n 0.5306 6599.5n 0.5306 6600.0n 0.5525 7199.5n 0.5525 7200.0n 0.6050 7799.5n 0.6050 7800.0n 0.5788 8399.5n 0.5788 8400.0n 0.6050 8999.5n 0.6050 9000.0n 0.5762 9599.5n 0.5762 9600.0n 0.5952 10199.5n 0.5952 10200.0n 0.6050 10799.5n 0.6050 10800.0n 0.6050 11399.5n 0.6050 11400.0n 0.6050 11999.5n 0.6050 12000.0n 0.6050 12599.5n 0.6050 12600.0n 0.6050 13199.5n 0.6050 13200.0n 0.6050 13799.5n 0.6050 13800.0n 0.6050 14399.5n 0.6050)
Vyp_wih_11_12 yp_wih_11_12 0 PWL(0.0n 0.5038 599.5n 0.5038 600.0n 0.4765 1199.5n 0.4765 1200.0n 0.5076 1799.5n 0.5076 1800.0n 0.5204 2399.5n 0.5204 2400.0n 0.4979 2999.5n 0.4979 3000.0n 0.5327 3599.5n 0.5327 3600.0n 0.4940 4199.5n 0.4940 4200.0n 0.5334 4799.5n 0.5334 4800.0n 0.4973 5399.5n 0.4973 5400.0n 0.4631 5999.5n 0.4631 6000.0n 0.5027 6599.5n 0.5027 6600.0n 0.5071 7199.5n 0.5071 7200.0n 0.4509 7799.5n 0.4509 7800.0n 0.4602 8399.5n 0.4602 8400.0n 0.4490 8999.5n 0.4490 9000.0n 0.4816 9599.5n 0.4816 9600.0n 0.4448 10199.5n 0.4448 10200.0n 0.4879 10799.5n 0.4879 10800.0n 0.4724 11399.5n 0.4724 11400.0n 0.4900 11999.5n 0.4900 12000.0n 0.4627 12599.5n 0.4627 12600.0n 0.5135 13199.5n 0.5135 13200.0n 0.4905 13799.5n 0.4905 13800.0n 0.4830 14399.5n 0.4830)
Vyn_wih_11_12 yn_wih_11_12 0 PWL(0.0n 0.4962 599.5n 0.4962 600.0n 0.5235 1199.5n 0.5235 1200.0n 0.4924 1799.5n 0.4924 1800.0n 0.4796 2399.5n 0.4796 2400.0n 0.5021 2999.5n 0.5021 3000.0n 0.4673 3599.5n 0.4673 3600.0n 0.5060 4199.5n 0.5060 4200.0n 0.4666 4799.5n 0.4666 4800.0n 0.5027 5399.5n 0.5027 5400.0n 0.5369 5999.5n 0.5369 6000.0n 0.4973 6599.5n 0.4973 6600.0n 0.4929 7199.5n 0.4929 7200.0n 0.5491 7799.5n 0.5491 7800.0n 0.5398 8399.5n 0.5398 8400.0n 0.5510 8999.5n 0.5510 9000.0n 0.5184 9599.5n 0.5184 9600.0n 0.5552 10199.5n 0.5552 10200.0n 0.5121 10799.5n 0.5121 10800.0n 0.5276 11399.5n 0.5276 11400.0n 0.5100 11999.5n 0.5100 12000.0n 0.5373 12599.5n 0.5373 12600.0n 0.4865 13199.5n 0.4865 13200.0n 0.5095 13799.5n 0.5095 13800.0n 0.5170 14399.5n 0.5170)
Cwp_wih_11_12 wp_wih_11_12 0 400p
Cwn_wih_11_12 wn_wih_11_12 0 400p
Xu_wih_11_12 xp_wih_11_12 xn_wih_11_12 yp_wih_11_12 yn_wih_11_12 wp_wih_11_12 wn_wih_11_12 vdd gbn gprod
Vxp_wih_14_12 xp_wih_14_12 0 PWL(0.0n 0.6001 599.5n 0.6001 600.0n 0.5297 1199.5n 0.5297 1200.0n 0.5896 1799.5n 0.5896 1800.0n 0.5907 2399.5n 0.5907 2400.0n 0.5716 2999.5n 0.5716 3000.0n 0.6050 3599.5n 0.6050 3600.0n 0.6050 4199.5n 0.6050 4200.0n 0.5822 4799.5n 0.5822 4800.0n 0.6050 5399.5n 0.6050 5400.0n 0.5614 5999.5n 0.5614 6000.0n 0.6050 6599.5n 0.6050 6600.0n 0.6050 7199.5n 0.6050 7200.0n 0.4856 7799.5n 0.4856 7800.0n 0.5853 8399.5n 0.5853 8400.0n 0.5568 8999.5n 0.5568 9000.0n 0.5679 9599.5n 0.5679 9600.0n 0.5656 10199.5n 0.5656 10200.0n 0.5506 10799.5n 0.5506 10800.0n 0.5781 11399.5n 0.5781 11400.0n 0.5508 11999.5n 0.5508 12000.0n 0.5935 12599.5n 0.5935 12600.0n 0.6050 13199.5n 0.6050 13200.0n 0.5617 13799.5n 0.5617 13800.0n 0.4729 14399.5n 0.4729)
Vxn_wih_14_12 xn_wih_14_12 0 PWL(0.0n 0.3999 599.5n 0.3999 600.0n 0.4703 1199.5n 0.4703 1200.0n 0.4104 1799.5n 0.4104 1800.0n 0.4093 2399.5n 0.4093 2400.0n 0.4284 2999.5n 0.4284 3000.0n 0.3950 3599.5n 0.3950 3600.0n 0.3950 4199.5n 0.3950 4200.0n 0.4178 4799.5n 0.4178 4800.0n 0.3950 5399.5n 0.3950 5400.0n 0.4386 5999.5n 0.4386 6000.0n 0.3950 6599.5n 0.3950 6600.0n 0.3950 7199.5n 0.3950 7200.0n 0.5144 7799.5n 0.5144 7800.0n 0.4147 8399.5n 0.4147 8400.0n 0.4432 8999.5n 0.4432 9000.0n 0.4321 9599.5n 0.4321 9600.0n 0.4344 10199.5n 0.4344 10200.0n 0.4494 10799.5n 0.4494 10800.0n 0.4219 11399.5n 0.4219 11400.0n 0.4492 11999.5n 0.4492 12000.0n 0.4065 12599.5n 0.4065 12600.0n 0.3950 13199.5n 0.3950 13200.0n 0.4383 13799.5n 0.4383 13800.0n 0.5271 14399.5n 0.5271)
Vyp_wih_14_12 yp_wih_14_12 0 PWL(0.0n 0.5038 599.5n 0.5038 600.0n 0.4765 1199.5n 0.4765 1200.0n 0.5076 1799.5n 0.5076 1800.0n 0.5204 2399.5n 0.5204 2400.0n 0.4979 2999.5n 0.4979 3000.0n 0.5327 3599.5n 0.5327 3600.0n 0.4940 4199.5n 0.4940 4200.0n 0.5334 4799.5n 0.5334 4800.0n 0.4973 5399.5n 0.4973 5400.0n 0.4631 5999.5n 0.4631 6000.0n 0.5027 6599.5n 0.5027 6600.0n 0.5071 7199.5n 0.5071 7200.0n 0.4509 7799.5n 0.4509 7800.0n 0.4602 8399.5n 0.4602 8400.0n 0.4490 8999.5n 0.4490 9000.0n 0.4816 9599.5n 0.4816 9600.0n 0.4448 10199.5n 0.4448 10200.0n 0.4879 10799.5n 0.4879 10800.0n 0.4724 11399.5n 0.4724 11400.0n 0.4900 11999.5n 0.4900 12000.0n 0.4627 12599.5n 0.4627 12600.0n 0.5135 13199.5n 0.5135 13200.0n 0.4905 13799.5n 0.4905 13800.0n 0.4830 14399.5n 0.4830)
Vyn_wih_14_12 yn_wih_14_12 0 PWL(0.0n 0.4962 599.5n 0.4962 600.0n 0.5235 1199.5n 0.5235 1200.0n 0.4924 1799.5n 0.4924 1800.0n 0.4796 2399.5n 0.4796 2400.0n 0.5021 2999.5n 0.5021 3000.0n 0.4673 3599.5n 0.4673 3600.0n 0.5060 4199.5n 0.5060 4200.0n 0.4666 4799.5n 0.4666 4800.0n 0.5027 5399.5n 0.5027 5400.0n 0.5369 5999.5n 0.5369 6000.0n 0.4973 6599.5n 0.4973 6600.0n 0.4929 7199.5n 0.4929 7200.0n 0.5491 7799.5n 0.5491 7800.0n 0.5398 8399.5n 0.5398 8400.0n 0.5510 8999.5n 0.5510 9000.0n 0.5184 9599.5n 0.5184 9600.0n 0.5552 10199.5n 0.5552 10200.0n 0.5121 10799.5n 0.5121 10800.0n 0.5276 11399.5n 0.5276 11400.0n 0.5100 11999.5n 0.5100 12000.0n 0.5373 12599.5n 0.5373 12600.0n 0.4865 13199.5n 0.4865 13200.0n 0.5095 13799.5n 0.5095 13800.0n 0.5170 14399.5n 0.5170)
Cwp_wih_14_12 wp_wih_14_12 0 400p
Cwn_wih_14_12 wn_wih_14_12 0 400p
Xu_wih_14_12 xp_wih_14_12 xn_wih_14_12 yp_wih_14_12 yn_wih_14_12 wp_wih_14_12 wn_wih_14_12 vdd gbn gprod
Vxp_wih_15_12 xp_wih_15_12 0 PWL(0.0n 0.4097 599.5n 0.4097 600.0n 0.3950 1199.5n 0.3950 1200.0n 0.4001 1799.5n 0.4001 1800.0n 0.4045 2399.5n 0.4045 2400.0n 0.4045 2999.5n 0.4045 3000.0n 0.4589 3599.5n 0.4589 3600.0n 0.4133 4199.5n 0.4133 4200.0n 0.4178 4799.5n 0.4178 4800.0n 0.4512 5399.5n 0.4512 5400.0n 0.3950 5999.5n 0.3950 6000.0n 0.3994 6599.5n 0.3994 6600.0n 0.3998 7199.5n 0.3998 7200.0n 0.3950 7799.5n 0.3950 7800.0n 0.4344 8399.5n 0.4344 8400.0n 0.4088 8999.5n 0.4088 9000.0n 0.4279 9599.5n 0.4279 9600.0n 0.3950 10199.5n 0.3950 10200.0n 0.3950 10799.5n 0.3950 10800.0n 0.3950 11399.5n 0.3950 11400.0n 0.3950 11999.5n 0.3950 12000.0n 0.3950 12599.5n 0.3950 12600.0n 0.5231 13199.5n 0.5231 13200.0n 0.4017 13799.5n 0.4017 13800.0n 0.3950 14399.5n 0.3950)
Vxn_wih_15_12 xn_wih_15_12 0 PWL(0.0n 0.5903 599.5n 0.5903 600.0n 0.6050 1199.5n 0.6050 1200.0n 0.5999 1799.5n 0.5999 1800.0n 0.5955 2399.5n 0.5955 2400.0n 0.5955 2999.5n 0.5955 3000.0n 0.5411 3599.5n 0.5411 3600.0n 0.5867 4199.5n 0.5867 4200.0n 0.5822 4799.5n 0.5822 4800.0n 0.5488 5399.5n 0.5488 5400.0n 0.6050 5999.5n 0.6050 6000.0n 0.6006 6599.5n 0.6006 6600.0n 0.6002 7199.5n 0.6002 7200.0n 0.6050 7799.5n 0.6050 7800.0n 0.5656 8399.5n 0.5656 8400.0n 0.5912 8999.5n 0.5912 9000.0n 0.5721 9599.5n 0.5721 9600.0n 0.6050 10199.5n 0.6050 10200.0n 0.6050 10799.5n 0.6050 10800.0n 0.6050 11399.5n 0.6050 11400.0n 0.6050 11999.5n 0.6050 12000.0n 0.6050 12599.5n 0.6050 12600.0n 0.4769 13199.5n 0.4769 13200.0n 0.5983 13799.5n 0.5983 13800.0n 0.6050 14399.5n 0.6050)
Vyp_wih_15_12 yp_wih_15_12 0 PWL(0.0n 0.5038 599.5n 0.5038 600.0n 0.4765 1199.5n 0.4765 1200.0n 0.5076 1799.5n 0.5076 1800.0n 0.5204 2399.5n 0.5204 2400.0n 0.4979 2999.5n 0.4979 3000.0n 0.5327 3599.5n 0.5327 3600.0n 0.4940 4199.5n 0.4940 4200.0n 0.5334 4799.5n 0.5334 4800.0n 0.4973 5399.5n 0.4973 5400.0n 0.4631 5999.5n 0.4631 6000.0n 0.5027 6599.5n 0.5027 6600.0n 0.5071 7199.5n 0.5071 7200.0n 0.4509 7799.5n 0.4509 7800.0n 0.4602 8399.5n 0.4602 8400.0n 0.4490 8999.5n 0.4490 9000.0n 0.4816 9599.5n 0.4816 9600.0n 0.4448 10199.5n 0.4448 10200.0n 0.4879 10799.5n 0.4879 10800.0n 0.4724 11399.5n 0.4724 11400.0n 0.4900 11999.5n 0.4900 12000.0n 0.4627 12599.5n 0.4627 12600.0n 0.5135 13199.5n 0.5135 13200.0n 0.4905 13799.5n 0.4905 13800.0n 0.4830 14399.5n 0.4830)
Vyn_wih_15_12 yn_wih_15_12 0 PWL(0.0n 0.4962 599.5n 0.4962 600.0n 0.5235 1199.5n 0.5235 1200.0n 0.4924 1799.5n 0.4924 1800.0n 0.4796 2399.5n 0.4796 2400.0n 0.5021 2999.5n 0.5021 3000.0n 0.4673 3599.5n 0.4673 3600.0n 0.5060 4199.5n 0.5060 4200.0n 0.4666 4799.5n 0.4666 4800.0n 0.5027 5399.5n 0.5027 5400.0n 0.5369 5999.5n 0.5369 6000.0n 0.4973 6599.5n 0.4973 6600.0n 0.4929 7199.5n 0.4929 7200.0n 0.5491 7799.5n 0.5491 7800.0n 0.5398 8399.5n 0.5398 8400.0n 0.5510 8999.5n 0.5510 9000.0n 0.5184 9599.5n 0.5184 9600.0n 0.5552 10199.5n 0.5552 10200.0n 0.5121 10799.5n 0.5121 10800.0n 0.5276 11399.5n 0.5276 11400.0n 0.5100 11999.5n 0.5100 12000.0n 0.5373 12599.5n 0.5373 12600.0n 0.4865 13199.5n 0.4865 13200.0n 0.5095 13799.5n 0.5095 13800.0n 0.5170 14399.5n 0.5170)
Cwp_wih_15_12 wp_wih_15_12 0 400p
Cwn_wih_15_12 wn_wih_15_12 0 400p
Xu_wih_15_12 xp_wih_15_12 xn_wih_15_12 yp_wih_15_12 yn_wih_15_12 wp_wih_15_12 wn_wih_15_12 vdd gbn gprod
Vxp_who_12_0 xp_who_12_0 0 PWL(0.0n 0.5038 599.5n 0.5038 600.0n 0.4765 1199.5n 0.4765 1200.0n 0.5076 1799.5n 0.5076 1800.0n 0.5204 2399.5n 0.5204 2400.0n 0.4979 2999.5n 0.4979 3000.0n 0.5327 3599.5n 0.5327 3600.0n 0.4940 4199.5n 0.4940 4200.0n 0.5334 4799.5n 0.5334 4800.0n 0.4973 5399.5n 0.4973 5400.0n 0.4631 5999.5n 0.4631 6000.0n 0.5027 6599.5n 0.5027 6600.0n 0.5071 7199.5n 0.5071 7200.0n 0.4509 7799.5n 0.4509 7800.0n 0.4602 8399.5n 0.4602 8400.0n 0.4490 8999.5n 0.4490 9000.0n 0.4816 9599.5n 0.4816 9600.0n 0.4448 10199.5n 0.4448 10200.0n 0.4879 10799.5n 0.4879 10800.0n 0.4724 11399.5n 0.4724 11400.0n 0.4900 11999.5n 0.4900 12000.0n 0.4627 12599.5n 0.4627 12600.0n 0.5135 13199.5n 0.5135 13200.0n 0.4905 13799.5n 0.4905 13800.0n 0.4830 14399.5n 0.4830)
Vxn_who_12_0 xn_who_12_0 0 PWL(0.0n 0.4962 599.5n 0.4962 600.0n 0.5235 1199.5n 0.5235 1200.0n 0.4924 1799.5n 0.4924 1800.0n 0.4796 2399.5n 0.4796 2400.0n 0.5021 2999.5n 0.5021 3000.0n 0.4673 3599.5n 0.4673 3600.0n 0.5060 4199.5n 0.5060 4200.0n 0.4666 4799.5n 0.4666 4800.0n 0.5027 5399.5n 0.5027 5400.0n 0.5369 5999.5n 0.5369 6000.0n 0.4973 6599.5n 0.4973 6600.0n 0.4929 7199.5n 0.4929 7200.0n 0.5491 7799.5n 0.5491 7800.0n 0.5398 8399.5n 0.5398 8400.0n 0.5510 8999.5n 0.5510 9000.0n 0.5184 9599.5n 0.5184 9600.0n 0.5552 10199.5n 0.5552 10200.0n 0.5121 10799.5n 0.5121 10800.0n 0.5276 11399.5n 0.5276 11400.0n 0.5100 11999.5n 0.5100 12000.0n 0.5373 12599.5n 0.5373 12600.0n 0.4865 13199.5n 0.4865 13200.0n 0.5095 13799.5n 0.5095 13800.0n 0.5170 14399.5n 0.5170)
Vyp_who_12_0 yp_who_12_0 0 PWL(0.0n 0.5073 599.5n 0.5073 600.0n 0.5065 1199.5n 0.5065 1200.0n 0.5065 1799.5n 0.5065 1800.0n 0.5052 2399.5n 0.5052 2400.0n 0.5058 2999.5n 0.5058 3000.0n 0.5039 3599.5n 0.5039 3600.0n 0.5059 4199.5n 0.5059 4200.0n 0.5077 4799.5n 0.5077 4800.0n 0.5054 5399.5n 0.5054 5400.0n 0.5066 5999.5n 0.5066 6000.0n 0.5083 6599.5n 0.5083 6600.0n 0.5078 7199.5n 0.5078 7200.0n 0.5043 7799.5n 0.5043 7800.0n 0.5035 8399.5n 0.5035 8400.0n 0.5035 8999.5n 0.5035 9000.0n 0.5038 9599.5n 0.5038 9600.0n 0.5043 10199.5n 0.5043 10200.0n 0.5053 10799.5n 0.5053 10800.0n 0.5050 11399.5n 0.5050 11400.0n 0.5055 11999.5n 0.5055 12000.0n 0.5043 12599.5n 0.5043 12600.0n 0.5028 13199.5n 0.5028 13200.0n 0.5045 13799.5n 0.5045 13800.0n 0.5043 14399.5n 0.5043)
Vyn_who_12_0 yn_who_12_0 0 PWL(0.0n 0.4927 599.5n 0.4927 600.0n 0.4935 1199.5n 0.4935 1200.0n 0.4935 1799.5n 0.4935 1800.0n 0.4948 2399.5n 0.4948 2400.0n 0.4942 2999.5n 0.4942 3000.0n 0.4961 3599.5n 0.4961 3600.0n 0.4941 4199.5n 0.4941 4200.0n 0.4923 4799.5n 0.4923 4800.0n 0.4946 5399.5n 0.4946 5400.0n 0.4934 5999.5n 0.4934 6000.0n 0.4917 6599.5n 0.4917 6600.0n 0.4922 7199.5n 0.4922 7200.0n 0.4957 7799.5n 0.4957 7800.0n 0.4965 8399.5n 0.4965 8400.0n 0.4965 8999.5n 0.4965 9000.0n 0.4962 9599.5n 0.4962 9600.0n 0.4957 10199.5n 0.4957 10200.0n 0.4947 10799.5n 0.4947 10800.0n 0.4950 11399.5n 0.4950 11400.0n 0.4945 11999.5n 0.4945 12000.0n 0.4957 12599.5n 0.4957 12600.0n 0.4972 13199.5n 0.4972 13200.0n 0.4955 13799.5n 0.4955 13800.0n 0.4957 14399.5n 0.4957)
Cwp_who_12_0 wp_who_12_0 0 400p
Cwn_who_12_0 wn_who_12_0 0 400p
Xu_who_12_0 xp_who_12_0 xn_who_12_0 yp_who_12_0 yn_who_12_0 wp_who_12_0 wn_who_12_0 vdd gbn gprod
Vxp_who_12_1 xp_who_12_1 0 PWL(0.0n 0.5038 599.5n 0.5038 600.0n 0.4765 1199.5n 0.4765 1200.0n 0.5076 1799.5n 0.5076 1800.0n 0.5204 2399.5n 0.5204 2400.0n 0.4979 2999.5n 0.4979 3000.0n 0.5327 3599.5n 0.5327 3600.0n 0.4940 4199.5n 0.4940 4200.0n 0.5334 4799.5n 0.5334 4800.0n 0.4973 5399.5n 0.4973 5400.0n 0.4631 5999.5n 0.4631 6000.0n 0.5027 6599.5n 0.5027 6600.0n 0.5071 7199.5n 0.5071 7200.0n 0.4509 7799.5n 0.4509 7800.0n 0.4602 8399.5n 0.4602 8400.0n 0.4490 8999.5n 0.4490 9000.0n 0.4816 9599.5n 0.4816 9600.0n 0.4448 10199.5n 0.4448 10200.0n 0.4879 10799.5n 0.4879 10800.0n 0.4724 11399.5n 0.4724 11400.0n 0.4900 11999.5n 0.4900 12000.0n 0.4627 12599.5n 0.4627 12600.0n 0.5135 13199.5n 0.5135 13200.0n 0.4905 13799.5n 0.4905 13800.0n 0.4830 14399.5n 0.4830)
Vxn_who_12_1 xn_who_12_1 0 PWL(0.0n 0.4962 599.5n 0.4962 600.0n 0.5235 1199.5n 0.5235 1200.0n 0.4924 1799.5n 0.4924 1800.0n 0.4796 2399.5n 0.4796 2400.0n 0.5021 2999.5n 0.5021 3000.0n 0.4673 3599.5n 0.4673 3600.0n 0.5060 4199.5n 0.5060 4200.0n 0.4666 4799.5n 0.4666 4800.0n 0.5027 5399.5n 0.5027 5400.0n 0.5369 5999.5n 0.5369 6000.0n 0.4973 6599.5n 0.4973 6600.0n 0.4929 7199.5n 0.4929 7200.0n 0.5491 7799.5n 0.5491 7800.0n 0.5398 8399.5n 0.5398 8400.0n 0.5510 8999.5n 0.5510 9000.0n 0.5184 9599.5n 0.5184 9600.0n 0.5552 10199.5n 0.5552 10200.0n 0.5121 10799.5n 0.5121 10800.0n 0.5276 11399.5n 0.5276 11400.0n 0.5100 11999.5n 0.5100 12000.0n 0.5373 12599.5n 0.5373 12600.0n 0.4865 13199.5n 0.4865 13200.0n 0.5095 13799.5n 0.5095 13800.0n 0.5170 14399.5n 0.5170)
Vyp_who_12_1 yp_who_12_1 0 PWL(0.0n 0.4909 599.5n 0.4909 600.0n 0.4933 1199.5n 0.4933 1200.0n 0.4930 1799.5n 0.4930 1800.0n 0.4893 2399.5n 0.4893 2400.0n 0.4904 2999.5n 0.4904 3000.0n 0.4923 3599.5n 0.4923 3600.0n 0.4897 4199.5n 0.4897 4200.0n 0.4890 4799.5n 0.4890 4800.0n 0.4921 5399.5n 0.4921 5400.0n 0.4899 5999.5n 0.4899 6000.0n 0.4870 6599.5n 0.4870 6600.0n 0.4903 7199.5n 0.4903 7200.0n 0.4970 7799.5n 0.4970 7800.0n 0.4989 8399.5n 0.4989 8400.0n 0.4994 8999.5n 0.4994 9000.0n 0.4991 9599.5n 0.4991 9600.0n 0.5000 10199.5n 0.5000 10200.0n 0.4948 10799.5n 0.4948 10800.0n 0.4959 11399.5n 0.4959 11400.0n 0.4926 11999.5n 0.4926 12000.0n 0.4993 12599.5n 0.4993 12600.0n 0.4862 13199.5n 0.4862 13200.0n 0.4993 13799.5n 0.4993 13800.0n 0.4961 14399.5n 0.4961)
Vyn_who_12_1 yn_who_12_1 0 PWL(0.0n 0.5091 599.5n 0.5091 600.0n 0.5067 1199.5n 0.5067 1200.0n 0.5070 1799.5n 0.5070 1800.0n 0.5107 2399.5n 0.5107 2400.0n 0.5096 2999.5n 0.5096 3000.0n 0.5077 3599.5n 0.5077 3600.0n 0.5103 4199.5n 0.5103 4200.0n 0.5110 4799.5n 0.5110 4800.0n 0.5079 5399.5n 0.5079 5400.0n 0.5101 5999.5n 0.5101 6000.0n 0.5130 6599.5n 0.5130 6600.0n 0.5097 7199.5n 0.5097 7200.0n 0.5030 7799.5n 0.5030 7800.0n 0.5011 8399.5n 0.5011 8400.0n 0.5006 8999.5n 0.5006 9000.0n 0.5009 9599.5n 0.5009 9600.0n 0.5000 10199.5n 0.5000 10200.0n 0.5052 10799.5n 0.5052 10800.0n 0.5041 11399.5n 0.5041 11400.0n 0.5074 11999.5n 0.5074 12000.0n 0.5007 12599.5n 0.5007 12600.0n 0.5138 13199.5n 0.5138 13200.0n 0.5007 13799.5n 0.5007 13800.0n 0.5039 14399.5n 0.5039)
Cwp_who_12_1 wp_who_12_1 0 400p
Cwn_who_12_1 wn_who_12_1 0 400p
Xu_who_12_1 xp_who_12_1 xn_who_12_1 yp_who_12_1 yn_who_12_1 wp_who_12_1 wn_who_12_1 vdd gbn gprod
Vxp_bh_12 xp_bh_12 0 PWL(0.0n 0.7100 599.5n 0.7100 600.0n 0.7100 1199.5n 0.7100 1200.0n 0.7100 1799.5n 0.7100 1800.0n 0.7100 2399.5n 0.7100 2400.0n 0.7100 2999.5n 0.7100 3000.0n 0.7100 3599.5n 0.7100 3600.0n 0.7100 4199.5n 0.7100 4200.0n 0.7100 4799.5n 0.7100 4800.0n 0.7100 5399.5n 0.7100 5400.0n 0.7100 5999.5n 0.7100 6000.0n 0.7100 6599.5n 0.7100 6600.0n 0.7100 7199.5n 0.7100 7200.0n 0.7100 7799.5n 0.7100 7800.0n 0.7100 8399.5n 0.7100 8400.0n 0.7100 8999.5n 0.7100 9000.0n 0.7100 9599.5n 0.7100 9600.0n 0.7100 10199.5n 0.7100 10200.0n 0.7100 10799.5n 0.7100 10800.0n 0.7100 11399.5n 0.7100 11400.0n 0.7100 11999.5n 0.7100 12000.0n 0.7100 12599.5n 0.7100 12600.0n 0.7100 13199.5n 0.7100 13200.0n 0.7100 13799.5n 0.7100 13800.0n 0.7100 14399.5n 0.7100)
Vxn_bh_12 xn_bh_12 0 PWL(0.0n 0.2900 599.5n 0.2900 600.0n 0.2900 1199.5n 0.2900 1200.0n 0.2900 1799.5n 0.2900 1800.0n 0.2900 2399.5n 0.2900 2400.0n 0.2900 2999.5n 0.2900 3000.0n 0.2900 3599.5n 0.2900 3600.0n 0.2900 4199.5n 0.2900 4200.0n 0.2900 4799.5n 0.2900 4800.0n 0.2900 5399.5n 0.2900 5400.0n 0.2900 5999.5n 0.2900 6000.0n 0.2900 6599.5n 0.2900 6600.0n 0.2900 7199.5n 0.2900 7200.0n 0.2900 7799.5n 0.2900 7800.0n 0.2900 8399.5n 0.2900 8400.0n 0.2900 8999.5n 0.2900 9000.0n 0.2900 9599.5n 0.2900 9600.0n 0.2900 10199.5n 0.2900 10200.0n 0.2900 10799.5n 0.2900 10800.0n 0.2900 11399.5n 0.2900 11400.0n 0.2900 11999.5n 0.2900 12000.0n 0.2900 12599.5n 0.2900 12600.0n 0.2900 13199.5n 0.2900 13200.0n 0.2900 13799.5n 0.2900 13800.0n 0.2900 14399.5n 0.2900)
Vyp_bh_12 yp_bh_12 0 PWL(0.0n 0.5038 599.5n 0.5038 600.0n 0.4765 1199.5n 0.4765 1200.0n 0.5076 1799.5n 0.5076 1800.0n 0.5204 2399.5n 0.5204 2400.0n 0.4979 2999.5n 0.4979 3000.0n 0.5327 3599.5n 0.5327 3600.0n 0.4940 4199.5n 0.4940 4200.0n 0.5334 4799.5n 0.5334 4800.0n 0.4973 5399.5n 0.4973 5400.0n 0.4631 5999.5n 0.4631 6000.0n 0.5027 6599.5n 0.5027 6600.0n 0.5071 7199.5n 0.5071 7200.0n 0.4509 7799.5n 0.4509 7800.0n 0.4602 8399.5n 0.4602 8400.0n 0.4490 8999.5n 0.4490 9000.0n 0.4816 9599.5n 0.4816 9600.0n 0.4448 10199.5n 0.4448 10200.0n 0.4879 10799.5n 0.4879 10800.0n 0.4724 11399.5n 0.4724 11400.0n 0.4900 11999.5n 0.4900 12000.0n 0.4627 12599.5n 0.4627 12600.0n 0.5135 13199.5n 0.5135 13200.0n 0.4905 13799.5n 0.4905 13800.0n 0.4830 14399.5n 0.4830)
Vyn_bh_12 yn_bh_12 0 PWL(0.0n 0.4962 599.5n 0.4962 600.0n 0.5235 1199.5n 0.5235 1200.0n 0.4924 1799.5n 0.4924 1800.0n 0.4796 2399.5n 0.4796 2400.0n 0.5021 2999.5n 0.5021 3000.0n 0.4673 3599.5n 0.4673 3600.0n 0.5060 4199.5n 0.5060 4200.0n 0.4666 4799.5n 0.4666 4800.0n 0.5027 5399.5n 0.5027 5400.0n 0.5369 5999.5n 0.5369 6000.0n 0.4973 6599.5n 0.4973 6600.0n 0.4929 7199.5n 0.4929 7200.0n 0.5491 7799.5n 0.5491 7800.0n 0.5398 8399.5n 0.5398 8400.0n 0.5510 8999.5n 0.5510 9000.0n 0.5184 9599.5n 0.5184 9600.0n 0.5552 10199.5n 0.5552 10200.0n 0.5121 10799.5n 0.5121 10800.0n 0.5276 11399.5n 0.5276 11400.0n 0.5100 11999.5n 0.5100 12000.0n 0.5373 12599.5n 0.5373 12600.0n 0.4865 13199.5n 0.4865 13200.0n 0.5095 13799.5n 0.5095 13800.0n 0.5170 14399.5n 0.5170)
Cwp_bh_12 wp_bh_12 0 400p
Cwn_bh_12 wn_bh_12 0 400p
Xu_bh_12 xp_bh_12 xn_bh_12 yp_bh_12 yn_bh_12 wp_bh_12 wn_bh_12 vdd gbn gprod
Vxp_wih_10_13 xp_wih_10_13 0 PWL(0.0n 0.4780 599.5n 0.4780 600.0n 0.4782 1199.5n 0.4782 1200.0n 0.4616 1799.5n 0.4616 1800.0n 0.4427 2399.5n 0.4427 2400.0n 0.4570 2999.5n 0.4570 3000.0n 0.4178 3599.5n 0.4178 3600.0n 0.4817 4199.5n 0.4817 4200.0n 0.4270 4799.5n 0.4270 4800.0n 0.4662 5399.5n 0.4662 5400.0n 0.5654 5999.5n 0.5654 6000.0n 0.4694 6599.5n 0.4694 6600.0n 0.4809 7199.5n 0.4809 7200.0n 0.5515 7799.5n 0.5515 7800.0n 0.5820 8399.5n 0.5820 8400.0n 0.5809 8999.5n 0.5809 9000.0n 0.5432 9599.5n 0.5432 9600.0n 0.6050 10199.5n 0.6050 10200.0n 0.5272 10799.5n 0.5272 10800.0n 0.5727 11399.5n 0.5727 11400.0n 0.5237 11999.5n 0.5237 12000.0n 0.6050 12599.5n 0.6050 12600.0n 0.5374 13199.5n 0.5374 13200.0n 0.5350 13799.5n 0.5350 13800.0n 0.4763 14399.5n 0.4763)
Vxn_wih_10_13 xn_wih_10_13 0 PWL(0.0n 0.5220 599.5n 0.5220 600.0n 0.5218 1199.5n 0.5218 1200.0n 0.5384 1799.5n 0.5384 1800.0n 0.5573 2399.5n 0.5573 2400.0n 0.5430 2999.5n 0.5430 3000.0n 0.5822 3599.5n 0.5822 3600.0n 0.5183 4199.5n 0.5183 4200.0n 0.5730 4799.5n 0.5730 4800.0n 0.5338 5399.5n 0.5338 5400.0n 0.4346 5999.5n 0.4346 6000.0n 0.5306 6599.5n 0.5306 6600.0n 0.5191 7199.5n 0.5191 7200.0n 0.4485 7799.5n 0.4485 7800.0n 0.4180 8399.5n 0.4180 8400.0n 0.4191 8999.5n 0.4191 9000.0n 0.4568 9599.5n 0.4568 9600.0n 0.3950 10199.5n 0.3950 10200.0n 0.4728 10799.5n 0.4728 10800.0n 0.4273 11399.5n 0.4273 11400.0n 0.4763 11999.5n 0.4763 12000.0n 0.3950 12599.5n 0.3950 12600.0n 0.4626 13199.5n 0.4626 13200.0n 0.4650 13799.5n 0.4650 13800.0n 0.5237 14399.5n 0.5237)
Vyp_wih_10_13 yp_wih_10_13 0 PWL(0.0n 0.5632 599.5n 0.5632 600.0n 0.5507 1199.5n 0.5507 1200.0n 0.5670 1799.5n 0.5670 1800.0n 0.5681 2399.5n 0.5681 2400.0n 0.5614 2999.5n 0.5614 3000.0n 0.5324 3599.5n 0.5324 3600.0n 0.5618 4199.5n 0.5618 4200.0n 0.5688 4799.5n 0.5688 4800.0n 0.5271 5399.5n 0.5271 5400.0n 0.5398 5999.5n 0.5398 6000.0n 0.5702 6599.5n 0.5702 6600.0n 0.5669 7199.5n 0.5669 7200.0n 0.5296 7799.5n 0.5296 7800.0n 0.5154 8399.5n 0.5154 8400.0n 0.5248 8999.5n 0.5248 9000.0n 0.5288 9599.5n 0.5288 9600.0n 0.5299 10199.5n 0.5299 10200.0n 0.5432 10799.5n 0.5432 10800.0n 0.5409 11399.5n 0.5409 11400.0n 0.5438 11999.5n 0.5438 12000.0n 0.5372 12599.5n 0.5372 12600.0n 0.4671 13199.5n 0.4671 13200.0n 0.5421 13799.5n 0.5421 13800.0n 0.5380 14399.5n 0.5380)
Vyn_wih_10_13 yn_wih_10_13 0 PWL(0.0n 0.4368 599.5n 0.4368 600.0n 0.4493 1199.5n 0.4493 1200.0n 0.4330 1799.5n 0.4330 1800.0n 0.4319 2399.5n 0.4319 2400.0n 0.4386 2999.5n 0.4386 3000.0n 0.4676 3599.5n 0.4676 3600.0n 0.4382 4199.5n 0.4382 4200.0n 0.4312 4799.5n 0.4312 4800.0n 0.4729 5399.5n 0.4729 5400.0n 0.4602 5999.5n 0.4602 6000.0n 0.4298 6599.5n 0.4298 6600.0n 0.4331 7199.5n 0.4331 7200.0n 0.4704 7799.5n 0.4704 7800.0n 0.4846 8399.5n 0.4846 8400.0n 0.4752 8999.5n 0.4752 9000.0n 0.4712 9599.5n 0.4712 9600.0n 0.4701 10199.5n 0.4701 10200.0n 0.4568 10799.5n 0.4568 10800.0n 0.4591 11399.5n 0.4591 11400.0n 0.4562 11999.5n 0.4562 12000.0n 0.4628 12599.5n 0.4628 12600.0n 0.5329 13199.5n 0.5329 13200.0n 0.4579 13799.5n 0.4579 13800.0n 0.4620 14399.5n 0.4620)
Cwp_wih_10_13 wp_wih_10_13 0 400p
Cwn_wih_10_13 wn_wih_10_13 0 400p
Xu_wih_10_13 xp_wih_10_13 xn_wih_10_13 yp_wih_10_13 yn_wih_10_13 wp_wih_10_13 wn_wih_10_13 vdd gbn gprod
Vxp_wih_11_13 xp_wih_11_13 0 PWL(0.0n 0.4536 599.5n 0.4536 600.0n 0.4386 1199.5n 0.4386 1200.0n 0.4565 1799.5n 0.4565 1800.0n 0.4618 2399.5n 0.4618 2400.0n 0.4666 2999.5n 0.4666 3000.0n 0.5046 3599.5n 0.5046 3600.0n 0.4772 4199.5n 0.4772 4200.0n 0.4635 4799.5n 0.4635 4800.0n 0.4887 5399.5n 0.4887 5400.0n 0.4108 5999.5n 0.4108 6000.0n 0.4694 6599.5n 0.4694 6600.0n 0.4475 7199.5n 0.4475 7200.0n 0.3950 7799.5n 0.3950 7800.0n 0.4212 8399.5n 0.4212 8400.0n 0.3950 8999.5n 0.3950 9000.0n 0.4238 9599.5n 0.4238 9600.0n 0.4048 10199.5n 0.4048 10200.0n 0.3950 10799.5n 0.3950 10800.0n 0.3950 11399.5n 0.3950 11400.0n 0.3950 11999.5n 0.3950 12000.0n 0.3950 12599.5n 0.3950 12600.0n 0.3950 13199.5n 0.3950 13200.0n 0.3950 13799.5n 0.3950 13800.0n 0.3950 14399.5n 0.3950)
Vxn_wih_11_13 xn_wih_11_13 0 PWL(0.0n 0.5464 599.5n 0.5464 600.0n 0.5614 1199.5n 0.5614 1200.0n 0.5435 1799.5n 0.5435 1800.0n 0.5382 2399.5n 0.5382 2400.0n 0.5334 2999.5n 0.5334 3000.0n 0.4954 3599.5n 0.4954 3600.0n 0.5228 4199.5n 0.5228 4200.0n 0.5365 4799.5n 0.5365 4800.0n 0.5113 5399.5n 0.5113 5400.0n 0.5892 5999.5n 0.5892 6000.0n 0.5306 6599.5n 0.5306 6600.0n 0.5525 7199.5n 0.5525 7200.0n 0.6050 7799.5n 0.6050 7800.0n 0.5788 8399.5n 0.5788 8400.0n 0.6050 8999.5n 0.6050 9000.0n 0.5762 9599.5n 0.5762 9600.0n 0.5952 10199.5n 0.5952 10200.0n 0.6050 10799.5n 0.6050 10800.0n 0.6050 11399.5n 0.6050 11400.0n 0.6050 11999.5n 0.6050 12000.0n 0.6050 12599.5n 0.6050 12600.0n 0.6050 13199.5n 0.6050 13200.0n 0.6050 13799.5n 0.6050 13800.0n 0.6050 14399.5n 0.6050)
Vyp_wih_11_13 yp_wih_11_13 0 PWL(0.0n 0.5632 599.5n 0.5632 600.0n 0.5507 1199.5n 0.5507 1200.0n 0.5670 1799.5n 0.5670 1800.0n 0.5681 2399.5n 0.5681 2400.0n 0.5614 2999.5n 0.5614 3000.0n 0.5324 3599.5n 0.5324 3600.0n 0.5618 4199.5n 0.5618 4200.0n 0.5688 4799.5n 0.5688 4800.0n 0.5271 5399.5n 0.5271 5400.0n 0.5398 5999.5n 0.5398 6000.0n 0.5702 6599.5n 0.5702 6600.0n 0.5669 7199.5n 0.5669 7200.0n 0.5296 7799.5n 0.5296 7800.0n 0.5154 8399.5n 0.5154 8400.0n 0.5248 8999.5n 0.5248 9000.0n 0.5288 9599.5n 0.5288 9600.0n 0.5299 10199.5n 0.5299 10200.0n 0.5432 10799.5n 0.5432 10800.0n 0.5409 11399.5n 0.5409 11400.0n 0.5438 11999.5n 0.5438 12000.0n 0.5372 12599.5n 0.5372 12600.0n 0.4671 13199.5n 0.4671 13200.0n 0.5421 13799.5n 0.5421 13800.0n 0.5380 14399.5n 0.5380)
Vyn_wih_11_13 yn_wih_11_13 0 PWL(0.0n 0.4368 599.5n 0.4368 600.0n 0.4493 1199.5n 0.4493 1200.0n 0.4330 1799.5n 0.4330 1800.0n 0.4319 2399.5n 0.4319 2400.0n 0.4386 2999.5n 0.4386 3000.0n 0.4676 3599.5n 0.4676 3600.0n 0.4382 4199.5n 0.4382 4200.0n 0.4312 4799.5n 0.4312 4800.0n 0.4729 5399.5n 0.4729 5400.0n 0.4602 5999.5n 0.4602 6000.0n 0.4298 6599.5n 0.4298 6600.0n 0.4331 7199.5n 0.4331 7200.0n 0.4704 7799.5n 0.4704 7800.0n 0.4846 8399.5n 0.4846 8400.0n 0.4752 8999.5n 0.4752 9000.0n 0.4712 9599.5n 0.4712 9600.0n 0.4701 10199.5n 0.4701 10200.0n 0.4568 10799.5n 0.4568 10800.0n 0.4591 11399.5n 0.4591 11400.0n 0.4562 11999.5n 0.4562 12000.0n 0.4628 12599.5n 0.4628 12600.0n 0.5329 13199.5n 0.5329 13200.0n 0.4579 13799.5n 0.4579 13800.0n 0.4620 14399.5n 0.4620)
Cwp_wih_11_13 wp_wih_11_13 0 400p
Cwn_wih_11_13 wn_wih_11_13 0 400p
Xu_wih_11_13 xp_wih_11_13 xn_wih_11_13 yp_wih_11_13 yn_wih_11_13 wp_wih_11_13 wn_wih_11_13 vdd gbn gprod
Vxp_wih_14_13 xp_wih_14_13 0 PWL(0.0n 0.6001 599.5n 0.6001 600.0n 0.5297 1199.5n 0.5297 1200.0n 0.5896 1799.5n 0.5896 1800.0n 0.5907 2399.5n 0.5907 2400.0n 0.5716 2999.5n 0.5716 3000.0n 0.6050 3599.5n 0.6050 3600.0n 0.6050 4199.5n 0.6050 4200.0n 0.5822 4799.5n 0.5822 4800.0n 0.6050 5399.5n 0.6050 5400.0n 0.5614 5999.5n 0.5614 6000.0n 0.6050 6599.5n 0.6050 6600.0n 0.6050 7199.5n 0.6050 7200.0n 0.4856 7799.5n 0.4856 7800.0n 0.5853 8399.5n 0.5853 8400.0n 0.5568 8999.5n 0.5568 9000.0n 0.5679 9599.5n 0.5679 9600.0n 0.5656 10199.5n 0.5656 10200.0n 0.5506 10799.5n 0.5506 10800.0n 0.5781 11399.5n 0.5781 11400.0n 0.5508 11999.5n 0.5508 12000.0n 0.5935 12599.5n 0.5935 12600.0n 0.6050 13199.5n 0.6050 13200.0n 0.5617 13799.5n 0.5617 13800.0n 0.4729 14399.5n 0.4729)
Vxn_wih_14_13 xn_wih_14_13 0 PWL(0.0n 0.3999 599.5n 0.3999 600.0n 0.4703 1199.5n 0.4703 1200.0n 0.4104 1799.5n 0.4104 1800.0n 0.4093 2399.5n 0.4093 2400.0n 0.4284 2999.5n 0.4284 3000.0n 0.3950 3599.5n 0.3950 3600.0n 0.3950 4199.5n 0.3950 4200.0n 0.4178 4799.5n 0.4178 4800.0n 0.3950 5399.5n 0.3950 5400.0n 0.4386 5999.5n 0.4386 6000.0n 0.3950 6599.5n 0.3950 6600.0n 0.3950 7199.5n 0.3950 7200.0n 0.5144 7799.5n 0.5144 7800.0n 0.4147 8399.5n 0.4147 8400.0n 0.4432 8999.5n 0.4432 9000.0n 0.4321 9599.5n 0.4321 9600.0n 0.4344 10199.5n 0.4344 10200.0n 0.4494 10799.5n 0.4494 10800.0n 0.4219 11399.5n 0.4219 11400.0n 0.4492 11999.5n 0.4492 12000.0n 0.4065 12599.5n 0.4065 12600.0n 0.3950 13199.5n 0.3950 13200.0n 0.4383 13799.5n 0.4383 13800.0n 0.5271 14399.5n 0.5271)
Vyp_wih_14_13 yp_wih_14_13 0 PWL(0.0n 0.5632 599.5n 0.5632 600.0n 0.5507 1199.5n 0.5507 1200.0n 0.5670 1799.5n 0.5670 1800.0n 0.5681 2399.5n 0.5681 2400.0n 0.5614 2999.5n 0.5614 3000.0n 0.5324 3599.5n 0.5324 3600.0n 0.5618 4199.5n 0.5618 4200.0n 0.5688 4799.5n 0.5688 4800.0n 0.5271 5399.5n 0.5271 5400.0n 0.5398 5999.5n 0.5398 6000.0n 0.5702 6599.5n 0.5702 6600.0n 0.5669 7199.5n 0.5669 7200.0n 0.5296 7799.5n 0.5296 7800.0n 0.5154 8399.5n 0.5154 8400.0n 0.5248 8999.5n 0.5248 9000.0n 0.5288 9599.5n 0.5288 9600.0n 0.5299 10199.5n 0.5299 10200.0n 0.5432 10799.5n 0.5432 10800.0n 0.5409 11399.5n 0.5409 11400.0n 0.5438 11999.5n 0.5438 12000.0n 0.5372 12599.5n 0.5372 12600.0n 0.4671 13199.5n 0.4671 13200.0n 0.5421 13799.5n 0.5421 13800.0n 0.5380 14399.5n 0.5380)
Vyn_wih_14_13 yn_wih_14_13 0 PWL(0.0n 0.4368 599.5n 0.4368 600.0n 0.4493 1199.5n 0.4493 1200.0n 0.4330 1799.5n 0.4330 1800.0n 0.4319 2399.5n 0.4319 2400.0n 0.4386 2999.5n 0.4386 3000.0n 0.4676 3599.5n 0.4676 3600.0n 0.4382 4199.5n 0.4382 4200.0n 0.4312 4799.5n 0.4312 4800.0n 0.4729 5399.5n 0.4729 5400.0n 0.4602 5999.5n 0.4602 6000.0n 0.4298 6599.5n 0.4298 6600.0n 0.4331 7199.5n 0.4331 7200.0n 0.4704 7799.5n 0.4704 7800.0n 0.4846 8399.5n 0.4846 8400.0n 0.4752 8999.5n 0.4752 9000.0n 0.4712 9599.5n 0.4712 9600.0n 0.4701 10199.5n 0.4701 10200.0n 0.4568 10799.5n 0.4568 10800.0n 0.4591 11399.5n 0.4591 11400.0n 0.4562 11999.5n 0.4562 12000.0n 0.4628 12599.5n 0.4628 12600.0n 0.5329 13199.5n 0.5329 13200.0n 0.4579 13799.5n 0.4579 13800.0n 0.4620 14399.5n 0.4620)
Cwp_wih_14_13 wp_wih_14_13 0 400p
Cwn_wih_14_13 wn_wih_14_13 0 400p
Xu_wih_14_13 xp_wih_14_13 xn_wih_14_13 yp_wih_14_13 yn_wih_14_13 wp_wih_14_13 wn_wih_14_13 vdd gbn gprod
Vxp_wih_15_13 xp_wih_15_13 0 PWL(0.0n 0.4097 599.5n 0.4097 600.0n 0.3950 1199.5n 0.3950 1200.0n 0.4001 1799.5n 0.4001 1800.0n 0.4045 2399.5n 0.4045 2400.0n 0.4045 2999.5n 0.4045 3000.0n 0.4589 3599.5n 0.4589 3600.0n 0.4133 4199.5n 0.4133 4200.0n 0.4178 4799.5n 0.4178 4800.0n 0.4512 5399.5n 0.4512 5400.0n 0.3950 5999.5n 0.3950 6000.0n 0.3994 6599.5n 0.3994 6600.0n 0.3998 7199.5n 0.3998 7200.0n 0.3950 7799.5n 0.3950 7800.0n 0.4344 8399.5n 0.4344 8400.0n 0.4088 8999.5n 0.4088 9000.0n 0.4279 9599.5n 0.4279 9600.0n 0.3950 10199.5n 0.3950 10200.0n 0.3950 10799.5n 0.3950 10800.0n 0.3950 11399.5n 0.3950 11400.0n 0.3950 11999.5n 0.3950 12000.0n 0.3950 12599.5n 0.3950 12600.0n 0.5231 13199.5n 0.5231 13200.0n 0.4017 13799.5n 0.4017 13800.0n 0.3950 14399.5n 0.3950)
Vxn_wih_15_13 xn_wih_15_13 0 PWL(0.0n 0.5903 599.5n 0.5903 600.0n 0.6050 1199.5n 0.6050 1200.0n 0.5999 1799.5n 0.5999 1800.0n 0.5955 2399.5n 0.5955 2400.0n 0.5955 2999.5n 0.5955 3000.0n 0.5411 3599.5n 0.5411 3600.0n 0.5867 4199.5n 0.5867 4200.0n 0.5822 4799.5n 0.5822 4800.0n 0.5488 5399.5n 0.5488 5400.0n 0.6050 5999.5n 0.6050 6000.0n 0.6006 6599.5n 0.6006 6600.0n 0.6002 7199.5n 0.6002 7200.0n 0.6050 7799.5n 0.6050 7800.0n 0.5656 8399.5n 0.5656 8400.0n 0.5912 8999.5n 0.5912 9000.0n 0.5721 9599.5n 0.5721 9600.0n 0.6050 10199.5n 0.6050 10200.0n 0.6050 10799.5n 0.6050 10800.0n 0.6050 11399.5n 0.6050 11400.0n 0.6050 11999.5n 0.6050 12000.0n 0.6050 12599.5n 0.6050 12600.0n 0.4769 13199.5n 0.4769 13200.0n 0.5983 13799.5n 0.5983 13800.0n 0.6050 14399.5n 0.6050)
Vyp_wih_15_13 yp_wih_15_13 0 PWL(0.0n 0.5632 599.5n 0.5632 600.0n 0.5507 1199.5n 0.5507 1200.0n 0.5670 1799.5n 0.5670 1800.0n 0.5681 2399.5n 0.5681 2400.0n 0.5614 2999.5n 0.5614 3000.0n 0.5324 3599.5n 0.5324 3600.0n 0.5618 4199.5n 0.5618 4200.0n 0.5688 4799.5n 0.5688 4800.0n 0.5271 5399.5n 0.5271 5400.0n 0.5398 5999.5n 0.5398 6000.0n 0.5702 6599.5n 0.5702 6600.0n 0.5669 7199.5n 0.5669 7200.0n 0.5296 7799.5n 0.5296 7800.0n 0.5154 8399.5n 0.5154 8400.0n 0.5248 8999.5n 0.5248 9000.0n 0.5288 9599.5n 0.5288 9600.0n 0.5299 10199.5n 0.5299 10200.0n 0.5432 10799.5n 0.5432 10800.0n 0.5409 11399.5n 0.5409 11400.0n 0.5438 11999.5n 0.5438 12000.0n 0.5372 12599.5n 0.5372 12600.0n 0.4671 13199.5n 0.4671 13200.0n 0.5421 13799.5n 0.5421 13800.0n 0.5380 14399.5n 0.5380)
Vyn_wih_15_13 yn_wih_15_13 0 PWL(0.0n 0.4368 599.5n 0.4368 600.0n 0.4493 1199.5n 0.4493 1200.0n 0.4330 1799.5n 0.4330 1800.0n 0.4319 2399.5n 0.4319 2400.0n 0.4386 2999.5n 0.4386 3000.0n 0.4676 3599.5n 0.4676 3600.0n 0.4382 4199.5n 0.4382 4200.0n 0.4312 4799.5n 0.4312 4800.0n 0.4729 5399.5n 0.4729 5400.0n 0.4602 5999.5n 0.4602 6000.0n 0.4298 6599.5n 0.4298 6600.0n 0.4331 7199.5n 0.4331 7200.0n 0.4704 7799.5n 0.4704 7800.0n 0.4846 8399.5n 0.4846 8400.0n 0.4752 8999.5n 0.4752 9000.0n 0.4712 9599.5n 0.4712 9600.0n 0.4701 10199.5n 0.4701 10200.0n 0.4568 10799.5n 0.4568 10800.0n 0.4591 11399.5n 0.4591 11400.0n 0.4562 11999.5n 0.4562 12000.0n 0.4628 12599.5n 0.4628 12600.0n 0.5329 13199.5n 0.5329 13200.0n 0.4579 13799.5n 0.4579 13800.0n 0.4620 14399.5n 0.4620)
Cwp_wih_15_13 wp_wih_15_13 0 400p
Cwn_wih_15_13 wn_wih_15_13 0 400p
Xu_wih_15_13 xp_wih_15_13 xn_wih_15_13 yp_wih_15_13 yn_wih_15_13 wp_wih_15_13 wn_wih_15_13 vdd gbn gprod
Vxp_who_13_0 xp_who_13_0 0 PWL(0.0n 0.5632 599.5n 0.5632 600.0n 0.5507 1199.5n 0.5507 1200.0n 0.5670 1799.5n 0.5670 1800.0n 0.5681 2399.5n 0.5681 2400.0n 0.5614 2999.5n 0.5614 3000.0n 0.5324 3599.5n 0.5324 3600.0n 0.5618 4199.5n 0.5618 4200.0n 0.5688 4799.5n 0.5688 4800.0n 0.5271 5399.5n 0.5271 5400.0n 0.5398 5999.5n 0.5398 6000.0n 0.5702 6599.5n 0.5702 6600.0n 0.5669 7199.5n 0.5669 7200.0n 0.5296 7799.5n 0.5296 7800.0n 0.5154 8399.5n 0.5154 8400.0n 0.5248 8999.5n 0.5248 9000.0n 0.5288 9599.5n 0.5288 9600.0n 0.5299 10199.5n 0.5299 10200.0n 0.5432 10799.5n 0.5432 10800.0n 0.5409 11399.5n 0.5409 11400.0n 0.5438 11999.5n 0.5438 12000.0n 0.5372 12599.5n 0.5372 12600.0n 0.4671 13199.5n 0.4671 13200.0n 0.5421 13799.5n 0.5421 13800.0n 0.5380 14399.5n 0.5380)
Vxn_who_13_0 xn_who_13_0 0 PWL(0.0n 0.4368 599.5n 0.4368 600.0n 0.4493 1199.5n 0.4493 1200.0n 0.4330 1799.5n 0.4330 1800.0n 0.4319 2399.5n 0.4319 2400.0n 0.4386 2999.5n 0.4386 3000.0n 0.4676 3599.5n 0.4676 3600.0n 0.4382 4199.5n 0.4382 4200.0n 0.4312 4799.5n 0.4312 4800.0n 0.4729 5399.5n 0.4729 5400.0n 0.4602 5999.5n 0.4602 6000.0n 0.4298 6599.5n 0.4298 6600.0n 0.4331 7199.5n 0.4331 7200.0n 0.4704 7799.5n 0.4704 7800.0n 0.4846 8399.5n 0.4846 8400.0n 0.4752 8999.5n 0.4752 9000.0n 0.4712 9599.5n 0.4712 9600.0n 0.4701 10199.5n 0.4701 10200.0n 0.4568 10799.5n 0.4568 10800.0n 0.4591 11399.5n 0.4591 11400.0n 0.4562 11999.5n 0.4562 12000.0n 0.4628 12599.5n 0.4628 12600.0n 0.5329 13199.5n 0.5329 13200.0n 0.4579 13799.5n 0.4579 13800.0n 0.4620 14399.5n 0.4620)
Vyp_who_13_0 yp_who_13_0 0 PWL(0.0n 0.5073 599.5n 0.5073 600.0n 0.5065 1199.5n 0.5065 1200.0n 0.5065 1799.5n 0.5065 1800.0n 0.5052 2399.5n 0.5052 2400.0n 0.5058 2999.5n 0.5058 3000.0n 0.5039 3599.5n 0.5039 3600.0n 0.5059 4199.5n 0.5059 4200.0n 0.5077 4799.5n 0.5077 4800.0n 0.5054 5399.5n 0.5054 5400.0n 0.5066 5999.5n 0.5066 6000.0n 0.5083 6599.5n 0.5083 6600.0n 0.5078 7199.5n 0.5078 7200.0n 0.5043 7799.5n 0.5043 7800.0n 0.5035 8399.5n 0.5035 8400.0n 0.5035 8999.5n 0.5035 9000.0n 0.5038 9599.5n 0.5038 9600.0n 0.5043 10199.5n 0.5043 10200.0n 0.5053 10799.5n 0.5053 10800.0n 0.5050 11399.5n 0.5050 11400.0n 0.5055 11999.5n 0.5055 12000.0n 0.5043 12599.5n 0.5043 12600.0n 0.5028 13199.5n 0.5028 13200.0n 0.5045 13799.5n 0.5045 13800.0n 0.5043 14399.5n 0.5043)
Vyn_who_13_0 yn_who_13_0 0 PWL(0.0n 0.4927 599.5n 0.4927 600.0n 0.4935 1199.5n 0.4935 1200.0n 0.4935 1799.5n 0.4935 1800.0n 0.4948 2399.5n 0.4948 2400.0n 0.4942 2999.5n 0.4942 3000.0n 0.4961 3599.5n 0.4961 3600.0n 0.4941 4199.5n 0.4941 4200.0n 0.4923 4799.5n 0.4923 4800.0n 0.4946 5399.5n 0.4946 5400.0n 0.4934 5999.5n 0.4934 6000.0n 0.4917 6599.5n 0.4917 6600.0n 0.4922 7199.5n 0.4922 7200.0n 0.4957 7799.5n 0.4957 7800.0n 0.4965 8399.5n 0.4965 8400.0n 0.4965 8999.5n 0.4965 9000.0n 0.4962 9599.5n 0.4962 9600.0n 0.4957 10199.5n 0.4957 10200.0n 0.4947 10799.5n 0.4947 10800.0n 0.4950 11399.5n 0.4950 11400.0n 0.4945 11999.5n 0.4945 12000.0n 0.4957 12599.5n 0.4957 12600.0n 0.4972 13199.5n 0.4972 13200.0n 0.4955 13799.5n 0.4955 13800.0n 0.4957 14399.5n 0.4957)
Cwp_who_13_0 wp_who_13_0 0 400p
Cwn_who_13_0 wn_who_13_0 0 400p
Xu_who_13_0 xp_who_13_0 xn_who_13_0 yp_who_13_0 yn_who_13_0 wp_who_13_0 wn_who_13_0 vdd gbn gprod
Vxp_who_13_1 xp_who_13_1 0 PWL(0.0n 0.5632 599.5n 0.5632 600.0n 0.5507 1199.5n 0.5507 1200.0n 0.5670 1799.5n 0.5670 1800.0n 0.5681 2399.5n 0.5681 2400.0n 0.5614 2999.5n 0.5614 3000.0n 0.5324 3599.5n 0.5324 3600.0n 0.5618 4199.5n 0.5618 4200.0n 0.5688 4799.5n 0.5688 4800.0n 0.5271 5399.5n 0.5271 5400.0n 0.5398 5999.5n 0.5398 6000.0n 0.5702 6599.5n 0.5702 6600.0n 0.5669 7199.5n 0.5669 7200.0n 0.5296 7799.5n 0.5296 7800.0n 0.5154 8399.5n 0.5154 8400.0n 0.5248 8999.5n 0.5248 9000.0n 0.5288 9599.5n 0.5288 9600.0n 0.5299 10199.5n 0.5299 10200.0n 0.5432 10799.5n 0.5432 10800.0n 0.5409 11399.5n 0.5409 11400.0n 0.5438 11999.5n 0.5438 12000.0n 0.5372 12599.5n 0.5372 12600.0n 0.4671 13199.5n 0.4671 13200.0n 0.5421 13799.5n 0.5421 13800.0n 0.5380 14399.5n 0.5380)
Vxn_who_13_1 xn_who_13_1 0 PWL(0.0n 0.4368 599.5n 0.4368 600.0n 0.4493 1199.5n 0.4493 1200.0n 0.4330 1799.5n 0.4330 1800.0n 0.4319 2399.5n 0.4319 2400.0n 0.4386 2999.5n 0.4386 3000.0n 0.4676 3599.5n 0.4676 3600.0n 0.4382 4199.5n 0.4382 4200.0n 0.4312 4799.5n 0.4312 4800.0n 0.4729 5399.5n 0.4729 5400.0n 0.4602 5999.5n 0.4602 6000.0n 0.4298 6599.5n 0.4298 6600.0n 0.4331 7199.5n 0.4331 7200.0n 0.4704 7799.5n 0.4704 7800.0n 0.4846 8399.5n 0.4846 8400.0n 0.4752 8999.5n 0.4752 9000.0n 0.4712 9599.5n 0.4712 9600.0n 0.4701 10199.5n 0.4701 10200.0n 0.4568 10799.5n 0.4568 10800.0n 0.4591 11399.5n 0.4591 11400.0n 0.4562 11999.5n 0.4562 12000.0n 0.4628 12599.5n 0.4628 12600.0n 0.5329 13199.5n 0.5329 13200.0n 0.4579 13799.5n 0.4579 13800.0n 0.4620 14399.5n 0.4620)
Vyp_who_13_1 yp_who_13_1 0 PWL(0.0n 0.4909 599.5n 0.4909 600.0n 0.4933 1199.5n 0.4933 1200.0n 0.4930 1799.5n 0.4930 1800.0n 0.4893 2399.5n 0.4893 2400.0n 0.4904 2999.5n 0.4904 3000.0n 0.4923 3599.5n 0.4923 3600.0n 0.4897 4199.5n 0.4897 4200.0n 0.4890 4799.5n 0.4890 4800.0n 0.4921 5399.5n 0.4921 5400.0n 0.4899 5999.5n 0.4899 6000.0n 0.4870 6599.5n 0.4870 6600.0n 0.4903 7199.5n 0.4903 7200.0n 0.4970 7799.5n 0.4970 7800.0n 0.4989 8399.5n 0.4989 8400.0n 0.4994 8999.5n 0.4994 9000.0n 0.4991 9599.5n 0.4991 9600.0n 0.5000 10199.5n 0.5000 10200.0n 0.4948 10799.5n 0.4948 10800.0n 0.4959 11399.5n 0.4959 11400.0n 0.4926 11999.5n 0.4926 12000.0n 0.4993 12599.5n 0.4993 12600.0n 0.4862 13199.5n 0.4862 13200.0n 0.4993 13799.5n 0.4993 13800.0n 0.4961 14399.5n 0.4961)
Vyn_who_13_1 yn_who_13_1 0 PWL(0.0n 0.5091 599.5n 0.5091 600.0n 0.5067 1199.5n 0.5067 1200.0n 0.5070 1799.5n 0.5070 1800.0n 0.5107 2399.5n 0.5107 2400.0n 0.5096 2999.5n 0.5096 3000.0n 0.5077 3599.5n 0.5077 3600.0n 0.5103 4199.5n 0.5103 4200.0n 0.5110 4799.5n 0.5110 4800.0n 0.5079 5399.5n 0.5079 5400.0n 0.5101 5999.5n 0.5101 6000.0n 0.5130 6599.5n 0.5130 6600.0n 0.5097 7199.5n 0.5097 7200.0n 0.5030 7799.5n 0.5030 7800.0n 0.5011 8399.5n 0.5011 8400.0n 0.5006 8999.5n 0.5006 9000.0n 0.5009 9599.5n 0.5009 9600.0n 0.5000 10199.5n 0.5000 10200.0n 0.5052 10799.5n 0.5052 10800.0n 0.5041 11399.5n 0.5041 11400.0n 0.5074 11999.5n 0.5074 12000.0n 0.5007 12599.5n 0.5007 12600.0n 0.5138 13199.5n 0.5138 13200.0n 0.5007 13799.5n 0.5007 13800.0n 0.5039 14399.5n 0.5039)
Cwp_who_13_1 wp_who_13_1 0 400p
Cwn_who_13_1 wn_who_13_1 0 400p
Xu_who_13_1 xp_who_13_1 xn_who_13_1 yp_who_13_1 yn_who_13_1 wp_who_13_1 wn_who_13_1 vdd gbn gprod
Vxp_bh_13 xp_bh_13 0 PWL(0.0n 0.7100 599.5n 0.7100 600.0n 0.7100 1199.5n 0.7100 1200.0n 0.7100 1799.5n 0.7100 1800.0n 0.7100 2399.5n 0.7100 2400.0n 0.7100 2999.5n 0.7100 3000.0n 0.7100 3599.5n 0.7100 3600.0n 0.7100 4199.5n 0.7100 4200.0n 0.7100 4799.5n 0.7100 4800.0n 0.7100 5399.5n 0.7100 5400.0n 0.7100 5999.5n 0.7100 6000.0n 0.7100 6599.5n 0.7100 6600.0n 0.7100 7199.5n 0.7100 7200.0n 0.7100 7799.5n 0.7100 7800.0n 0.7100 8399.5n 0.7100 8400.0n 0.7100 8999.5n 0.7100 9000.0n 0.7100 9599.5n 0.7100 9600.0n 0.7100 10199.5n 0.7100 10200.0n 0.7100 10799.5n 0.7100 10800.0n 0.7100 11399.5n 0.7100 11400.0n 0.7100 11999.5n 0.7100 12000.0n 0.7100 12599.5n 0.7100 12600.0n 0.7100 13199.5n 0.7100 13200.0n 0.7100 13799.5n 0.7100 13800.0n 0.7100 14399.5n 0.7100)
Vxn_bh_13 xn_bh_13 0 PWL(0.0n 0.2900 599.5n 0.2900 600.0n 0.2900 1199.5n 0.2900 1200.0n 0.2900 1799.5n 0.2900 1800.0n 0.2900 2399.5n 0.2900 2400.0n 0.2900 2999.5n 0.2900 3000.0n 0.2900 3599.5n 0.2900 3600.0n 0.2900 4199.5n 0.2900 4200.0n 0.2900 4799.5n 0.2900 4800.0n 0.2900 5399.5n 0.2900 5400.0n 0.2900 5999.5n 0.2900 6000.0n 0.2900 6599.5n 0.2900 6600.0n 0.2900 7199.5n 0.2900 7200.0n 0.2900 7799.5n 0.2900 7800.0n 0.2900 8399.5n 0.2900 8400.0n 0.2900 8999.5n 0.2900 9000.0n 0.2900 9599.5n 0.2900 9600.0n 0.2900 10199.5n 0.2900 10200.0n 0.2900 10799.5n 0.2900 10800.0n 0.2900 11399.5n 0.2900 11400.0n 0.2900 11999.5n 0.2900 12000.0n 0.2900 12599.5n 0.2900 12600.0n 0.2900 13199.5n 0.2900 13200.0n 0.2900 13799.5n 0.2900 13800.0n 0.2900 14399.5n 0.2900)
Vyp_bh_13 yp_bh_13 0 PWL(0.0n 0.5632 599.5n 0.5632 600.0n 0.5507 1199.5n 0.5507 1200.0n 0.5670 1799.5n 0.5670 1800.0n 0.5681 2399.5n 0.5681 2400.0n 0.5614 2999.5n 0.5614 3000.0n 0.5324 3599.5n 0.5324 3600.0n 0.5618 4199.5n 0.5618 4200.0n 0.5688 4799.5n 0.5688 4800.0n 0.5271 5399.5n 0.5271 5400.0n 0.5398 5999.5n 0.5398 6000.0n 0.5702 6599.5n 0.5702 6600.0n 0.5669 7199.5n 0.5669 7200.0n 0.5296 7799.5n 0.5296 7800.0n 0.5154 8399.5n 0.5154 8400.0n 0.5248 8999.5n 0.5248 9000.0n 0.5288 9599.5n 0.5288 9600.0n 0.5299 10199.5n 0.5299 10200.0n 0.5432 10799.5n 0.5432 10800.0n 0.5409 11399.5n 0.5409 11400.0n 0.5438 11999.5n 0.5438 12000.0n 0.5372 12599.5n 0.5372 12600.0n 0.4671 13199.5n 0.4671 13200.0n 0.5421 13799.5n 0.5421 13800.0n 0.5380 14399.5n 0.5380)
Vyn_bh_13 yn_bh_13 0 PWL(0.0n 0.4368 599.5n 0.4368 600.0n 0.4493 1199.5n 0.4493 1200.0n 0.4330 1799.5n 0.4330 1800.0n 0.4319 2399.5n 0.4319 2400.0n 0.4386 2999.5n 0.4386 3000.0n 0.4676 3599.5n 0.4676 3600.0n 0.4382 4199.5n 0.4382 4200.0n 0.4312 4799.5n 0.4312 4800.0n 0.4729 5399.5n 0.4729 5400.0n 0.4602 5999.5n 0.4602 6000.0n 0.4298 6599.5n 0.4298 6600.0n 0.4331 7199.5n 0.4331 7200.0n 0.4704 7799.5n 0.4704 7800.0n 0.4846 8399.5n 0.4846 8400.0n 0.4752 8999.5n 0.4752 9000.0n 0.4712 9599.5n 0.4712 9600.0n 0.4701 10199.5n 0.4701 10200.0n 0.4568 10799.5n 0.4568 10800.0n 0.4591 11399.5n 0.4591 11400.0n 0.4562 11999.5n 0.4562 12000.0n 0.4628 12599.5n 0.4628 12600.0n 0.5329 13199.5n 0.5329 13200.0n 0.4579 13799.5n 0.4579 13800.0n 0.4620 14399.5n 0.4620)
Cwp_bh_13 wp_bh_13 0 400p
Cwn_bh_13 wn_bh_13 0 400p
Xu_bh_13 xp_bh_13 xn_bh_13 yp_bh_13 yn_bh_13 wp_bh_13 wn_bh_13 vdd gbn gprod
Vxp_wih_10_14 xp_wih_10_14 0 PWL(0.0n 0.4780 599.5n 0.4780 600.0n 0.4782 1199.5n 0.4782 1200.0n 0.4616 1799.5n 0.4616 1800.0n 0.4427 2399.5n 0.4427 2400.0n 0.4570 2999.5n 0.4570 3000.0n 0.4178 3599.5n 0.4178 3600.0n 0.4817 4199.5n 0.4817 4200.0n 0.4270 4799.5n 0.4270 4800.0n 0.4662 5399.5n 0.4662 5400.0n 0.5654 5999.5n 0.5654 6000.0n 0.4694 6599.5n 0.4694 6600.0n 0.4809 7199.5n 0.4809 7200.0n 0.5515 7799.5n 0.5515 7800.0n 0.5820 8399.5n 0.5820 8400.0n 0.5809 8999.5n 0.5809 9000.0n 0.5432 9599.5n 0.5432 9600.0n 0.6050 10199.5n 0.6050 10200.0n 0.5272 10799.5n 0.5272 10800.0n 0.5727 11399.5n 0.5727 11400.0n 0.5237 11999.5n 0.5237 12000.0n 0.6050 12599.5n 0.6050 12600.0n 0.5374 13199.5n 0.5374 13200.0n 0.5350 13799.5n 0.5350 13800.0n 0.4763 14399.5n 0.4763)
Vxn_wih_10_14 xn_wih_10_14 0 PWL(0.0n 0.5220 599.5n 0.5220 600.0n 0.5218 1199.5n 0.5218 1200.0n 0.5384 1799.5n 0.5384 1800.0n 0.5573 2399.5n 0.5573 2400.0n 0.5430 2999.5n 0.5430 3000.0n 0.5822 3599.5n 0.5822 3600.0n 0.5183 4199.5n 0.5183 4200.0n 0.5730 4799.5n 0.5730 4800.0n 0.5338 5399.5n 0.5338 5400.0n 0.4346 5999.5n 0.4346 6000.0n 0.5306 6599.5n 0.5306 6600.0n 0.5191 7199.5n 0.5191 7200.0n 0.4485 7799.5n 0.4485 7800.0n 0.4180 8399.5n 0.4180 8400.0n 0.4191 8999.5n 0.4191 9000.0n 0.4568 9599.5n 0.4568 9600.0n 0.3950 10199.5n 0.3950 10200.0n 0.4728 10799.5n 0.4728 10800.0n 0.4273 11399.5n 0.4273 11400.0n 0.4763 11999.5n 0.4763 12000.0n 0.3950 12599.5n 0.3950 12600.0n 0.4626 13199.5n 0.4626 13200.0n 0.4650 13799.5n 0.4650 13800.0n 0.5237 14399.5n 0.5237)
Vyp_wih_10_14 yp_wih_10_14 0 PWL(0.0n 0.5011 599.5n 0.5011 600.0n 0.4723 1199.5n 0.4723 1200.0n 0.4862 1799.5n 0.4862 1800.0n 0.4622 2399.5n 0.4622 2400.0n 0.4699 2999.5n 0.4699 3000.0n 0.3893 3599.5n 0.3893 3600.0n 0.4994 4199.5n 0.4994 4200.0n 0.4336 4799.5n 0.4336 4800.0n 0.4526 5399.5n 0.4526 5400.0n 0.5781 5999.5n 0.5781 6000.0n 0.4966 6599.5n 0.4966 6600.0n 0.5094 7199.5n 0.5094 7200.0n 0.5293 7799.5n 0.5293 7800.0n 0.5861 8399.5n 0.5861 8400.0n 0.5869 8999.5n 0.5869 9000.0n 0.5339 9599.5n 0.5339 9600.0n 0.6081 10199.5n 0.6081 10200.0n 0.5280 10799.5n 0.5280 10800.0n 0.6006 11399.5n 0.6006 11400.0n 0.5261 11999.5n 0.5261 12000.0n 0.6239 12599.5n 0.6239 12600.0n 0.4983 13199.5n 0.4983 13200.0n 0.5388 13799.5n 0.5388 13800.0n 0.4654 14399.5n 0.4654)
Vyn_wih_10_14 yn_wih_10_14 0 PWL(0.0n 0.4989 599.5n 0.4989 600.0n 0.5277 1199.5n 0.5277 1200.0n 0.5138 1799.5n 0.5138 1800.0n 0.5378 2399.5n 0.5378 2400.0n 0.5301 2999.5n 0.5301 3000.0n 0.6107 3599.5n 0.6107 3600.0n 0.5006 4199.5n 0.5006 4200.0n 0.5664 4799.5n 0.5664 4800.0n 0.5474 5399.5n 0.5474 5400.0n 0.4219 5999.5n 0.4219 6000.0n 0.5034 6599.5n 0.5034 6600.0n 0.4906 7199.5n 0.4906 7200.0n 0.4707 7799.5n 0.4707 7800.0n 0.4139 8399.5n 0.4139 8400.0n 0.4131 8999.5n 0.4131 9000.0n 0.4661 9599.5n 0.4661 9600.0n 0.3919 10199.5n 0.3919 10200.0n 0.4720 10799.5n 0.4720 10800.0n 0.3994 11399.5n 0.3994 11400.0n 0.4739 11999.5n 0.4739 12000.0n 0.3761 12599.5n 0.3761 12600.0n 0.5017 13199.5n 0.5017 13200.0n 0.4612 13799.5n 0.4612 13800.0n 0.5346 14399.5n 0.5346)
Cwp_wih_10_14 wp_wih_10_14 0 400p
Cwn_wih_10_14 wn_wih_10_14 0 400p
Xu_wih_10_14 xp_wih_10_14 xn_wih_10_14 yp_wih_10_14 yn_wih_10_14 wp_wih_10_14 wn_wih_10_14 vdd gbn gprod
Vxp_wih_11_14 xp_wih_11_14 0 PWL(0.0n 0.4536 599.5n 0.4536 600.0n 0.4386 1199.5n 0.4386 1200.0n 0.4565 1799.5n 0.4565 1800.0n 0.4618 2399.5n 0.4618 2400.0n 0.4666 2999.5n 0.4666 3000.0n 0.5046 3599.5n 0.5046 3600.0n 0.4772 4199.5n 0.4772 4200.0n 0.4635 4799.5n 0.4635 4800.0n 0.4887 5399.5n 0.4887 5400.0n 0.4108 5999.5n 0.4108 6000.0n 0.4694 6599.5n 0.4694 6600.0n 0.4475 7199.5n 0.4475 7200.0n 0.3950 7799.5n 0.3950 7800.0n 0.4212 8399.5n 0.4212 8400.0n 0.3950 8999.5n 0.3950 9000.0n 0.4238 9599.5n 0.4238 9600.0n 0.4048 10199.5n 0.4048 10200.0n 0.3950 10799.5n 0.3950 10800.0n 0.3950 11399.5n 0.3950 11400.0n 0.3950 11999.5n 0.3950 12000.0n 0.3950 12599.5n 0.3950 12600.0n 0.3950 13199.5n 0.3950 13200.0n 0.3950 13799.5n 0.3950 13800.0n 0.3950 14399.5n 0.3950)
Vxn_wih_11_14 xn_wih_11_14 0 PWL(0.0n 0.5464 599.5n 0.5464 600.0n 0.5614 1199.5n 0.5614 1200.0n 0.5435 1799.5n 0.5435 1800.0n 0.5382 2399.5n 0.5382 2400.0n 0.5334 2999.5n 0.5334 3000.0n 0.4954 3599.5n 0.4954 3600.0n 0.5228 4199.5n 0.5228 4200.0n 0.5365 4799.5n 0.5365 4800.0n 0.5113 5399.5n 0.5113 5400.0n 0.5892 5999.5n 0.5892 6000.0n 0.5306 6599.5n 0.5306 6600.0n 0.5525 7199.5n 0.5525 7200.0n 0.6050 7799.5n 0.6050 7800.0n 0.5788 8399.5n 0.5788 8400.0n 0.6050 8999.5n 0.6050 9000.0n 0.5762 9599.5n 0.5762 9600.0n 0.5952 10199.5n 0.5952 10200.0n 0.6050 10799.5n 0.6050 10800.0n 0.6050 11399.5n 0.6050 11400.0n 0.6050 11999.5n 0.6050 12000.0n 0.6050 12599.5n 0.6050 12600.0n 0.6050 13199.5n 0.6050 13200.0n 0.6050 13799.5n 0.6050 13800.0n 0.6050 14399.5n 0.6050)
Vyp_wih_11_14 yp_wih_11_14 0 PWL(0.0n 0.5011 599.5n 0.5011 600.0n 0.4723 1199.5n 0.4723 1200.0n 0.4862 1799.5n 0.4862 1800.0n 0.4622 2399.5n 0.4622 2400.0n 0.4699 2999.5n 0.4699 3000.0n 0.3893 3599.5n 0.3893 3600.0n 0.4994 4199.5n 0.4994 4200.0n 0.4336 4799.5n 0.4336 4800.0n 0.4526 5399.5n 0.4526 5400.0n 0.5781 5999.5n 0.5781 6000.0n 0.4966 6599.5n 0.4966 6600.0n 0.5094 7199.5n 0.5094 7200.0n 0.5293 7799.5n 0.5293 7800.0n 0.5861 8399.5n 0.5861 8400.0n 0.5869 8999.5n 0.5869 9000.0n 0.5339 9599.5n 0.5339 9600.0n 0.6081 10199.5n 0.6081 10200.0n 0.5280 10799.5n 0.5280 10800.0n 0.6006 11399.5n 0.6006 11400.0n 0.5261 11999.5n 0.5261 12000.0n 0.6239 12599.5n 0.6239 12600.0n 0.4983 13199.5n 0.4983 13200.0n 0.5388 13799.5n 0.5388 13800.0n 0.4654 14399.5n 0.4654)
Vyn_wih_11_14 yn_wih_11_14 0 PWL(0.0n 0.4989 599.5n 0.4989 600.0n 0.5277 1199.5n 0.5277 1200.0n 0.5138 1799.5n 0.5138 1800.0n 0.5378 2399.5n 0.5378 2400.0n 0.5301 2999.5n 0.5301 3000.0n 0.6107 3599.5n 0.6107 3600.0n 0.5006 4199.5n 0.5006 4200.0n 0.5664 4799.5n 0.5664 4800.0n 0.5474 5399.5n 0.5474 5400.0n 0.4219 5999.5n 0.4219 6000.0n 0.5034 6599.5n 0.5034 6600.0n 0.4906 7199.5n 0.4906 7200.0n 0.4707 7799.5n 0.4707 7800.0n 0.4139 8399.5n 0.4139 8400.0n 0.4131 8999.5n 0.4131 9000.0n 0.4661 9599.5n 0.4661 9600.0n 0.3919 10199.5n 0.3919 10200.0n 0.4720 10799.5n 0.4720 10800.0n 0.3994 11399.5n 0.3994 11400.0n 0.4739 11999.5n 0.4739 12000.0n 0.3761 12599.5n 0.3761 12600.0n 0.5017 13199.5n 0.5017 13200.0n 0.4612 13799.5n 0.4612 13800.0n 0.5346 14399.5n 0.5346)
Cwp_wih_11_14 wp_wih_11_14 0 400p
Cwn_wih_11_14 wn_wih_11_14 0 400p
Xu_wih_11_14 xp_wih_11_14 xn_wih_11_14 yp_wih_11_14 yn_wih_11_14 wp_wih_11_14 wn_wih_11_14 vdd gbn gprod
Vxp_wih_14_14 xp_wih_14_14 0 PWL(0.0n 0.6001 599.5n 0.6001 600.0n 0.5297 1199.5n 0.5297 1200.0n 0.5896 1799.5n 0.5896 1800.0n 0.5907 2399.5n 0.5907 2400.0n 0.5716 2999.5n 0.5716 3000.0n 0.6050 3599.5n 0.6050 3600.0n 0.6050 4199.5n 0.6050 4200.0n 0.5822 4799.5n 0.5822 4800.0n 0.6050 5399.5n 0.6050 5400.0n 0.5614 5999.5n 0.5614 6000.0n 0.6050 6599.5n 0.6050 6600.0n 0.6050 7199.5n 0.6050 7200.0n 0.4856 7799.5n 0.4856 7800.0n 0.5853 8399.5n 0.5853 8400.0n 0.5568 8999.5n 0.5568 9000.0n 0.5679 9599.5n 0.5679 9600.0n 0.5656 10199.5n 0.5656 10200.0n 0.5506 10799.5n 0.5506 10800.0n 0.5781 11399.5n 0.5781 11400.0n 0.5508 11999.5n 0.5508 12000.0n 0.5935 12599.5n 0.5935 12600.0n 0.6050 13199.5n 0.6050 13200.0n 0.5617 13799.5n 0.5617 13800.0n 0.4729 14399.5n 0.4729)
Vxn_wih_14_14 xn_wih_14_14 0 PWL(0.0n 0.3999 599.5n 0.3999 600.0n 0.4703 1199.5n 0.4703 1200.0n 0.4104 1799.5n 0.4104 1800.0n 0.4093 2399.5n 0.4093 2400.0n 0.4284 2999.5n 0.4284 3000.0n 0.3950 3599.5n 0.3950 3600.0n 0.3950 4199.5n 0.3950 4200.0n 0.4178 4799.5n 0.4178 4800.0n 0.3950 5399.5n 0.3950 5400.0n 0.4386 5999.5n 0.4386 6000.0n 0.3950 6599.5n 0.3950 6600.0n 0.3950 7199.5n 0.3950 7200.0n 0.5144 7799.5n 0.5144 7800.0n 0.4147 8399.5n 0.4147 8400.0n 0.4432 8999.5n 0.4432 9000.0n 0.4321 9599.5n 0.4321 9600.0n 0.4344 10199.5n 0.4344 10200.0n 0.4494 10799.5n 0.4494 10800.0n 0.4219 11399.5n 0.4219 11400.0n 0.4492 11999.5n 0.4492 12000.0n 0.4065 12599.5n 0.4065 12600.0n 0.3950 13199.5n 0.3950 13200.0n 0.4383 13799.5n 0.4383 13800.0n 0.5271 14399.5n 0.5271)
Vyp_wih_14_14 yp_wih_14_14 0 PWL(0.0n 0.5011 599.5n 0.5011 600.0n 0.4723 1199.5n 0.4723 1200.0n 0.4862 1799.5n 0.4862 1800.0n 0.4622 2399.5n 0.4622 2400.0n 0.4699 2999.5n 0.4699 3000.0n 0.3893 3599.5n 0.3893 3600.0n 0.4994 4199.5n 0.4994 4200.0n 0.4336 4799.5n 0.4336 4800.0n 0.4526 5399.5n 0.4526 5400.0n 0.5781 5999.5n 0.5781 6000.0n 0.4966 6599.5n 0.4966 6600.0n 0.5094 7199.5n 0.5094 7200.0n 0.5293 7799.5n 0.5293 7800.0n 0.5861 8399.5n 0.5861 8400.0n 0.5869 8999.5n 0.5869 9000.0n 0.5339 9599.5n 0.5339 9600.0n 0.6081 10199.5n 0.6081 10200.0n 0.5280 10799.5n 0.5280 10800.0n 0.6006 11399.5n 0.6006 11400.0n 0.5261 11999.5n 0.5261 12000.0n 0.6239 12599.5n 0.6239 12600.0n 0.4983 13199.5n 0.4983 13200.0n 0.5388 13799.5n 0.5388 13800.0n 0.4654 14399.5n 0.4654)
Vyn_wih_14_14 yn_wih_14_14 0 PWL(0.0n 0.4989 599.5n 0.4989 600.0n 0.5277 1199.5n 0.5277 1200.0n 0.5138 1799.5n 0.5138 1800.0n 0.5378 2399.5n 0.5378 2400.0n 0.5301 2999.5n 0.5301 3000.0n 0.6107 3599.5n 0.6107 3600.0n 0.5006 4199.5n 0.5006 4200.0n 0.5664 4799.5n 0.5664 4800.0n 0.5474 5399.5n 0.5474 5400.0n 0.4219 5999.5n 0.4219 6000.0n 0.5034 6599.5n 0.5034 6600.0n 0.4906 7199.5n 0.4906 7200.0n 0.4707 7799.5n 0.4707 7800.0n 0.4139 8399.5n 0.4139 8400.0n 0.4131 8999.5n 0.4131 9000.0n 0.4661 9599.5n 0.4661 9600.0n 0.3919 10199.5n 0.3919 10200.0n 0.4720 10799.5n 0.4720 10800.0n 0.3994 11399.5n 0.3994 11400.0n 0.4739 11999.5n 0.4739 12000.0n 0.3761 12599.5n 0.3761 12600.0n 0.5017 13199.5n 0.5017 13200.0n 0.4612 13799.5n 0.4612 13800.0n 0.5346 14399.5n 0.5346)
Cwp_wih_14_14 wp_wih_14_14 0 400p
Cwn_wih_14_14 wn_wih_14_14 0 400p
Xu_wih_14_14 xp_wih_14_14 xn_wih_14_14 yp_wih_14_14 yn_wih_14_14 wp_wih_14_14 wn_wih_14_14 vdd gbn gprod
Vxp_wih_15_14 xp_wih_15_14 0 PWL(0.0n 0.4097 599.5n 0.4097 600.0n 0.3950 1199.5n 0.3950 1200.0n 0.4001 1799.5n 0.4001 1800.0n 0.4045 2399.5n 0.4045 2400.0n 0.4045 2999.5n 0.4045 3000.0n 0.4589 3599.5n 0.4589 3600.0n 0.4133 4199.5n 0.4133 4200.0n 0.4178 4799.5n 0.4178 4800.0n 0.4512 5399.5n 0.4512 5400.0n 0.3950 5999.5n 0.3950 6000.0n 0.3994 6599.5n 0.3994 6600.0n 0.3998 7199.5n 0.3998 7200.0n 0.3950 7799.5n 0.3950 7800.0n 0.4344 8399.5n 0.4344 8400.0n 0.4088 8999.5n 0.4088 9000.0n 0.4279 9599.5n 0.4279 9600.0n 0.3950 10199.5n 0.3950 10200.0n 0.3950 10799.5n 0.3950 10800.0n 0.3950 11399.5n 0.3950 11400.0n 0.3950 11999.5n 0.3950 12000.0n 0.3950 12599.5n 0.3950 12600.0n 0.5231 13199.5n 0.5231 13200.0n 0.4017 13799.5n 0.4017 13800.0n 0.3950 14399.5n 0.3950)
Vxn_wih_15_14 xn_wih_15_14 0 PWL(0.0n 0.5903 599.5n 0.5903 600.0n 0.6050 1199.5n 0.6050 1200.0n 0.5999 1799.5n 0.5999 1800.0n 0.5955 2399.5n 0.5955 2400.0n 0.5955 2999.5n 0.5955 3000.0n 0.5411 3599.5n 0.5411 3600.0n 0.5867 4199.5n 0.5867 4200.0n 0.5822 4799.5n 0.5822 4800.0n 0.5488 5399.5n 0.5488 5400.0n 0.6050 5999.5n 0.6050 6000.0n 0.6006 6599.5n 0.6006 6600.0n 0.6002 7199.5n 0.6002 7200.0n 0.6050 7799.5n 0.6050 7800.0n 0.5656 8399.5n 0.5656 8400.0n 0.5912 8999.5n 0.5912 9000.0n 0.5721 9599.5n 0.5721 9600.0n 0.6050 10199.5n 0.6050 10200.0n 0.6050 10799.5n 0.6050 10800.0n 0.6050 11399.5n 0.6050 11400.0n 0.6050 11999.5n 0.6050 12000.0n 0.6050 12599.5n 0.6050 12600.0n 0.4769 13199.5n 0.4769 13200.0n 0.5983 13799.5n 0.5983 13800.0n 0.6050 14399.5n 0.6050)
Vyp_wih_15_14 yp_wih_15_14 0 PWL(0.0n 0.5011 599.5n 0.5011 600.0n 0.4723 1199.5n 0.4723 1200.0n 0.4862 1799.5n 0.4862 1800.0n 0.4622 2399.5n 0.4622 2400.0n 0.4699 2999.5n 0.4699 3000.0n 0.3893 3599.5n 0.3893 3600.0n 0.4994 4199.5n 0.4994 4200.0n 0.4336 4799.5n 0.4336 4800.0n 0.4526 5399.5n 0.4526 5400.0n 0.5781 5999.5n 0.5781 6000.0n 0.4966 6599.5n 0.4966 6600.0n 0.5094 7199.5n 0.5094 7200.0n 0.5293 7799.5n 0.5293 7800.0n 0.5861 8399.5n 0.5861 8400.0n 0.5869 8999.5n 0.5869 9000.0n 0.5339 9599.5n 0.5339 9600.0n 0.6081 10199.5n 0.6081 10200.0n 0.5280 10799.5n 0.5280 10800.0n 0.6006 11399.5n 0.6006 11400.0n 0.5261 11999.5n 0.5261 12000.0n 0.6239 12599.5n 0.6239 12600.0n 0.4983 13199.5n 0.4983 13200.0n 0.5388 13799.5n 0.5388 13800.0n 0.4654 14399.5n 0.4654)
Vyn_wih_15_14 yn_wih_15_14 0 PWL(0.0n 0.4989 599.5n 0.4989 600.0n 0.5277 1199.5n 0.5277 1200.0n 0.5138 1799.5n 0.5138 1800.0n 0.5378 2399.5n 0.5378 2400.0n 0.5301 2999.5n 0.5301 3000.0n 0.6107 3599.5n 0.6107 3600.0n 0.5006 4199.5n 0.5006 4200.0n 0.5664 4799.5n 0.5664 4800.0n 0.5474 5399.5n 0.5474 5400.0n 0.4219 5999.5n 0.4219 6000.0n 0.5034 6599.5n 0.5034 6600.0n 0.4906 7199.5n 0.4906 7200.0n 0.4707 7799.5n 0.4707 7800.0n 0.4139 8399.5n 0.4139 8400.0n 0.4131 8999.5n 0.4131 9000.0n 0.4661 9599.5n 0.4661 9600.0n 0.3919 10199.5n 0.3919 10200.0n 0.4720 10799.5n 0.4720 10800.0n 0.3994 11399.5n 0.3994 11400.0n 0.4739 11999.5n 0.4739 12000.0n 0.3761 12599.5n 0.3761 12600.0n 0.5017 13199.5n 0.5017 13200.0n 0.4612 13799.5n 0.4612 13800.0n 0.5346 14399.5n 0.5346)
Cwp_wih_15_14 wp_wih_15_14 0 400p
Cwn_wih_15_14 wn_wih_15_14 0 400p
Xu_wih_15_14 xp_wih_15_14 xn_wih_15_14 yp_wih_15_14 yn_wih_15_14 wp_wih_15_14 wn_wih_15_14 vdd gbn gprod
Vxp_who_14_0 xp_who_14_0 0 PWL(0.0n 0.5011 599.5n 0.5011 600.0n 0.4723 1199.5n 0.4723 1200.0n 0.4862 1799.5n 0.4862 1800.0n 0.4622 2399.5n 0.4622 2400.0n 0.4699 2999.5n 0.4699 3000.0n 0.3893 3599.5n 0.3893 3600.0n 0.4994 4199.5n 0.4994 4200.0n 0.4336 4799.5n 0.4336 4800.0n 0.4526 5399.5n 0.4526 5400.0n 0.5781 5999.5n 0.5781 6000.0n 0.4966 6599.5n 0.4966 6600.0n 0.5094 7199.5n 0.5094 7200.0n 0.5293 7799.5n 0.5293 7800.0n 0.5861 8399.5n 0.5861 8400.0n 0.5869 8999.5n 0.5869 9000.0n 0.5339 9599.5n 0.5339 9600.0n 0.6081 10199.5n 0.6081 10200.0n 0.5280 10799.5n 0.5280 10800.0n 0.6006 11399.5n 0.6006 11400.0n 0.5261 11999.5n 0.5261 12000.0n 0.6239 12599.5n 0.6239 12600.0n 0.4983 13199.5n 0.4983 13200.0n 0.5388 13799.5n 0.5388 13800.0n 0.4654 14399.5n 0.4654)
Vxn_who_14_0 xn_who_14_0 0 PWL(0.0n 0.4989 599.5n 0.4989 600.0n 0.5277 1199.5n 0.5277 1200.0n 0.5138 1799.5n 0.5138 1800.0n 0.5378 2399.5n 0.5378 2400.0n 0.5301 2999.5n 0.5301 3000.0n 0.6107 3599.5n 0.6107 3600.0n 0.5006 4199.5n 0.5006 4200.0n 0.5664 4799.5n 0.5664 4800.0n 0.5474 5399.5n 0.5474 5400.0n 0.4219 5999.5n 0.4219 6000.0n 0.5034 6599.5n 0.5034 6600.0n 0.4906 7199.5n 0.4906 7200.0n 0.4707 7799.5n 0.4707 7800.0n 0.4139 8399.5n 0.4139 8400.0n 0.4131 8999.5n 0.4131 9000.0n 0.4661 9599.5n 0.4661 9600.0n 0.3919 10199.5n 0.3919 10200.0n 0.4720 10799.5n 0.4720 10800.0n 0.3994 11399.5n 0.3994 11400.0n 0.4739 11999.5n 0.4739 12000.0n 0.3761 12599.5n 0.3761 12600.0n 0.5017 13199.5n 0.5017 13200.0n 0.4612 13799.5n 0.4612 13800.0n 0.5346 14399.5n 0.5346)
Vyp_who_14_0 yp_who_14_0 0 PWL(0.0n 0.5073 599.5n 0.5073 600.0n 0.5065 1199.5n 0.5065 1200.0n 0.5065 1799.5n 0.5065 1800.0n 0.5052 2399.5n 0.5052 2400.0n 0.5058 2999.5n 0.5058 3000.0n 0.5039 3599.5n 0.5039 3600.0n 0.5059 4199.5n 0.5059 4200.0n 0.5077 4799.5n 0.5077 4800.0n 0.5054 5399.5n 0.5054 5400.0n 0.5066 5999.5n 0.5066 6000.0n 0.5083 6599.5n 0.5083 6600.0n 0.5078 7199.5n 0.5078 7200.0n 0.5043 7799.5n 0.5043 7800.0n 0.5035 8399.5n 0.5035 8400.0n 0.5035 8999.5n 0.5035 9000.0n 0.5038 9599.5n 0.5038 9600.0n 0.5043 10199.5n 0.5043 10200.0n 0.5053 10799.5n 0.5053 10800.0n 0.5050 11399.5n 0.5050 11400.0n 0.5055 11999.5n 0.5055 12000.0n 0.5043 12599.5n 0.5043 12600.0n 0.5028 13199.5n 0.5028 13200.0n 0.5045 13799.5n 0.5045 13800.0n 0.5043 14399.5n 0.5043)
Vyn_who_14_0 yn_who_14_0 0 PWL(0.0n 0.4927 599.5n 0.4927 600.0n 0.4935 1199.5n 0.4935 1200.0n 0.4935 1799.5n 0.4935 1800.0n 0.4948 2399.5n 0.4948 2400.0n 0.4942 2999.5n 0.4942 3000.0n 0.4961 3599.5n 0.4961 3600.0n 0.4941 4199.5n 0.4941 4200.0n 0.4923 4799.5n 0.4923 4800.0n 0.4946 5399.5n 0.4946 5400.0n 0.4934 5999.5n 0.4934 6000.0n 0.4917 6599.5n 0.4917 6600.0n 0.4922 7199.5n 0.4922 7200.0n 0.4957 7799.5n 0.4957 7800.0n 0.4965 8399.5n 0.4965 8400.0n 0.4965 8999.5n 0.4965 9000.0n 0.4962 9599.5n 0.4962 9600.0n 0.4957 10199.5n 0.4957 10200.0n 0.4947 10799.5n 0.4947 10800.0n 0.4950 11399.5n 0.4950 11400.0n 0.4945 11999.5n 0.4945 12000.0n 0.4957 12599.5n 0.4957 12600.0n 0.4972 13199.5n 0.4972 13200.0n 0.4955 13799.5n 0.4955 13800.0n 0.4957 14399.5n 0.4957)
Cwp_who_14_0 wp_who_14_0 0 400p
Cwn_who_14_0 wn_who_14_0 0 400p
Xu_who_14_0 xp_who_14_0 xn_who_14_0 yp_who_14_0 yn_who_14_0 wp_who_14_0 wn_who_14_0 vdd gbn gprod
Vxp_who_14_1 xp_who_14_1 0 PWL(0.0n 0.5011 599.5n 0.5011 600.0n 0.4723 1199.5n 0.4723 1200.0n 0.4862 1799.5n 0.4862 1800.0n 0.4622 2399.5n 0.4622 2400.0n 0.4699 2999.5n 0.4699 3000.0n 0.3893 3599.5n 0.3893 3600.0n 0.4994 4199.5n 0.4994 4200.0n 0.4336 4799.5n 0.4336 4800.0n 0.4526 5399.5n 0.4526 5400.0n 0.5781 5999.5n 0.5781 6000.0n 0.4966 6599.5n 0.4966 6600.0n 0.5094 7199.5n 0.5094 7200.0n 0.5293 7799.5n 0.5293 7800.0n 0.5861 8399.5n 0.5861 8400.0n 0.5869 8999.5n 0.5869 9000.0n 0.5339 9599.5n 0.5339 9600.0n 0.6081 10199.5n 0.6081 10200.0n 0.5280 10799.5n 0.5280 10800.0n 0.6006 11399.5n 0.6006 11400.0n 0.5261 11999.5n 0.5261 12000.0n 0.6239 12599.5n 0.6239 12600.0n 0.4983 13199.5n 0.4983 13200.0n 0.5388 13799.5n 0.5388 13800.0n 0.4654 14399.5n 0.4654)
Vxn_who_14_1 xn_who_14_1 0 PWL(0.0n 0.4989 599.5n 0.4989 600.0n 0.5277 1199.5n 0.5277 1200.0n 0.5138 1799.5n 0.5138 1800.0n 0.5378 2399.5n 0.5378 2400.0n 0.5301 2999.5n 0.5301 3000.0n 0.6107 3599.5n 0.6107 3600.0n 0.5006 4199.5n 0.5006 4200.0n 0.5664 4799.5n 0.5664 4800.0n 0.5474 5399.5n 0.5474 5400.0n 0.4219 5999.5n 0.4219 6000.0n 0.5034 6599.5n 0.5034 6600.0n 0.4906 7199.5n 0.4906 7200.0n 0.4707 7799.5n 0.4707 7800.0n 0.4139 8399.5n 0.4139 8400.0n 0.4131 8999.5n 0.4131 9000.0n 0.4661 9599.5n 0.4661 9600.0n 0.3919 10199.5n 0.3919 10200.0n 0.4720 10799.5n 0.4720 10800.0n 0.3994 11399.5n 0.3994 11400.0n 0.4739 11999.5n 0.4739 12000.0n 0.3761 12599.5n 0.3761 12600.0n 0.5017 13199.5n 0.5017 13200.0n 0.4612 13799.5n 0.4612 13800.0n 0.5346 14399.5n 0.5346)
Vyp_who_14_1 yp_who_14_1 0 PWL(0.0n 0.4909 599.5n 0.4909 600.0n 0.4933 1199.5n 0.4933 1200.0n 0.4930 1799.5n 0.4930 1800.0n 0.4893 2399.5n 0.4893 2400.0n 0.4904 2999.5n 0.4904 3000.0n 0.4923 3599.5n 0.4923 3600.0n 0.4897 4199.5n 0.4897 4200.0n 0.4890 4799.5n 0.4890 4800.0n 0.4921 5399.5n 0.4921 5400.0n 0.4899 5999.5n 0.4899 6000.0n 0.4870 6599.5n 0.4870 6600.0n 0.4903 7199.5n 0.4903 7200.0n 0.4970 7799.5n 0.4970 7800.0n 0.4989 8399.5n 0.4989 8400.0n 0.4994 8999.5n 0.4994 9000.0n 0.4991 9599.5n 0.4991 9600.0n 0.5000 10199.5n 0.5000 10200.0n 0.4948 10799.5n 0.4948 10800.0n 0.4959 11399.5n 0.4959 11400.0n 0.4926 11999.5n 0.4926 12000.0n 0.4993 12599.5n 0.4993 12600.0n 0.4862 13199.5n 0.4862 13200.0n 0.4993 13799.5n 0.4993 13800.0n 0.4961 14399.5n 0.4961)
Vyn_who_14_1 yn_who_14_1 0 PWL(0.0n 0.5091 599.5n 0.5091 600.0n 0.5067 1199.5n 0.5067 1200.0n 0.5070 1799.5n 0.5070 1800.0n 0.5107 2399.5n 0.5107 2400.0n 0.5096 2999.5n 0.5096 3000.0n 0.5077 3599.5n 0.5077 3600.0n 0.5103 4199.5n 0.5103 4200.0n 0.5110 4799.5n 0.5110 4800.0n 0.5079 5399.5n 0.5079 5400.0n 0.5101 5999.5n 0.5101 6000.0n 0.5130 6599.5n 0.5130 6600.0n 0.5097 7199.5n 0.5097 7200.0n 0.5030 7799.5n 0.5030 7800.0n 0.5011 8399.5n 0.5011 8400.0n 0.5006 8999.5n 0.5006 9000.0n 0.5009 9599.5n 0.5009 9600.0n 0.5000 10199.5n 0.5000 10200.0n 0.5052 10799.5n 0.5052 10800.0n 0.5041 11399.5n 0.5041 11400.0n 0.5074 11999.5n 0.5074 12000.0n 0.5007 12599.5n 0.5007 12600.0n 0.5138 13199.5n 0.5138 13200.0n 0.5007 13799.5n 0.5007 13800.0n 0.5039 14399.5n 0.5039)
Cwp_who_14_1 wp_who_14_1 0 400p
Cwn_who_14_1 wn_who_14_1 0 400p
Xu_who_14_1 xp_who_14_1 xn_who_14_1 yp_who_14_1 yn_who_14_1 wp_who_14_1 wn_who_14_1 vdd gbn gprod
Vxp_bh_14 xp_bh_14 0 PWL(0.0n 0.7100 599.5n 0.7100 600.0n 0.7100 1199.5n 0.7100 1200.0n 0.7100 1799.5n 0.7100 1800.0n 0.7100 2399.5n 0.7100 2400.0n 0.7100 2999.5n 0.7100 3000.0n 0.7100 3599.5n 0.7100 3600.0n 0.7100 4199.5n 0.7100 4200.0n 0.7100 4799.5n 0.7100 4800.0n 0.7100 5399.5n 0.7100 5400.0n 0.7100 5999.5n 0.7100 6000.0n 0.7100 6599.5n 0.7100 6600.0n 0.7100 7199.5n 0.7100 7200.0n 0.7100 7799.5n 0.7100 7800.0n 0.7100 8399.5n 0.7100 8400.0n 0.7100 8999.5n 0.7100 9000.0n 0.7100 9599.5n 0.7100 9600.0n 0.7100 10199.5n 0.7100 10200.0n 0.7100 10799.5n 0.7100 10800.0n 0.7100 11399.5n 0.7100 11400.0n 0.7100 11999.5n 0.7100 12000.0n 0.7100 12599.5n 0.7100 12600.0n 0.7100 13199.5n 0.7100 13200.0n 0.7100 13799.5n 0.7100 13800.0n 0.7100 14399.5n 0.7100)
Vxn_bh_14 xn_bh_14 0 PWL(0.0n 0.2900 599.5n 0.2900 600.0n 0.2900 1199.5n 0.2900 1200.0n 0.2900 1799.5n 0.2900 1800.0n 0.2900 2399.5n 0.2900 2400.0n 0.2900 2999.5n 0.2900 3000.0n 0.2900 3599.5n 0.2900 3600.0n 0.2900 4199.5n 0.2900 4200.0n 0.2900 4799.5n 0.2900 4800.0n 0.2900 5399.5n 0.2900 5400.0n 0.2900 5999.5n 0.2900 6000.0n 0.2900 6599.5n 0.2900 6600.0n 0.2900 7199.5n 0.2900 7200.0n 0.2900 7799.5n 0.2900 7800.0n 0.2900 8399.5n 0.2900 8400.0n 0.2900 8999.5n 0.2900 9000.0n 0.2900 9599.5n 0.2900 9600.0n 0.2900 10199.5n 0.2900 10200.0n 0.2900 10799.5n 0.2900 10800.0n 0.2900 11399.5n 0.2900 11400.0n 0.2900 11999.5n 0.2900 12000.0n 0.2900 12599.5n 0.2900 12600.0n 0.2900 13199.5n 0.2900 13200.0n 0.2900 13799.5n 0.2900 13800.0n 0.2900 14399.5n 0.2900)
Vyp_bh_14 yp_bh_14 0 PWL(0.0n 0.5011 599.5n 0.5011 600.0n 0.4723 1199.5n 0.4723 1200.0n 0.4862 1799.5n 0.4862 1800.0n 0.4622 2399.5n 0.4622 2400.0n 0.4699 2999.5n 0.4699 3000.0n 0.3893 3599.5n 0.3893 3600.0n 0.4994 4199.5n 0.4994 4200.0n 0.4336 4799.5n 0.4336 4800.0n 0.4526 5399.5n 0.4526 5400.0n 0.5781 5999.5n 0.5781 6000.0n 0.4966 6599.5n 0.4966 6600.0n 0.5094 7199.5n 0.5094 7200.0n 0.5293 7799.5n 0.5293 7800.0n 0.5861 8399.5n 0.5861 8400.0n 0.5869 8999.5n 0.5869 9000.0n 0.5339 9599.5n 0.5339 9600.0n 0.6081 10199.5n 0.6081 10200.0n 0.5280 10799.5n 0.5280 10800.0n 0.6006 11399.5n 0.6006 11400.0n 0.5261 11999.5n 0.5261 12000.0n 0.6239 12599.5n 0.6239 12600.0n 0.4983 13199.5n 0.4983 13200.0n 0.5388 13799.5n 0.5388 13800.0n 0.4654 14399.5n 0.4654)
Vyn_bh_14 yn_bh_14 0 PWL(0.0n 0.4989 599.5n 0.4989 600.0n 0.5277 1199.5n 0.5277 1200.0n 0.5138 1799.5n 0.5138 1800.0n 0.5378 2399.5n 0.5378 2400.0n 0.5301 2999.5n 0.5301 3000.0n 0.6107 3599.5n 0.6107 3600.0n 0.5006 4199.5n 0.5006 4200.0n 0.5664 4799.5n 0.5664 4800.0n 0.5474 5399.5n 0.5474 5400.0n 0.4219 5999.5n 0.4219 6000.0n 0.5034 6599.5n 0.5034 6600.0n 0.4906 7199.5n 0.4906 7200.0n 0.4707 7799.5n 0.4707 7800.0n 0.4139 8399.5n 0.4139 8400.0n 0.4131 8999.5n 0.4131 9000.0n 0.4661 9599.5n 0.4661 9600.0n 0.3919 10199.5n 0.3919 10200.0n 0.4720 10799.5n 0.4720 10800.0n 0.3994 11399.5n 0.3994 11400.0n 0.4739 11999.5n 0.4739 12000.0n 0.3761 12599.5n 0.3761 12600.0n 0.5017 13199.5n 0.5017 13200.0n 0.4612 13799.5n 0.4612 13800.0n 0.5346 14399.5n 0.5346)
Cwp_bh_14 wp_bh_14 0 400p
Cwn_bh_14 wn_bh_14 0 400p
Xu_bh_14 xp_bh_14 xn_bh_14 yp_bh_14 yn_bh_14 wp_bh_14 wn_bh_14 vdd gbn gprod
Vxp_wih_10_15 xp_wih_10_15 0 PWL(0.0n 0.4780 599.5n 0.4780 600.0n 0.4782 1199.5n 0.4782 1200.0n 0.4616 1799.5n 0.4616 1800.0n 0.4427 2399.5n 0.4427 2400.0n 0.4570 2999.5n 0.4570 3000.0n 0.4178 3599.5n 0.4178 3600.0n 0.4817 4199.5n 0.4817 4200.0n 0.4270 4799.5n 0.4270 4800.0n 0.4662 5399.5n 0.4662 5400.0n 0.5654 5999.5n 0.5654 6000.0n 0.4694 6599.5n 0.4694 6600.0n 0.4809 7199.5n 0.4809 7200.0n 0.5515 7799.5n 0.5515 7800.0n 0.5820 8399.5n 0.5820 8400.0n 0.5809 8999.5n 0.5809 9000.0n 0.5432 9599.5n 0.5432 9600.0n 0.6050 10199.5n 0.6050 10200.0n 0.5272 10799.5n 0.5272 10800.0n 0.5727 11399.5n 0.5727 11400.0n 0.5237 11999.5n 0.5237 12000.0n 0.6050 12599.5n 0.6050 12600.0n 0.5374 13199.5n 0.5374 13200.0n 0.5350 13799.5n 0.5350 13800.0n 0.4763 14399.5n 0.4763)
Vxn_wih_10_15 xn_wih_10_15 0 PWL(0.0n 0.5220 599.5n 0.5220 600.0n 0.5218 1199.5n 0.5218 1200.0n 0.5384 1799.5n 0.5384 1800.0n 0.5573 2399.5n 0.5573 2400.0n 0.5430 2999.5n 0.5430 3000.0n 0.5822 3599.5n 0.5822 3600.0n 0.5183 4199.5n 0.5183 4200.0n 0.5730 4799.5n 0.5730 4800.0n 0.5338 5399.5n 0.5338 5400.0n 0.4346 5999.5n 0.4346 6000.0n 0.5306 6599.5n 0.5306 6600.0n 0.5191 7199.5n 0.5191 7200.0n 0.4485 7799.5n 0.4485 7800.0n 0.4180 8399.5n 0.4180 8400.0n 0.4191 8999.5n 0.4191 9000.0n 0.4568 9599.5n 0.4568 9600.0n 0.3950 10199.5n 0.3950 10200.0n 0.4728 10799.5n 0.4728 10800.0n 0.4273 11399.5n 0.4273 11400.0n 0.4763 11999.5n 0.4763 12000.0n 0.3950 12599.5n 0.3950 12600.0n 0.4626 13199.5n 0.4626 13200.0n 0.4650 13799.5n 0.4650 13800.0n 0.5237 14399.5n 0.5237)
Vyp_wih_10_15 yp_wih_10_15 0 PWL(0.0n 0.6586 599.5n 0.6586 600.0n 0.6076 1199.5n 0.6076 1200.0n 0.6602 1799.5n 0.6602 1800.0n 0.6617 2399.5n 0.6617 2400.0n 0.6568 2999.5n 0.6568 3000.0n 0.6539 3599.5n 0.6539 3600.0n 0.6612 4199.5n 0.6612 4200.0n 0.6601 4799.5n 0.6601 4800.0n 0.6485 5399.5n 0.6485 5400.0n 0.6029 5999.5n 0.6029 6000.0n 0.6628 6599.5n 0.6628 6600.0n 0.6595 7199.5n 0.6595 7200.0n 0.5345 7799.5n 0.5345 7800.0n 0.5958 8399.5n 0.5958 8400.0n 0.5790 8999.5n 0.5790 9000.0n 0.6052 9599.5n 0.6052 9600.0n 0.5969 10199.5n 0.5969 10200.0n 0.5950 10799.5n 0.5950 10800.0n 0.6151 11399.5n 0.6151 11400.0n 0.5955 11999.5n 0.5955 12000.0n 0.6178 12599.5n 0.6178 12600.0n 0.5133 13199.5n 0.5133 13200.0n 0.6078 13799.5n 0.6078 13800.0n 0.5391 14399.5n 0.5391)
Vyn_wih_10_15 yn_wih_10_15 0 PWL(0.0n 0.3414 599.5n 0.3414 600.0n 0.3924 1199.5n 0.3924 1200.0n 0.3398 1799.5n 0.3398 1800.0n 0.3383 2399.5n 0.3383 2400.0n 0.3432 2999.5n 0.3432 3000.0n 0.3461 3599.5n 0.3461 3600.0n 0.3388 4199.5n 0.3388 4200.0n 0.3399 4799.5n 0.3399 4800.0n 0.3515 5399.5n 0.3515 5400.0n 0.3971 5999.5n 0.3971 6000.0n 0.3372 6599.5n 0.3372 6600.0n 0.3405 7199.5n 0.3405 7200.0n 0.4655 7799.5n 0.4655 7800.0n 0.4042 8399.5n 0.4042 8400.0n 0.4210 8999.5n 0.4210 9000.0n 0.3948 9599.5n 0.3948 9600.0n 0.4031 10199.5n 0.4031 10200.0n 0.4050 10799.5n 0.4050 10800.0n 0.3849 11399.5n 0.3849 11400.0n 0.4045 11999.5n 0.4045 12000.0n 0.3822 12599.5n 0.3822 12600.0n 0.4867 13199.5n 0.4867 13200.0n 0.3922 13799.5n 0.3922 13800.0n 0.4609 14399.5n 0.4609)
Cwp_wih_10_15 wp_wih_10_15 0 400p
Cwn_wih_10_15 wn_wih_10_15 0 400p
Xu_wih_10_15 xp_wih_10_15 xn_wih_10_15 yp_wih_10_15 yn_wih_10_15 wp_wih_10_15 wn_wih_10_15 vdd gbn gprod
Vxp_wih_11_15 xp_wih_11_15 0 PWL(0.0n 0.4536 599.5n 0.4536 600.0n 0.4386 1199.5n 0.4386 1200.0n 0.4565 1799.5n 0.4565 1800.0n 0.4618 2399.5n 0.4618 2400.0n 0.4666 2999.5n 0.4666 3000.0n 0.5046 3599.5n 0.5046 3600.0n 0.4772 4199.5n 0.4772 4200.0n 0.4635 4799.5n 0.4635 4800.0n 0.4887 5399.5n 0.4887 5400.0n 0.4108 5999.5n 0.4108 6000.0n 0.4694 6599.5n 0.4694 6600.0n 0.4475 7199.5n 0.4475 7200.0n 0.3950 7799.5n 0.3950 7800.0n 0.4212 8399.5n 0.4212 8400.0n 0.3950 8999.5n 0.3950 9000.0n 0.4238 9599.5n 0.4238 9600.0n 0.4048 10199.5n 0.4048 10200.0n 0.3950 10799.5n 0.3950 10800.0n 0.3950 11399.5n 0.3950 11400.0n 0.3950 11999.5n 0.3950 12000.0n 0.3950 12599.5n 0.3950 12600.0n 0.3950 13199.5n 0.3950 13200.0n 0.3950 13799.5n 0.3950 13800.0n 0.3950 14399.5n 0.3950)
Vxn_wih_11_15 xn_wih_11_15 0 PWL(0.0n 0.5464 599.5n 0.5464 600.0n 0.5614 1199.5n 0.5614 1200.0n 0.5435 1799.5n 0.5435 1800.0n 0.5382 2399.5n 0.5382 2400.0n 0.5334 2999.5n 0.5334 3000.0n 0.4954 3599.5n 0.4954 3600.0n 0.5228 4199.5n 0.5228 4200.0n 0.5365 4799.5n 0.5365 4800.0n 0.5113 5399.5n 0.5113 5400.0n 0.5892 5999.5n 0.5892 6000.0n 0.5306 6599.5n 0.5306 6600.0n 0.5525 7199.5n 0.5525 7200.0n 0.6050 7799.5n 0.6050 7800.0n 0.5788 8399.5n 0.5788 8400.0n 0.6050 8999.5n 0.6050 9000.0n 0.5762 9599.5n 0.5762 9600.0n 0.5952 10199.5n 0.5952 10200.0n 0.6050 10799.5n 0.6050 10800.0n 0.6050 11399.5n 0.6050 11400.0n 0.6050 11999.5n 0.6050 12000.0n 0.6050 12599.5n 0.6050 12600.0n 0.6050 13199.5n 0.6050 13200.0n 0.6050 13799.5n 0.6050 13800.0n 0.6050 14399.5n 0.6050)
Vyp_wih_11_15 yp_wih_11_15 0 PWL(0.0n 0.6586 599.5n 0.6586 600.0n 0.6076 1199.5n 0.6076 1200.0n 0.6602 1799.5n 0.6602 1800.0n 0.6617 2399.5n 0.6617 2400.0n 0.6568 2999.5n 0.6568 3000.0n 0.6539 3599.5n 0.6539 3600.0n 0.6612 4199.5n 0.6612 4200.0n 0.6601 4799.5n 0.6601 4800.0n 0.6485 5399.5n 0.6485 5400.0n 0.6029 5999.5n 0.6029 6000.0n 0.6628 6599.5n 0.6628 6600.0n 0.6595 7199.5n 0.6595 7200.0n 0.5345 7799.5n 0.5345 7800.0n 0.5958 8399.5n 0.5958 8400.0n 0.5790 8999.5n 0.5790 9000.0n 0.6052 9599.5n 0.6052 9600.0n 0.5969 10199.5n 0.5969 10200.0n 0.5950 10799.5n 0.5950 10800.0n 0.6151 11399.5n 0.6151 11400.0n 0.5955 11999.5n 0.5955 12000.0n 0.6178 12599.5n 0.6178 12600.0n 0.5133 13199.5n 0.5133 13200.0n 0.6078 13799.5n 0.6078 13800.0n 0.5391 14399.5n 0.5391)
Vyn_wih_11_15 yn_wih_11_15 0 PWL(0.0n 0.3414 599.5n 0.3414 600.0n 0.3924 1199.5n 0.3924 1200.0n 0.3398 1799.5n 0.3398 1800.0n 0.3383 2399.5n 0.3383 2400.0n 0.3432 2999.5n 0.3432 3000.0n 0.3461 3599.5n 0.3461 3600.0n 0.3388 4199.5n 0.3388 4200.0n 0.3399 4799.5n 0.3399 4800.0n 0.3515 5399.5n 0.3515 5400.0n 0.3971 5999.5n 0.3971 6000.0n 0.3372 6599.5n 0.3372 6600.0n 0.3405 7199.5n 0.3405 7200.0n 0.4655 7799.5n 0.4655 7800.0n 0.4042 8399.5n 0.4042 8400.0n 0.4210 8999.5n 0.4210 9000.0n 0.3948 9599.5n 0.3948 9600.0n 0.4031 10199.5n 0.4031 10200.0n 0.4050 10799.5n 0.4050 10800.0n 0.3849 11399.5n 0.3849 11400.0n 0.4045 11999.5n 0.4045 12000.0n 0.3822 12599.5n 0.3822 12600.0n 0.4867 13199.5n 0.4867 13200.0n 0.3922 13799.5n 0.3922 13800.0n 0.4609 14399.5n 0.4609)
Cwp_wih_11_15 wp_wih_11_15 0 400p
Cwn_wih_11_15 wn_wih_11_15 0 400p
Xu_wih_11_15 xp_wih_11_15 xn_wih_11_15 yp_wih_11_15 yn_wih_11_15 wp_wih_11_15 wn_wih_11_15 vdd gbn gprod
Vxp_wih_14_15 xp_wih_14_15 0 PWL(0.0n 0.6001 599.5n 0.6001 600.0n 0.5297 1199.5n 0.5297 1200.0n 0.5896 1799.5n 0.5896 1800.0n 0.5907 2399.5n 0.5907 2400.0n 0.5716 2999.5n 0.5716 3000.0n 0.6050 3599.5n 0.6050 3600.0n 0.6050 4199.5n 0.6050 4200.0n 0.5822 4799.5n 0.5822 4800.0n 0.6050 5399.5n 0.6050 5400.0n 0.5614 5999.5n 0.5614 6000.0n 0.6050 6599.5n 0.6050 6600.0n 0.6050 7199.5n 0.6050 7200.0n 0.4856 7799.5n 0.4856 7800.0n 0.5853 8399.5n 0.5853 8400.0n 0.5568 8999.5n 0.5568 9000.0n 0.5679 9599.5n 0.5679 9600.0n 0.5656 10199.5n 0.5656 10200.0n 0.5506 10799.5n 0.5506 10800.0n 0.5781 11399.5n 0.5781 11400.0n 0.5508 11999.5n 0.5508 12000.0n 0.5935 12599.5n 0.5935 12600.0n 0.6050 13199.5n 0.6050 13200.0n 0.5617 13799.5n 0.5617 13800.0n 0.4729 14399.5n 0.4729)
Vxn_wih_14_15 xn_wih_14_15 0 PWL(0.0n 0.3999 599.5n 0.3999 600.0n 0.4703 1199.5n 0.4703 1200.0n 0.4104 1799.5n 0.4104 1800.0n 0.4093 2399.5n 0.4093 2400.0n 0.4284 2999.5n 0.4284 3000.0n 0.3950 3599.5n 0.3950 3600.0n 0.3950 4199.5n 0.3950 4200.0n 0.4178 4799.5n 0.4178 4800.0n 0.3950 5399.5n 0.3950 5400.0n 0.4386 5999.5n 0.4386 6000.0n 0.3950 6599.5n 0.3950 6600.0n 0.3950 7199.5n 0.3950 7200.0n 0.5144 7799.5n 0.5144 7800.0n 0.4147 8399.5n 0.4147 8400.0n 0.4432 8999.5n 0.4432 9000.0n 0.4321 9599.5n 0.4321 9600.0n 0.4344 10199.5n 0.4344 10200.0n 0.4494 10799.5n 0.4494 10800.0n 0.4219 11399.5n 0.4219 11400.0n 0.4492 11999.5n 0.4492 12000.0n 0.4065 12599.5n 0.4065 12600.0n 0.3950 13199.5n 0.3950 13200.0n 0.4383 13799.5n 0.4383 13800.0n 0.5271 14399.5n 0.5271)
Vyp_wih_14_15 yp_wih_14_15 0 PWL(0.0n 0.6586 599.5n 0.6586 600.0n 0.6076 1199.5n 0.6076 1200.0n 0.6602 1799.5n 0.6602 1800.0n 0.6617 2399.5n 0.6617 2400.0n 0.6568 2999.5n 0.6568 3000.0n 0.6539 3599.5n 0.6539 3600.0n 0.6612 4199.5n 0.6612 4200.0n 0.6601 4799.5n 0.6601 4800.0n 0.6485 5399.5n 0.6485 5400.0n 0.6029 5999.5n 0.6029 6000.0n 0.6628 6599.5n 0.6628 6600.0n 0.6595 7199.5n 0.6595 7200.0n 0.5345 7799.5n 0.5345 7800.0n 0.5958 8399.5n 0.5958 8400.0n 0.5790 8999.5n 0.5790 9000.0n 0.6052 9599.5n 0.6052 9600.0n 0.5969 10199.5n 0.5969 10200.0n 0.5950 10799.5n 0.5950 10800.0n 0.6151 11399.5n 0.6151 11400.0n 0.5955 11999.5n 0.5955 12000.0n 0.6178 12599.5n 0.6178 12600.0n 0.5133 13199.5n 0.5133 13200.0n 0.6078 13799.5n 0.6078 13800.0n 0.5391 14399.5n 0.5391)
Vyn_wih_14_15 yn_wih_14_15 0 PWL(0.0n 0.3414 599.5n 0.3414 600.0n 0.3924 1199.5n 0.3924 1200.0n 0.3398 1799.5n 0.3398 1800.0n 0.3383 2399.5n 0.3383 2400.0n 0.3432 2999.5n 0.3432 3000.0n 0.3461 3599.5n 0.3461 3600.0n 0.3388 4199.5n 0.3388 4200.0n 0.3399 4799.5n 0.3399 4800.0n 0.3515 5399.5n 0.3515 5400.0n 0.3971 5999.5n 0.3971 6000.0n 0.3372 6599.5n 0.3372 6600.0n 0.3405 7199.5n 0.3405 7200.0n 0.4655 7799.5n 0.4655 7800.0n 0.4042 8399.5n 0.4042 8400.0n 0.4210 8999.5n 0.4210 9000.0n 0.3948 9599.5n 0.3948 9600.0n 0.4031 10199.5n 0.4031 10200.0n 0.4050 10799.5n 0.4050 10800.0n 0.3849 11399.5n 0.3849 11400.0n 0.4045 11999.5n 0.4045 12000.0n 0.3822 12599.5n 0.3822 12600.0n 0.4867 13199.5n 0.4867 13200.0n 0.3922 13799.5n 0.3922 13800.0n 0.4609 14399.5n 0.4609)
Cwp_wih_14_15 wp_wih_14_15 0 400p
Cwn_wih_14_15 wn_wih_14_15 0 400p
Xu_wih_14_15 xp_wih_14_15 xn_wih_14_15 yp_wih_14_15 yn_wih_14_15 wp_wih_14_15 wn_wih_14_15 vdd gbn gprod
Vxp_wih_15_15 xp_wih_15_15 0 PWL(0.0n 0.4097 599.5n 0.4097 600.0n 0.3950 1199.5n 0.3950 1200.0n 0.4001 1799.5n 0.4001 1800.0n 0.4045 2399.5n 0.4045 2400.0n 0.4045 2999.5n 0.4045 3000.0n 0.4589 3599.5n 0.4589 3600.0n 0.4133 4199.5n 0.4133 4200.0n 0.4178 4799.5n 0.4178 4800.0n 0.4512 5399.5n 0.4512 5400.0n 0.3950 5999.5n 0.3950 6000.0n 0.3994 6599.5n 0.3994 6600.0n 0.3998 7199.5n 0.3998 7200.0n 0.3950 7799.5n 0.3950 7800.0n 0.4344 8399.5n 0.4344 8400.0n 0.4088 8999.5n 0.4088 9000.0n 0.4279 9599.5n 0.4279 9600.0n 0.3950 10199.5n 0.3950 10200.0n 0.3950 10799.5n 0.3950 10800.0n 0.3950 11399.5n 0.3950 11400.0n 0.3950 11999.5n 0.3950 12000.0n 0.3950 12599.5n 0.3950 12600.0n 0.5231 13199.5n 0.5231 13200.0n 0.4017 13799.5n 0.4017 13800.0n 0.3950 14399.5n 0.3950)
Vxn_wih_15_15 xn_wih_15_15 0 PWL(0.0n 0.5903 599.5n 0.5903 600.0n 0.6050 1199.5n 0.6050 1200.0n 0.5999 1799.5n 0.5999 1800.0n 0.5955 2399.5n 0.5955 2400.0n 0.5955 2999.5n 0.5955 3000.0n 0.5411 3599.5n 0.5411 3600.0n 0.5867 4199.5n 0.5867 4200.0n 0.5822 4799.5n 0.5822 4800.0n 0.5488 5399.5n 0.5488 5400.0n 0.6050 5999.5n 0.6050 6000.0n 0.6006 6599.5n 0.6006 6600.0n 0.6002 7199.5n 0.6002 7200.0n 0.6050 7799.5n 0.6050 7800.0n 0.5656 8399.5n 0.5656 8400.0n 0.5912 8999.5n 0.5912 9000.0n 0.5721 9599.5n 0.5721 9600.0n 0.6050 10199.5n 0.6050 10200.0n 0.6050 10799.5n 0.6050 10800.0n 0.6050 11399.5n 0.6050 11400.0n 0.6050 11999.5n 0.6050 12000.0n 0.6050 12599.5n 0.6050 12600.0n 0.4769 13199.5n 0.4769 13200.0n 0.5983 13799.5n 0.5983 13800.0n 0.6050 14399.5n 0.6050)
Vyp_wih_15_15 yp_wih_15_15 0 PWL(0.0n 0.6586 599.5n 0.6586 600.0n 0.6076 1199.5n 0.6076 1200.0n 0.6602 1799.5n 0.6602 1800.0n 0.6617 2399.5n 0.6617 2400.0n 0.6568 2999.5n 0.6568 3000.0n 0.6539 3599.5n 0.6539 3600.0n 0.6612 4199.5n 0.6612 4200.0n 0.6601 4799.5n 0.6601 4800.0n 0.6485 5399.5n 0.6485 5400.0n 0.6029 5999.5n 0.6029 6000.0n 0.6628 6599.5n 0.6628 6600.0n 0.6595 7199.5n 0.6595 7200.0n 0.5345 7799.5n 0.5345 7800.0n 0.5958 8399.5n 0.5958 8400.0n 0.5790 8999.5n 0.5790 9000.0n 0.6052 9599.5n 0.6052 9600.0n 0.5969 10199.5n 0.5969 10200.0n 0.5950 10799.5n 0.5950 10800.0n 0.6151 11399.5n 0.6151 11400.0n 0.5955 11999.5n 0.5955 12000.0n 0.6178 12599.5n 0.6178 12600.0n 0.5133 13199.5n 0.5133 13200.0n 0.6078 13799.5n 0.6078 13800.0n 0.5391 14399.5n 0.5391)
Vyn_wih_15_15 yn_wih_15_15 0 PWL(0.0n 0.3414 599.5n 0.3414 600.0n 0.3924 1199.5n 0.3924 1200.0n 0.3398 1799.5n 0.3398 1800.0n 0.3383 2399.5n 0.3383 2400.0n 0.3432 2999.5n 0.3432 3000.0n 0.3461 3599.5n 0.3461 3600.0n 0.3388 4199.5n 0.3388 4200.0n 0.3399 4799.5n 0.3399 4800.0n 0.3515 5399.5n 0.3515 5400.0n 0.3971 5999.5n 0.3971 6000.0n 0.3372 6599.5n 0.3372 6600.0n 0.3405 7199.5n 0.3405 7200.0n 0.4655 7799.5n 0.4655 7800.0n 0.4042 8399.5n 0.4042 8400.0n 0.4210 8999.5n 0.4210 9000.0n 0.3948 9599.5n 0.3948 9600.0n 0.4031 10199.5n 0.4031 10200.0n 0.4050 10799.5n 0.4050 10800.0n 0.3849 11399.5n 0.3849 11400.0n 0.4045 11999.5n 0.4045 12000.0n 0.3822 12599.5n 0.3822 12600.0n 0.4867 13199.5n 0.4867 13200.0n 0.3922 13799.5n 0.3922 13800.0n 0.4609 14399.5n 0.4609)
Cwp_wih_15_15 wp_wih_15_15 0 400p
Cwn_wih_15_15 wn_wih_15_15 0 400p
Xu_wih_15_15 xp_wih_15_15 xn_wih_15_15 yp_wih_15_15 yn_wih_15_15 wp_wih_15_15 wn_wih_15_15 vdd gbn gprod
Vxp_who_15_0 xp_who_15_0 0 PWL(0.0n 0.6586 599.5n 0.6586 600.0n 0.6076 1199.5n 0.6076 1200.0n 0.6602 1799.5n 0.6602 1800.0n 0.6617 2399.5n 0.6617 2400.0n 0.6568 2999.5n 0.6568 3000.0n 0.6539 3599.5n 0.6539 3600.0n 0.6612 4199.5n 0.6612 4200.0n 0.6601 4799.5n 0.6601 4800.0n 0.6485 5399.5n 0.6485 5400.0n 0.6029 5999.5n 0.6029 6000.0n 0.6628 6599.5n 0.6628 6600.0n 0.6595 7199.5n 0.6595 7200.0n 0.5345 7799.5n 0.5345 7800.0n 0.5958 8399.5n 0.5958 8400.0n 0.5790 8999.5n 0.5790 9000.0n 0.6052 9599.5n 0.6052 9600.0n 0.5969 10199.5n 0.5969 10200.0n 0.5950 10799.5n 0.5950 10800.0n 0.6151 11399.5n 0.6151 11400.0n 0.5955 11999.5n 0.5955 12000.0n 0.6178 12599.5n 0.6178 12600.0n 0.5133 13199.5n 0.5133 13200.0n 0.6078 13799.5n 0.6078 13800.0n 0.5391 14399.5n 0.5391)
Vxn_who_15_0 xn_who_15_0 0 PWL(0.0n 0.3414 599.5n 0.3414 600.0n 0.3924 1199.5n 0.3924 1200.0n 0.3398 1799.5n 0.3398 1800.0n 0.3383 2399.5n 0.3383 2400.0n 0.3432 2999.5n 0.3432 3000.0n 0.3461 3599.5n 0.3461 3600.0n 0.3388 4199.5n 0.3388 4200.0n 0.3399 4799.5n 0.3399 4800.0n 0.3515 5399.5n 0.3515 5400.0n 0.3971 5999.5n 0.3971 6000.0n 0.3372 6599.5n 0.3372 6600.0n 0.3405 7199.5n 0.3405 7200.0n 0.4655 7799.5n 0.4655 7800.0n 0.4042 8399.5n 0.4042 8400.0n 0.4210 8999.5n 0.4210 9000.0n 0.3948 9599.5n 0.3948 9600.0n 0.4031 10199.5n 0.4031 10200.0n 0.4050 10799.5n 0.4050 10800.0n 0.3849 11399.5n 0.3849 11400.0n 0.4045 11999.5n 0.4045 12000.0n 0.3822 12599.5n 0.3822 12600.0n 0.4867 13199.5n 0.4867 13200.0n 0.3922 13799.5n 0.3922 13800.0n 0.4609 14399.5n 0.4609)
Vyp_who_15_0 yp_who_15_0 0 PWL(0.0n 0.5073 599.5n 0.5073 600.0n 0.5065 1199.5n 0.5065 1200.0n 0.5065 1799.5n 0.5065 1800.0n 0.5052 2399.5n 0.5052 2400.0n 0.5058 2999.5n 0.5058 3000.0n 0.5039 3599.5n 0.5039 3600.0n 0.5059 4199.5n 0.5059 4200.0n 0.5077 4799.5n 0.5077 4800.0n 0.5054 5399.5n 0.5054 5400.0n 0.5066 5999.5n 0.5066 6000.0n 0.5083 6599.5n 0.5083 6600.0n 0.5078 7199.5n 0.5078 7200.0n 0.5043 7799.5n 0.5043 7800.0n 0.5035 8399.5n 0.5035 8400.0n 0.5035 8999.5n 0.5035 9000.0n 0.5038 9599.5n 0.5038 9600.0n 0.5043 10199.5n 0.5043 10200.0n 0.5053 10799.5n 0.5053 10800.0n 0.5050 11399.5n 0.5050 11400.0n 0.5055 11999.5n 0.5055 12000.0n 0.5043 12599.5n 0.5043 12600.0n 0.5028 13199.5n 0.5028 13200.0n 0.5045 13799.5n 0.5045 13800.0n 0.5043 14399.5n 0.5043)
Vyn_who_15_0 yn_who_15_0 0 PWL(0.0n 0.4927 599.5n 0.4927 600.0n 0.4935 1199.5n 0.4935 1200.0n 0.4935 1799.5n 0.4935 1800.0n 0.4948 2399.5n 0.4948 2400.0n 0.4942 2999.5n 0.4942 3000.0n 0.4961 3599.5n 0.4961 3600.0n 0.4941 4199.5n 0.4941 4200.0n 0.4923 4799.5n 0.4923 4800.0n 0.4946 5399.5n 0.4946 5400.0n 0.4934 5999.5n 0.4934 6000.0n 0.4917 6599.5n 0.4917 6600.0n 0.4922 7199.5n 0.4922 7200.0n 0.4957 7799.5n 0.4957 7800.0n 0.4965 8399.5n 0.4965 8400.0n 0.4965 8999.5n 0.4965 9000.0n 0.4962 9599.5n 0.4962 9600.0n 0.4957 10199.5n 0.4957 10200.0n 0.4947 10799.5n 0.4947 10800.0n 0.4950 11399.5n 0.4950 11400.0n 0.4945 11999.5n 0.4945 12000.0n 0.4957 12599.5n 0.4957 12600.0n 0.4972 13199.5n 0.4972 13200.0n 0.4955 13799.5n 0.4955 13800.0n 0.4957 14399.5n 0.4957)
Cwp_who_15_0 wp_who_15_0 0 400p
Cwn_who_15_0 wn_who_15_0 0 400p
Xu_who_15_0 xp_who_15_0 xn_who_15_0 yp_who_15_0 yn_who_15_0 wp_who_15_0 wn_who_15_0 vdd gbn gprod
Vxp_who_15_1 xp_who_15_1 0 PWL(0.0n 0.6586 599.5n 0.6586 600.0n 0.6076 1199.5n 0.6076 1200.0n 0.6602 1799.5n 0.6602 1800.0n 0.6617 2399.5n 0.6617 2400.0n 0.6568 2999.5n 0.6568 3000.0n 0.6539 3599.5n 0.6539 3600.0n 0.6612 4199.5n 0.6612 4200.0n 0.6601 4799.5n 0.6601 4800.0n 0.6485 5399.5n 0.6485 5400.0n 0.6029 5999.5n 0.6029 6000.0n 0.6628 6599.5n 0.6628 6600.0n 0.6595 7199.5n 0.6595 7200.0n 0.5345 7799.5n 0.5345 7800.0n 0.5958 8399.5n 0.5958 8400.0n 0.5790 8999.5n 0.5790 9000.0n 0.6052 9599.5n 0.6052 9600.0n 0.5969 10199.5n 0.5969 10200.0n 0.5950 10799.5n 0.5950 10800.0n 0.6151 11399.5n 0.6151 11400.0n 0.5955 11999.5n 0.5955 12000.0n 0.6178 12599.5n 0.6178 12600.0n 0.5133 13199.5n 0.5133 13200.0n 0.6078 13799.5n 0.6078 13800.0n 0.5391 14399.5n 0.5391)
Vxn_who_15_1 xn_who_15_1 0 PWL(0.0n 0.3414 599.5n 0.3414 600.0n 0.3924 1199.5n 0.3924 1200.0n 0.3398 1799.5n 0.3398 1800.0n 0.3383 2399.5n 0.3383 2400.0n 0.3432 2999.5n 0.3432 3000.0n 0.3461 3599.5n 0.3461 3600.0n 0.3388 4199.5n 0.3388 4200.0n 0.3399 4799.5n 0.3399 4800.0n 0.3515 5399.5n 0.3515 5400.0n 0.3971 5999.5n 0.3971 6000.0n 0.3372 6599.5n 0.3372 6600.0n 0.3405 7199.5n 0.3405 7200.0n 0.4655 7799.5n 0.4655 7800.0n 0.4042 8399.5n 0.4042 8400.0n 0.4210 8999.5n 0.4210 9000.0n 0.3948 9599.5n 0.3948 9600.0n 0.4031 10199.5n 0.4031 10200.0n 0.4050 10799.5n 0.4050 10800.0n 0.3849 11399.5n 0.3849 11400.0n 0.4045 11999.5n 0.4045 12000.0n 0.3822 12599.5n 0.3822 12600.0n 0.4867 13199.5n 0.4867 13200.0n 0.3922 13799.5n 0.3922 13800.0n 0.4609 14399.5n 0.4609)
Vyp_who_15_1 yp_who_15_1 0 PWL(0.0n 0.4909 599.5n 0.4909 600.0n 0.4933 1199.5n 0.4933 1200.0n 0.4930 1799.5n 0.4930 1800.0n 0.4893 2399.5n 0.4893 2400.0n 0.4904 2999.5n 0.4904 3000.0n 0.4923 3599.5n 0.4923 3600.0n 0.4897 4199.5n 0.4897 4200.0n 0.4890 4799.5n 0.4890 4800.0n 0.4921 5399.5n 0.4921 5400.0n 0.4899 5999.5n 0.4899 6000.0n 0.4870 6599.5n 0.4870 6600.0n 0.4903 7199.5n 0.4903 7200.0n 0.4970 7799.5n 0.4970 7800.0n 0.4989 8399.5n 0.4989 8400.0n 0.4994 8999.5n 0.4994 9000.0n 0.4991 9599.5n 0.4991 9600.0n 0.5000 10199.5n 0.5000 10200.0n 0.4948 10799.5n 0.4948 10800.0n 0.4959 11399.5n 0.4959 11400.0n 0.4926 11999.5n 0.4926 12000.0n 0.4993 12599.5n 0.4993 12600.0n 0.4862 13199.5n 0.4862 13200.0n 0.4993 13799.5n 0.4993 13800.0n 0.4961 14399.5n 0.4961)
Vyn_who_15_1 yn_who_15_1 0 PWL(0.0n 0.5091 599.5n 0.5091 600.0n 0.5067 1199.5n 0.5067 1200.0n 0.5070 1799.5n 0.5070 1800.0n 0.5107 2399.5n 0.5107 2400.0n 0.5096 2999.5n 0.5096 3000.0n 0.5077 3599.5n 0.5077 3600.0n 0.5103 4199.5n 0.5103 4200.0n 0.5110 4799.5n 0.5110 4800.0n 0.5079 5399.5n 0.5079 5400.0n 0.5101 5999.5n 0.5101 6000.0n 0.5130 6599.5n 0.5130 6600.0n 0.5097 7199.5n 0.5097 7200.0n 0.5030 7799.5n 0.5030 7800.0n 0.5011 8399.5n 0.5011 8400.0n 0.5006 8999.5n 0.5006 9000.0n 0.5009 9599.5n 0.5009 9600.0n 0.5000 10199.5n 0.5000 10200.0n 0.5052 10799.5n 0.5052 10800.0n 0.5041 11399.5n 0.5041 11400.0n 0.5074 11999.5n 0.5074 12000.0n 0.5007 12599.5n 0.5007 12600.0n 0.5138 13199.5n 0.5138 13200.0n 0.5007 13799.5n 0.5007 13800.0n 0.5039 14399.5n 0.5039)
Cwp_who_15_1 wp_who_15_1 0 400p
Cwn_who_15_1 wn_who_15_1 0 400p
Xu_who_15_1 xp_who_15_1 xn_who_15_1 yp_who_15_1 yn_who_15_1 wp_who_15_1 wn_who_15_1 vdd gbn gprod
Vxp_bh_15 xp_bh_15 0 PWL(0.0n 0.7100 599.5n 0.7100 600.0n 0.7100 1199.5n 0.7100 1200.0n 0.7100 1799.5n 0.7100 1800.0n 0.7100 2399.5n 0.7100 2400.0n 0.7100 2999.5n 0.7100 3000.0n 0.7100 3599.5n 0.7100 3600.0n 0.7100 4199.5n 0.7100 4200.0n 0.7100 4799.5n 0.7100 4800.0n 0.7100 5399.5n 0.7100 5400.0n 0.7100 5999.5n 0.7100 6000.0n 0.7100 6599.5n 0.7100 6600.0n 0.7100 7199.5n 0.7100 7200.0n 0.7100 7799.5n 0.7100 7800.0n 0.7100 8399.5n 0.7100 8400.0n 0.7100 8999.5n 0.7100 9000.0n 0.7100 9599.5n 0.7100 9600.0n 0.7100 10199.5n 0.7100 10200.0n 0.7100 10799.5n 0.7100 10800.0n 0.7100 11399.5n 0.7100 11400.0n 0.7100 11999.5n 0.7100 12000.0n 0.7100 12599.5n 0.7100 12600.0n 0.7100 13199.5n 0.7100 13200.0n 0.7100 13799.5n 0.7100 13800.0n 0.7100 14399.5n 0.7100)
Vxn_bh_15 xn_bh_15 0 PWL(0.0n 0.2900 599.5n 0.2900 600.0n 0.2900 1199.5n 0.2900 1200.0n 0.2900 1799.5n 0.2900 1800.0n 0.2900 2399.5n 0.2900 2400.0n 0.2900 2999.5n 0.2900 3000.0n 0.2900 3599.5n 0.2900 3600.0n 0.2900 4199.5n 0.2900 4200.0n 0.2900 4799.5n 0.2900 4800.0n 0.2900 5399.5n 0.2900 5400.0n 0.2900 5999.5n 0.2900 6000.0n 0.2900 6599.5n 0.2900 6600.0n 0.2900 7199.5n 0.2900 7200.0n 0.2900 7799.5n 0.2900 7800.0n 0.2900 8399.5n 0.2900 8400.0n 0.2900 8999.5n 0.2900 9000.0n 0.2900 9599.5n 0.2900 9600.0n 0.2900 10199.5n 0.2900 10200.0n 0.2900 10799.5n 0.2900 10800.0n 0.2900 11399.5n 0.2900 11400.0n 0.2900 11999.5n 0.2900 12000.0n 0.2900 12599.5n 0.2900 12600.0n 0.2900 13199.5n 0.2900 13200.0n 0.2900 13799.5n 0.2900 13800.0n 0.2900 14399.5n 0.2900)
Vyp_bh_15 yp_bh_15 0 PWL(0.0n 0.6586 599.5n 0.6586 600.0n 0.6076 1199.5n 0.6076 1200.0n 0.6602 1799.5n 0.6602 1800.0n 0.6617 2399.5n 0.6617 2400.0n 0.6568 2999.5n 0.6568 3000.0n 0.6539 3599.5n 0.6539 3600.0n 0.6612 4199.5n 0.6612 4200.0n 0.6601 4799.5n 0.6601 4800.0n 0.6485 5399.5n 0.6485 5400.0n 0.6029 5999.5n 0.6029 6000.0n 0.6628 6599.5n 0.6628 6600.0n 0.6595 7199.5n 0.6595 7200.0n 0.5345 7799.5n 0.5345 7800.0n 0.5958 8399.5n 0.5958 8400.0n 0.5790 8999.5n 0.5790 9000.0n 0.6052 9599.5n 0.6052 9600.0n 0.5969 10199.5n 0.5969 10200.0n 0.5950 10799.5n 0.5950 10800.0n 0.6151 11399.5n 0.6151 11400.0n 0.5955 11999.5n 0.5955 12000.0n 0.6178 12599.5n 0.6178 12600.0n 0.5133 13199.5n 0.5133 13200.0n 0.6078 13799.5n 0.6078 13800.0n 0.5391 14399.5n 0.5391)
Vyn_bh_15 yn_bh_15 0 PWL(0.0n 0.3414 599.5n 0.3414 600.0n 0.3924 1199.5n 0.3924 1200.0n 0.3398 1799.5n 0.3398 1800.0n 0.3383 2399.5n 0.3383 2400.0n 0.3432 2999.5n 0.3432 3000.0n 0.3461 3599.5n 0.3461 3600.0n 0.3388 4199.5n 0.3388 4200.0n 0.3399 4799.5n 0.3399 4800.0n 0.3515 5399.5n 0.3515 5400.0n 0.3971 5999.5n 0.3971 6000.0n 0.3372 6599.5n 0.3372 6600.0n 0.3405 7199.5n 0.3405 7200.0n 0.4655 7799.5n 0.4655 7800.0n 0.4042 8399.5n 0.4042 8400.0n 0.4210 8999.5n 0.4210 9000.0n 0.3948 9599.5n 0.3948 9600.0n 0.4031 10199.5n 0.4031 10200.0n 0.4050 10799.5n 0.4050 10800.0n 0.3849 11399.5n 0.3849 11400.0n 0.4045 11999.5n 0.4045 12000.0n 0.3822 12599.5n 0.3822 12600.0n 0.4867 13199.5n 0.4867 13200.0n 0.3922 13799.5n 0.3922 13800.0n 0.4609 14399.5n 0.4609)
Cwp_bh_15 wp_bh_15 0 400p
Cwn_bh_15 wn_bh_15 0 400p
Xu_bh_15 xp_bh_15 xn_bh_15 yp_bh_15 yn_bh_15 wp_bh_15 wn_bh_15 vdd gbn gprod
Vxp_bo_0 xp_bo_0 0 PWL(0.0n 0.7100 599.5n 0.7100 600.0n 0.7100 1199.5n 0.7100 1200.0n 0.7100 1799.5n 0.7100 1800.0n 0.7100 2399.5n 0.7100 2400.0n 0.7100 2999.5n 0.7100 3000.0n 0.7100 3599.5n 0.7100 3600.0n 0.7100 4199.5n 0.7100 4200.0n 0.7100 4799.5n 0.7100 4800.0n 0.7100 5399.5n 0.7100 5400.0n 0.7100 5999.5n 0.7100 6000.0n 0.7100 6599.5n 0.7100 6600.0n 0.7100 7199.5n 0.7100 7200.0n 0.7100 7799.5n 0.7100 7800.0n 0.7100 8399.5n 0.7100 8400.0n 0.7100 8999.5n 0.7100 9000.0n 0.7100 9599.5n 0.7100 9600.0n 0.7100 10199.5n 0.7100 10200.0n 0.7100 10799.5n 0.7100 10800.0n 0.7100 11399.5n 0.7100 11400.0n 0.7100 11999.5n 0.7100 12000.0n 0.7100 12599.5n 0.7100 12600.0n 0.7100 13199.5n 0.7100 13200.0n 0.7100 13799.5n 0.7100 13800.0n 0.7100 14399.5n 0.7100)
Vxn_bo_0 xn_bo_0 0 PWL(0.0n 0.2900 599.5n 0.2900 600.0n 0.2900 1199.5n 0.2900 1200.0n 0.2900 1799.5n 0.2900 1800.0n 0.2900 2399.5n 0.2900 2400.0n 0.2900 2999.5n 0.2900 3000.0n 0.2900 3599.5n 0.2900 3600.0n 0.2900 4199.5n 0.2900 4200.0n 0.2900 4799.5n 0.2900 4800.0n 0.2900 5399.5n 0.2900 5400.0n 0.2900 5999.5n 0.2900 6000.0n 0.2900 6599.5n 0.2900 6600.0n 0.2900 7199.5n 0.2900 7200.0n 0.2900 7799.5n 0.2900 7800.0n 0.2900 8399.5n 0.2900 8400.0n 0.2900 8999.5n 0.2900 9000.0n 0.2900 9599.5n 0.2900 9600.0n 0.2900 10199.5n 0.2900 10200.0n 0.2900 10799.5n 0.2900 10800.0n 0.2900 11399.5n 0.2900 11400.0n 0.2900 11999.5n 0.2900 12000.0n 0.2900 12599.5n 0.2900 12600.0n 0.2900 13199.5n 0.2900 13200.0n 0.2900 13799.5n 0.2900 13800.0n 0.2900 14399.5n 0.2900)
Vyp_bo_0 yp_bo_0 0 PWL(0.0n 0.5073 599.5n 0.5073 600.0n 0.5065 1199.5n 0.5065 1200.0n 0.5065 1799.5n 0.5065 1800.0n 0.5052 2399.5n 0.5052 2400.0n 0.5058 2999.5n 0.5058 3000.0n 0.5039 3599.5n 0.5039 3600.0n 0.5059 4199.5n 0.5059 4200.0n 0.5077 4799.5n 0.5077 4800.0n 0.5054 5399.5n 0.5054 5400.0n 0.5066 5999.5n 0.5066 6000.0n 0.5083 6599.5n 0.5083 6600.0n 0.5078 7199.5n 0.5078 7200.0n 0.5043 7799.5n 0.5043 7800.0n 0.5035 8399.5n 0.5035 8400.0n 0.5035 8999.5n 0.5035 9000.0n 0.5038 9599.5n 0.5038 9600.0n 0.5043 10199.5n 0.5043 10200.0n 0.5053 10799.5n 0.5053 10800.0n 0.5050 11399.5n 0.5050 11400.0n 0.5055 11999.5n 0.5055 12000.0n 0.5043 12599.5n 0.5043 12600.0n 0.5028 13199.5n 0.5028 13200.0n 0.5045 13799.5n 0.5045 13800.0n 0.5043 14399.5n 0.5043)
Vyn_bo_0 yn_bo_0 0 PWL(0.0n 0.4927 599.5n 0.4927 600.0n 0.4935 1199.5n 0.4935 1200.0n 0.4935 1799.5n 0.4935 1800.0n 0.4948 2399.5n 0.4948 2400.0n 0.4942 2999.5n 0.4942 3000.0n 0.4961 3599.5n 0.4961 3600.0n 0.4941 4199.5n 0.4941 4200.0n 0.4923 4799.5n 0.4923 4800.0n 0.4946 5399.5n 0.4946 5400.0n 0.4934 5999.5n 0.4934 6000.0n 0.4917 6599.5n 0.4917 6600.0n 0.4922 7199.5n 0.4922 7200.0n 0.4957 7799.5n 0.4957 7800.0n 0.4965 8399.5n 0.4965 8400.0n 0.4965 8999.5n 0.4965 9000.0n 0.4962 9599.5n 0.4962 9600.0n 0.4957 10199.5n 0.4957 10200.0n 0.4947 10799.5n 0.4947 10800.0n 0.4950 11399.5n 0.4950 11400.0n 0.4945 11999.5n 0.4945 12000.0n 0.4957 12599.5n 0.4957 12600.0n 0.4972 13199.5n 0.4972 13200.0n 0.4955 13799.5n 0.4955 13800.0n 0.4957 14399.5n 0.4957)
Cwp_bo_0 wp_bo_0 0 400p
Cwn_bo_0 wn_bo_0 0 400p
Xu_bo_0 xp_bo_0 xn_bo_0 yp_bo_0 yn_bo_0 wp_bo_0 wn_bo_0 vdd gbn gprod
Vxp_bo_1 xp_bo_1 0 PWL(0.0n 0.7100 599.5n 0.7100 600.0n 0.7100 1199.5n 0.7100 1200.0n 0.7100 1799.5n 0.7100 1800.0n 0.7100 2399.5n 0.7100 2400.0n 0.7100 2999.5n 0.7100 3000.0n 0.7100 3599.5n 0.7100 3600.0n 0.7100 4199.5n 0.7100 4200.0n 0.7100 4799.5n 0.7100 4800.0n 0.7100 5399.5n 0.7100 5400.0n 0.7100 5999.5n 0.7100 6000.0n 0.7100 6599.5n 0.7100 6600.0n 0.7100 7199.5n 0.7100 7200.0n 0.7100 7799.5n 0.7100 7800.0n 0.7100 8399.5n 0.7100 8400.0n 0.7100 8999.5n 0.7100 9000.0n 0.7100 9599.5n 0.7100 9600.0n 0.7100 10199.5n 0.7100 10200.0n 0.7100 10799.5n 0.7100 10800.0n 0.7100 11399.5n 0.7100 11400.0n 0.7100 11999.5n 0.7100 12000.0n 0.7100 12599.5n 0.7100 12600.0n 0.7100 13199.5n 0.7100 13200.0n 0.7100 13799.5n 0.7100 13800.0n 0.7100 14399.5n 0.7100)
Vxn_bo_1 xn_bo_1 0 PWL(0.0n 0.2900 599.5n 0.2900 600.0n 0.2900 1199.5n 0.2900 1200.0n 0.2900 1799.5n 0.2900 1800.0n 0.2900 2399.5n 0.2900 2400.0n 0.2900 2999.5n 0.2900 3000.0n 0.2900 3599.5n 0.2900 3600.0n 0.2900 4199.5n 0.2900 4200.0n 0.2900 4799.5n 0.2900 4800.0n 0.2900 5399.5n 0.2900 5400.0n 0.2900 5999.5n 0.2900 6000.0n 0.2900 6599.5n 0.2900 6600.0n 0.2900 7199.5n 0.2900 7200.0n 0.2900 7799.5n 0.2900 7800.0n 0.2900 8399.5n 0.2900 8400.0n 0.2900 8999.5n 0.2900 9000.0n 0.2900 9599.5n 0.2900 9600.0n 0.2900 10199.5n 0.2900 10200.0n 0.2900 10799.5n 0.2900 10800.0n 0.2900 11399.5n 0.2900 11400.0n 0.2900 11999.5n 0.2900 12000.0n 0.2900 12599.5n 0.2900 12600.0n 0.2900 13199.5n 0.2900 13200.0n 0.2900 13799.5n 0.2900 13800.0n 0.2900 14399.5n 0.2900)
Vyp_bo_1 yp_bo_1 0 PWL(0.0n 0.4909 599.5n 0.4909 600.0n 0.4933 1199.5n 0.4933 1200.0n 0.4930 1799.5n 0.4930 1800.0n 0.4893 2399.5n 0.4893 2400.0n 0.4904 2999.5n 0.4904 3000.0n 0.4923 3599.5n 0.4923 3600.0n 0.4897 4199.5n 0.4897 4200.0n 0.4890 4799.5n 0.4890 4800.0n 0.4921 5399.5n 0.4921 5400.0n 0.4899 5999.5n 0.4899 6000.0n 0.4870 6599.5n 0.4870 6600.0n 0.4903 7199.5n 0.4903 7200.0n 0.4970 7799.5n 0.4970 7800.0n 0.4989 8399.5n 0.4989 8400.0n 0.4994 8999.5n 0.4994 9000.0n 0.4991 9599.5n 0.4991 9600.0n 0.5000 10199.5n 0.5000 10200.0n 0.4948 10799.5n 0.4948 10800.0n 0.4959 11399.5n 0.4959 11400.0n 0.4926 11999.5n 0.4926 12000.0n 0.4993 12599.5n 0.4993 12600.0n 0.4862 13199.5n 0.4862 13200.0n 0.4993 13799.5n 0.4993 13800.0n 0.4961 14399.5n 0.4961)
Vyn_bo_1 yn_bo_1 0 PWL(0.0n 0.5091 599.5n 0.5091 600.0n 0.5067 1199.5n 0.5067 1200.0n 0.5070 1799.5n 0.5070 1800.0n 0.5107 2399.5n 0.5107 2400.0n 0.5096 2999.5n 0.5096 3000.0n 0.5077 3599.5n 0.5077 3600.0n 0.5103 4199.5n 0.5103 4200.0n 0.5110 4799.5n 0.5110 4800.0n 0.5079 5399.5n 0.5079 5400.0n 0.5101 5999.5n 0.5101 6000.0n 0.5130 6599.5n 0.5130 6600.0n 0.5097 7199.5n 0.5097 7200.0n 0.5030 7799.5n 0.5030 7800.0n 0.5011 8399.5n 0.5011 8400.0n 0.5006 8999.5n 0.5006 9000.0n 0.5009 9599.5n 0.5009 9600.0n 0.5000 10199.5n 0.5000 10200.0n 0.5052 10799.5n 0.5052 10800.0n 0.5041 11399.5n 0.5041 11400.0n 0.5074 11999.5n 0.5074 12000.0n 0.5007 12599.5n 0.5007 12600.0n 0.5138 13199.5n 0.5138 13200.0n 0.5007 13799.5n 0.5007 13800.0n 0.5039 14399.5n 0.5039)
Cwp_bo_1 wp_bo_1 0 400p
Cwn_bo_1 wn_bo_1 0 400p
Xu_bo_1 xp_bo_1 xn_bo_1 yp_bo_1 yn_bo_1 wp_bo_1 wn_bo_1 vdd gbn gprod
.ic v(wp_wih_0_0)=0.5 v(wn_wih_0_0)=0.5
.ic v(wp_wih_1_0)=0.5 v(wn_wih_1_0)=0.5
.ic v(wp_wih_4_0)=0.5 v(wn_wih_4_0)=0.5
.ic v(wp_wih_5_0)=0.5 v(wn_wih_5_0)=0.5
.ic v(wp_who_0_0)=0.5 v(wn_who_0_0)=0.5
.ic v(wp_who_0_1)=0.5 v(wn_who_0_1)=0.5
.ic v(wp_bh_0)=0.5 v(wn_bh_0)=0.5
.ic v(wp_wih_0_1)=0.5 v(wn_wih_0_1)=0.5
.ic v(wp_wih_1_1)=0.5 v(wn_wih_1_1)=0.5
.ic v(wp_wih_4_1)=0.5 v(wn_wih_4_1)=0.5
.ic v(wp_wih_5_1)=0.5 v(wn_wih_5_1)=0.5
.ic v(wp_who_1_0)=0.5 v(wn_who_1_0)=0.5
.ic v(wp_who_1_1)=0.5 v(wn_who_1_1)=0.5
.ic v(wp_bh_1)=0.5 v(wn_bh_1)=0.5
.ic v(wp_wih_0_2)=0.5 v(wn_wih_0_2)=0.5
.ic v(wp_wih_1_2)=0.5 v(wn_wih_1_2)=0.5
.ic v(wp_wih_4_2)=0.5 v(wn_wih_4_2)=0.5
.ic v(wp_wih_5_2)=0.5 v(wn_wih_5_2)=0.5
.ic v(wp_who_2_0)=0.5 v(wn_who_2_0)=0.5
.ic v(wp_who_2_1)=0.5 v(wn_who_2_1)=0.5
.ic v(wp_bh_2)=0.5 v(wn_bh_2)=0.5
.ic v(wp_wih_0_3)=0.5 v(wn_wih_0_3)=0.5
.ic v(wp_wih_1_3)=0.5 v(wn_wih_1_3)=0.5
.ic v(wp_wih_4_3)=0.5 v(wn_wih_4_3)=0.5
.ic v(wp_wih_5_3)=0.5 v(wn_wih_5_3)=0.5
.ic v(wp_who_3_0)=0.5 v(wn_who_3_0)=0.5
.ic v(wp_who_3_1)=0.5 v(wn_who_3_1)=0.5
.ic v(wp_bh_3)=0.5 v(wn_bh_3)=0.5
.ic v(wp_wih_2_4)=0.5 v(wn_wih_2_4)=0.5
.ic v(wp_wih_3_4)=0.5 v(wn_wih_3_4)=0.5
.ic v(wp_wih_6_4)=0.5 v(wn_wih_6_4)=0.5
.ic v(wp_wih_7_4)=0.5 v(wn_wih_7_4)=0.5
.ic v(wp_who_4_0)=0.5 v(wn_who_4_0)=0.5
.ic v(wp_who_4_1)=0.5 v(wn_who_4_1)=0.5
.ic v(wp_bh_4)=0.5 v(wn_bh_4)=0.5
.ic v(wp_wih_2_5)=0.5 v(wn_wih_2_5)=0.5
.ic v(wp_wih_3_5)=0.5 v(wn_wih_3_5)=0.5
.ic v(wp_wih_6_5)=0.5 v(wn_wih_6_5)=0.5
.ic v(wp_wih_7_5)=0.5 v(wn_wih_7_5)=0.5
.ic v(wp_who_5_0)=0.5 v(wn_who_5_0)=0.5
.ic v(wp_who_5_1)=0.5 v(wn_who_5_1)=0.5
.ic v(wp_bh_5)=0.5 v(wn_bh_5)=0.5
.ic v(wp_wih_2_6)=0.5 v(wn_wih_2_6)=0.5
.ic v(wp_wih_3_6)=0.5 v(wn_wih_3_6)=0.5
.ic v(wp_wih_6_6)=0.5 v(wn_wih_6_6)=0.5
.ic v(wp_wih_7_6)=0.5 v(wn_wih_7_6)=0.5
.ic v(wp_who_6_0)=0.5 v(wn_who_6_0)=0.5
.ic v(wp_who_6_1)=0.5 v(wn_who_6_1)=0.5
.ic v(wp_bh_6)=0.5 v(wn_bh_6)=0.5
.ic v(wp_wih_2_7)=0.5 v(wn_wih_2_7)=0.5
.ic v(wp_wih_3_7)=0.5 v(wn_wih_3_7)=0.5
.ic v(wp_wih_6_7)=0.5 v(wn_wih_6_7)=0.5
.ic v(wp_wih_7_7)=0.5 v(wn_wih_7_7)=0.5
.ic v(wp_who_7_0)=0.5 v(wn_who_7_0)=0.5
.ic v(wp_who_7_1)=0.5 v(wn_who_7_1)=0.5
.ic v(wp_bh_7)=0.5 v(wn_bh_7)=0.5
.ic v(wp_wih_8_8)=0.5 v(wn_wih_8_8)=0.5
.ic v(wp_wih_9_8)=0.5 v(wn_wih_9_8)=0.5
.ic v(wp_wih_12_8)=0.5 v(wn_wih_12_8)=0.5
.ic v(wp_wih_13_8)=0.5 v(wn_wih_13_8)=0.5
.ic v(wp_who_8_0)=0.5 v(wn_who_8_0)=0.5
.ic v(wp_who_8_1)=0.5 v(wn_who_8_1)=0.5
.ic v(wp_bh_8)=0.5 v(wn_bh_8)=0.5
.ic v(wp_wih_8_9)=0.5 v(wn_wih_8_9)=0.5
.ic v(wp_wih_9_9)=0.5 v(wn_wih_9_9)=0.5
.ic v(wp_wih_12_9)=0.5 v(wn_wih_12_9)=0.5
.ic v(wp_wih_13_9)=0.5 v(wn_wih_13_9)=0.5
.ic v(wp_who_9_0)=0.5 v(wn_who_9_0)=0.5
.ic v(wp_who_9_1)=0.5 v(wn_who_9_1)=0.5
.ic v(wp_bh_9)=0.5 v(wn_bh_9)=0.5
.ic v(wp_wih_8_10)=0.5 v(wn_wih_8_10)=0.5
.ic v(wp_wih_9_10)=0.5 v(wn_wih_9_10)=0.5
.ic v(wp_wih_12_10)=0.5 v(wn_wih_12_10)=0.5
.ic v(wp_wih_13_10)=0.5 v(wn_wih_13_10)=0.5
.ic v(wp_who_10_0)=0.5 v(wn_who_10_0)=0.5
.ic v(wp_who_10_1)=0.5 v(wn_who_10_1)=0.5
.ic v(wp_bh_10)=0.5 v(wn_bh_10)=0.5
.ic v(wp_wih_8_11)=0.5 v(wn_wih_8_11)=0.5
.ic v(wp_wih_9_11)=0.5 v(wn_wih_9_11)=0.5
.ic v(wp_wih_12_11)=0.5 v(wn_wih_12_11)=0.5
.ic v(wp_wih_13_11)=0.5 v(wn_wih_13_11)=0.5
.ic v(wp_who_11_0)=0.5 v(wn_who_11_0)=0.5
.ic v(wp_who_11_1)=0.5 v(wn_who_11_1)=0.5
.ic v(wp_bh_11)=0.5 v(wn_bh_11)=0.5
.ic v(wp_wih_10_12)=0.5 v(wn_wih_10_12)=0.5
.ic v(wp_wih_11_12)=0.5 v(wn_wih_11_12)=0.5
.ic v(wp_wih_14_12)=0.5 v(wn_wih_14_12)=0.5
.ic v(wp_wih_15_12)=0.5 v(wn_wih_15_12)=0.5
.ic v(wp_who_12_0)=0.5 v(wn_who_12_0)=0.5
.ic v(wp_who_12_1)=0.5 v(wn_who_12_1)=0.5
.ic v(wp_bh_12)=0.5 v(wn_bh_12)=0.5
.ic v(wp_wih_10_13)=0.5 v(wn_wih_10_13)=0.5
.ic v(wp_wih_11_13)=0.5 v(wn_wih_11_13)=0.5
.ic v(wp_wih_14_13)=0.5 v(wn_wih_14_13)=0.5
.ic v(wp_wih_15_13)=0.5 v(wn_wih_15_13)=0.5
.ic v(wp_who_13_0)=0.5 v(wn_who_13_0)=0.5
.ic v(wp_who_13_1)=0.5 v(wn_who_13_1)=0.5
.ic v(wp_bh_13)=0.5 v(wn_bh_13)=0.5
.ic v(wp_wih_10_14)=0.5 v(wn_wih_10_14)=0.5
.ic v(wp_wih_11_14)=0.5 v(wn_wih_11_14)=0.5
.ic v(wp_wih_14_14)=0.5 v(wn_wih_14_14)=0.5
.ic v(wp_wih_15_14)=0.5 v(wn_wih_15_14)=0.5
.ic v(wp_who_14_0)=0.5 v(wn_who_14_0)=0.5
.ic v(wp_who_14_1)=0.5 v(wn_who_14_1)=0.5
.ic v(wp_bh_14)=0.5 v(wn_bh_14)=0.5
.ic v(wp_wih_10_15)=0.5 v(wn_wih_10_15)=0.5
.ic v(wp_wih_11_15)=0.5 v(wn_wih_11_15)=0.5
.ic v(wp_wih_14_15)=0.5 v(wn_wih_14_15)=0.5
.ic v(wp_wih_15_15)=0.5 v(wn_wih_15_15)=0.5
.ic v(wp_who_15_0)=0.5 v(wn_who_15_0)=0.5
.ic v(wp_who_15_1)=0.5 v(wn_who_15_1)=0.5
.ic v(wp_bh_15)=0.5 v(wn_bh_15)=0.5
.ic v(wp_bo_0)=0.5 v(wn_bo_0)=0.5
.ic v(wp_bo_1)=0.5 v(wn_bo_1)=0.5
.tran 1n 14400n uic
.control
run
wrdata pddtr.dat v(wp_wih_0_0) v(wn_wih_0_0) v(wp_wih_1_0) v(wn_wih_1_0) v(wp_wih_4_0) v(wn_wih_4_0) v(wp_wih_5_0) v(wn_wih_5_0) v(wp_who_0_0) v(wn_who_0_0) v(wp_who_0_1) v(wn_who_0_1) v(wp_bh_0) v(wn_bh_0) v(wp_wih_0_1) v(wn_wih_0_1) v(wp_wih_1_1) v(wn_wih_1_1) v(wp_wih_4_1) v(wn_wih_4_1) v(wp_wih_5_1) v(wn_wih_5_1) v(wp_who_1_0) v(wn_who_1_0) v(wp_who_1_1) v(wn_who_1_1) v(wp_bh_1) v(wn_bh_1) v(wp_wih_0_2) v(wn_wih_0_2) v(wp_wih_1_2) v(wn_wih_1_2) v(wp_wih_4_2) v(wn_wih_4_2) v(wp_wih_5_2) v(wn_wih_5_2) v(wp_who_2_0) v(wn_who_2_0) v(wp_who_2_1) v(wn_who_2_1) v(wp_bh_2) v(wn_bh_2) v(wp_wih_0_3) v(wn_wih_0_3) v(wp_wih_1_3) v(wn_wih_1_3) v(wp_wih_4_3) v(wn_wih_4_3) v(wp_wih_5_3) v(wn_wih_5_3) v(wp_who_3_0) v(wn_who_3_0) v(wp_who_3_1) v(wn_who_3_1) v(wp_bh_3) v(wn_bh_3) v(wp_wih_2_4) v(wn_wih_2_4) v(wp_wih_3_4) v(wn_wih_3_4) v(wp_wih_6_4) v(wn_wih_6_4) v(wp_wih_7_4) v(wn_wih_7_4) v(wp_who_4_0) v(wn_who_4_0) v(wp_who_4_1) v(wn_who_4_1) v(wp_bh_4) v(wn_bh_4) v(wp_wih_2_5) v(wn_wih_2_5) v(wp_wih_3_5) v(wn_wih_3_5) v(wp_wih_6_5) v(wn_wih_6_5) v(wp_wih_7_5) v(wn_wih_7_5) v(wp_who_5_0) v(wn_who_5_0) v(wp_who_5_1) v(wn_who_5_1) v(wp_bh_5) v(wn_bh_5) v(wp_wih_2_6) v(wn_wih_2_6) v(wp_wih_3_6) v(wn_wih_3_6) v(wp_wih_6_6) v(wn_wih_6_6) v(wp_wih_7_6) v(wn_wih_7_6) v(wp_who_6_0) v(wn_who_6_0) v(wp_who_6_1) v(wn_who_6_1) v(wp_bh_6) v(wn_bh_6) v(wp_wih_2_7) v(wn_wih_2_7) v(wp_wih_3_7) v(wn_wih_3_7) v(wp_wih_6_7) v(wn_wih_6_7) v(wp_wih_7_7) v(wn_wih_7_7) v(wp_who_7_0) v(wn_who_7_0) v(wp_who_7_1) v(wn_who_7_1) v(wp_bh_7) v(wn_bh_7) v(wp_wih_8_8) v(wn_wih_8_8) v(wp_wih_9_8) v(wn_wih_9_8) v(wp_wih_12_8) v(wn_wih_12_8) v(wp_wih_13_8) v(wn_wih_13_8) v(wp_who_8_0) v(wn_who_8_0) v(wp_who_8_1) v(wn_who_8_1) v(wp_bh_8) v(wn_bh_8) v(wp_wih_8_9) v(wn_wih_8_9) v(wp_wih_9_9) v(wn_wih_9_9) v(wp_wih_12_9) v(wn_wih_12_9) v(wp_wih_13_9) v(wn_wih_13_9) v(wp_who_9_0) v(wn_who_9_0) v(wp_who_9_1) v(wn_who_9_1) v(wp_bh_9) v(wn_bh_9) v(wp_wih_8_10) v(wn_wih_8_10) v(wp_wih_9_10) v(wn_wih_9_10) v(wp_wih_12_10) v(wn_wih_12_10) v(wp_wih_13_10) v(wn_wih_13_10) v(wp_who_10_0) v(wn_who_10_0) v(wp_who_10_1) v(wn_who_10_1) v(wp_bh_10) v(wn_bh_10) v(wp_wih_8_11) v(wn_wih_8_11) v(wp_wih_9_11) v(wn_wih_9_11) v(wp_wih_12_11) v(wn_wih_12_11) v(wp_wih_13_11) v(wn_wih_13_11) v(wp_who_11_0) v(wn_who_11_0) v(wp_who_11_1) v(wn_who_11_1) v(wp_bh_11) v(wn_bh_11) v(wp_wih_10_12) v(wn_wih_10_12) v(wp_wih_11_12) v(wn_wih_11_12) v(wp_wih_14_12) v(wn_wih_14_12) v(wp_wih_15_12) v(wn_wih_15_12) v(wp_who_12_0) v(wn_who_12_0) v(wp_who_12_1) v(wn_who_12_1) v(wp_bh_12) v(wn_bh_12) v(wp_wih_10_13) v(wn_wih_10_13) v(wp_wih_11_13) v(wn_wih_11_13) v(wp_wih_14_13) v(wn_wih_14_13) v(wp_wih_15_13) v(wn_wih_15_13) v(wp_who_13_0) v(wn_who_13_0) v(wp_who_13_1) v(wn_who_13_1) v(wp_bh_13) v(wn_bh_13) v(wp_wih_10_14) v(wn_wih_10_14) v(wp_wih_11_14) v(wn_wih_11_14) v(wp_wih_14_14) v(wn_wih_14_14) v(wp_wih_15_14) v(wn_wih_15_14) v(wp_who_14_0) v(wn_who_14_0) v(wp_who_14_1) v(wn_who_14_1) v(wp_bh_14) v(wn_bh_14) v(wp_wih_10_15) v(wn_wih_10_15) v(wp_wih_11_15) v(wn_wih_11_15) v(wp_wih_14_15) v(wn_wih_14_15) v(wp_wih_15_15) v(wn_wih_15_15) v(wp_who_15_0) v(wn_who_15_0) v(wp_who_15_1) v(wn_who_15_1) v(wp_bh_15) v(wn_bh_15) v(wp_bo_0) v(wn_bo_0) v(wp_bo_1) v(wn_bo_1)
.endc
.end
